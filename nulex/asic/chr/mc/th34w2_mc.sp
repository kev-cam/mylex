* Monte-Carlo Vt-mismatch variant of th34w2 (from /usr/local/src/ldx/asic/cells/th_gates.sp)
* Auto-generated by gen_mc.py; A_Vt=3.5 mV*um; 17 devices.
.subckt th34w2 A B C D Y VDD VSS
.param kvt=1  ; overall Vt-mismatch scale (1 = nominal Pelgrom)
* Pull-up: 4 PMOS in series
MPA  P1 A VDD VDD sg13g2_pmos W=1.2u L=0.13u DELVTO={AGAUSS(0,kvt*8.8615e-03,1)}  ; sigma_Vt=8.9 mV (W=1.2 L=0.13)
MPB  P2 B P1  VDD sg13g2_pmos W=1.2u L=0.13u DELVTO={AGAUSS(0,kvt*8.8615e-03,1)}  ; sigma_Vt=8.9 mV (W=1.2 L=0.13)
MPC  P3 C P2  VDD sg13g2_pmos W=1.2u L=0.13u DELVTO={AGAUSS(0,kvt*8.8615e-03,1)}  ; sigma_Vt=8.9 mV (W=1.2 L=0.13)
MPD  X  D P3  VDD sg13g2_pmos W=1.2u L=0.13u DELVTO={AGAUSS(0,kvt*8.8615e-03,1)}  ; sigma_Vt=8.9 mV (W=1.2 L=0.13)
* Pull-down branch 1: A·B
MNAB1 Q1 A VSS VSS sg13g2_nmos W=0.7u L=0.13u DELVTO={AGAUSS(0,kvt*1.1602e-02,1)}  ; sigma_Vt=11.6 mV (W=0.7 L=0.13)
MNAB2 X  B Q1  VSS sg13g2_nmos W=0.7u L=0.13u DELVTO={AGAUSS(0,kvt*1.1602e-02,1)}  ; sigma_Vt=11.6 mV (W=0.7 L=0.13)
* Pull-down branch 2: A·C
MNAC1 Q2 A VSS VSS sg13g2_nmos W=0.7u L=0.13u DELVTO={AGAUSS(0,kvt*1.1602e-02,1)}  ; sigma_Vt=11.6 mV (W=0.7 L=0.13)
MNAC2 X  C Q2  VSS sg13g2_nmos W=0.7u L=0.13u DELVTO={AGAUSS(0,kvt*1.1602e-02,1)}  ; sigma_Vt=11.6 mV (W=0.7 L=0.13)
* Pull-down branch 3: A·D
MNAD1 Q3 A VSS VSS sg13g2_nmos W=0.7u L=0.13u DELVTO={AGAUSS(0,kvt*1.1602e-02,1)}  ; sigma_Vt=11.6 mV (W=0.7 L=0.13)
MNAD2 X  D Q3  VSS sg13g2_nmos W=0.7u L=0.13u DELVTO={AGAUSS(0,kvt*1.1602e-02,1)}  ; sigma_Vt=11.6 mV (W=0.7 L=0.13)
* Pull-down branch 4: B·C·D
MNBCD1 Q4 B VSS VSS sg13g2_nmos W=0.7u L=0.13u DELVTO={AGAUSS(0,kvt*1.1602e-02,1)}  ; sigma_Vt=11.6 mV (W=0.7 L=0.13)
MNBCD2 Q5 C Q4  VSS sg13g2_nmos W=0.7u L=0.13u DELVTO={AGAUSS(0,kvt*1.1602e-02,1)}  ; sigma_Vt=11.6 mV (W=0.7 L=0.13)
MNBCD3 X  D Q5  VSS sg13g2_nmos W=0.7u L=0.13u DELVTO={AGAUSS(0,kvt*1.1602e-02,1)}  ; sigma_Vt=11.6 mV (W=0.7 L=0.13)
* Output inverter
MPY  Y  X VDD VDD sg13g2_pmos W=0.7u L=0.13u DELVTO={AGAUSS(0,kvt*1.1602e-02,1)}  ; sigma_Vt=11.6 mV (W=0.7 L=0.13)
MNY  Y  X VSS VSS sg13g2_nmos W=0.35u L=0.13u DELVTO={AGAUSS(0,kvt*1.6408e-02,1)}  ; sigma_Vt=16.4 mV (W=0.35 L=0.13)
* Keeper
MPK  X  Y VDD VDD sg13g2_pmos W=0.35u L=1.0u DELVTO={AGAUSS(0,kvt*5.9161e-03,1)}  ; sigma_Vt=5.9 mV (W=0.35 L=1)
MNK  X  Y VSS VSS sg13g2_nmos W=0.15u L=1.0u DELVTO={AGAUSS(0,kvt*9.0370e-03,1)}  ; sigma_Vt=9.0 mV (W=0.15 L=1)
.ends th34w2
