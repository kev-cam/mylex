* Monte-Carlo Vt-mismatch variant of th23 (from /usr/local/src/ldx/asic/cells/th_gates.sp)
* Auto-generated by gen_mc.py; A_Vt=3.5 mV*um; 13 devices.
.subckt th23 A B C Y VDD VSS
.param kvt=1  ; overall Vt-mismatch scale (1 = nominal Pelgrom)
* Pull-up: all three PMOS in series
MPA  N1 A VDD VDD sg13g2_pmos W=1.0u L=0.13u DELVTO={AGAUSS(0,kvt*9.7073e-03,1)}  ; sigma_Vt=9.7 mV (W=1 L=0.13)
MPB  N2 B N1  VDD sg13g2_pmos W=1.0u L=0.13u DELVTO={AGAUSS(0,kvt*9.7073e-03,1)}  ; sigma_Vt=9.7 mV (W=1 L=0.13)
MPC  X  C N2  VDD sg13g2_pmos W=1.0u L=0.13u DELVTO={AGAUSS(0,kvt*9.7073e-03,1)}  ; sigma_Vt=9.7 mV (W=1 L=0.13)
* Pull-down: three 2-input AND branches in parallel, each is 2 nMOS in series
* Branch 1: A·B
MNAB1 M1 A VSS VSS sg13g2_nmos W=0.7u L=0.13u DELVTO={AGAUSS(0,kvt*1.1602e-02,1)}  ; sigma_Vt=11.6 mV (W=0.7 L=0.13)
MNAB2 X  B M1  VSS sg13g2_nmos W=0.7u L=0.13u DELVTO={AGAUSS(0,kvt*1.1602e-02,1)}  ; sigma_Vt=11.6 mV (W=0.7 L=0.13)
* Branch 2: A·C
MNAC1 M2 A VSS VSS sg13g2_nmos W=0.7u L=0.13u DELVTO={AGAUSS(0,kvt*1.1602e-02,1)}  ; sigma_Vt=11.6 mV (W=0.7 L=0.13)
MNAC2 X  C M2  VSS sg13g2_nmos W=0.7u L=0.13u DELVTO={AGAUSS(0,kvt*1.1602e-02,1)}  ; sigma_Vt=11.6 mV (W=0.7 L=0.13)
* Branch 3: B·C
MNBC1 M3 B VSS VSS sg13g2_nmos W=0.7u L=0.13u DELVTO={AGAUSS(0,kvt*1.1602e-02,1)}  ; sigma_Vt=11.6 mV (W=0.7 L=0.13)
MNBC2 X  C M3  VSS sg13g2_nmos W=0.7u L=0.13u DELVTO={AGAUSS(0,kvt*1.1602e-02,1)}  ; sigma_Vt=11.6 mV (W=0.7 L=0.13)
* Output inverter
MPY  Y  X VDD VDD sg13g2_pmos W=0.7u L=0.13u DELVTO={AGAUSS(0,kvt*1.1602e-02,1)}  ; sigma_Vt=11.6 mV (W=0.7 L=0.13)
MNY  Y  X VSS VSS sg13g2_nmos W=0.35u L=0.13u DELVTO={AGAUSS(0,kvt*1.6408e-02,1)}  ; sigma_Vt=16.4 mV (W=0.35 L=0.13)
* Keeper
MPK  X  Y VDD VDD sg13g2_pmos W=0.35u L=1.0u DELVTO={AGAUSS(0,kvt*5.9161e-03,1)}  ; sigma_Vt=5.9 mV (W=0.35 L=1)
MNK  X  Y VSS VSS sg13g2_nmos W=0.15u L=1.0u DELVTO={AGAUSS(0,kvt*9.0370e-03,1)}  ; sigma_Vt=9.0 mV (W=0.15 L=1)
.ends th23
