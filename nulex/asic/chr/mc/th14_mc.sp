* Monte-Carlo Vt-mismatch variant of th14 (from /usr/local/src/mylex/nulex/lib/th_cells_sg13g2.sp)
* Auto-generated by gen_mc.py; A_Vt=3.5 mV*um; 10 devices.
.subckt th14 A B C D Y VDD VSS
.param kvt=1  ; overall Vt-mismatch scale (1 = nominal Pelgrom)
* Pull-up: 4 PMOS in series (X high only when all inputs 0); widened further.
MPA  N1 A VDD VDD sg13g2_pmos W=1.4u L=0.13u DELVTO={AGAUSS(0,kvt*8.2041e-03,1)}  ; sigma_Vt=8.2 mV (W=1.4 L=0.13)
MPB  N2 B N1  VDD sg13g2_pmos W=1.4u L=0.13u DELVTO={AGAUSS(0,kvt*8.2041e-03,1)}  ; sigma_Vt=8.2 mV (W=1.4 L=0.13)
MPC  N3 C N2  VDD sg13g2_pmos W=1.4u L=0.13u DELVTO={AGAUSS(0,kvt*8.2041e-03,1)}  ; sigma_Vt=8.2 mV (W=1.4 L=0.13)
MPD  X  D N3  VDD sg13g2_pmos W=1.4u L=0.13u DELVTO={AGAUSS(0,kvt*8.2041e-03,1)}  ; sigma_Vt=8.2 mV (W=1.4 L=0.13)
* Pull-down: 4 NMOS in parallel.
MNA  X  A VSS VSS sg13g2_nmos W=0.35u L=0.13u DELVTO={AGAUSS(0,kvt*1.6408e-02,1)}  ; sigma_Vt=16.4 mV (W=0.35 L=0.13)
MNB  X  B VSS VSS sg13g2_nmos W=0.35u L=0.13u DELVTO={AGAUSS(0,kvt*1.6408e-02,1)}  ; sigma_Vt=16.4 mV (W=0.35 L=0.13)
MNC  X  C VSS VSS sg13g2_nmos W=0.35u L=0.13u DELVTO={AGAUSS(0,kvt*1.6408e-02,1)}  ; sigma_Vt=16.4 mV (W=0.35 L=0.13)
MND  X  D VSS VSS sg13g2_nmos W=0.35u L=0.13u DELVTO={AGAUSS(0,kvt*1.6408e-02,1)}  ; sigma_Vt=16.4 mV (W=0.35 L=0.13)
* Output inverter X -> Y.
MPY  Y  X VDD VDD sg13g2_pmos W=0.7u  L=0.13u DELVTO={AGAUSS(0,kvt*1.1602e-02,1)}  ; sigma_Vt=11.6 mV (W=0.7 L=0.13)
MNY  Y  X VSS VSS sg13g2_nmos W=0.35u L=0.13u DELVTO={AGAUSS(0,kvt*1.6408e-02,1)}  ; sigma_Vt=16.4 mV (W=0.35 L=0.13)
.ends th14
