* 8-bit ripple worst-case carry (A=1..1,B=0..0,Cin=1): coH = 8-deep th23 chain
.hdl "/usr/local/share/xyce/verilog-a/psp103/psp103.va"
.include "/usr/local/src/kestrel/sim/models/sg13g2_psp103_tt.lib"
.include "/usr/local/src/mylex/nulex/asic/chr/mc/th23_mc.sp"
.include "/usr/local/src/mylex/nulex/asic/chr/mc/th34w2_mc.sp"
.include "/usr/local/src/mylex/nulex/asic/chr/mc/nclfa_mc.sp"
.include "/usr/local/src/mylex/nulex/asic/chr/mc/nclfa8_mc.sp"
.param kvt=1
VVDD VDD 0 1.2
Xdut a0H a0L a1H a1L a2H a2L a3H a3L a4H a4L a5H a5L a6H a6L a7H a7L b0H b0L b1H b1L b2H b2L b3H b3L b4H b4L b5H b5L b6H b6L b7H b7L ciH ciL s0H s0L s1H s1L s2H s2L s3H s3L s4H s4L s5H s5L s6H s6L s7H s7L coH coL VDD 0 nclfa8 kvt={kvt}
CcoH coH 0 2f
Va0H a0H 0 PWL(0 0 4n 0 4.2n 1.2 16n 1.2 16.2n 0)
Va0L a0L 0 PWL(0 0 4n 0 4.2n 0 16n 0 16.2n 0)
Vb0H b0H 0 PWL(0 0 4n 0 4.2n 0 16n 0 16.2n 0)
Vb0L b0L 0 PWL(0 0 4n 0 4.2n 1.2 16n 1.2 16.2n 0)
Va1H a1H 0 PWL(0 0 4n 0 4.2n 1.2 16n 1.2 16.2n 0)
Va1L a1L 0 PWL(0 0 4n 0 4.2n 0 16n 0 16.2n 0)
Vb1H b1H 0 PWL(0 0 4n 0 4.2n 0 16n 0 16.2n 0)
Vb1L b1L 0 PWL(0 0 4n 0 4.2n 1.2 16n 1.2 16.2n 0)
Va2H a2H 0 PWL(0 0 4n 0 4.2n 1.2 16n 1.2 16.2n 0)
Va2L a2L 0 PWL(0 0 4n 0 4.2n 0 16n 0 16.2n 0)
Vb2H b2H 0 PWL(0 0 4n 0 4.2n 0 16n 0 16.2n 0)
Vb2L b2L 0 PWL(0 0 4n 0 4.2n 1.2 16n 1.2 16.2n 0)
Va3H a3H 0 PWL(0 0 4n 0 4.2n 1.2 16n 1.2 16.2n 0)
Va3L a3L 0 PWL(0 0 4n 0 4.2n 0 16n 0 16.2n 0)
Vb3H b3H 0 PWL(0 0 4n 0 4.2n 0 16n 0 16.2n 0)
Vb3L b3L 0 PWL(0 0 4n 0 4.2n 1.2 16n 1.2 16.2n 0)
Va4H a4H 0 PWL(0 0 4n 0 4.2n 1.2 16n 1.2 16.2n 0)
Va4L a4L 0 PWL(0 0 4n 0 4.2n 0 16n 0 16.2n 0)
Vb4H b4H 0 PWL(0 0 4n 0 4.2n 0 16n 0 16.2n 0)
Vb4L b4L 0 PWL(0 0 4n 0 4.2n 1.2 16n 1.2 16.2n 0)
Va5H a5H 0 PWL(0 0 4n 0 4.2n 1.2 16n 1.2 16.2n 0)
Va5L a5L 0 PWL(0 0 4n 0 4.2n 0 16n 0 16.2n 0)
Vb5H b5H 0 PWL(0 0 4n 0 4.2n 0 16n 0 16.2n 0)
Vb5L b5L 0 PWL(0 0 4n 0 4.2n 1.2 16n 1.2 16.2n 0)
Va6H a6H 0 PWL(0 0 4n 0 4.2n 1.2 16n 1.2 16.2n 0)
Va6L a6L 0 PWL(0 0 4n 0 4.2n 0 16n 0 16.2n 0)
Vb6H b6H 0 PWL(0 0 4n 0 4.2n 0 16n 0 16.2n 0)
Vb6L b6L 0 PWL(0 0 4n 0 4.2n 1.2 16n 1.2 16.2n 0)
Va7H a7H 0 PWL(0 0 4n 0 4.2n 1.2 16n 1.2 16.2n 0)
Va7L a7L 0 PWL(0 0 4n 0 4.2n 0 16n 0 16.2n 0)
Vb7H b7H 0 PWL(0 0 4n 0 4.2n 0 16n 0 16.2n 0)
Vb7L b7L 0 PWL(0 0 4n 0 4.2n 1.2 16n 1.2 16.2n 0)
VciH ciH 0 PWL(0 0 4n 0 4.2n 1.2 16n 1.2 16.2n 0)
VciL ciL 0 PWL(0 0 4n 0 4.2n 0 16n 0 16.2n 0)
.tran 20p 20n
.measure tran cout FIND V(coH) AT=15.6n
.measure tran tripple TRIG V(ciH) VAL=0.6 RISE=1 TD=3.9n TARG V(coH) VAL=0.6 RISE=1 TD=3.9n
.SAMPLING useExpr=true
.options SAMPLES numsamples=200 SAMPLE_TYPE=MC SEED=1
+ measures=cout,tripple OUTPUT_SAMPLE_STATS=true stdoutput=true
.end
