`include "disciplines.vams"
module m(p,n); electrical p,n; inout p,n; real g;
analog begin g = V(p,n)*10.0; if (g > 5.0) g = 5.0; else if (g < -5.0) g = -5.0; I(p,n) <+ g; end
endmodule
