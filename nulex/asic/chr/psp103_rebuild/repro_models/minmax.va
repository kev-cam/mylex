`include "disciplines.vams"
module m(p,n); electrical p,n; inout p,n; real g;
analog begin g = min(5.0, max(-5.0, V(p,n)*10.0)); I(p,n) <+ g; end
endmodule
