`include "disciplines.vams"
module m(p,n); electrical p,n; inout p,n; real g;
analog begin g = V(p,n)*10.0; g = g - (g - 3.0)*0.5; I(p,n) <+ g; end
endmodule
