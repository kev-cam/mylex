`include "disciplines.vams"
module m(p,n); electrical p,n; inout p,n; real g;
analog begin g = 0.0; if (V(p,n) > 0.5) g = V(p,n)*2.0; I(p,n) <+ g; end
endmodule
