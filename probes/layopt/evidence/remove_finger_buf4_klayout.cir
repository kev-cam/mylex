* cell t
.SUBCKT t
* device instance $1 r0 *1 2.31,0.56 sky130_fd_pr__nfet_01v8
M$1 1 3 2 2 sky130_fd_pr__nfet_01v8 L=0.15U W=0.65U AS=0.169P AD=0.08775P
+ PS=1.82U PD=0.92U
* device instance $2 r0 *1 2.73,0.56 sky130_fd_pr__nfet_01v8
M$2 4 2 1 1 sky130_fd_pr__nfet_01v8 L=0.15U W=1.95U AS=0.26325P AD=0.3445P
+ PS=2.76U PD=3.66U
* device instance $5 r0 *1 2.31,1.985 sky130_fd_pr__pfet_01v8
M$5 5 3 2 2 sky130_fd_pr__pfet_01v8 L=0.15U W=1U AS=0.26P AD=0.135P PS=2.52U
+ PD=1.27U
* device instance $6 r0 *1 2.73,1.985 sky130_fd_pr__pfet_01v8
M$6 4 2 5 5 sky130_fd_pr__pfet_01v8 L=0.15U W=3U AS=0.405P AD=0.53P PS=3.81U
+ PD=5.06U
.ENDS t
