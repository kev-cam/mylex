* cell t
.SUBCKT t
* net 1 VGND
* net 7 VPWR
* device instance $1 r0 *1 2.33,0.56 sky130_fd_pr__nfet_01v8
M$1 5 4 1 1 sky130_fd_pr__nfet_01v8 L=0.15U W=0.65U AS=0.169P AD=0.08775P
+ PS=1.82U PD=0.92U
* device instance $2 r0 *1 2.75,0.56 sky130_fd_pr__nfet_01v8
M$2 2 3 5 5 sky130_fd_pr__nfet_01v8 L=0.15U W=0.65U AS=0.08775P AD=0.105625P
+ PS=0.92U PD=0.975U
* device instance $3 r0 *1 3.225,0.56 sky130_fd_pr__nfet_01v8
M$3 6 3 2 2 sky130_fd_pr__nfet_01v8 L=0.15U W=0.65U AS=0.105625P AD=0.08775P
+ PS=0.975U PD=0.92U
* device instance $4 r0 *1 3.645,0.56 sky130_fd_pr__nfet_01v8
M$4 1 4 6 6 sky130_fd_pr__nfet_01v8 L=0.15U W=0.65U AS=0.08775P AD=0.169P
+ PS=0.92U PD=1.82U
* device instance $5 r0 *1 2.33,1.985 sky130_fd_pr__pfet_01v8
M$5 2 4 7 7 sky130_fd_pr__pfet_01v8 L=0.15U W=1U AS=0.26P AD=0.135P PS=2.52U
+ PD=1.27U
* device instance $6 r0 *1 2.75,1.985 sky130_fd_pr__pfet_01v8
M$6 7 3 2 2 sky130_fd_pr__pfet_01v8 L=0.15U W=2U AS=0.315P AD=0.45P PS=2.63U
+ PD=3.9U
.ENDS t
