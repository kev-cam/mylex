* cell gcd
.SUBCKT gcd
* net 1 resp_msg[6]
* net 2 resp_msg[8]
* net 15 dpath.a_mux$out\[8\]
* net 20 dpath.a_lt_b$in0\[8\]
* net 31 clknet_2_0__leaf_clk
* net 32 dpath.b_mux$out\[2\]
* net 43 dpath.a_lt_b$in0\[2\]
* net 50 dpath.a_mux$out\[2\]
* net 51 dpath.a_mux$out\[6\]
* net 54 _089_
* net 55 req_rdy
* net 56 _004_
* net 57 resp_msg[7]
* net 70 dpath.b_mux$out\[6\]
* net 71 _075_
* net 72 _048_
* net 73 dpath.b_mux$out\[8\]
* net 87 _069_
* net 88 net1
* net 90 VSS
* net 105 _093_
* net 108 _076_
* net 117 _088_
* net 118 dpath.b_mux$out\[7\]
* net 120 req_msg[7]
* net 123 _087_
* net 126 req_msg[8]
* net 128 dpath.a_lt_b$in1\[2\]
* net 129 _080_
* net 130 net2
* net 131 resp_msg[2]
* net 134 dpath.a_lt_b$in0\[7\]
* net 135 dpath.a_lt_b$in1\[8\]
* net 136 net6
* net 155 req_msg[18]
* net 157 req_msg[22]
* net 158 req_msg[21]
* net 159 req_msg[23]
* net 160 req_msg[24]
* net 162 VDD
* net 164 dpath.a_lt_b$in1\[6\]
* net 165 _090_
* net 187 dpath.a_lt_b$in0\[6\]
* net 189 dpath.a_mux$out\[7\]
* net 204 _022_
* net 205 req_msg[2]
* net 207 _040_
* net 208 req_msg[6]
* net 210 net32
* net 228 net9
* net 229 _047_
* net 230 dpath.a_lt_b$in1\[7\]
* net 231 _023_
* net 256 _041_
* net 259 _070_
* net 261 _030_
* net 265 _049_
* net 266 _024_
* net 267 _025_
* net 270 _050_
* net 274 _027_
* net 275 net11
* net 276 _046_
* net 277 _026_
* net 280 _036_
* net 283 _051_
* net 292 _042_
* net 306 _052_
* net 310 clknet_0_clk
* net 311 ctrl$a_reg_en\[0\]
* net 316 _020_
* net 329 clknet_2_1__leaf_clk
* net 330 _068_
* net 333 _019_
* net 334 dpath.a_lt_b$in1\[9\]
* net 335 _039_
* net 337 _043_
* net 338 _034_
* net 339 _021_
* net 341 dpath.a_lt_b$in0\[9\]
* net 346 resp_msg[9]
* net 352 _092_
* net 366 net52
* net 377 req_msg[19]
* net 378 dpath.a_lt_b$in1\[3\]
* net 380 _073_
* net 384 _100_
* net 386 _086_
* net 388 dpath.b_mux$out\[9\]
* net 403 resp_msg[3]
* net 404 dpath.b_mux$out\[5\]
* net 405 dpath.a_mux$out\[3\]
* net 406 _103_
* net 407 dpath.a_lt_b$in1\[5\]
* net 408 dpath.a_mux$out\[9\]
* net 433 _035_
* net 436 _071_
* net 437 _045_
* net 439 resp_msg[5]
* net 443 req_msg[25]
* net 445 req_msg[9]
* net 447 dpath.b_mux$out\[3\]
* net 449 dpath.a_lt_b$in0\[3\]
* net 462 req_msg[3]
* net 484 _029_
* net 486 req_msg[5]
* net 496 _033_
* net 497 _031_
* net 499 dpath.a_lt_b$in0\[5\]
* net 536 _028_
* net 543 _072_
* net 544 _044_
* net 547 dpath.a_mux$out\[5\]
* net 553 dpath.a_lt_b$in1\[10\]
* net 560 resp_msg[10]
* net 561 resp_msg[4]
* net 566 net8
* net 574 dpath.a_lt_b$in1\[1\]
* net 575 _085_
* net 576 _005_
* net 577 dpath.a_mux$out\[10\]
* net 587 dpath.a_mux$out\[1\]
* net 589 _037_
* net 590 dpath.a_lt_b$in0\[1\]
* net 591 _032_
* net 592 dpath.a_lt_b$in0\[4\]
* net 593 dpath.a_lt_b$in1\[4\]
* net 595 req_msg[26]
* net 596 _053_
* net 598 _018_
* net 600 _017_
* net 605 _094_
* net 606 net16
* net 621 req_msg[1]
* net 623 dpath.b_mux$out\[1\]
* net 625 net12
* net 633 _054_
* net 635 dpath.b_mux$out\[10\]
* net 637 req_msg[17]
* net 638 resp_msg[1]
* net 640 _038_
* net 642 dpath.a_mux$out\[4\]
* net 643 _055_
* net 645 dpath.a_lt_b$in0\[10\]
* net 646 req_msg[10]
* net 657 _091_
* net 659 clk
* net 693 _101_
* net 694 dpath.a_lt_b$in1\[14\]
* net 695 _099_
* net 708 dpath.b_mux$out\[4\]
* net 710 dpath.a_lt_b$in1\[11\]
* net 711 _067_
* net 732 req_msg[20]
* net 733 resp_msg[11]
* net 767 req_msg[4]
* net 776 _015_
* net 801 dpath.b_mux$out\[11\]
* net 802 dpath.a_lt_b$in0\[11\]
* net 803 _016_
* net 809 _084_
* net 810 dpath.a_mux$out\[11\]
* net 811 _003_
* net 850 net3
* net 851 _095_
* net 852 net13
* net 853 resp_msg[0]
* net 854 dpath.a_lt_b$in1\[0\]
* net 856 clknet_2_3__leaf_clk
* net 870 _074_
* net 873 dpath.a_mux$out\[0\]
* net 876 _102_
* net 891 dpath.b_mux$out\[0\]
* net 894 _104_
* net 907 req_msg[16]
* net 908 net7
* net 909 dpath.a_lt_b$in1\[15\]
* net 910 req_msg[27]
* net 911 dpath.b_mux$out\[12\]
* net 917 req_msg[0]
* net 937 dpath.a_lt_b$in0\[0\]
* net 939 clknet_2_2__leaf_clk
* net 941 _056_
* net 944 req_msg[12]
* net 948 net30
* net 949 dpath.a_lt_b$in0\[12\]
* net 974 dpath.a_lt_b$in0\[15\]
* net 977 _062_
* net 978 net4
* net 981 _066_
* net 982 _014_
* net 984 resp_msg[12]
* net 985 _013_
* net 987 _079_
* net 989 dpath.a_lt_b$in1\[12\]
* net 1000 _012_
* net 1010 _078_
* net 1016 resp_msg[14]
* net 1017 _059_
* net 1019 net15
* net 1022 _010_
* net 1025 net10
* net 1027 _064_
* net 1028 _083_
* net 1033 _058_
* net 1038 dpath.a_mux$out\[12\]
* net 1039 _057_
* net 1049 _063_
* net 1062 ctrl$b_reg_en\[0\]
* net 1063 _061_
* net 1065 _008_
* net 1066 _077_
* net 1069 _011_
* net 1070 net28
* net 1071 _060_
* net 1081 _000_
* net 1083 _009_
* net 1097 _007_
* net 1099 _002_
* net 1100 _105_
* net 1101 _006_
* net 1102 _096_
* net 1118 reset
* net 1119 ctrl.state.out\[2\]
* net 1120 dpath.a_mux$out\[15\]
* net 1122 dpath.a_lt_b$in0\[14\]
* net 1123 dpath.a_lt_b$in0\[13\]
* net 1124 dpath.a_lt_b$in1\[13\]
* net 1134 net5
* net 1135 _106_
* net 1145 req_val
* net 1146 _001_
* net 1148 ctrl.state.out\[1\]
* net 1149 resp_val
* net 1150 _098_
* net 1152 req_msg[31]
* net 1155 dpath.a_mux$out\[14\]
* net 1158 _081_
* net 1165 dpath.b_mux$out\[14\]
* net 1167 _065_
* net 1178 _097_
* net 1182 resp_msg[15]
* net 1187 resp_msg[13]
* net 1188 dpath.b_mux$out\[13\]
* net 1202 resp_rdy
* net 1252 dpath.a_mux$out\[13\]
* net 1255 dpath.b_mux$out\[15\]
* net 1258 req_msg[11]
* net 1261 _082_
* net 1262 net53
* net 1287 net14
* net 1288 req_msg[30]
* net 1289 req_msg[28]
* net 1292 req_msg[13]
* net 1316 req_msg[14]
* net 1332 req_msg[15]
* net 1333 req_msg[29]
* device instance $1 r0 *1 5.07,3.165 sky130_fd_pr__nfet_01v8
M$1 90 31 8 8 sky130_fd_pr__nfet_01v8 L=0.15U W=0.42U AS=0.1092P AD=0.0567P
+ PS=1.36U PD=0.69U
* device instance $2 r0 *1 5.49,3.165 sky130_fd_pr__nfet_01v8
M$2 9 8 90 90 sky130_fd_pr__nfet_01v8 L=0.15U W=0.42U AS=0.0567P AD=0.1092P
+ PS=0.69U PD=1.36U
* device instance $3 r0 *1 6.43,3.165 sky130_fd_pr__nfet_01v8
M$3 21 32 10 10 sky130_fd_pr__nfet_01v8 L=0.15U W=0.42U AS=0.1092P AD=0.0441P
+ PS=1.36U PD=0.63U
* device instance $4 r0 *1 6.79,3.165 sky130_fd_pr__nfet_01v8
M$4 90 88 21 21 sky130_fd_pr__nfet_01v8 L=0.15U W=0.42U AS=0.0441P AD=0.1092P
+ PS=0.63U PD=1.36U
* device instance $5 r0 *1 9.59,3.135 sky130_fd_pr__nfet_01v8
M$5 3 8 10 10 sky130_fd_pr__nfet_01v8 L=0.15U W=0.36U AS=0.1446P AD=0.0522P
+ PS=1.18U PD=0.65U
* device instance $6 r0 *1 10.03,3.135 sky130_fd_pr__nfet_01v8
M$6 26 9 3 3 sky130_fd_pr__nfet_01v8 L=0.15U W=0.36U AS=0.0522P AD=0.0759P
+ PS=0.65U PD=0.8U
* device instance $7 r0 *1 7.73,3.165 sky130_fd_pr__nfet_01v8
M$7 90 88 11 11 sky130_fd_pr__nfet_01v8 L=0.15U W=0.42U AS=0.1092P AD=0.0609P
+ PS=1.36U PD=0.71U
* device instance $8 r0 *1 8.17,3.165 sky130_fd_pr__nfet_01v8
M$8 24 11 90 90 sky130_fd_pr__nfet_01v8 L=0.15U W=0.42U AS=0.0609P AD=0.0756P
+ PS=0.71U PD=0.78U
* device instance $9 r0 *1 8.68,3.165 sky130_fd_pr__nfet_01v8
M$9 10 12 24 24 sky130_fd_pr__nfet_01v8 L=0.15U W=0.42U AS=0.0756P AD=0.1446P
+ PS=0.78U PD=1.18U
* device instance $10 r0 *1 10.56,3.165 sky130_fd_pr__nfet_01v8
M$10 90 4 26 26 sky130_fd_pr__nfet_01v8 L=0.15U W=0.42U AS=0.0759P AD=0.12095P
+ PS=0.8U PD=1.085U
* device instance $11 r0 *1 11.155,3.275 sky130_fd_pr__nfet_01v8
M$11 4 3 90 90 sky130_fd_pr__nfet_01v8 L=0.15U W=0.64U AS=0.12095P AD=0.1664P
+ PS=1.085U PD=1.8U
* device instance $12 r0 *1 12.58,3.135 sky130_fd_pr__nfet_01v8
M$12 13 9 28 28 sky130_fd_pr__nfet_01v8 L=0.15U W=0.36U AS=0.0678P AD=0.0684P
+ PS=0.755U PD=0.74U
* device instance $13 r0 *1 13.11,3.135 sky130_fd_pr__nfet_01v8
M$13 29 8 13 13 sky130_fd_pr__nfet_01v8 L=0.15U W=0.36U AS=0.0684P AD=0.066P
+ PS=0.74U PD=0.745U
* device instance $14 r0 *1 12.095,3.165 sky130_fd_pr__nfet_01v8
M$14 28 4 90 90 sky130_fd_pr__nfet_01v8 L=0.15U W=0.42U AS=0.1092P AD=0.0678P
+ PS=1.36U PD=0.755U
* device instance $15 r0 *1 13.585,3.165 sky130_fd_pr__nfet_01v8
M$15 90 12 29 29 sky130_fd_pr__nfet_01v8 L=0.15U W=0.42U AS=0.066P AD=0.1092P
+ PS=0.745U PD=1.36U
* device instance $16 r0 *1 14.525,3.165 sky130_fd_pr__nfet_01v8
M$16 90 13 12 12 sky130_fd_pr__nfet_01v8 L=0.15U W=0.42U AS=0.1092P AD=0.10025P
+ PS=1.36U PD=0.985U
* device instance $17 r0 *1 15.01,3.28 sky130_fd_pr__nfet_01v8
M$17 128 13 90 90 sky130_fd_pr__nfet_01v8 L=0.15U W=0.65U AS=0.10025P AD=0.182P
+ PS=0.985U PD=1.86U
* device instance $18 r0 *1 60.73,3.165 sky130_fd_pr__nfet_01v8
M$18 90 329 14 14 sky130_fd_pr__nfet_01v8 L=0.15U W=0.42U AS=0.1092P AD=0.0567P
+ PS=1.36U PD=0.69U
* device instance $19 r0 *1 61.15,3.165 sky130_fd_pr__nfet_01v8
M$19 16 14 90 90 sky130_fd_pr__nfet_01v8 L=0.15U W=0.42U AS=0.0567P AD=0.1092P
+ PS=0.69U PD=1.36U
* device instance $20 r0 *1 62.09,3.165 sky130_fd_pr__nfet_01v8
M$20 30 15 5 5 sky130_fd_pr__nfet_01v8 L=0.15U W=0.42U AS=0.1092P AD=0.0441P
+ PS=1.36U PD=0.63U
* device instance $21 r0 *1 62.45,3.165 sky130_fd_pr__nfet_01v8
M$21 90 311 30 30 sky130_fd_pr__nfet_01v8 L=0.15U W=0.42U AS=0.0441P AD=0.1092P
+ PS=0.63U PD=1.36U
* device instance $22 r0 *1 65.25,3.135 sky130_fd_pr__nfet_01v8
M$22 6 14 5 5 sky130_fd_pr__nfet_01v8 L=0.15U W=0.36U AS=0.1446P AD=0.0522P
+ PS=1.18U PD=0.65U
* device instance $23 r0 *1 65.69,3.135 sky130_fd_pr__nfet_01v8
M$23 25 16 6 6 sky130_fd_pr__nfet_01v8 L=0.15U W=0.36U AS=0.0522P AD=0.0759P
+ PS=0.65U PD=0.8U
* device instance $24 r0 *1 63.39,3.165 sky130_fd_pr__nfet_01v8
M$24 90 311 17 17 sky130_fd_pr__nfet_01v8 L=0.15U W=0.42U AS=0.1092P AD=0.0609P
+ PS=1.36U PD=0.71U
* device instance $25 r0 *1 63.83,3.165 sky130_fd_pr__nfet_01v8
M$25 27 17 90 90 sky130_fd_pr__nfet_01v8 L=0.15U W=0.42U AS=0.0609P AD=0.0756P
+ PS=0.71U PD=0.78U
* device instance $26 r0 *1 64.34,3.165 sky130_fd_pr__nfet_01v8
M$26 5 18 27 27 sky130_fd_pr__nfet_01v8 L=0.15U W=0.42U AS=0.0756P AD=0.1446P
+ PS=0.78U PD=1.18U
* device instance $27 r0 *1 66.22,3.165 sky130_fd_pr__nfet_01v8
M$27 90 7 25 25 sky130_fd_pr__nfet_01v8 L=0.15U W=0.42U AS=0.0759P AD=0.12095P
+ PS=0.8U PD=1.085U
* device instance $28 r0 *1 66.815,3.275 sky130_fd_pr__nfet_01v8
M$28 7 6 90 90 sky130_fd_pr__nfet_01v8 L=0.15U W=0.64U AS=0.12095P AD=0.1664P
+ PS=1.085U PD=1.8U
* device instance $29 r0 *1 68.24,3.135 sky130_fd_pr__nfet_01v8
M$29 19 16 23 23 sky130_fd_pr__nfet_01v8 L=0.15U W=0.36U AS=0.0678P AD=0.0684P
+ PS=0.755U PD=0.74U
* device instance $30 r0 *1 68.77,3.135 sky130_fd_pr__nfet_01v8
M$30 22 14 19 19 sky130_fd_pr__nfet_01v8 L=0.15U W=0.36U AS=0.0684P AD=0.066P
+ PS=0.74U PD=0.745U
* device instance $31 r0 *1 67.755,3.165 sky130_fd_pr__nfet_01v8
M$31 23 7 90 90 sky130_fd_pr__nfet_01v8 L=0.15U W=0.42U AS=0.1092P AD=0.0678P
+ PS=1.36U PD=0.755U
* device instance $32 r0 *1 69.245,3.165 sky130_fd_pr__nfet_01v8
M$32 90 18 22 22 sky130_fd_pr__nfet_01v8 L=0.15U W=0.42U AS=0.066P AD=0.1092P
+ PS=0.745U PD=1.36U
* device instance $33 r0 *1 70.185,3.165 sky130_fd_pr__nfet_01v8
M$33 90 19 18 18 sky130_fd_pr__nfet_01v8 L=0.15U W=0.42U AS=0.1092P AD=0.10025P
+ PS=1.36U PD=0.985U
* device instance $34 r0 *1 70.67,3.28 sky130_fd_pr__nfet_01v8
M$34 20 19 90 90 sky130_fd_pr__nfet_01v8 L=0.15U W=0.65U AS=0.10025P AD=0.182P
+ PS=0.985U PD=1.86U
* device instance $35 r0 *1 5.69,7.6 sky130_fd_pr__nfet_01v8
M$35 90 44 43 43 sky130_fd_pr__nfet_01v8 L=0.15U W=0.65U AS=0.182P AD=0.10025P
+ PS=1.86U PD=0.985U
* device instance $36 r0 *1 6.175,7.715 sky130_fd_pr__nfet_01v8
M$36 45 44 90 90 sky130_fd_pr__nfet_01v8 L=0.15U W=0.42U AS=0.10025P AD=0.1092P
+ PS=0.985U PD=1.36U
* device instance $37 r0 *1 7.115,7.715 sky130_fd_pr__nfet_01v8
M$37 91 45 90 90 sky130_fd_pr__nfet_01v8 L=0.15U W=0.42U AS=0.1092P AD=0.066P
+ PS=1.36U PD=0.745U
* device instance $38 r0 *1 7.59,7.745 sky130_fd_pr__nfet_01v8
M$38 44 68 91 91 sky130_fd_pr__nfet_01v8 L=0.15U W=0.36U AS=0.066P AD=0.0684P
+ PS=0.745U PD=0.74U
* device instance $39 r0 *1 8.12,7.745 sky130_fd_pr__nfet_01v8
M$39 44 67 92 92 sky130_fd_pr__nfet_01v8 L=0.15U W=0.36U AS=0.0678P AD=0.0684P
+ PS=0.755U PD=0.74U
* device instance $40 r0 *1 8.605,7.715 sky130_fd_pr__nfet_01v8
M$40 90 46 92 92 sky130_fd_pr__nfet_01v8 L=0.15U W=0.42U AS=0.0678P AD=0.1092P
+ PS=0.755U PD=1.36U
* device instance $41 r0 *1 9.545,7.605 sky130_fd_pr__nfet_01v8
M$41 90 47 46 46 sky130_fd_pr__nfet_01v8 L=0.15U W=0.64U AS=0.1664P AD=0.12095P
+ PS=1.8U PD=1.085U
* device instance $42 r0 *1 10.14,7.715 sky130_fd_pr__nfet_01v8
M$42 95 46 90 90 sky130_fd_pr__nfet_01v8 L=0.15U W=0.42U AS=0.12095P AD=0.0759P
+ PS=1.085U PD=0.8U
* device instance $43 r0 *1 10.67,7.745 sky130_fd_pr__nfet_01v8
M$43 47 67 95 95 sky130_fd_pr__nfet_01v8 L=0.15U W=0.36U AS=0.0759P AD=0.0522P
+ PS=0.8U PD=0.65U
* device instance $44 r0 *1 11.11,7.745 sky130_fd_pr__nfet_01v8
M$44 47 68 48 48 sky130_fd_pr__nfet_01v8 L=0.15U W=0.36U AS=0.1446P AD=0.0522P
+ PS=1.18U PD=0.65U
* device instance $45 r0 *1 12.02,7.715 sky130_fd_pr__nfet_01v8
M$45 96 45 48 48 sky130_fd_pr__nfet_01v8 L=0.15U W=0.42U AS=0.1446P AD=0.0756P
+ PS=1.18U PD=0.78U
* device instance $46 r0 *1 12.53,7.715 sky130_fd_pr__nfet_01v8
M$46 90 49 96 96 sky130_fd_pr__nfet_01v8 L=0.15U W=0.42U AS=0.0756P AD=0.0609P
+ PS=0.78U PD=0.71U
* device instance $47 r0 *1 12.97,7.715 sky130_fd_pr__nfet_01v8
M$47 49 311 90 90 sky130_fd_pr__nfet_01v8 L=0.15U W=0.42U AS=0.0609P AD=0.1092P
+ PS=0.71U PD=1.36U
* device instance $48 r0 *1 13.91,7.715 sky130_fd_pr__nfet_01v8
M$48 98 311 90 90 sky130_fd_pr__nfet_01v8 L=0.15U W=0.42U AS=0.1092P AD=0.0441P
+ PS=1.36U PD=0.63U
* device instance $49 r0 *1 14.27,7.715 sky130_fd_pr__nfet_01v8
M$49 48 50 98 98 sky130_fd_pr__nfet_01v8 L=0.15U W=0.42U AS=0.0441P AD=0.1092P
+ PS=0.63U PD=1.36U
* device instance $50 r0 *1 15.21,7.715 sky130_fd_pr__nfet_01v8
M$50 90 68 67 67 sky130_fd_pr__nfet_01v8 L=0.15U W=0.42U AS=0.1092P AD=0.0567P
+ PS=1.36U PD=0.69U
* device instance $51 r0 *1 15.63,7.715 sky130_fd_pr__nfet_01v8
M$51 68 31 90 90 sky130_fd_pr__nfet_01v8 L=0.15U W=0.42U AS=0.0567P AD=0.1092P
+ PS=0.69U PD=1.36U
* device instance $52 r0 *1 23.485,7.6 sky130_fd_pr__nfet_01v8
M$52 90 69 51 51 sky130_fd_pr__nfet_01v8 L=0.15U W=0.65U AS=0.169P AD=0.102375P
+ PS=1.82U PD=0.965U
* device instance $53 r0 *1 23.95,7.6 sky130_fd_pr__nfet_01v8
M$53 101 1 90 90 sky130_fd_pr__nfet_01v8 L=0.15U W=0.65U AS=0.102375P
+ AD=0.10725P PS=0.965U PD=0.98U
* device instance $54 r0 *1 24.43,7.6 sky130_fd_pr__nfet_01v8
M$54 69 130 101 101 sky130_fd_pr__nfet_01v8 L=0.15U W=0.65U AS=0.10725P
+ AD=0.169P PS=0.98U PD=1.82U
* device instance $55 r0 *1 25.37,7.6 sky130_fd_pr__nfet_01v8
M$55 103 129 69 69 sky130_fd_pr__nfet_01v8 L=0.15U W=0.65U AS=0.169P
+ AD=0.06825P PS=1.82U PD=0.86U
* device instance $56 r0 *1 25.73,7.6 sky130_fd_pr__nfet_01v8
M$56 90 164 103 103 sky130_fd_pr__nfet_01v8 L=0.15U W=0.65U AS=0.06825P
+ AD=0.10725P PS=0.86U PD=0.98U
* device instance $57 r0 *1 26.21,7.6 sky130_fd_pr__nfet_01v8
M$57 69 54 90 90 sky130_fd_pr__nfet_01v8 L=0.15U W=0.65U AS=0.10725P AD=0.169P
+ PS=0.98U PD=1.82U
* device instance $58 r0 *1 27.62,7.715 sky130_fd_pr__nfet_01v8
M$58 89 71 70 70 sky130_fd_pr__nfet_01v8 L=0.15U W=0.42U AS=0.1113P AD=0.0588P
+ PS=1.37U PD=0.7U
* device instance $59 r0 *1 28.05,7.715 sky130_fd_pr__nfet_01v8
M$59 90 55 89 89 sky130_fd_pr__nfet_01v8 L=0.15U W=0.42U AS=0.0588P AD=0.0588P
+ PS=0.7U PD=0.7U
* device instance $60 r0 *1 28.48,7.715 sky130_fd_pr__nfet_01v8
M$60 89 56 90 90 sky130_fd_pr__nfet_01v8 L=0.15U W=0.42U AS=0.0588P AD=0.1113P
+ PS=0.7U PD=1.37U
* device instance $61 r0 *1 44.69,7.6 sky130_fd_pr__nfet_01v8
M$61 57 58 90 90 sky130_fd_pr__nfet_01v8 L=0.15U W=0.65U AS=0.208P AD=0.25025P
+ PS=1.94U PD=1.42U
* device instance $62 r0 *1 45.61,7.6 sky130_fd_pr__nfet_01v8
M$62 102 72 57 57 sky130_fd_pr__nfet_01v8 L=0.15U W=0.65U AS=0.25025P
+ AD=0.08775P PS=1.42U PD=0.92U
* device instance $63 r0 *1 46.03,7.6 sky130_fd_pr__nfet_01v8
M$63 90 87 102 102 sky130_fd_pr__nfet_01v8 L=0.15U W=0.65U AS=0.08775P
+ AD=0.08775P PS=0.92U PD=0.92U
* device instance $64 r0 *1 46.45,7.6 sky130_fd_pr__nfet_01v8
M$64 58 87 90 90 sky130_fd_pr__nfet_01v8 L=0.15U W=0.65U AS=0.08775P
+ AD=0.08775P PS=0.92U PD=0.92U
* device instance $65 r0 *1 46.87,7.6 sky130_fd_pr__nfet_01v8
M$65 90 72 58 58 sky130_fd_pr__nfet_01v8 L=0.15U W=0.65U AS=0.08775P AD=0.169P
+ PS=0.92U PD=1.82U
* device instance $66 r0 *1 64.87,7.715 sky130_fd_pr__nfet_01v8
M$66 90 329 60 60 sky130_fd_pr__nfet_01v8 L=0.15U W=0.42U AS=0.1092P AD=0.0567P
+ PS=1.36U PD=0.69U
* device instance $67 r0 *1 65.29,7.715 sky130_fd_pr__nfet_01v8
M$67 61 60 90 90 sky130_fd_pr__nfet_01v8 L=0.15U W=0.42U AS=0.0567P AD=0.1092P
+ PS=0.69U PD=1.36U
* device instance $68 r0 *1 66.23,7.715 sky130_fd_pr__nfet_01v8
M$68 100 73 63 63 sky130_fd_pr__nfet_01v8 L=0.15U W=0.42U AS=0.1092P AD=0.0441P
+ PS=1.36U PD=0.63U
* device instance $69 r0 *1 66.59,7.715 sky130_fd_pr__nfet_01v8
M$69 90 88 100 100 sky130_fd_pr__nfet_01v8 L=0.15U W=0.42U AS=0.0441P
+ AD=0.1092P PS=0.63U PD=1.36U
* device instance $70 r0 *1 67.53,7.715 sky130_fd_pr__nfet_01v8
M$70 90 88 62 62 sky130_fd_pr__nfet_01v8 L=0.15U W=0.42U AS=0.1092P AD=0.0609P
+ PS=1.36U PD=0.71U
* device instance $71 r0 *1 67.97,7.715 sky130_fd_pr__nfet_01v8
M$71 99 62 90 90 sky130_fd_pr__nfet_01v8 L=0.15U W=0.42U AS=0.0609P AD=0.0756P
+ PS=0.71U PD=0.78U
* device instance $72 r0 *1 68.48,7.715 sky130_fd_pr__nfet_01v8
M$72 63 66 99 99 sky130_fd_pr__nfet_01v8 L=0.15U W=0.42U AS=0.0756P AD=0.1446P
+ PS=0.78U PD=1.18U
* device instance $73 r0 *1 69.39,7.745 sky130_fd_pr__nfet_01v8
M$73 64 60 63 63 sky130_fd_pr__nfet_01v8 L=0.15U W=0.36U AS=0.1446P AD=0.0522P
+ PS=1.18U PD=0.65U
* device instance $74 r0 *1 69.83,7.745 sky130_fd_pr__nfet_01v8
M$74 64 61 97 97 sky130_fd_pr__nfet_01v8 L=0.15U W=0.36U AS=0.0759P AD=0.0522P
+ PS=0.8U PD=0.65U
* device instance $75 r0 *1 70.36,7.715 sky130_fd_pr__nfet_01v8
M$75 97 65 90 90 sky130_fd_pr__nfet_01v8 L=0.15U W=0.42U AS=0.12095P AD=0.0759P
+ PS=1.085U PD=0.8U
* device instance $76 r0 *1 70.955,7.605 sky130_fd_pr__nfet_01v8
M$76 65 64 90 90 sky130_fd_pr__nfet_01v8 L=0.15U W=0.64U AS=0.12095P AD=0.1664P
+ PS=1.085U PD=1.8U
* device instance $77 r0 *1 71.895,7.715 sky130_fd_pr__nfet_01v8
M$77 94 65 90 90 sky130_fd_pr__nfet_01v8 L=0.15U W=0.42U AS=0.1092P AD=0.0678P
+ PS=1.36U PD=0.755U
* device instance $78 r0 *1 72.38,7.745 sky130_fd_pr__nfet_01v8
M$78 74 61 94 94 sky130_fd_pr__nfet_01v8 L=0.15U W=0.36U AS=0.0678P AD=0.0684P
+ PS=0.755U PD=0.74U
* device instance $79 r0 *1 72.91,7.745 sky130_fd_pr__nfet_01v8
M$79 74 60 93 93 sky130_fd_pr__nfet_01v8 L=0.15U W=0.36U AS=0.066P AD=0.0684P
+ PS=0.745U PD=0.74U
* device instance $80 r0 *1 73.385,7.715 sky130_fd_pr__nfet_01v8
M$80 90 66 93 93 sky130_fd_pr__nfet_01v8 L=0.15U W=0.42U AS=0.066P AD=0.1092P
+ PS=0.745U PD=1.36U
* device instance $81 r0 *1 74.325,7.715 sky130_fd_pr__nfet_01v8
M$81 66 74 90 90 sky130_fd_pr__nfet_01v8 L=0.15U W=0.42U AS=0.10025P AD=0.1092P
+ PS=0.985U PD=1.36U
* device instance $82 r0 *1 74.81,7.6 sky130_fd_pr__nfet_01v8
M$82 135 74 90 90 sky130_fd_pr__nfet_01v8 L=0.15U W=0.65U AS=0.10025P AD=0.182P
+ PS=0.985U PD=1.86U
* device instance $83 r0 *1 6.98,8.605 sky130_fd_pr__nfet_01v8
M$83 137 155 104 104 sky130_fd_pr__nfet_01v8 L=0.15U W=0.42U AS=0.1113P
+ AD=0.0441P PS=1.37U PD=0.63U
* device instance $84 r0 *1 7.34,8.605 sky130_fd_pr__nfet_01v8
M$84 90 108 137 137 sky130_fd_pr__nfet_01v8 L=0.15U W=0.42U AS=0.0441P
+ AD=0.0966P PS=0.63U PD=0.88U
* device instance $85 r0 *1 7.95,8.605 sky130_fd_pr__nfet_01v8
M$85 105 104 90 90 sky130_fd_pr__nfet_01v8 L=0.15U W=0.42U AS=0.0966P
+ AD=0.1113P PS=0.88U PD=1.37U
* device instance $86 r0 *1 9.21,8.72 sky130_fd_pr__nfet_01v8
M$86 90 105 106 106 sky130_fd_pr__nfet_01v8 L=0.15U W=0.65U AS=0.169P
+ AD=0.10725P PS=1.82U PD=0.98U
* device instance $87 r0 *1 9.69,8.72 sky130_fd_pr__nfet_01v8
M$87 140 128 90 90 sky130_fd_pr__nfet_01v8 L=0.15U W=0.65U AS=0.10725P
+ AD=0.06825P PS=0.98U PD=0.86U
* device instance $88 r0 *1 10.05,8.72 sky130_fd_pr__nfet_01v8
M$88 106 129 140 140 sky130_fd_pr__nfet_01v8 L=0.15U W=0.65U AS=0.06825P
+ AD=0.169P PS=0.86U PD=1.82U
* device instance $89 r0 *1 10.99,8.72 sky130_fd_pr__nfet_01v8
M$89 141 130 106 106 sky130_fd_pr__nfet_01v8 L=0.15U W=0.65U AS=0.169P
+ AD=0.10725P PS=1.82U PD=0.98U
* device instance $90 r0 *1 11.47,8.72 sky130_fd_pr__nfet_01v8
M$90 90 131 141 141 sky130_fd_pr__nfet_01v8 L=0.15U W=0.65U AS=0.10725P
+ AD=0.102375P PS=0.98U PD=0.965U
* device instance $91 r0 *1 11.935,8.72 sky130_fd_pr__nfet_01v8
M$91 50 106 90 90 sky130_fd_pr__nfet_01v8 L=0.15U W=0.65U AS=0.102375P
+ AD=0.169P PS=0.965U PD=1.82U
* device instance $92 r0 *1 23.08,8.605 sky130_fd_pr__nfet_01v8
M$92 143 157 107 107 sky130_fd_pr__nfet_01v8 L=0.15U W=0.42U AS=0.1113P
+ AD=0.0441P PS=1.37U PD=0.63U
* device instance $93 r0 *1 23.44,8.605 sky130_fd_pr__nfet_01v8
M$93 90 108 143 143 sky130_fd_pr__nfet_01v8 L=0.15U W=0.42U AS=0.0441P
+ AD=0.0966P PS=0.63U PD=0.88U
* device instance $94 r0 *1 24.05,8.605 sky130_fd_pr__nfet_01v8
M$94 54 107 90 90 sky130_fd_pr__nfet_01v8 L=0.15U W=0.42U AS=0.0966P AD=0.1113P
+ PS=0.88U PD=1.37U
* device instance $95 r0 *1 25.31,8.605 sky130_fd_pr__nfet_01v8
M$95 90 31 109 109 sky130_fd_pr__nfet_01v8 L=0.15U W=0.42U AS=0.1092P
+ AD=0.0567P PS=1.36U PD=0.69U
* device instance $96 r0 *1 25.73,8.605 sky130_fd_pr__nfet_01v8
M$96 110 109 90 90 sky130_fd_pr__nfet_01v8 L=0.15U W=0.42U AS=0.0567P
+ AD=0.1092P PS=0.69U PD=1.36U
* device instance $97 r0 *1 26.67,8.605 sky130_fd_pr__nfet_01v8
M$97 146 70 111 111 sky130_fd_pr__nfet_01v8 L=0.15U W=0.42U AS=0.1092P
+ AD=0.0441P PS=1.36U PD=0.63U
* device instance $98 r0 *1 27.03,8.605 sky130_fd_pr__nfet_01v8
M$98 90 88 146 146 sky130_fd_pr__nfet_01v8 L=0.15U W=0.42U AS=0.0441P
+ AD=0.1092P PS=0.63U PD=1.36U
* device instance $99 r0 *1 29.83,8.575 sky130_fd_pr__nfet_01v8
M$99 113 109 111 111 sky130_fd_pr__nfet_01v8 L=0.15U W=0.36U AS=0.1446P
+ AD=0.0522P PS=1.18U PD=0.65U
* device instance $100 r0 *1 30.27,8.575 sky130_fd_pr__nfet_01v8
M$100 148 110 113 113 sky130_fd_pr__nfet_01v8 L=0.15U W=0.36U AS=0.0522P
+ AD=0.0759P PS=0.65U PD=0.8U
* device instance $101 r0 *1 27.97,8.605 sky130_fd_pr__nfet_01v8
M$101 90 88 112 112 sky130_fd_pr__nfet_01v8 L=0.15U W=0.42U AS=0.1092P
+ AD=0.0609P PS=1.36U PD=0.71U
* device instance $102 r0 *1 28.41,8.605 sky130_fd_pr__nfet_01v8
M$102 147 112 90 90 sky130_fd_pr__nfet_01v8 L=0.15U W=0.42U AS=0.0609P
+ AD=0.0756P PS=0.71U PD=0.78U
* device instance $103 r0 *1 28.92,8.605 sky130_fd_pr__nfet_01v8
M$103 111 132 147 147 sky130_fd_pr__nfet_01v8 L=0.15U W=0.42U AS=0.0756P
+ AD=0.1446P PS=0.78U PD=1.18U
* device instance $104 r0 *1 30.8,8.605 sky130_fd_pr__nfet_01v8
M$104 90 114 148 148 sky130_fd_pr__nfet_01v8 L=0.15U W=0.42U AS=0.0759P
+ AD=0.12095P PS=0.8U PD=1.085U
* device instance $105 r0 *1 31.395,8.715 sky130_fd_pr__nfet_01v8
M$105 114 113 90 90 sky130_fd_pr__nfet_01v8 L=0.15U W=0.64U AS=0.12095P
+ AD=0.1664P PS=1.085U PD=1.8U
* device instance $106 r0 *1 32.82,8.575 sky130_fd_pr__nfet_01v8
M$106 115 110 150 150 sky130_fd_pr__nfet_01v8 L=0.15U W=0.36U AS=0.0678P
+ AD=0.0684P PS=0.755U PD=0.74U
* device instance $107 r0 *1 33.35,8.575 sky130_fd_pr__nfet_01v8
M$107 151 109 115 115 sky130_fd_pr__nfet_01v8 L=0.15U W=0.36U AS=0.0684P
+ AD=0.066P PS=0.74U PD=0.745U
* device instance $108 r0 *1 32.335,8.605 sky130_fd_pr__nfet_01v8
M$108 150 114 90 90 sky130_fd_pr__nfet_01v8 L=0.15U W=0.42U AS=0.1092P
+ AD=0.0678P PS=1.36U PD=0.755U
* device instance $109 r0 *1 33.825,8.605 sky130_fd_pr__nfet_01v8
M$109 90 132 151 151 sky130_fd_pr__nfet_01v8 L=0.15U W=0.42U AS=0.066P
+ AD=0.1092P PS=0.745U PD=1.36U
* device instance $110 r0 *1 34.765,8.605 sky130_fd_pr__nfet_01v8
M$110 90 115 132 132 sky130_fd_pr__nfet_01v8 L=0.15U W=0.42U AS=0.1092P
+ AD=0.10025P PS=1.36U PD=0.985U
* device instance $111 r0 *1 35.25,8.72 sky130_fd_pr__nfet_01v8
M$111 164 115 90 90 sky130_fd_pr__nfet_01v8 L=0.15U W=0.65U AS=0.10025P
+ AD=0.182P PS=0.985U PD=1.86U
* device instance $112 r0 *1 37.34,8.605 sky130_fd_pr__nfet_01v8
M$112 153 158 116 116 sky130_fd_pr__nfet_01v8 L=0.15U W=0.42U AS=0.1113P
+ AD=0.0441P PS=1.37U PD=0.63U
* device instance $113 r0 *1 37.7,8.605 sky130_fd_pr__nfet_01v8
M$113 90 108 153 153 sky130_fd_pr__nfet_01v8 L=0.15U W=0.42U AS=0.0441P
+ AD=0.0966P PS=0.63U PD=0.88U
* device instance $114 r0 *1 38.31,8.605 sky130_fd_pr__nfet_01v8
M$114 165 116 90 90 sky130_fd_pr__nfet_01v8 L=0.15U W=0.42U AS=0.0966P
+ AD=0.1113P PS=0.88U PD=1.37U
* device instance $115 r0 *1 44.95,8.605 sky130_fd_pr__nfet_01v8
M$115 90 133 117 117 sky130_fd_pr__nfet_01v8 L=0.15U W=0.42U AS=0.1113P
+ AD=0.0966P PS=1.37U PD=0.88U
* device instance $116 r0 *1 45.56,8.605 sky130_fd_pr__nfet_01v8
M$116 154 108 90 90 sky130_fd_pr__nfet_01v8 L=0.15U W=0.42U AS=0.0966P
+ AD=0.0441P PS=0.88U PD=0.63U
* device instance $117 r0 *1 45.92,8.605 sky130_fd_pr__nfet_01v8
M$117 133 159 154 154 sky130_fd_pr__nfet_01v8 L=0.15U W=0.42U AS=0.0441P
+ AD=0.1113P PS=0.63U PD=1.37U
* device instance $118 r0 *1 47.475,8.605 sky130_fd_pr__nfet_01v8
M$118 152 55 90 90 sky130_fd_pr__nfet_01v8 L=0.15U W=0.42U AS=0.11285P
+ AD=0.0693P PS=1.045U PD=0.75U
* device instance $119 r0 *1 47.955,8.605 sky130_fd_pr__nfet_01v8
M$119 119 120 152 152 sky130_fd_pr__nfet_01v8 L=0.15U W=0.42U AS=0.0693P
+ AD=0.09975P PS=0.75U PD=0.895U
* device instance $120 r0 *1 48.58,8.605 sky130_fd_pr__nfet_01v8
M$120 149 134 119 119 sky130_fd_pr__nfet_01v8 L=0.15U W=0.42U AS=0.09975P
+ AD=0.0693P PS=0.895U PD=0.75U
* device instance $121 r0 *1 49.06,8.605 sky130_fd_pr__nfet_01v8
M$121 90 121 149 149 sky130_fd_pr__nfet_01v8 L=0.15U W=0.42U AS=0.0693P
+ AD=0.1449P PS=0.75U PD=1.11U
* device instance $122 r0 *1 49.9,8.605 sky130_fd_pr__nfet_01v8
M$122 121 55 90 90 sky130_fd_pr__nfet_01v8 L=0.15U W=0.42U AS=0.1449P
+ AD=0.1092P PS=1.11U PD=1.36U
* device instance $123 r0 *1 46.93,8.72 sky130_fd_pr__nfet_01v8
M$123 90 119 118 118 sky130_fd_pr__nfet_01v8 L=0.15U W=0.65U AS=0.169P
+ AD=0.11285P PS=1.82U PD=1.045U
* device instance $124 r0 *1 57.58,8.605 sky130_fd_pr__nfet_01v8
M$124 145 160 122 122 sky130_fd_pr__nfet_01v8 L=0.15U W=0.42U AS=0.1113P
+ AD=0.0441P PS=1.37U PD=0.63U
* device instance $125 r0 *1 57.94,8.605 sky130_fd_pr__nfet_01v8
M$125 90 108 145 145 sky130_fd_pr__nfet_01v8 L=0.15U W=0.42U AS=0.0441P
+ AD=0.0966P PS=0.63U PD=0.88U
* device instance $126 r0 *1 58.55,8.605 sky130_fd_pr__nfet_01v8
M$126 123 122 90 90 sky130_fd_pr__nfet_01v8 L=0.15U W=0.42U AS=0.0966P
+ AD=0.1113P PS=0.88U PD=1.37U
* device instance $127 r0 *1 59.81,8.72 sky130_fd_pr__nfet_01v8
M$127 90 123 124 124 sky130_fd_pr__nfet_01v8 L=0.15U W=0.65U AS=0.169P
+ AD=0.10725P PS=1.82U PD=0.98U
* device instance $128 r0 *1 60.29,8.72 sky130_fd_pr__nfet_01v8
M$128 144 135 90 90 sky130_fd_pr__nfet_01v8 L=0.15U W=0.65U AS=0.10725P
+ AD=0.06825P PS=0.98U PD=0.86U
* device instance $129 r0 *1 60.65,8.72 sky130_fd_pr__nfet_01v8
M$129 124 129 144 144 sky130_fd_pr__nfet_01v8 L=0.15U W=0.65U AS=0.06825P
+ AD=0.169P PS=0.86U PD=1.82U
* device instance $130 r0 *1 61.59,8.72 sky130_fd_pr__nfet_01v8
M$130 142 136 124 124 sky130_fd_pr__nfet_01v8 L=0.15U W=0.65U AS=0.169P
+ AD=0.10725P PS=1.82U PD=0.98U
* device instance $131 r0 *1 62.07,8.72 sky130_fd_pr__nfet_01v8
M$131 90 2 142 142 sky130_fd_pr__nfet_01v8 L=0.15U W=0.65U AS=0.10725P
+ AD=0.102375P PS=0.98U PD=0.965U
* device instance $132 r0 *1 62.535,8.72 sky130_fd_pr__nfet_01v8
M$132 15 124 90 90 sky130_fd_pr__nfet_01v8 L=0.15U W=0.65U AS=0.102375P
+ AD=0.169P PS=0.965U PD=1.82U
* device instance $133 r0 *1 68.175,8.605 sky130_fd_pr__nfet_01v8
M$133 139 55 90 90 sky130_fd_pr__nfet_01v8 L=0.15U W=0.42U AS=0.11285P
+ AD=0.0693P PS=1.045U PD=0.75U
* device instance $134 r0 *1 68.655,8.605 sky130_fd_pr__nfet_01v8
M$134 125 126 139 139 sky130_fd_pr__nfet_01v8 L=0.15U W=0.42U AS=0.0693P
+ AD=0.09975P PS=0.75U PD=0.895U
* device instance $135 r0 *1 69.28,8.605 sky130_fd_pr__nfet_01v8
M$135 138 20 125 125 sky130_fd_pr__nfet_01v8 L=0.15U W=0.42U AS=0.09975P
+ AD=0.0693P PS=0.895U PD=0.75U
* device instance $136 r0 *1 69.76,8.605 sky130_fd_pr__nfet_01v8
M$136 90 127 138 138 sky130_fd_pr__nfet_01v8 L=0.15U W=0.42U AS=0.0693P
+ AD=0.1449P PS=0.75U PD=1.11U
* device instance $137 r0 *1 70.6,8.605 sky130_fd_pr__nfet_01v8
M$137 127 55 90 90 sky130_fd_pr__nfet_01v8 L=0.15U W=0.42U AS=0.1449P
+ AD=0.1092P PS=1.11U PD=1.36U
* device instance $138 r0 *1 67.63,8.72 sky130_fd_pr__nfet_01v8
M$138 90 125 73 73 sky130_fd_pr__nfet_01v8 L=0.15U W=0.65U AS=0.169P
+ AD=0.11285P PS=1.82U PD=1.045U
* device instance $139 r0 *1 7.83,13.04 sky130_fd_pr__nfet_01v8
M$139 90 176 32 32 sky130_fd_pr__nfet_01v8 L=0.15U W=0.65U AS=0.169P
+ AD=0.11285P PS=1.82U PD=1.045U
* device instance $140 r0 *1 8.375,13.155 sky130_fd_pr__nfet_01v8
M$140 235 55 90 90 sky130_fd_pr__nfet_01v8 L=0.15U W=0.42U AS=0.11285P
+ AD=0.0693P PS=1.045U PD=0.75U
* device instance $141 r0 *1 8.855,13.155 sky130_fd_pr__nfet_01v8
M$141 176 205 235 235 sky130_fd_pr__nfet_01v8 L=0.15U W=0.42U AS=0.0693P
+ AD=0.09975P PS=0.75U PD=0.895U
* device instance $142 r0 *1 9.48,13.155 sky130_fd_pr__nfet_01v8
M$142 237 43 176 176 sky130_fd_pr__nfet_01v8 L=0.15U W=0.42U AS=0.09975P
+ AD=0.0693P PS=0.895U PD=0.75U
* device instance $143 r0 *1 9.96,13.155 sky130_fd_pr__nfet_01v8
M$143 90 232 237 237 sky130_fd_pr__nfet_01v8 L=0.15U W=0.42U AS=0.0693P
+ AD=0.1449P PS=0.75U PD=1.11U
* device instance $144 r0 *1 10.8,13.155 sky130_fd_pr__nfet_01v8
M$144 232 55 90 90 sky130_fd_pr__nfet_01v8 L=0.15U W=0.42U AS=0.1449P
+ AD=0.1092P PS=1.11U PD=1.36U
* device instance $145 r0 *1 12.47,13.04 sky130_fd_pr__nfet_01v8
M$145 233 206 131 131 sky130_fd_pr__nfet_01v8 L=0.15U W=0.65U AS=0.195P
+ AD=0.08775P PS=1.9U PD=0.92U
* device instance $146 r0 *1 12.89,13.04 sky130_fd_pr__nfet_01v8
M$146 90 207 233 233 sky130_fd_pr__nfet_01v8 L=0.15U W=0.65U AS=0.08775P
+ AD=0.169P PS=0.92U PD=1.82U
* device instance $147 r0 *1 13.83,13.04 sky130_fd_pr__nfet_01v8
M$147 90 228 233 233 sky130_fd_pr__nfet_01v8 L=0.15U W=0.65U AS=0.169P
+ AD=0.08775P PS=1.82U PD=0.92U
* device instance $148 r0 *1 14.25,13.04 sky130_fd_pr__nfet_01v8
M$148 239 228 90 90 sky130_fd_pr__nfet_01v8 L=0.15U W=0.65U AS=0.08775P
+ AD=0.06825P PS=0.92U PD=0.86U
* device instance $149 r0 *1 14.61,13.04 sky130_fd_pr__nfet_01v8
M$149 206 207 239 239 sky130_fd_pr__nfet_01v8 L=0.15U W=0.65U AS=0.06825P
+ AD=0.169P PS=0.86U PD=1.82U
* device instance $150 r0 *1 15.71,13.04 sky130_fd_pr__nfet_01v8
M$150 207 177 90 90 sky130_fd_pr__nfet_01v8 L=0.15U W=0.65U AS=0.208P
+ AD=0.25025P PS=1.94U PD=1.42U
* device instance $151 r0 *1 16.63,13.04 sky130_fd_pr__nfet_01v8
M$151 241 43 207 207 sky130_fd_pr__nfet_01v8 L=0.15U W=0.65U AS=0.25025P
+ AD=0.08775P PS=1.42U PD=0.92U
* device instance $152 r0 *1 17.05,13.04 sky130_fd_pr__nfet_01v8
M$152 90 128 241 241 sky130_fd_pr__nfet_01v8 L=0.15U W=0.65U AS=0.08775P
+ AD=0.08775P PS=0.92U PD=0.92U
* device instance $153 r0 *1 17.47,13.04 sky130_fd_pr__nfet_01v8
M$153 177 128 90 90 sky130_fd_pr__nfet_01v8 L=0.15U W=0.65U AS=0.08775P
+ AD=0.08775P PS=0.92U PD=0.92U
* device instance $154 r0 *1 17.89,13.04 sky130_fd_pr__nfet_01v8
M$154 90 43 177 177 sky130_fd_pr__nfet_01v8 L=0.15U W=0.65U AS=0.08775P
+ AD=0.169P PS=0.92U PD=1.82U
* device instance $155 r0 *1 19.33,13.155 sky130_fd_pr__nfet_01v8
M$155 90 31 179 179 sky130_fd_pr__nfet_01v8 L=0.15U W=0.42U AS=0.1092P
+ AD=0.0567P PS=1.36U PD=0.69U
* device instance $156 r0 *1 19.75,13.155 sky130_fd_pr__nfet_01v8
M$156 180 179 90 90 sky130_fd_pr__nfet_01v8 L=0.15U W=0.42U AS=0.0567P
+ AD=0.1092P PS=0.69U PD=1.36U
* device instance $157 r0 *1 20.69,13.155 sky130_fd_pr__nfet_01v8
M$157 243 51 181 181 sky130_fd_pr__nfet_01v8 L=0.15U W=0.42U AS=0.1092P
+ AD=0.0441P PS=1.36U PD=0.63U
* device instance $158 r0 *1 21.05,13.155 sky130_fd_pr__nfet_01v8
M$158 90 311 243 243 sky130_fd_pr__nfet_01v8 L=0.15U W=0.42U AS=0.0441P
+ AD=0.1092P PS=0.63U PD=1.36U
* device instance $159 r0 *1 21.99,13.155 sky130_fd_pr__nfet_01v8
M$159 90 311 182 182 sky130_fd_pr__nfet_01v8 L=0.15U W=0.42U AS=0.1092P
+ AD=0.0609P PS=1.36U PD=0.71U
* device instance $160 r0 *1 22.43,13.155 sky130_fd_pr__nfet_01v8
M$160 245 182 90 90 sky130_fd_pr__nfet_01v8 L=0.15U W=0.42U AS=0.0609P
+ AD=0.0756P PS=0.71U PD=0.78U
* device instance $161 r0 *1 22.94,13.155 sky130_fd_pr__nfet_01v8
M$161 181 186 245 245 sky130_fd_pr__nfet_01v8 L=0.15U W=0.42U AS=0.0756P
+ AD=0.1446P PS=0.78U PD=1.18U
* device instance $162 r0 *1 23.85,13.185 sky130_fd_pr__nfet_01v8
M$162 183 179 181 181 sky130_fd_pr__nfet_01v8 L=0.15U W=0.36U AS=0.1446P
+ AD=0.0522P PS=1.18U PD=0.65U
* device instance $163 r0 *1 24.29,13.185 sky130_fd_pr__nfet_01v8
M$163 183 180 246 246 sky130_fd_pr__nfet_01v8 L=0.15U W=0.36U AS=0.0759P
+ AD=0.0522P PS=0.8U PD=0.65U
* device instance $164 r0 *1 24.82,13.155 sky130_fd_pr__nfet_01v8
M$164 246 184 90 90 sky130_fd_pr__nfet_01v8 L=0.15U W=0.42U AS=0.12095P
+ AD=0.0759P PS=1.085U PD=0.8U
* device instance $165 r0 *1 25.415,13.045 sky130_fd_pr__nfet_01v8
M$165 184 183 90 90 sky130_fd_pr__nfet_01v8 L=0.15U W=0.64U AS=0.12095P
+ AD=0.1664P PS=1.085U PD=1.8U
* device instance $166 r0 *1 26.355,13.155 sky130_fd_pr__nfet_01v8
M$166 247 184 90 90 sky130_fd_pr__nfet_01v8 L=0.15U W=0.42U AS=0.1092P
+ AD=0.0678P PS=1.36U PD=0.755U
* device instance $167 r0 *1 26.84,13.185 sky130_fd_pr__nfet_01v8
M$167 185 180 247 247 sky130_fd_pr__nfet_01v8 L=0.15U W=0.36U AS=0.0678P
+ AD=0.0684P PS=0.755U PD=0.74U
* device instance $168 r0 *1 27.37,13.185 sky130_fd_pr__nfet_01v8
M$168 185 179 248 248 sky130_fd_pr__nfet_01v8 L=0.15U W=0.36U AS=0.066P
+ AD=0.0684P PS=0.745U PD=0.74U
* device instance $169 r0 *1 27.845,13.155 sky130_fd_pr__nfet_01v8
M$169 90 186 248 248 sky130_fd_pr__nfet_01v8 L=0.15U W=0.42U AS=0.066P
+ AD=0.1092P PS=0.745U PD=1.36U
* device instance $170 r0 *1 28.785,13.155 sky130_fd_pr__nfet_01v8
M$170 186 185 90 90 sky130_fd_pr__nfet_01v8 L=0.15U W=0.42U AS=0.10025P
+ AD=0.1092P PS=0.985U PD=1.36U
* device instance $171 r0 *1 29.27,13.04 sky130_fd_pr__nfet_01v8
M$171 187 185 90 90 sky130_fd_pr__nfet_01v8 L=0.15U W=0.65U AS=0.10025P
+ AD=0.182P PS=0.985U PD=1.86U
* device instance $172 r0 *1 30.85,13.04 sky130_fd_pr__nfet_01v8
M$172 251 208 90 90 sky130_fd_pr__nfet_01v8 L=0.15U W=0.65U AS=0.169P
+ AD=0.08775P PS=1.82U PD=0.92U
* device instance $173 r0 *1 31.27,13.04 sky130_fd_pr__nfet_01v8
M$173 71 55 251 251 sky130_fd_pr__nfet_01v8 L=0.15U W=0.65U AS=0.08775P
+ AD=0.169P PS=0.92U PD=1.82U
* device instance $174 r0 *1 32.625,13.155 sky130_fd_pr__nfet_01v8
M$174 90 187 56 56 sky130_fd_pr__nfet_01v8 L=0.15U W=0.42U AS=0.1092P
+ AD=0.1197P PS=1.36U PD=1.41U
* device instance $175 r0 *1 33.595,13.04 sky130_fd_pr__nfet_01v8
M$175 72 229 234 234 sky130_fd_pr__nfet_01v8 L=0.15U W=1.3U AS=0.26325P
+ AD=0.182P PS=2.76U PD=1.86U
* device instance $177 r0 *1 34.455,13.04 sky130_fd_pr__nfet_01v8
M$177 90 164 234 234 sky130_fd_pr__nfet_01v8 L=0.15U W=1.3U AS=0.182P AD=0.299P
+ PS=1.86U PD=2.87U
* device instance $178 r0 *1 34.995,13.04 sky130_fd_pr__nfet_01v8
M$178 234 56 90 90 sky130_fd_pr__nfet_01v8 L=0.15U W=1.3U AS=0.21775P AD=0.182P
+ PS=1.97U PD=1.86U
* device instance $181 r0 *1 40.965,13.04 sky130_fd_pr__nfet_01v8
M$181 90 209 189 189 sky130_fd_pr__nfet_01v8 L=0.15U W=0.65U AS=0.169P
+ AD=0.102375P PS=1.82U PD=0.965U
* device instance $182 r0 *1 41.43,13.04 sky130_fd_pr__nfet_01v8
M$182 254 57 90 90 sky130_fd_pr__nfet_01v8 L=0.15U W=0.65U AS=0.102375P
+ AD=0.10725P PS=0.965U PD=0.98U
* device instance $183 r0 *1 41.91,13.04 sky130_fd_pr__nfet_01v8
M$183 209 136 254 254 sky130_fd_pr__nfet_01v8 L=0.15U W=0.65U AS=0.10725P
+ AD=0.169P PS=0.98U PD=1.82U
* device instance $184 r0 *1 42.85,13.04 sky130_fd_pr__nfet_01v8
M$184 253 129 209 209 sky130_fd_pr__nfet_01v8 L=0.15U W=0.65U AS=0.169P
+ AD=0.06825P PS=1.82U PD=0.86U
* device instance $185 r0 *1 43.21,13.04 sky130_fd_pr__nfet_01v8
M$185 90 230 253 253 sky130_fd_pr__nfet_01v8 L=0.15U W=0.65U AS=0.06825P
+ AD=0.10725P PS=0.86U PD=0.98U
* device instance $186 r0 *1 43.69,13.04 sky130_fd_pr__nfet_01v8
M$186 209 117 90 90 sky130_fd_pr__nfet_01v8 L=0.15U W=0.65U AS=0.10725P
+ AD=0.169P PS=0.98U PD=1.82U
* device instance $187 r0 *1 46.93,13.155 sky130_fd_pr__nfet_01v8
M$187 90 329 192 192 sky130_fd_pr__nfet_01v8 L=0.15U W=0.42U AS=0.1092P
+ AD=0.0567P PS=1.36U PD=0.69U
* device instance $188 r0 *1 47.35,13.155 sky130_fd_pr__nfet_01v8
M$188 193 192 90 90 sky130_fd_pr__nfet_01v8 L=0.15U W=0.42U AS=0.0567P
+ AD=0.1092P PS=0.69U PD=1.36U
* device instance $189 r0 *1 48.29,13.155 sky130_fd_pr__nfet_01v8
M$189 252 118 194 194 sky130_fd_pr__nfet_01v8 L=0.15U W=0.42U AS=0.1092P
+ AD=0.0441P PS=1.36U PD=0.63U
* device instance $190 r0 *1 48.65,13.155 sky130_fd_pr__nfet_01v8
M$190 90 88 252 252 sky130_fd_pr__nfet_01v8 L=0.15U W=0.42U AS=0.0441P
+ AD=0.1092P PS=0.63U PD=1.36U
* device instance $191 r0 *1 49.59,13.155 sky130_fd_pr__nfet_01v8
M$191 90 88 195 195 sky130_fd_pr__nfet_01v8 L=0.15U W=0.42U AS=0.1092P
+ AD=0.0609P PS=1.36U PD=0.71U
* device instance $192 r0 *1 50.03,13.155 sky130_fd_pr__nfet_01v8
M$192 250 195 90 90 sky130_fd_pr__nfet_01v8 L=0.15U W=0.42U AS=0.0609P
+ AD=0.0756P PS=0.71U PD=0.78U
* device instance $193 r0 *1 50.54,13.155 sky130_fd_pr__nfet_01v8
M$193 194 199 250 250 sky130_fd_pr__nfet_01v8 L=0.15U W=0.42U AS=0.0756P
+ AD=0.1446P PS=0.78U PD=1.18U
* device instance $194 r0 *1 51.45,13.185 sky130_fd_pr__nfet_01v8
M$194 196 192 194 194 sky130_fd_pr__nfet_01v8 L=0.15U W=0.36U AS=0.1446P
+ AD=0.0522P PS=1.18U PD=0.65U
* device instance $195 r0 *1 51.89,13.185 sky130_fd_pr__nfet_01v8
M$195 196 193 249 249 sky130_fd_pr__nfet_01v8 L=0.15U W=0.36U AS=0.0759P
+ AD=0.0522P PS=0.8U PD=0.65U
* device instance $196 r0 *1 52.42,13.155 sky130_fd_pr__nfet_01v8
M$196 249 197 90 90 sky130_fd_pr__nfet_01v8 L=0.15U W=0.42U AS=0.12095P
+ AD=0.0759P PS=1.085U PD=0.8U
* device instance $197 r0 *1 53.015,13.045 sky130_fd_pr__nfet_01v8
M$197 197 196 90 90 sky130_fd_pr__nfet_01v8 L=0.15U W=0.64U AS=0.12095P
+ AD=0.1664P PS=1.085U PD=1.8U
* device instance $198 r0 *1 53.955,13.155 sky130_fd_pr__nfet_01v8
M$198 244 197 90 90 sky130_fd_pr__nfet_01v8 L=0.15U W=0.42U AS=0.1092P
+ AD=0.0678P PS=1.36U PD=0.755U
* device instance $199 r0 *1 54.44,13.185 sky130_fd_pr__nfet_01v8
M$199 198 193 244 244 sky130_fd_pr__nfet_01v8 L=0.15U W=0.36U AS=0.0678P
+ AD=0.0684P PS=0.755U PD=0.74U
* device instance $200 r0 *1 54.97,13.185 sky130_fd_pr__nfet_01v8
M$200 198 192 242 242 sky130_fd_pr__nfet_01v8 L=0.15U W=0.36U AS=0.066P
+ AD=0.0684P PS=0.745U PD=0.74U
* device instance $201 r0 *1 55.445,13.155 sky130_fd_pr__nfet_01v8
M$201 90 199 242 242 sky130_fd_pr__nfet_01v8 L=0.15U W=0.42U AS=0.066P
+ AD=0.1092P PS=0.745U PD=1.36U
* device instance $202 r0 *1 56.385,13.155 sky130_fd_pr__nfet_01v8
M$202 199 198 90 90 sky130_fd_pr__nfet_01v8 L=0.15U W=0.42U AS=0.10025P
+ AD=0.1092P PS=0.985U PD=1.36U
* device instance $203 r0 *1 56.87,13.04 sky130_fd_pr__nfet_01v8
M$203 230 198 90 90 sky130_fd_pr__nfet_01v8 L=0.15U W=0.65U AS=0.10025P
+ AD=0.182P PS=0.985U PD=1.86U
* device instance $204 r0 *1 61.71,13.04 sky130_fd_pr__nfet_01v8
M$204 2 200 90 90 sky130_fd_pr__nfet_01v8 L=0.15U W=0.65U AS=0.208P AD=0.25025P
+ PS=1.94U PD=1.42U
* device instance $205 r0 *1 62.63,13.04 sky130_fd_pr__nfet_01v8
M$205 240 210 2 2 sky130_fd_pr__nfet_01v8 L=0.15U W=0.65U AS=0.25025P
+ AD=0.08775P PS=1.42U PD=0.92U
* device instance $206 r0 *1 63.05,13.04 sky130_fd_pr__nfet_01v8
M$206 90 231 240 240 sky130_fd_pr__nfet_01v8 L=0.15U W=0.65U AS=0.08775P
+ AD=0.08775P PS=0.92U PD=0.92U
* device instance $207 r0 *1 63.47,13.04 sky130_fd_pr__nfet_01v8
M$207 200 231 90 90 sky130_fd_pr__nfet_01v8 L=0.15U W=0.65U AS=0.08775P
+ AD=0.08775P PS=0.92U PD=0.92U
* device instance $208 r0 *1 63.89,13.04 sky130_fd_pr__nfet_01v8
M$208 90 210 200 200 sky130_fd_pr__nfet_01v8 L=0.15U W=0.65U AS=0.08775P
+ AD=0.169P PS=0.92U PD=1.82U
* device instance $209 r0 *1 66.31,13.04 sky130_fd_pr__nfet_01v8
M$209 231 202 90 90 sky130_fd_pr__nfet_01v8 L=0.15U W=0.65U AS=0.208P
+ AD=0.25025P PS=1.94U PD=1.42U
* device instance $210 r0 *1 67.23,13.04 sky130_fd_pr__nfet_01v8
M$210 238 20 231 231 sky130_fd_pr__nfet_01v8 L=0.15U W=0.65U AS=0.25025P
+ AD=0.08775P PS=1.42U PD=0.92U
* device instance $211 r0 *1 67.65,13.04 sky130_fd_pr__nfet_01v8
M$211 90 135 238 238 sky130_fd_pr__nfet_01v8 L=0.15U W=0.65U AS=0.08775P
+ AD=0.08775P PS=0.92U PD=0.92U
* device instance $212 r0 *1 68.07,13.04 sky130_fd_pr__nfet_01v8
M$212 202 135 90 90 sky130_fd_pr__nfet_01v8 L=0.15U W=0.65U AS=0.08775P
+ AD=0.08775P PS=0.92U PD=0.92U
* device instance $213 r0 *1 68.49,13.04 sky130_fd_pr__nfet_01v8
M$213 90 20 202 202 sky130_fd_pr__nfet_01v8 L=0.15U W=0.65U AS=0.08775P
+ AD=0.169P PS=0.92U PD=1.82U
* device instance $214 r0 *1 70.83,12.925 sky130_fd_pr__nfet_01v8
M$214 211 135 90 90 sky130_fd_pr__nfet_01v8 L=0.15U W=0.42U AS=0.10025P
+ AD=0.1092P PS=0.985U PD=1.36U
* device instance $215 r0 *1 69.925,13.04 sky130_fd_pr__nfet_01v8
M$215 236 211 204 204 sky130_fd_pr__nfet_01v8 L=0.15U W=0.65U AS=0.169P
+ AD=0.08775P PS=1.82U PD=0.92U
* device instance $216 r0 *1 70.345,13.04 sky130_fd_pr__nfet_01v8
M$216 90 20 236 236 sky130_fd_pr__nfet_01v8 L=0.15U W=0.65U AS=0.08775P
+ AD=0.10025P PS=0.92U PD=0.985U
* device instance $217 r0 *1 12.665,14.045 sky130_fd_pr__nfet_01v8
M$217 90 43 255 255 sky130_fd_pr__nfet_01v8 L=0.15U W=0.42U AS=0.1092P
+ AD=0.10025P PS=1.36U PD=0.985U
* device instance $218 r0 *1 13.15,14.16 sky130_fd_pr__nfet_01v8
M$218 280 128 90 90 sky130_fd_pr__nfet_01v8 L=0.15U W=0.65U AS=0.10025P
+ AD=0.08775P PS=0.985U PD=0.92U
* device instance $219 r0 *1 13.57,14.16 sky130_fd_pr__nfet_01v8
M$219 90 255 280 280 sky130_fd_pr__nfet_01v8 L=0.15U W=0.65U AS=0.08775P
+ AD=0.169P PS=0.92U PD=1.82U
* device instance $220 r0 *1 13.82,18.48 sky130_fd_pr__nfet_01v8
M$220 90 293 292 292 sky130_fd_pr__nfet_01v8 L=0.15U W=0.65U AS=0.169P
+ AD=0.25675P PS=1.82U PD=1.44U
* device instance $221 r0 *1 14.76,18.48 sky130_fd_pr__nfet_01v8
M$221 293 280 90 90 sky130_fd_pr__nfet_01v8 L=0.15U W=0.65U AS=0.25675P
+ AD=0.089375P PS=1.44U PD=0.925U
* device instance $222 r0 *1 15.185,18.48 sky130_fd_pr__nfet_01v8
M$222 318 228 293 293 sky130_fd_pr__nfet_01v8 L=0.15U W=0.65U AS=0.089375P
+ AD=0.091P PS=0.925U PD=0.93U
* device instance $223 r0 *1 15.615,18.48 sky130_fd_pr__nfet_01v8
M$223 90 256 318 318 sky130_fd_pr__nfet_01v8 L=0.15U W=0.65U AS=0.091P
+ AD=0.17225P PS=0.93U PD=1.83U
* device instance $224 r0 *1 15.145,14.045 sky130_fd_pr__nfet_01v8
M$224 90 207 256 256 sky130_fd_pr__nfet_01v8 L=0.15U W=0.42U AS=0.1092P
+ AD=0.1197P PS=1.36U PD=1.41U
* device instance $225 r0 *1 28.63,14.16 sky130_fd_pr__nfet_01v8
M$225 279 187 257 257 sky130_fd_pr__nfet_01v8 L=0.15U W=0.65U AS=0.169P
+ AD=0.06825P PS=1.82U PD=0.86U
* device instance $226 r0 *1 28.99,14.16 sky130_fd_pr__nfet_01v8
M$226 90 164 279 279 sky130_fd_pr__nfet_01v8 L=0.15U W=0.65U AS=0.06825P
+ AD=0.08775P PS=0.86U PD=0.92U
* device instance $227 r0 *1 29.41,14.16 sky130_fd_pr__nfet_01v8
M$227 258 164 90 90 sky130_fd_pr__nfet_01v8 L=0.15U W=0.65U AS=0.08775P
+ AD=0.169P PS=0.92U PD=1.82U
* device instance $228 r0 *1 30.35,14.16 sky130_fd_pr__nfet_01v8
M$228 258 187 90 90 sky130_fd_pr__nfet_01v8 L=0.15U W=0.65U AS=0.169P
+ AD=0.08775P PS=1.82U PD=0.92U
* device instance $229 r0 *1 30.77,14.16 sky130_fd_pr__nfet_01v8
M$229 274 257 258 258 sky130_fd_pr__nfet_01v8 L=0.15U W=0.65U AS=0.08775P
+ AD=0.195P PS=0.92U PD=1.9U
* device instance $230 r0 *1 32.875,14.045 sky130_fd_pr__nfet_01v8
M$230 273 229 90 90 sky130_fd_pr__nfet_01v8 L=0.15U W=0.42U AS=0.10025P
+ AD=0.1092P PS=0.985U PD=1.36U
* device instance $231 r0 *1 31.97,14.16 sky130_fd_pr__nfet_01v8
M$231 1 273 90 90 sky130_fd_pr__nfet_01v8 L=0.15U W=0.65U AS=0.169P AD=0.08775P
+ PS=1.82U PD=0.92U
* device instance $232 r0 *1 32.39,14.16 sky130_fd_pr__nfet_01v8
M$232 90 259 1 1 sky130_fd_pr__nfet_01v8 L=0.15U W=0.65U AS=0.08775P
+ AD=0.10025P PS=0.92U PD=0.985U
* device instance $233 r0 *1 34.05,14.16 sky130_fd_pr__nfet_01v8
M$233 229 274 260 260 sky130_fd_pr__nfet_01v8 L=0.15U W=1.3U AS=0.25675P
+ AD=0.1755P PS=2.74U PD=1.84U
* device instance $235 r0 *1 34.89,14.16 sky130_fd_pr__nfet_01v8
M$235 262 261 260 260 sky130_fd_pr__nfet_01v8 L=0.15U W=1.3U AS=0.1755P
+ AD=0.25675P PS=1.84U PD=2.74U
* device instance $237 r0 *1 34.07,18.48 sky130_fd_pr__nfet_01v8
M$237 259 274 90 90 sky130_fd_pr__nfet_01v8 L=0.15U W=0.65U AS=0.17225P
+ AD=0.091P PS=1.83U PD=0.93U
* device instance $238 r0 *1 34.5,18.48 sky130_fd_pr__nfet_01v8
M$238 324 261 259 259 sky130_fd_pr__nfet_01v8 L=0.15U W=0.65U AS=0.091P
+ AD=0.095875P PS=0.93U PD=0.945U
* device instance $239 r0 *1 34.945,18.48 sky130_fd_pr__nfet_01v8
M$239 90 275 324 324 sky130_fd_pr__nfet_01v8 L=0.15U W=0.65U AS=0.095875P
+ AD=0.17225P PS=0.945U PD=1.83U
* device instance $240 r0 *1 35.91,18.48 sky130_fd_pr__nfet_01v8
M$240 277 164 90 90 sky130_fd_pr__nfet_01v8 L=0.15U W=0.65U AS=0.169P
+ AD=0.08775P PS=1.82U PD=0.92U
* device instance $241 r0 *1 36.33,18.48 sky130_fd_pr__nfet_01v8
M$241 90 56 277 277 sky130_fd_pr__nfet_01v8 L=0.15U W=0.65U AS=0.08775P
+ AD=0.169P PS=0.92U PD=1.82U
* device instance $242 r0 *1 36.25,14.16 sky130_fd_pr__nfet_01v8
M$242 262 275 90 90 sky130_fd_pr__nfet_01v8 L=0.15U W=1.3U AS=0.25675P
+ AD=0.28925P PS=2.74U PD=2.84U
* device instance $244 r0 *1 37.73,14.16 sky130_fd_pr__nfet_01v8
M$244 90 261 263 263 sky130_fd_pr__nfet_01v8 L=0.15U W=1.3U AS=0.25675P
+ AD=0.1755P PS=2.74U PD=1.84U
* device instance $246 r0 *1 38.57,14.16 sky130_fd_pr__nfet_01v8
M$246 264 276 263 263 sky130_fd_pr__nfet_01v8 L=0.15U W=1.3U AS=0.1755P
+ AD=0.25675P PS=1.84U PD=2.74U
* device instance $248 r0 *1 39.93,14.16 sky130_fd_pr__nfet_01v8
M$248 264 274 265 265 sky130_fd_pr__nfet_01v8 L=0.15U W=1.3U AS=0.25675P
+ AD=0.18525P PS=2.74U PD=1.87U
* device instance $250 r0 *1 40.8,14.16 sky130_fd_pr__nfet_01v8
M$250 90 277 265 265 sky130_fd_pr__nfet_01v8 L=0.15U W=1.3U AS=0.18525P
+ AD=0.25675P PS=1.87U PD=2.09U
* device instance $252 r0 *1 41.89,14.16 sky130_fd_pr__nfet_01v8
M$252 90 266 265 265 sky130_fd_pr__nfet_01v8 L=0.15U W=1.3U AS=0.25675P
+ AD=0.25675P PS=2.09U PD=2.74U
* device instance $254 r0 *1 46.215,14.045 sky130_fd_pr__nfet_01v8
M$254 278 134 90 90 sky130_fd_pr__nfet_01v8 L=0.15U W=0.42U AS=0.10025P
+ AD=0.1092P PS=0.985U PD=1.36U
* device instance $255 r0 *1 45.31,14.16 sky130_fd_pr__nfet_01v8
M$255 266 278 90 90 sky130_fd_pr__nfet_01v8 L=0.15U W=0.65U AS=0.169P
+ AD=0.08775P PS=1.82U PD=0.92U
* device instance $256 r0 *1 45.73,14.16 sky130_fd_pr__nfet_01v8
M$256 90 230 266 266 sky130_fd_pr__nfet_01v8 L=0.15U W=0.65U AS=0.08775P
+ AD=0.10025P PS=0.92U PD=0.985U
* device instance $257 r0 *1 47.41,14.16 sky130_fd_pr__nfet_01v8
M$257 87 266 90 90 sky130_fd_pr__nfet_01v8 L=0.15U W=0.65U AS=0.169P
+ AD=0.08775P PS=1.82U PD=0.92U
* device instance $258 r0 *1 47.83,14.16 sky130_fd_pr__nfet_01v8
M$258 90 267 87 87 sky130_fd_pr__nfet_01v8 L=0.15U W=0.65U AS=0.08775P
+ AD=0.169P PS=0.92U PD=1.82U
* device instance $259 r0 *1 50.385,14.045 sky130_fd_pr__nfet_01v8
M$259 90 230 268 268 sky130_fd_pr__nfet_01v8 L=0.15U W=0.42U AS=0.1092P
+ AD=0.10025P PS=1.36U PD=0.985U
* device instance $260 r0 *1 50.87,14.16 sky130_fd_pr__nfet_01v8
M$260 267 134 90 90 sky130_fd_pr__nfet_01v8 L=0.15U W=0.65U AS=0.10025P
+ AD=0.08775P PS=0.985U PD=0.92U
* device instance $261 r0 *1 51.29,14.16 sky130_fd_pr__nfet_01v8
M$261 90 268 267 267 sky130_fd_pr__nfet_01v8 L=0.15U W=0.65U AS=0.08775P
+ AD=0.169P PS=0.92U PD=1.82U
* device instance $262 r0 *1 53.625,18.595 sky130_fd_pr__nfet_01v8
M$262 303 302 90 90 sky130_fd_pr__nfet_01v8 L=0.15U W=0.42U AS=0.10025P
+ AD=0.1092P PS=0.985U PD=1.36U
* device instance $263 r0 *1 54.11,18.48 sky130_fd_pr__nfet_01v8
M$263 134 302 90 90 sky130_fd_pr__nfet_01v8 L=0.15U W=0.65U AS=0.10025P
+ AD=0.182P PS=0.985U PD=1.86U
* device instance $264 r0 *1 57.655,14.045 sky130_fd_pr__nfet_01v8
M$264 269 267 90 90 sky130_fd_pr__nfet_01v8 L=0.15U W=0.42U AS=0.1092P
+ AD=0.0567P PS=1.36U PD=0.69U
* device instance $265 r0 *1 58.075,14.045 sky130_fd_pr__nfet_01v8
M$265 90 265 269 269 sky130_fd_pr__nfet_01v8 L=0.15U W=0.42U AS=0.0567P
+ AD=0.10025P PS=0.69U PD=0.985U
* device instance $266 r0 *1 58.56,14.16 sky130_fd_pr__nfet_01v8
M$266 270 269 90 90 sky130_fd_pr__nfet_01v8 L=0.15U W=0.65U AS=0.10025P
+ AD=0.169P PS=0.985U PD=1.82U
* device instance $267 r0 *1 59.95,18.48 sky130_fd_pr__nfet_01v8
M$267 90 231 315 315 sky130_fd_pr__nfet_01v8 L=0.15U W=1.3U AS=0.25675P
+ AD=0.1755P PS=2.74U PD=1.84U
* device instance $269 r0 *1 60.79,18.48 sky130_fd_pr__nfet_01v8
M$269 90 265 315 315 sky130_fd_pr__nfet_01v8 L=0.15U W=1.3U AS=0.1755P
+ AD=0.1755P PS=1.84U PD=1.84U
* device instance $271 r0 *1 61.63,18.48 sky130_fd_pr__nfet_01v8
M$271 90 267 315 315 sky130_fd_pr__nfet_01v8 L=0.15U W=1.3U AS=0.3185P
+ AD=0.3185P PS=2.28U PD=2.28U
* device instance $273 r0 *1 62.91,18.48 sky130_fd_pr__nfet_01v8
M$273 317 204 315 315 sky130_fd_pr__nfet_01v8 L=0.15U W=1.3U AS=0.1755P
+ AD=0.26975P PS=1.84U PD=2.78U
* device instance $275 r0 *1 63.64,14.16 sky130_fd_pr__nfet_01v8
M$275 90 270 271 271 sky130_fd_pr__nfet_01v8 L=0.15U W=0.65U AS=0.169P
+ AD=0.08775P PS=1.82U PD=0.92U
* device instance $276 r0 *1 64.06,14.16 sky130_fd_pr__nfet_01v8
M$276 210 271 90 90 sky130_fd_pr__nfet_01v8 L=0.15U W=2.6U AS=0.351P
+ AD=0.43225P PS=3.68U PD=4.58U
* device instance $280 r0 *1 64.31,18.48 sky130_fd_pr__nfet_01v8
M$280 317 316 306 306 sky130_fd_pr__nfet_01v8 L=0.15U W=1.3U AS=0.26975P
+ AD=0.25675P PS=2.78U PD=2.74U
* device instance $282 r0 *1 66.28,14.045 sky130_fd_pr__nfet_01v8
M$282 90 231 272 272 sky130_fd_pr__nfet_01v8 L=0.15U W=0.42U AS=0.1113P
+ AD=0.0588P PS=1.37U PD=0.7U
* device instance $283 r0 *1 66.71,14.045 sky130_fd_pr__nfet_01v8
M$283 272 270 90 90 sky130_fd_pr__nfet_01v8 L=0.15U W=0.42U AS=0.0588P
+ AD=0.0588P PS=0.7U PD=0.7U
* device instance $284 r0 *1 67.14,14.045 sky130_fd_pr__nfet_01v8
M$284 283 204 272 272 sky130_fd_pr__nfet_01v8 L=0.15U W=0.42U AS=0.0588P
+ AD=0.1113P PS=0.7U PD=1.37U
* device instance $285 r0 *1 17.03,19.6 sky130_fd_pr__nfet_01v8
M$285 90 335 336 336 sky130_fd_pr__nfet_01v8 L=0.15U W=0.65U AS=0.169P
+ AD=0.08775P PS=1.82U PD=0.92U
* device instance $286 r0 *1 17.45,19.6 sky130_fd_pr__nfet_01v8
M$286 228 336 90 90 sky130_fd_pr__nfet_01v8 L=0.15U W=2.6U AS=0.351P AD=0.52P
+ PS=3.68U PD=4.2U
* device instance $290 r0 *1 19.65,19.6 sky130_fd_pr__nfet_01v8
M$290 325 335 90 90 sky130_fd_pr__nfet_01v8 L=0.15U W=2.6U AS=0.52P AD=0.351P
+ PS=4.2U PD=3.68U
* device instance $293 r0 *1 20.91,19.6 sky130_fd_pr__nfet_01v8
M$293 337 256 325 325 sky130_fd_pr__nfet_01v8 L=0.15U W=2.6U AS=0.351P
+ AD=0.351P PS=3.68U PD=3.68U
* device instance $298 r0 *1 23.01,19.6 sky130_fd_pr__nfet_01v8
M$298 337 338 90 90 sky130_fd_pr__nfet_01v8 L=0.15U W=2.6U AS=0.378625P
+ AD=0.47775P PS=3.765U PD=4.72U
* device instance $301 r0 *1 24.35,19.6 sky130_fd_pr__nfet_01v8
M$301 90 280 337 337 sky130_fd_pr__nfet_01v8 L=0.15U W=2.6U AS=0.352625P
+ AD=0.35425P PS=3.685U PD=3.69U
* device instance $306 r0 *1 27.155,19.485 sky130_fd_pr__nfet_01v8
M$306 326 310 90 90 sky130_fd_pr__nfet_01v8 L=0.15U W=1.68U AS=0.2877P
+ AD=0.2352P PS=3.47U PD=2.8U
* device instance $310 r0 *1 28.875,19.485 sky130_fd_pr__nfet_01v8
M$310 31 326 90 90 sky130_fd_pr__nfet_01v8 L=0.15U W=6.72U AS=0.93975P
+ AD=1.07465P PS=11.195U PD=11.925U
* device instance $326 r0 *1 36.25,19.6 sky130_fd_pr__nfet_01v8
M$326 275 327 90 90 sky130_fd_pr__nfet_01v8 L=0.15U W=2.6U AS=0.45695P
+ AD=0.351P PS=4.19U PD=3.68U
* device instance $330 r0 *1 37.93,19.6 sky130_fd_pr__nfet_01v8
M$330 327 276 90 90 sky130_fd_pr__nfet_01v8 L=0.15U W=0.65U AS=0.08775P
+ AD=0.169P PS=0.92U PD=1.82U
* device instance $331 r0 *1 44.17,18.595 sky130_fd_pr__nfet_01v8
M$331 90 329 296 296 sky130_fd_pr__nfet_01v8 L=0.15U W=0.42U AS=0.1092P
+ AD=0.0567P PS=1.36U PD=0.69U
* device instance $332 r0 *1 44.59,18.595 sky130_fd_pr__nfet_01v8
M$332 297 296 90 90 sky130_fd_pr__nfet_01v8 L=0.15U W=0.42U AS=0.0567P
+ AD=0.1092P PS=0.69U PD=1.36U
* device instance $333 r0 *1 45.53,18.595 sky130_fd_pr__nfet_01v8
M$333 323 189 298 298 sky130_fd_pr__nfet_01v8 L=0.15U W=0.42U AS=0.1092P
+ AD=0.0441P PS=1.36U PD=0.63U
* device instance $334 r0 *1 45.89,18.595 sky130_fd_pr__nfet_01v8
M$334 90 311 323 323 sky130_fd_pr__nfet_01v8 L=0.15U W=0.42U AS=0.0441P
+ AD=0.1092P PS=0.63U PD=1.36U
* device instance $335 r0 *1 46.475,19.485 sky130_fd_pr__nfet_01v8
M$335 328 310 90 90 sky130_fd_pr__nfet_01v8 L=0.15U W=1.68U AS=0.2877P
+ AD=0.2352P PS=3.47U PD=2.8U
* device instance $339 r0 *1 48.195,19.485 sky130_fd_pr__nfet_01v8
M$339 329 328 90 90 sky130_fd_pr__nfet_01v8 L=0.15U W=6.72U AS=0.93975P
+ AD=0.99225P PS=11.195U PD=11.865U
* device instance $355 r0 *1 46.83,18.595 sky130_fd_pr__nfet_01v8
M$355 90 311 299 299 sky130_fd_pr__nfet_01v8 L=0.15U W=0.42U AS=0.1092P
+ AD=0.0609P PS=1.36U PD=0.71U
* device instance $356 r0 *1 47.27,18.595 sky130_fd_pr__nfet_01v8
M$356 322 299 90 90 sky130_fd_pr__nfet_01v8 L=0.15U W=0.42U AS=0.0609P
+ AD=0.0756P PS=0.71U PD=0.78U
* device instance $357 r0 *1 47.78,18.595 sky130_fd_pr__nfet_01v8
M$357 298 303 322 322 sky130_fd_pr__nfet_01v8 L=0.15U W=0.42U AS=0.0756P
+ AD=0.1446P PS=0.78U PD=1.18U
* device instance $358 r0 *1 48.69,18.625 sky130_fd_pr__nfet_01v8
M$358 300 296 298 298 sky130_fd_pr__nfet_01v8 L=0.15U W=0.36U AS=0.1446P
+ AD=0.0522P PS=1.18U PD=0.65U
* device instance $359 r0 *1 49.13,18.625 sky130_fd_pr__nfet_01v8
M$359 300 297 321 321 sky130_fd_pr__nfet_01v8 L=0.15U W=0.36U AS=0.0759P
+ AD=0.0522P PS=0.8U PD=0.65U
* device instance $360 r0 *1 49.66,18.595 sky130_fd_pr__nfet_01v8
M$360 321 301 90 90 sky130_fd_pr__nfet_01v8 L=0.15U W=0.42U AS=0.12095P
+ AD=0.0759P PS=1.085U PD=0.8U
* device instance $361 r0 *1 50.255,18.485 sky130_fd_pr__nfet_01v8
M$361 301 300 90 90 sky130_fd_pr__nfet_01v8 L=0.15U W=0.64U AS=0.12095P
+ AD=0.1664P PS=1.085U PD=1.8U
* device instance $362 r0 *1 51.195,18.595 sky130_fd_pr__nfet_01v8
M$362 320 301 90 90 sky130_fd_pr__nfet_01v8 L=0.15U W=0.42U AS=0.1092P
+ AD=0.0678P PS=1.36U PD=0.755U
* device instance $363 r0 *1 51.68,18.625 sky130_fd_pr__nfet_01v8
M$363 302 297 320 320 sky130_fd_pr__nfet_01v8 L=0.15U W=0.36U AS=0.0678P
+ AD=0.0684P PS=0.755U PD=0.74U
* device instance $364 r0 *1 52.21,18.625 sky130_fd_pr__nfet_01v8
M$364 302 296 319 319 sky130_fd_pr__nfet_01v8 L=0.15U W=0.36U AS=0.066P
+ AD=0.0684P PS=0.745U PD=0.74U
* device instance $365 r0 *1 52.685,18.595 sky130_fd_pr__nfet_01v8
M$365 90 303 319 319 sky130_fd_pr__nfet_01v8 L=0.15U W=0.42U AS=0.066P
+ AD=0.1092P PS=0.745U PD=1.36U
* device instance $366 r0 *1 63.51,19.6 sky130_fd_pr__nfet_01v8
M$366 343 339 90 90 sky130_fd_pr__nfet_01v8 L=0.15U W=0.65U AS=0.169P
+ AD=0.08775P PS=1.82U PD=0.92U
* device instance $367 r0 *1 63.93,19.6 sky130_fd_pr__nfet_01v8
M$367 330 316 343 343 sky130_fd_pr__nfet_01v8 L=0.15U W=0.65U AS=0.08775P
+ AD=0.169P PS=0.92U PD=1.82U
* device instance $368 r0 *1 64.97,19.6 sky130_fd_pr__nfet_01v8
M$368 342 283 331 331 sky130_fd_pr__nfet_01v8 L=0.15U W=0.65U AS=0.169P
+ AD=0.06825P PS=1.82U PD=0.86U
* device instance $369 r0 *1 65.33,19.6 sky130_fd_pr__nfet_01v8
M$369 90 330 342 342 sky130_fd_pr__nfet_01v8 L=0.15U W=0.65U AS=0.06825P
+ AD=0.08775P PS=0.86U PD=0.92U
* device instance $370 r0 *1 65.75,19.6 sky130_fd_pr__nfet_01v8
M$370 332 330 90 90 sky130_fd_pr__nfet_01v8 L=0.15U W=0.65U AS=0.08775P
+ AD=0.169P PS=0.92U PD=1.82U
* device instance $371 r0 *1 66.69,19.6 sky130_fd_pr__nfet_01v8
M$371 332 283 90 90 sky130_fd_pr__nfet_01v8 L=0.15U W=0.65U AS=0.169P
+ AD=0.08775P PS=1.82U PD=0.92U
* device instance $372 r0 *1 67.11,19.6 sky130_fd_pr__nfet_01v8
M$372 346 331 332 332 sky130_fd_pr__nfet_01v8 L=0.15U W=0.65U AS=0.08775P
+ AD=0.195P PS=0.92U PD=1.9U
* device instance $373 r0 *1 69.215,19.485 sky130_fd_pr__nfet_01v8
M$373 340 341 90 90 sky130_fd_pr__nfet_01v8 L=0.15U W=0.42U AS=0.10025P
+ AD=0.1092P PS=0.985U PD=1.36U
* device instance $374 r0 *1 68.31,19.6 sky130_fd_pr__nfet_01v8
M$374 333 340 90 90 sky130_fd_pr__nfet_01v8 L=0.15U W=0.65U AS=0.169P
+ AD=0.08775P PS=1.82U PD=0.92U
* device instance $375 r0 *1 68.73,19.6 sky130_fd_pr__nfet_01v8
M$375 90 334 333 333 sky130_fd_pr__nfet_01v8 L=0.15U W=0.65U AS=0.08775P
+ AD=0.10025P PS=0.92U PD=0.985U
* device instance $376 r0 *1 6.98,24.035 sky130_fd_pr__nfet_01v8
M$376 409 377 351 351 sky130_fd_pr__nfet_01v8 L=0.15U W=0.42U AS=0.1113P
+ AD=0.0441P PS=1.37U PD=0.63U
* device instance $377 r0 *1 7.34,24.035 sky130_fd_pr__nfet_01v8
M$377 90 108 409 409 sky130_fd_pr__nfet_01v8 L=0.15U W=0.42U AS=0.0441P
+ AD=0.0966P PS=0.63U PD=0.88U
* device instance $378 r0 *1 7.95,24.035 sky130_fd_pr__nfet_01v8
M$378 352 351 90 90 sky130_fd_pr__nfet_01v8 L=0.15U W=0.42U AS=0.0966P
+ AD=0.1113P PS=0.88U PD=1.37U
* device instance $379 r0 *1 9.21,23.92 sky130_fd_pr__nfet_01v8
M$379 90 352 353 353 sky130_fd_pr__nfet_01v8 L=0.15U W=0.65U AS=0.169P
+ AD=0.10725P PS=1.82U PD=0.98U
* device instance $380 r0 *1 9.69,23.92 sky130_fd_pr__nfet_01v8
M$380 412 378 90 90 sky130_fd_pr__nfet_01v8 L=0.15U W=0.65U AS=0.10725P
+ AD=0.06825P PS=0.98U PD=0.86U
* device instance $381 r0 *1 10.05,23.92 sky130_fd_pr__nfet_01v8
M$381 353 129 412 412 sky130_fd_pr__nfet_01v8 L=0.15U W=0.65U AS=0.06825P
+ AD=0.169P PS=0.86U PD=1.82U
* device instance $382 r0 *1 10.99,23.92 sky130_fd_pr__nfet_01v8
M$382 414 130 353 353 sky130_fd_pr__nfet_01v8 L=0.15U W=0.65U AS=0.169P
+ AD=0.10725P PS=1.82U PD=0.98U
* device instance $383 r0 *1 11.47,23.92 sky130_fd_pr__nfet_01v8
M$383 90 403 414 414 sky130_fd_pr__nfet_01v8 L=0.15U W=0.65U AS=0.10725P
+ AD=0.102375P PS=0.98U PD=0.965U
* device instance $384 r0 *1 11.935,23.92 sky130_fd_pr__nfet_01v8
M$384 405 353 90 90 sky130_fd_pr__nfet_01v8 L=0.15U W=0.65U AS=0.102375P
+ AD=0.169P PS=0.965U PD=1.82U
* device instance $385 r0 *1 12.95,23.92 sky130_fd_pr__nfet_01v8
M$385 403 355 90 90 sky130_fd_pr__nfet_01v8 L=0.15U W=0.65U AS=0.208P
+ AD=0.25025P PS=1.94U PD=1.42U
* device instance $386 r0 *1 13.87,23.92 sky130_fd_pr__nfet_01v8
M$386 416 380 403 403 sky130_fd_pr__nfet_01v8 L=0.15U W=0.65U AS=0.25025P
+ AD=0.08775P PS=1.42U PD=0.92U
* device instance $387 r0 *1 14.29,23.92 sky130_fd_pr__nfet_01v8
M$387 90 292 416 416 sky130_fd_pr__nfet_01v8 L=0.15U W=0.65U AS=0.08775P
+ AD=0.08775P PS=0.92U PD=0.92U
* device instance $388 r0 *1 14.71,23.92 sky130_fd_pr__nfet_01v8
M$388 355 292 90 90 sky130_fd_pr__nfet_01v8 L=0.15U W=0.65U AS=0.08775P
+ AD=0.08775P PS=0.92U PD=0.92U
* device instance $389 r0 *1 15.13,23.92 sky130_fd_pr__nfet_01v8
M$389 90 380 355 355 sky130_fd_pr__nfet_01v8 L=0.15U W=0.65U AS=0.08775P
+ AD=0.169P PS=0.92U PD=1.82U
* device instance $390 r0 *1 17.49,24.005 sky130_fd_pr__nfet_01v8
M$390 381 606 90 90 sky130_fd_pr__nfet_01v8 L=0.15U W=0.42U AS=0.1092P
+ AD=0.0693P PS=1.36U PD=0.75U
* device instance $391 r0 *1 17.97,24.005 sky130_fd_pr__nfet_01v8
M$391 90 128 381 381 sky130_fd_pr__nfet_01v8 L=0.15U W=0.42U AS=0.0693P
+ AD=0.0567P PS=0.75U PD=0.69U
* device instance $392 r0 *1 18.39,24.005 sky130_fd_pr__nfet_01v8
M$392 381 378 90 90 sky130_fd_pr__nfet_01v8 L=0.15U W=0.42U AS=0.0567P
+ AD=0.0567P PS=0.69U PD=0.69U
* device instance $393 r0 *1 18.81,24.005 sky130_fd_pr__nfet_01v8
M$393 381 164 90 90 sky130_fd_pr__nfet_01v8 L=0.15U W=0.42U AS=0.101875P
+ AD=0.0567P PS=0.99U PD=0.69U
* device instance $394 r0 *1 19.3,23.92 sky130_fd_pr__nfet_01v8
M$394 406 381 90 90 sky130_fd_pr__nfet_01v8 L=0.15U W=0.65U AS=0.101875P
+ AD=0.1755P PS=0.99U PD=1.84U
* device instance $395 r0 *1 27.625,24.035 sky130_fd_pr__nfet_01v8
M$395 357 31 90 90 sky130_fd_pr__nfet_01v8 L=0.15U W=1.68U AS=0.315P AD=0.3423P
+ PS=3.6U PD=3.73U
* device instance $399 r0 *1 41.57,23.92 sky130_fd_pr__nfet_01v8
M$399 90 358 407 407 sky130_fd_pr__nfet_01v8 L=0.15U W=0.65U AS=0.182P
+ AD=0.10025P PS=1.86U PD=0.985U
* device instance $400 r0 *1 42.055,24.035 sky130_fd_pr__nfet_01v8
M$400 359 358 90 90 sky130_fd_pr__nfet_01v8 L=0.15U W=0.42U AS=0.10025P
+ AD=0.1092P PS=0.985U PD=1.36U
* device instance $401 r0 *1 42.995,24.035 sky130_fd_pr__nfet_01v8
M$401 421 359 90 90 sky130_fd_pr__nfet_01v8 L=0.15U W=0.42U AS=0.1092P
+ AD=0.066P PS=1.36U PD=0.745U
* device instance $402 r0 *1 43.47,24.065 sky130_fd_pr__nfet_01v8
M$402 358 383 421 421 sky130_fd_pr__nfet_01v8 L=0.15U W=0.36U AS=0.066P
+ AD=0.0684P PS=0.745U PD=0.74U
* device instance $403 r0 *1 44,24.065 sky130_fd_pr__nfet_01v8
M$403 358 382 423 423 sky130_fd_pr__nfet_01v8 L=0.15U W=0.36U AS=0.0678P
+ AD=0.0684P PS=0.755U PD=0.74U
* device instance $404 r0 *1 44.485,24.035 sky130_fd_pr__nfet_01v8
M$404 90 360 423 423 sky130_fd_pr__nfet_01v8 L=0.15U W=0.42U AS=0.0678P
+ AD=0.1092P PS=0.755U PD=1.36U
* device instance $405 r0 *1 45.425,23.925 sky130_fd_pr__nfet_01v8
M$405 90 361 360 360 sky130_fd_pr__nfet_01v8 L=0.15U W=0.64U AS=0.1664P
+ AD=0.12095P PS=1.8U PD=1.085U
* device instance $406 r0 *1 46.02,24.035 sky130_fd_pr__nfet_01v8
M$406 424 360 90 90 sky130_fd_pr__nfet_01v8 L=0.15U W=0.42U AS=0.12095P
+ AD=0.0759P PS=1.085U PD=0.8U
* device instance $407 r0 *1 46.55,24.065 sky130_fd_pr__nfet_01v8
M$407 361 382 424 424 sky130_fd_pr__nfet_01v8 L=0.15U W=0.36U AS=0.0759P
+ AD=0.0522P PS=0.8U PD=0.65U
* device instance $408 r0 *1 46.99,24.065 sky130_fd_pr__nfet_01v8
M$408 361 383 362 362 sky130_fd_pr__nfet_01v8 L=0.15U W=0.36U AS=0.1446P
+ AD=0.0522P PS=1.18U PD=0.65U
* device instance $409 r0 *1 47.9,24.035 sky130_fd_pr__nfet_01v8
M$409 422 359 362 362 sky130_fd_pr__nfet_01v8 L=0.15U W=0.42U AS=0.1446P
+ AD=0.0756P PS=1.18U PD=0.78U
* device instance $410 r0 *1 48.41,24.035 sky130_fd_pr__nfet_01v8
M$410 90 363 422 422 sky130_fd_pr__nfet_01v8 L=0.15U W=0.42U AS=0.0756P
+ AD=0.0609P PS=0.78U PD=0.71U
* device instance $411 r0 *1 48.85,24.035 sky130_fd_pr__nfet_01v8
M$411 363 88 90 90 sky130_fd_pr__nfet_01v8 L=0.15U W=0.42U AS=0.0609P
+ AD=0.1092P PS=0.71U PD=1.36U
* device instance $412 r0 *1 49.79,24.035 sky130_fd_pr__nfet_01v8
M$412 420 88 90 90 sky130_fd_pr__nfet_01v8 L=0.15U W=0.42U AS=0.1092P
+ AD=0.0441P PS=1.36U PD=0.63U
* device instance $413 r0 *1 50.15,24.035 sky130_fd_pr__nfet_01v8
M$413 362 404 420 420 sky130_fd_pr__nfet_01v8 L=0.15U W=0.42U AS=0.0441P
+ AD=0.1092P PS=0.63U PD=1.36U
* device instance $414 r0 *1 51.09,24.035 sky130_fd_pr__nfet_01v8
M$414 90 383 382 382 sky130_fd_pr__nfet_01v8 L=0.15U W=0.42U AS=0.1092P
+ AD=0.0567P PS=1.36U PD=0.69U
* device instance $415 r0 *1 51.51,24.035 sky130_fd_pr__nfet_01v8
M$415 383 329 90 90 sky130_fd_pr__nfet_01v8 L=0.15U W=0.42U AS=0.0567P
+ AD=0.1092P PS=0.69U PD=1.36U
* device instance $416 r0 *1 53.51,23.92 sky130_fd_pr__nfet_01v8
M$416 384 230 90 90 sky130_fd_pr__nfet_01v8 L=0.15U W=1.3U AS=0.25675P
+ AD=0.1755P PS=2.74U PD=1.84U
* device instance $418 r0 *1 54.35,23.92 sky130_fd_pr__nfet_01v8
M$418 384 135 90 90 sky130_fd_pr__nfet_01v8 L=0.15U W=1.3U AS=0.1755P
+ AD=0.26975P PS=1.84U PD=2.78U
* device instance $420 r0 *1 55.75,23.92 sky130_fd_pr__nfet_01v8
M$420 384 334 90 90 sky130_fd_pr__nfet_01v8 L=0.15U W=1.3U AS=0.26975P
+ AD=0.1755P PS=2.78U PD=1.84U
* device instance $422 r0 *1 56.59,23.92 sky130_fd_pr__nfet_01v8
M$422 384 366 90 90 sky130_fd_pr__nfet_01v8 L=0.15U W=1.3U AS=0.1755P
+ AD=0.26975P PS=1.84U PD=2.78U
* device instance $424 r0 *1 60.73,23.92 sky130_fd_pr__nfet_01v8
M$424 90 386 367 367 sky130_fd_pr__nfet_01v8 L=0.15U W=0.65U AS=0.169P
+ AD=0.10725P PS=1.82U PD=0.98U
* device instance $425 r0 *1 61.21,23.92 sky130_fd_pr__nfet_01v8
M$425 419 334 90 90 sky130_fd_pr__nfet_01v8 L=0.15U W=0.65U AS=0.10725P
+ AD=0.06825P PS=0.98U PD=0.86U
* device instance $426 r0 *1 61.57,23.92 sky130_fd_pr__nfet_01v8
M$426 367 129 419 419 sky130_fd_pr__nfet_01v8 L=0.15U W=0.65U AS=0.06825P
+ AD=0.169P PS=0.86U PD=1.82U
* device instance $427 r0 *1 62.51,23.92 sky130_fd_pr__nfet_01v8
M$427 418 136 367 367 sky130_fd_pr__nfet_01v8 L=0.15U W=0.65U AS=0.169P
+ AD=0.10725P PS=1.82U PD=0.98U
* device instance $428 r0 *1 62.99,23.92 sky130_fd_pr__nfet_01v8
M$428 90 346 418 418 sky130_fd_pr__nfet_01v8 L=0.15U W=0.65U AS=0.10725P
+ AD=0.102375P PS=0.98U PD=0.965U
* device instance $429 r0 *1 63.455,23.92 sky130_fd_pr__nfet_01v8
M$429 408 367 90 90 sky130_fd_pr__nfet_01v8 L=0.15U W=0.65U AS=0.102375P
+ AD=0.169P PS=0.965U PD=1.82U
* device instance $430 r0 *1 64.41,24.035 sky130_fd_pr__nfet_01v8
M$430 90 329 369 369 sky130_fd_pr__nfet_01v8 L=0.15U W=0.42U AS=0.1092P
+ AD=0.0567P PS=1.36U PD=0.69U
* device instance $431 r0 *1 64.83,24.035 sky130_fd_pr__nfet_01v8
M$431 370 369 90 90 sky130_fd_pr__nfet_01v8 L=0.15U W=0.42U AS=0.0567P
+ AD=0.1092P PS=0.69U PD=1.36U
* device instance $432 r0 *1 65.77,24.035 sky130_fd_pr__nfet_01v8
M$432 417 388 371 371 sky130_fd_pr__nfet_01v8 L=0.15U W=0.42U AS=0.1092P
+ AD=0.0441P PS=1.36U PD=0.63U
* device instance $433 r0 *1 66.13,24.035 sky130_fd_pr__nfet_01v8
M$433 90 1134 417 417 sky130_fd_pr__nfet_01v8 L=0.15U W=0.42U AS=0.0441P
+ AD=0.1092P PS=0.63U PD=1.36U
* device instance $434 r0 *1 67.07,24.035 sky130_fd_pr__nfet_01v8
M$434 90 1134 372 372 sky130_fd_pr__nfet_01v8 L=0.15U W=0.42U AS=0.1092P
+ AD=0.0609P PS=1.36U PD=0.71U
* device instance $435 r0 *1 67.51,24.035 sky130_fd_pr__nfet_01v8
M$435 415 372 90 90 sky130_fd_pr__nfet_01v8 L=0.15U W=0.42U AS=0.0609P
+ AD=0.0756P PS=0.71U PD=0.78U
* device instance $436 r0 *1 68.02,24.035 sky130_fd_pr__nfet_01v8
M$436 371 376 415 415 sky130_fd_pr__nfet_01v8 L=0.15U W=0.42U AS=0.0756P
+ AD=0.1446P PS=0.78U PD=1.18U
* device instance $437 r0 *1 68.93,24.065 sky130_fd_pr__nfet_01v8
M$437 373 369 371 371 sky130_fd_pr__nfet_01v8 L=0.15U W=0.36U AS=0.1446P
+ AD=0.0522P PS=1.18U PD=0.65U
* device instance $438 r0 *1 69.37,24.065 sky130_fd_pr__nfet_01v8
M$438 373 370 413 413 sky130_fd_pr__nfet_01v8 L=0.15U W=0.36U AS=0.0759P
+ AD=0.0522P PS=0.8U PD=0.65U
* device instance $439 r0 *1 69.9,24.035 sky130_fd_pr__nfet_01v8
M$439 413 374 90 90 sky130_fd_pr__nfet_01v8 L=0.15U W=0.42U AS=0.12095P
+ AD=0.0759P PS=1.085U PD=0.8U
* device instance $440 r0 *1 70.495,23.925 sky130_fd_pr__nfet_01v8
M$440 374 373 90 90 sky130_fd_pr__nfet_01v8 L=0.15U W=0.64U AS=0.12095P
+ AD=0.1664P PS=1.085U PD=1.8U
* device instance $441 r0 *1 71.435,24.035 sky130_fd_pr__nfet_01v8
M$441 411 374 90 90 sky130_fd_pr__nfet_01v8 L=0.15U W=0.42U AS=0.1092P
+ AD=0.0678P PS=1.36U PD=0.755U
* device instance $442 r0 *1 71.92,24.065 sky130_fd_pr__nfet_01v8
M$442 375 370 411 411 sky130_fd_pr__nfet_01v8 L=0.15U W=0.36U AS=0.0678P
+ AD=0.0684P PS=0.755U PD=0.74U
* device instance $443 r0 *1 72.45,24.065 sky130_fd_pr__nfet_01v8
M$443 375 369 410 410 sky130_fd_pr__nfet_01v8 L=0.15U W=0.36U AS=0.066P
+ AD=0.0684P PS=0.745U PD=0.74U
* device instance $444 r0 *1 72.925,24.035 sky130_fd_pr__nfet_01v8
M$444 90 376 410 410 sky130_fd_pr__nfet_01v8 L=0.15U W=0.42U AS=0.066P
+ AD=0.1092P PS=0.745U PD=1.36U
* device instance $445 r0 *1 73.865,24.035 sky130_fd_pr__nfet_01v8
M$445 376 375 90 90 sky130_fd_pr__nfet_01v8 L=0.15U W=0.42U AS=0.10025P
+ AD=0.1092P PS=0.985U PD=1.36U
* device instance $446 r0 *1 74.35,23.92 sky130_fd_pr__nfet_01v8
M$446 334 375 90 90 sky130_fd_pr__nfet_01v8 L=0.15U W=0.65U AS=0.10025P
+ AD=0.182P PS=0.985U PD=1.86U
* device instance $447 r0 *1 4.61,24.925 sky130_fd_pr__nfet_01v8
M$447 90 31 425 425 sky130_fd_pr__nfet_01v8 L=0.15U W=0.42U AS=0.1092P
+ AD=0.0567P PS=1.36U PD=0.69U
* device instance $448 r0 *1 5.03,24.925 sky130_fd_pr__nfet_01v8
M$448 426 425 90 90 sky130_fd_pr__nfet_01v8 L=0.15U W=0.42U AS=0.0567P
+ AD=0.1092P PS=0.69U PD=1.36U
* device instance $449 r0 *1 5.97,24.925 sky130_fd_pr__nfet_01v8
M$449 453 447 427 427 sky130_fd_pr__nfet_01v8 L=0.15U W=0.42U AS=0.1092P
+ AD=0.0441P PS=1.36U PD=0.63U
* device instance $450 r0 *1 6.33,24.925 sky130_fd_pr__nfet_01v8
M$450 90 88 453 453 sky130_fd_pr__nfet_01v8 L=0.15U W=0.42U AS=0.0441P
+ AD=0.1092P PS=0.63U PD=1.36U
* device instance $451 r0 *1 9.13,24.895 sky130_fd_pr__nfet_01v8
M$451 429 425 427 427 sky130_fd_pr__nfet_01v8 L=0.15U W=0.36U AS=0.1446P
+ AD=0.0522P PS=1.18U PD=0.65U
* device instance $452 r0 *1 9.57,24.895 sky130_fd_pr__nfet_01v8
M$452 455 426 429 429 sky130_fd_pr__nfet_01v8 L=0.15U W=0.36U AS=0.0522P
+ AD=0.0759P PS=0.65U PD=0.8U
* device instance $453 r0 *1 7.27,24.925 sky130_fd_pr__nfet_01v8
M$453 90 88 428 428 sky130_fd_pr__nfet_01v8 L=0.15U W=0.42U AS=0.1092P
+ AD=0.0609P PS=1.36U PD=0.71U
* device instance $454 r0 *1 7.71,24.925 sky130_fd_pr__nfet_01v8
M$454 454 428 90 90 sky130_fd_pr__nfet_01v8 L=0.15U W=0.42U AS=0.0609P
+ AD=0.0756P PS=0.71U PD=0.78U
* device instance $455 r0 *1 8.22,24.925 sky130_fd_pr__nfet_01v8
M$455 427 448 454 454 sky130_fd_pr__nfet_01v8 L=0.15U W=0.42U AS=0.0756P
+ AD=0.1446P PS=0.78U PD=1.18U
* device instance $456 r0 *1 10.1,24.925 sky130_fd_pr__nfet_01v8
M$456 90 430 455 455 sky130_fd_pr__nfet_01v8 L=0.15U W=0.42U AS=0.0759P
+ AD=0.12095P PS=0.8U PD=1.085U
* device instance $457 r0 *1 10.695,25.035 sky130_fd_pr__nfet_01v8
M$457 430 429 90 90 sky130_fd_pr__nfet_01v8 L=0.15U W=0.64U AS=0.12095P
+ AD=0.1664P PS=1.085U PD=1.8U
* device instance $458 r0 *1 12.12,24.895 sky130_fd_pr__nfet_01v8
M$458 431 426 457 457 sky130_fd_pr__nfet_01v8 L=0.15U W=0.36U AS=0.0678P
+ AD=0.0684P PS=0.755U PD=0.74U
* device instance $459 r0 *1 12.65,24.895 sky130_fd_pr__nfet_01v8
M$459 458 425 431 431 sky130_fd_pr__nfet_01v8 L=0.15U W=0.36U AS=0.0684P
+ AD=0.066P PS=0.74U PD=0.745U
* device instance $460 r0 *1 11.635,24.925 sky130_fd_pr__nfet_01v8
M$460 457 430 90 90 sky130_fd_pr__nfet_01v8 L=0.15U W=0.42U AS=0.1092P
+ AD=0.0678P PS=1.36U PD=0.755U
* device instance $461 r0 *1 13.125,24.925 sky130_fd_pr__nfet_01v8
M$461 90 448 458 458 sky130_fd_pr__nfet_01v8 L=0.15U W=0.42U AS=0.066P
+ AD=0.1092P PS=0.745U PD=1.36U
* device instance $462 r0 *1 14.065,24.925 sky130_fd_pr__nfet_01v8
M$462 90 431 448 448 sky130_fd_pr__nfet_01v8 L=0.15U W=0.42U AS=0.1092P
+ AD=0.10025P PS=1.36U PD=0.985U
* device instance $463 r0 *1 14.55,25.04 sky130_fd_pr__nfet_01v8
M$463 378 431 90 90 sky130_fd_pr__nfet_01v8 L=0.15U W=0.65U AS=0.10025P
+ AD=0.182P PS=0.985U PD=1.86U
* device instance $464 r0 *1 18.185,24.925 sky130_fd_pr__nfet_01v8
M$464 90 378 432 432 sky130_fd_pr__nfet_01v8 L=0.15U W=0.42U AS=0.1092P
+ AD=0.10025P PS=1.36U PD=0.985U
* device instance $465 r0 *1 18.67,25.04 sky130_fd_pr__nfet_01v8
M$465 433 449 90 90 sky130_fd_pr__nfet_01v8 L=0.15U W=0.65U AS=0.10025P
+ AD=0.08775P PS=0.985U PD=0.92U
* device instance $466 r0 *1 19.09,25.04 sky130_fd_pr__nfet_01v8
M$466 90 432 433 433 sky130_fd_pr__nfet_01v8 L=0.15U W=0.65U AS=0.08775P
+ AD=0.169P PS=0.92U PD=1.82U
* device instance $467 r0 *1 20.25,25.04 sky130_fd_pr__nfet_01v8
M$467 380 433 90 90 sky130_fd_pr__nfet_01v8 L=0.15U W=0.65U AS=0.169P
+ AD=0.08775P PS=1.82U PD=0.92U
* device instance $468 r0 *1 20.67,25.04 sky130_fd_pr__nfet_01v8
M$468 90 338 380 380 sky130_fd_pr__nfet_01v8 L=0.15U W=0.65U AS=0.08775P
+ AD=0.169P PS=0.92U PD=1.82U
* device instance $469 r0 *1 21.865,24.925 sky130_fd_pr__nfet_01v8
M$469 90 449 434 434 sky130_fd_pr__nfet_01v8 L=0.15U W=0.42U AS=0.1092P
+ AD=0.10025P PS=1.36U PD=0.985U
* device instance $470 r0 *1 22.35,25.04 sky130_fd_pr__nfet_01v8
M$470 338 378 90 90 sky130_fd_pr__nfet_01v8 L=0.15U W=0.65U AS=0.10025P
+ AD=0.08775P PS=0.985U PD=0.92U
* device instance $471 r0 *1 22.77,25.04 sky130_fd_pr__nfet_01v8
M$471 90 434 338 338 sky130_fd_pr__nfet_01v8 L=0.15U W=0.65U AS=0.08775P
+ AD=0.169P PS=0.92U PD=1.82U
* device instance $472 r0 *1 34.985,25.04 sky130_fd_pr__nfet_01v8
M$472 450 436 435 435 sky130_fd_pr__nfet_01v8 L=0.15U W=1.3U AS=0.2665P
+ AD=0.1755P PS=2.77U PD=1.84U
* device instance $474 r0 *1 35.825,25.04 sky130_fd_pr__nfet_01v8
M$474 90 437 435 435 sky130_fd_pr__nfet_01v8 L=0.15U W=1.3U AS=0.1755P
+ AD=0.26975P PS=1.84U PD=2.78U
* device instance $476 r0 *1 37.225,25.04 sky130_fd_pr__nfet_01v8
M$476 438 437 90 90 sky130_fd_pr__nfet_01v8 L=0.15U W=1.3U AS=0.26975P
+ AD=0.1755P PS=2.78U PD=1.84U
* device instance $478 r0 *1 38.065,25.04 sky130_fd_pr__nfet_01v8
M$478 438 436 90 90 sky130_fd_pr__nfet_01v8 L=0.15U W=1.3U AS=0.186875P
+ AD=0.268125P PS=1.875U PD=2.775U
* device instance $480 r0 *1 39.46,25.04 sky130_fd_pr__nfet_01v8
M$480 438 450 439 439 sky130_fd_pr__nfet_01v8 L=0.15U W=1.3U AS=0.25675P
+ AD=0.25675P PS=2.74U PD=2.74U
* device instance $482 r0 *1 46.47,25.04 sky130_fd_pr__nfet_01v8
M$482 90 329 440 440 sky130_fd_pr__nfet_01v8 L=0.15U W=1.95U AS=0.3445P
+ AD=0.26325P PS=3.66U PD=2.76U
* device instance $485 r0 *1 47.73,25.04 sky130_fd_pr__nfet_01v8
M$485 441 440 90 90 sky130_fd_pr__nfet_01v8 L=0.15U W=3.9U AS=0.5265P
+ AD=0.5265P PS=5.52U PD=5.52U
* device instance $491 r0 *1 50.25,25.04 sky130_fd_pr__nfet_01v8
M$491 442 441 90 90 sky130_fd_pr__nfet_01v8 L=0.15U W=10.4U AS=1.404P
+ AD=1.48525P PS=14.72U PD=15.62U
* device instance $507 r0 *1 61.51,24.925 sky130_fd_pr__nfet_01v8
M$507 90 451 386 386 sky130_fd_pr__nfet_01v8 L=0.15U W=0.42U AS=0.1113P
+ AD=0.0966P PS=1.37U PD=0.88U
* device instance $508 r0 *1 62.12,24.925 sky130_fd_pr__nfet_01v8
M$508 461 108 90 90 sky130_fd_pr__nfet_01v8 L=0.15U W=0.42U AS=0.0966P
+ AD=0.0441P PS=0.88U PD=0.63U
* device instance $509 r0 *1 62.48,24.925 sky130_fd_pr__nfet_01v8
M$509 451 443 461 461 sky130_fd_pr__nfet_01v8 L=0.15U W=0.42U AS=0.0441P
+ AD=0.1113P PS=0.63U PD=1.37U
* device instance $510 r0 *1 63.975,24.925 sky130_fd_pr__nfet_01v8
M$510 316 333 90 90 sky130_fd_pr__nfet_01v8 L=0.15U W=0.42U AS=0.1197P
+ AD=0.1092P PS=1.41U PD=1.36U
* device instance $511 r0 *1 65.785,25.04 sky130_fd_pr__nfet_01v8
M$511 460 452 339 339 sky130_fd_pr__nfet_01v8 L=0.15U W=0.65U AS=0.169P
+ AD=0.08775P PS=1.82U PD=0.92U
* device instance $512 r0 *1 66.205,25.04 sky130_fd_pr__nfet_01v8
M$512 90 334 460 460 sky130_fd_pr__nfet_01v8 L=0.15U W=0.65U AS=0.08775P
+ AD=0.10025P PS=0.92U PD=0.985U
* device instance $513 r0 *1 66.69,25.155 sky130_fd_pr__nfet_01v8
M$513 452 341 90 90 sky130_fd_pr__nfet_01v8 L=0.15U W=0.42U AS=0.10025P
+ AD=0.1092P PS=0.985U PD=1.36U
* device instance $514 r0 *1 68.175,24.925 sky130_fd_pr__nfet_01v8
M$514 459 55 90 90 sky130_fd_pr__nfet_01v8 L=0.15U W=0.42U AS=0.11285P
+ AD=0.0693P PS=1.045U PD=0.75U
* device instance $515 r0 *1 68.655,24.925 sky130_fd_pr__nfet_01v8
M$515 444 445 459 459 sky130_fd_pr__nfet_01v8 L=0.15U W=0.42U AS=0.0693P
+ AD=0.09975P PS=0.75U PD=0.895U
* device instance $516 r0 *1 69.28,24.925 sky130_fd_pr__nfet_01v8
M$516 456 341 444 444 sky130_fd_pr__nfet_01v8 L=0.15U W=0.42U AS=0.09975P
+ AD=0.0693P PS=0.895U PD=0.75U
* device instance $517 r0 *1 69.76,24.925 sky130_fd_pr__nfet_01v8
M$517 90 446 456 456 sky130_fd_pr__nfet_01v8 L=0.15U W=0.42U AS=0.0693P
+ AD=0.1449P PS=0.75U PD=1.11U
* device instance $518 r0 *1 70.6,24.925 sky130_fd_pr__nfet_01v8
M$518 446 55 90 90 sky130_fd_pr__nfet_01v8 L=0.15U W=0.42U AS=0.1449P
+ AD=0.1092P PS=1.11U PD=1.36U
* device instance $519 r0 *1 67.63,25.04 sky130_fd_pr__nfet_01v8
M$519 90 444 388 388 sky130_fd_pr__nfet_01v8 L=0.15U W=0.65U AS=0.169P
+ AD=0.11285P PS=1.82U PD=1.045U
* device instance $520 r0 *1 5.07,29.36 sky130_fd_pr__nfet_01v8
M$520 90 474 447 447 sky130_fd_pr__nfet_01v8 L=0.15U W=0.65U AS=0.169P
+ AD=0.11285P PS=1.82U PD=1.045U
* device instance $521 r0 *1 5.615,29.475 sky130_fd_pr__nfet_01v8
M$521 518 55 90 90 sky130_fd_pr__nfet_01v8 L=0.15U W=0.42U AS=0.11285P
+ AD=0.0693P PS=1.045U PD=0.75U
* device instance $522 r0 *1 6.095,29.475 sky130_fd_pr__nfet_01v8
M$522 474 462 518 518 sky130_fd_pr__nfet_01v8 L=0.15U W=0.42U AS=0.0693P
+ AD=0.09975P PS=0.75U PD=0.895U
* device instance $523 r0 *1 6.72,29.475 sky130_fd_pr__nfet_01v8
M$523 519 449 474 474 sky130_fd_pr__nfet_01v8 L=0.15U W=0.42U AS=0.09975P
+ AD=0.0693P PS=0.895U PD=0.75U
* device instance $524 r0 *1 7.2,29.475 sky130_fd_pr__nfet_01v8
M$524 90 515 519 519 sky130_fd_pr__nfet_01v8 L=0.15U W=0.42U AS=0.0693P
+ AD=0.1449P PS=0.75U PD=1.11U
* device instance $525 r0 *1 8.04,29.475 sky130_fd_pr__nfet_01v8
M$525 515 55 90 90 sky130_fd_pr__nfet_01v8 L=0.15U W=0.42U AS=0.1449P
+ AD=0.1092P PS=1.11U PD=1.36U
* device instance $526 r0 *1 9.21,29.475 sky130_fd_pr__nfet_01v8
M$526 90 31 475 475 sky130_fd_pr__nfet_01v8 L=0.15U W=0.42U AS=0.1092P
+ AD=0.0567P PS=1.36U PD=0.69U
* device instance $527 r0 *1 9.63,29.475 sky130_fd_pr__nfet_01v8
M$527 476 475 90 90 sky130_fd_pr__nfet_01v8 L=0.15U W=0.42U AS=0.0567P
+ AD=0.1092P PS=0.69U PD=1.36U
* device instance $528 r0 *1 10.57,29.475 sky130_fd_pr__nfet_01v8
M$528 522 405 478 478 sky130_fd_pr__nfet_01v8 L=0.15U W=0.42U AS=0.1092P
+ AD=0.0441P PS=1.36U PD=0.63U
* device instance $529 r0 *1 10.93,29.475 sky130_fd_pr__nfet_01v8
M$529 90 311 522 522 sky130_fd_pr__nfet_01v8 L=0.15U W=0.42U AS=0.0441P
+ AD=0.1092P PS=0.63U PD=1.36U
* device instance $530 r0 *1 11.87,29.475 sky130_fd_pr__nfet_01v8
M$530 90 311 477 477 sky130_fd_pr__nfet_01v8 L=0.15U W=0.42U AS=0.1092P
+ AD=0.0609P PS=1.36U PD=0.71U
* device instance $531 r0 *1 12.31,29.475 sky130_fd_pr__nfet_01v8
M$531 523 477 90 90 sky130_fd_pr__nfet_01v8 L=0.15U W=0.42U AS=0.0609P
+ AD=0.0756P PS=0.71U PD=0.78U
* device instance $532 r0 *1 12.82,29.475 sky130_fd_pr__nfet_01v8
M$532 478 482 523 523 sky130_fd_pr__nfet_01v8 L=0.15U W=0.42U AS=0.0756P
+ AD=0.1446P PS=0.78U PD=1.18U
* device instance $533 r0 *1 13.73,29.505 sky130_fd_pr__nfet_01v8
M$533 479 475 478 478 sky130_fd_pr__nfet_01v8 L=0.15U W=0.36U AS=0.1446P
+ AD=0.0522P PS=1.18U PD=0.65U
* device instance $534 r0 *1 14.17,29.505 sky130_fd_pr__nfet_01v8
M$534 479 476 524 524 sky130_fd_pr__nfet_01v8 L=0.15U W=0.36U AS=0.0759P
+ AD=0.0522P PS=0.8U PD=0.65U
* device instance $535 r0 *1 14.7,29.475 sky130_fd_pr__nfet_01v8
M$535 524 480 90 90 sky130_fd_pr__nfet_01v8 L=0.15U W=0.42U AS=0.12095P
+ AD=0.0759P PS=1.085U PD=0.8U
* device instance $536 r0 *1 15.295,29.365 sky130_fd_pr__nfet_01v8
M$536 480 479 90 90 sky130_fd_pr__nfet_01v8 L=0.15U W=0.64U AS=0.12095P
+ AD=0.1664P PS=1.085U PD=1.8U
* device instance $537 r0 *1 16.235,29.475 sky130_fd_pr__nfet_01v8
M$537 527 480 90 90 sky130_fd_pr__nfet_01v8 L=0.15U W=0.42U AS=0.1092P
+ AD=0.0678P PS=1.36U PD=0.755U
* device instance $538 r0 *1 16.72,29.505 sky130_fd_pr__nfet_01v8
M$538 481 476 527 527 sky130_fd_pr__nfet_01v8 L=0.15U W=0.36U AS=0.0678P
+ AD=0.0684P PS=0.755U PD=0.74U
* device instance $539 r0 *1 17.25,29.505 sky130_fd_pr__nfet_01v8
M$539 481 475 529 529 sky130_fd_pr__nfet_01v8 L=0.15U W=0.36U AS=0.066P
+ AD=0.0684P PS=0.745U PD=0.74U
* device instance $540 r0 *1 17.725,29.475 sky130_fd_pr__nfet_01v8
M$540 90 482 529 529 sky130_fd_pr__nfet_01v8 L=0.15U W=0.42U AS=0.066P
+ AD=0.1092P PS=0.745U PD=1.36U
* device instance $541 r0 *1 18.665,29.475 sky130_fd_pr__nfet_01v8
M$541 482 481 90 90 sky130_fd_pr__nfet_01v8 L=0.15U W=0.42U AS=0.10025P
+ AD=0.1092P PS=0.985U PD=1.36U
* device instance $542 r0 *1 19.15,29.36 sky130_fd_pr__nfet_01v8
M$542 449 481 90 90 sky130_fd_pr__nfet_01v8 L=0.15U W=0.65U AS=0.10025P
+ AD=0.182P PS=0.985U PD=1.86U
* device instance $543 r0 *1 26.26,30.365 sky130_fd_pr__nfet_01v8
M$543 90 433 533 533 sky130_fd_pr__nfet_01v8 L=0.15U W=0.42U AS=0.1113P
+ AD=0.0588P PS=1.37U PD=0.7U
* device instance $544 r0 *1 26.69,30.365 sky130_fd_pr__nfet_01v8
M$544 533 337 90 90 sky130_fd_pr__nfet_01v8 L=0.15U W=0.42U AS=0.0588P
+ AD=0.0588P PS=0.7U PD=0.7U
* device instance $545 r0 *1 27.12,30.365 sky130_fd_pr__nfet_01v8
M$545 543 496 533 533 sky130_fd_pr__nfet_01v8 L=0.15U W=0.42U AS=0.0588P
+ AD=0.1113P PS=0.7U PD=1.37U
* device instance $546 r0 *1 30.91,29.36 sky130_fd_pr__nfet_01v8
M$546 516 337 90 90 sky130_fd_pr__nfet_01v8 L=0.15U W=2.6U AS=0.44525P
+ AD=0.351P PS=4.62U PD=3.68U
* device instance $550 r0 *1 32.59,29.36 sky130_fd_pr__nfet_01v8
M$550 516 433 90 90 sky130_fd_pr__nfet_01v8 L=0.15U W=2.6U AS=0.351P AD=0.3575P
+ PS=3.68U PD=3.7U
* device instance $554 r0 *1 34.29,29.36 sky130_fd_pr__nfet_01v8
M$554 516 496 90 90 sky130_fd_pr__nfet_01v8 L=0.15U W=2.6U AS=0.3575P
+ AD=0.44525P PS=3.7U PD=4.62U
* device instance $558 r0 *1 31.77,30.48 sky130_fd_pr__nfet_01v8
M$558 539 544 90 90 sky130_fd_pr__nfet_01v8 L=0.15U W=0.65U AS=0.169P
+ AD=0.08775P PS=1.82U PD=0.92U
* device instance $559 r0 *1 32.19,30.48 sky130_fd_pr__nfet_01v8
M$559 437 497 539 539 sky130_fd_pr__nfet_01v8 L=0.15U W=0.65U AS=0.08775P
+ AD=0.169P PS=0.92U PD=1.82U
* device instance $560 r0 *1 35.91,30.48 sky130_fd_pr__nfet_01v8
M$560 540 261 90 90 sky130_fd_pr__nfet_01v8 L=0.15U W=0.65U AS=0.169P
+ AD=0.08775P PS=1.82U PD=0.92U
* device instance $561 r0 *1 36.33,30.48 sky130_fd_pr__nfet_01v8
M$561 436 484 540 540 sky130_fd_pr__nfet_01v8 L=0.15U W=0.65U AS=0.08775P
+ AD=0.169P PS=0.92U PD=1.82U
* device instance $562 r0 *1 36.53,29.36 sky130_fd_pr__nfet_01v8
M$562 516 497 517 517 sky130_fd_pr__nfet_01v8 L=0.15U W=2.6U AS=0.44525P
+ AD=0.351P PS=4.62U PD=3.68U
* device instance $566 r0 *1 38.21,29.36 sky130_fd_pr__nfet_01v8
M$566 276 484 517 517 sky130_fd_pr__nfet_01v8 L=0.15U W=2.6U AS=0.351P
+ AD=0.44525P PS=3.68U PD=4.62U
* device instance $570 r0 *1 38.19,30.48 sky130_fd_pr__nfet_01v8
M$570 90 165 535 535 sky130_fd_pr__nfet_01v8 L=0.15U W=0.65U AS=0.169P
+ AD=0.10725P PS=1.82U PD=0.98U
* device instance $571 r0 *1 38.67,30.48 sky130_fd_pr__nfet_01v8
M$571 541 407 90 90 sky130_fd_pr__nfet_01v8 L=0.15U W=0.65U AS=0.10725P
+ AD=0.06825P PS=0.98U PD=0.86U
* device instance $572 r0 *1 39.03,30.48 sky130_fd_pr__nfet_01v8
M$572 535 129 541 541 sky130_fd_pr__nfet_01v8 L=0.15U W=0.65U AS=0.06825P
+ AD=0.169P PS=0.86U PD=1.82U
* device instance $573 r0 *1 39.97,30.48 sky130_fd_pr__nfet_01v8
M$573 542 136 535 535 sky130_fd_pr__nfet_01v8 L=0.15U W=0.65U AS=0.169P
+ AD=0.10725P PS=1.82U PD=0.98U
* device instance $574 r0 *1 40.45,30.48 sky130_fd_pr__nfet_01v8
M$574 90 439 542 542 sky130_fd_pr__nfet_01v8 L=0.15U W=0.65U AS=0.10725P
+ AD=0.102375P PS=0.98U PD=0.965U
* device instance $575 r0 *1 40.915,30.48 sky130_fd_pr__nfet_01v8
M$575 547 535 90 90 sky130_fd_pr__nfet_01v8 L=0.15U W=0.65U AS=0.102375P
+ AD=0.169P PS=0.965U PD=1.82U
* device instance $576 r0 *1 41.895,30.365 sky130_fd_pr__nfet_01v8
M$576 484 536 90 90 sky130_fd_pr__nfet_01v8 L=0.15U W=0.42U AS=0.1197P
+ AD=0.1092P PS=1.41U PD=1.36U
* device instance $577 r0 *1 43.23,29.245 sky130_fd_pr__nfet_01v8
M$577 498 499 90 90 sky130_fd_pr__nfet_01v8 L=0.15U W=0.42U AS=0.10025P
+ AD=0.1092P PS=0.985U PD=1.36U
* device instance $578 r0 *1 42.325,29.36 sky130_fd_pr__nfet_01v8
M$578 532 498 261 261 sky130_fd_pr__nfet_01v8 L=0.15U W=0.65U AS=0.169P
+ AD=0.08775P PS=1.82U PD=0.92U
* device instance $579 r0 *1 42.745,29.36 sky130_fd_pr__nfet_01v8
M$579 90 407 532 532 sky130_fd_pr__nfet_01v8 L=0.15U W=0.65U AS=0.08775P
+ AD=0.10025P PS=0.92U PD=0.985U
* device instance $580 r0 *1 44.4,29.475 sky130_fd_pr__nfet_01v8
M$580 90 55 485 485 sky130_fd_pr__nfet_01v8 L=0.15U W=0.42U AS=0.1092P
+ AD=0.1449P PS=1.36U PD=1.11U
* device instance $581 r0 *1 45.24,29.475 sky130_fd_pr__nfet_01v8
M$581 531 485 90 90 sky130_fd_pr__nfet_01v8 L=0.15U W=0.42U AS=0.1449P
+ AD=0.0693P PS=1.11U PD=0.75U
* device instance $582 r0 *1 45.72,29.475 sky130_fd_pr__nfet_01v8
M$582 500 499 531 531 sky130_fd_pr__nfet_01v8 L=0.15U W=0.42U AS=0.0693P
+ AD=0.09975P PS=0.75U PD=0.895U
* device instance $583 r0 *1 46.345,29.475 sky130_fd_pr__nfet_01v8
M$583 530 486 500 500 sky130_fd_pr__nfet_01v8 L=0.15U W=0.42U AS=0.09975P
+ AD=0.0693P PS=0.895U PD=0.75U
* device instance $584 r0 *1 46.825,29.475 sky130_fd_pr__nfet_01v8
M$584 530 55 90 90 sky130_fd_pr__nfet_01v8 L=0.15U W=0.42U AS=0.11285P
+ AD=0.0693P PS=1.045U PD=0.75U
* device instance $585 r0 *1 47.37,29.36 sky130_fd_pr__nfet_01v8
M$585 404 500 90 90 sky130_fd_pr__nfet_01v8 L=0.15U W=0.65U AS=0.11285P
+ AD=0.169P PS=1.045U PD=1.82U
* device instance $586 r0 *1 44.865,30.365 sky130_fd_pr__nfet_01v8
M$586 90 499 537 537 sky130_fd_pr__nfet_01v8 L=0.15U W=0.42U AS=0.1092P
+ AD=0.10025P PS=1.36U PD=0.985U
* device instance $587 r0 *1 45.35,30.48 sky130_fd_pr__nfet_01v8
M$587 536 407 90 90 sky130_fd_pr__nfet_01v8 L=0.15U W=0.65U AS=0.10025P
+ AD=0.08775P PS=0.985U PD=0.92U
* device instance $588 r0 *1 45.77,30.48 sky130_fd_pr__nfet_01v8
M$588 90 537 536 536 sky130_fd_pr__nfet_01v8 L=0.15U W=0.65U AS=0.08775P
+ AD=0.349375P PS=0.92U PD=1.725U
* device instance $589 r0 *1 46.995,30.48 sky130_fd_pr__nfet_01v8
M$589 538 987 90 90 sky130_fd_pr__nfet_01v8 L=0.15U W=1.3U AS=0.437125P
+ AD=0.1755P PS=2.645U PD=1.84U
* device instance $591 r0 *1 47.835,30.48 sky130_fd_pr__nfet_01v8
M$591 136 538 90 90 sky130_fd_pr__nfet_01v8 L=0.15U W=3.9U AS=0.5265P
+ AD=0.60775P PS=5.52U PD=6.42U
* device instance $597 r0 *1 60.73,29.475 sky130_fd_pr__nfet_01v8
M$597 90 329 487 487 sky130_fd_pr__nfet_01v8 L=0.15U W=0.42U AS=0.1092P
+ AD=0.0567P PS=1.36U PD=0.69U
* device instance $598 r0 *1 61.15,29.475 sky130_fd_pr__nfet_01v8
M$598 488 487 90 90 sky130_fd_pr__nfet_01v8 L=0.15U W=0.42U AS=0.0567P
+ AD=0.1092P PS=0.69U PD=1.36U
* device instance $599 r0 *1 62.09,29.475 sky130_fd_pr__nfet_01v8
M$599 528 408 490 490 sky130_fd_pr__nfet_01v8 L=0.15U W=0.42U AS=0.1092P
+ AD=0.0441P PS=1.36U PD=0.63U
* device instance $600 r0 *1 62.45,29.475 sky130_fd_pr__nfet_01v8
M$600 90 311 528 528 sky130_fd_pr__nfet_01v8 L=0.15U W=0.42U AS=0.0441P
+ AD=0.1092P PS=0.63U PD=1.36U
* device instance $601 r0 *1 63.39,29.475 sky130_fd_pr__nfet_01v8
M$601 90 311 489 489 sky130_fd_pr__nfet_01v8 L=0.15U W=0.42U AS=0.1092P
+ AD=0.0609P PS=1.36U PD=0.71U
* device instance $602 r0 *1 63.83,29.475 sky130_fd_pr__nfet_01v8
M$602 526 489 90 90 sky130_fd_pr__nfet_01v8 L=0.15U W=0.42U AS=0.0609P
+ AD=0.0756P PS=0.71U PD=0.78U
* device instance $603 r0 *1 64.34,29.475 sky130_fd_pr__nfet_01v8
M$603 490 494 526 526 sky130_fd_pr__nfet_01v8 L=0.15U W=0.42U AS=0.0756P
+ AD=0.1446P PS=0.78U PD=1.18U
* device instance $604 r0 *1 65.25,29.505 sky130_fd_pr__nfet_01v8
M$604 491 487 490 490 sky130_fd_pr__nfet_01v8 L=0.15U W=0.36U AS=0.1446P
+ AD=0.0522P PS=1.18U PD=0.65U
* device instance $605 r0 *1 65.69,29.505 sky130_fd_pr__nfet_01v8
M$605 491 488 525 525 sky130_fd_pr__nfet_01v8 L=0.15U W=0.36U AS=0.0759P
+ AD=0.0522P PS=0.8U PD=0.65U
* device instance $606 r0 *1 66.22,29.475 sky130_fd_pr__nfet_01v8
M$606 525 492 90 90 sky130_fd_pr__nfet_01v8 L=0.15U W=0.42U AS=0.12095P
+ AD=0.0759P PS=1.085U PD=0.8U
* device instance $607 r0 *1 66.815,29.365 sky130_fd_pr__nfet_01v8
M$607 492 491 90 90 sky130_fd_pr__nfet_01v8 L=0.15U W=0.64U AS=0.12095P
+ AD=0.1664P PS=1.085U PD=1.8U
* device instance $608 r0 *1 67.755,29.475 sky130_fd_pr__nfet_01v8
M$608 521 492 90 90 sky130_fd_pr__nfet_01v8 L=0.15U W=0.42U AS=0.1092P
+ AD=0.0678P PS=1.36U PD=0.755U
* device instance $609 r0 *1 68.24,29.505 sky130_fd_pr__nfet_01v8
M$609 493 488 521 521 sky130_fd_pr__nfet_01v8 L=0.15U W=0.36U AS=0.0678P
+ AD=0.0684P PS=0.755U PD=0.74U
* device instance $610 r0 *1 68.77,29.505 sky130_fd_pr__nfet_01v8
M$610 493 487 520 520 sky130_fd_pr__nfet_01v8 L=0.15U W=0.36U AS=0.066P
+ AD=0.0684P PS=0.745U PD=0.74U
* device instance $611 r0 *1 69.245,29.475 sky130_fd_pr__nfet_01v8
M$611 90 494 520 520 sky130_fd_pr__nfet_01v8 L=0.15U W=0.42U AS=0.066P
+ AD=0.1092P PS=0.745U PD=1.36U
* device instance $612 r0 *1 70.185,29.475 sky130_fd_pr__nfet_01v8
M$612 494 493 90 90 sky130_fd_pr__nfet_01v8 L=0.15U W=0.42U AS=0.10025P
+ AD=0.1092P PS=0.985U PD=1.36U
* device instance $613 r0 *1 70.67,29.36 sky130_fd_pr__nfet_01v8
M$613 341 493 90 90 sky130_fd_pr__nfet_01v8 L=0.15U W=0.65U AS=0.10025P
+ AD=0.182P PS=0.985U PD=1.86U
* device instance $614 r0 *1 13.765,34.915 sky130_fd_pr__nfet_01v8
M$614 90 574 576 576 sky130_fd_pr__nfet_01v8 L=0.15U W=0.42U AS=0.1092P
+ AD=0.1197P PS=1.36U PD=1.41U
* device instance $615 r0 *1 27.2,34.8 sky130_fd_pr__nfet_01v8
M$615 561 556 90 90 sky130_fd_pr__nfet_01v8 L=0.15U W=2.6U AS=0.45825P
+ AD=0.411125P PS=4.66U PD=3.865U
* device instance $619 r0 *1 29.065,34.8 sky130_fd_pr__nfet_01v8
M$619 580 543 90 90 sky130_fd_pr__nfet_01v8 L=0.15U W=0.65U AS=0.138125P
+ AD=0.06825P PS=1.075U PD=0.86U
* device instance $620 r0 *1 29.425,34.8 sky130_fd_pr__nfet_01v8
M$620 556 544 580 580 sky130_fd_pr__nfet_01v8 L=0.15U W=0.65U AS=0.06825P
+ AD=0.17225P PS=0.86U PD=1.83U
* device instance $621 r0 *1 28.08,30.395 sky130_fd_pr__nfet_01v8
M$621 90 337 534 534 sky130_fd_pr__nfet_01v8 L=0.15U W=0.42U AS=0.1092P
+ AD=0.0567P PS=1.36U PD=0.69U
* device instance $622 r0 *1 28.5,30.395 sky130_fd_pr__nfet_01v8
M$622 534 433 90 90 sky130_fd_pr__nfet_01v8 L=0.15U W=0.42U AS=0.0567P
+ AD=0.0567P PS=0.69U PD=0.69U
* device instance $623 r0 *1 28.92,30.395 sky130_fd_pr__nfet_01v8
M$623 534 496 90 90 sky130_fd_pr__nfet_01v8 L=0.15U W=0.42U AS=0.101875P
+ AD=0.0567P PS=0.99U PD=0.69U
* device instance $624 r0 *1 29.41,30.48 sky130_fd_pr__nfet_01v8
M$624 544 534 90 90 sky130_fd_pr__nfet_01v8 L=0.15U W=0.65U AS=0.101875P
+ AD=0.182P PS=0.99U PD=1.86U
* device instance $625 r0 *1 40.49,34.915 sky130_fd_pr__nfet_01v8
M$625 90 329 562 562 sky130_fd_pr__nfet_01v8 L=0.15U W=0.42U AS=0.1092P
+ AD=0.0567P PS=1.36U PD=0.69U
* device instance $626 r0 *1 40.91,34.915 sky130_fd_pr__nfet_01v8
M$626 563 562 90 90 sky130_fd_pr__nfet_01v8 L=0.15U W=0.42U AS=0.0567P
+ AD=0.1092P PS=0.69U PD=1.36U
* device instance $627 r0 *1 41.85,34.915 sky130_fd_pr__nfet_01v8
M$627 583 547 557 557 sky130_fd_pr__nfet_01v8 L=0.15U W=0.42U AS=0.1092P
+ AD=0.0441P PS=1.36U PD=0.63U
* device instance $628 r0 *1 42.21,34.915 sky130_fd_pr__nfet_01v8
M$628 90 311 583 583 sky130_fd_pr__nfet_01v8 L=0.15U W=0.42U AS=0.0441P
+ AD=0.1092P PS=0.63U PD=1.36U
* device instance $629 r0 *1 43.15,34.915 sky130_fd_pr__nfet_01v8
M$629 90 311 550 550 sky130_fd_pr__nfet_01v8 L=0.15U W=0.42U AS=0.1092P
+ AD=0.0609P PS=1.36U PD=0.71U
* device instance $630 r0 *1 43.59,34.915 sky130_fd_pr__nfet_01v8
M$630 585 550 90 90 sky130_fd_pr__nfet_01v8 L=0.15U W=0.42U AS=0.0609P
+ AD=0.0756P PS=0.71U PD=0.78U
* device instance $631 r0 *1 44.1,34.915 sky130_fd_pr__nfet_01v8
M$631 557 552 585 585 sky130_fd_pr__nfet_01v8 L=0.15U W=0.42U AS=0.0756P
+ AD=0.1446P PS=0.78U PD=1.18U
* device instance $632 r0 *1 45.01,34.945 sky130_fd_pr__nfet_01v8
M$632 564 562 557 557 sky130_fd_pr__nfet_01v8 L=0.15U W=0.36U AS=0.1446P
+ AD=0.0522P PS=1.18U PD=0.65U
* device instance $633 r0 *1 45.45,34.945 sky130_fd_pr__nfet_01v8
M$633 564 563 584 584 sky130_fd_pr__nfet_01v8 L=0.15U W=0.36U AS=0.0759P
+ AD=0.0522P PS=0.8U PD=0.65U
* device instance $634 r0 *1 45.98,34.915 sky130_fd_pr__nfet_01v8
M$634 584 551 90 90 sky130_fd_pr__nfet_01v8 L=0.15U W=0.42U AS=0.12095P
+ AD=0.0759P PS=1.085U PD=0.8U
* device instance $635 r0 *1 46.575,34.805 sky130_fd_pr__nfet_01v8
M$635 551 564 90 90 sky130_fd_pr__nfet_01v8 L=0.15U W=0.64U AS=0.12095P
+ AD=0.1664P PS=1.085U PD=1.8U
* device instance $636 r0 *1 47.515,34.915 sky130_fd_pr__nfet_01v8
M$636 582 551 90 90 sky130_fd_pr__nfet_01v8 L=0.15U W=0.42U AS=0.1092P
+ AD=0.0678P PS=1.36U PD=0.755U
* device instance $637 r0 *1 48,34.945 sky130_fd_pr__nfet_01v8
M$637 565 563 582 582 sky130_fd_pr__nfet_01v8 L=0.15U W=0.36U AS=0.0678P
+ AD=0.0684P PS=0.755U PD=0.74U
* device instance $638 r0 *1 48.53,34.945 sky130_fd_pr__nfet_01v8
M$638 565 562 581 581 sky130_fd_pr__nfet_01v8 L=0.15U W=0.36U AS=0.066P
+ AD=0.0684P PS=0.745U PD=0.74U
* device instance $639 r0 *1 49.005,34.915 sky130_fd_pr__nfet_01v8
M$639 90 552 581 581 sky130_fd_pr__nfet_01v8 L=0.15U W=0.42U AS=0.066P
+ AD=0.1092P PS=0.745U PD=1.36U
* device instance $640 r0 *1 49.945,34.915 sky130_fd_pr__nfet_01v8
M$640 552 565 90 90 sky130_fd_pr__nfet_01v8 L=0.15U W=0.42U AS=0.10025P
+ AD=0.1092P PS=0.985U PD=1.36U
* device instance $641 r0 *1 50.43,34.8 sky130_fd_pr__nfet_01v8
M$641 499 565 90 90 sky130_fd_pr__nfet_01v8 L=0.15U W=0.65U AS=0.10025P
+ AD=0.182P PS=0.985U PD=1.86U
* device instance $642 r0 *1 59.95,34.8 sky130_fd_pr__nfet_01v8
M$642 566 558 90 90 sky130_fd_pr__nfet_01v8 L=0.15U W=2.6U AS=0.43225P
+ AD=0.351P PS=4.58U PD=3.68U
* device instance $646 r0 *1 61.63,34.8 sky130_fd_pr__nfet_01v8
M$646 558 306 90 90 sky130_fd_pr__nfet_01v8 L=0.15U W=0.65U AS=0.08775P
+ AD=0.169P PS=0.92U PD=1.82U
* device instance $647 r0 *1 62.57,34.8 sky130_fd_pr__nfet_01v8
M$647 90 575 567 567 sky130_fd_pr__nfet_01v8 L=0.15U W=0.65U AS=0.169P
+ AD=0.10725P PS=1.82U PD=0.98U
* device instance $648 r0 *1 63.05,34.8 sky130_fd_pr__nfet_01v8
M$648 579 553 90 90 sky130_fd_pr__nfet_01v8 L=0.15U W=0.65U AS=0.10725P
+ AD=0.06825P PS=0.98U PD=0.86U
* device instance $649 r0 *1 63.41,34.8 sky130_fd_pr__nfet_01v8
M$649 567 129 579 579 sky130_fd_pr__nfet_01v8 L=0.15U W=0.65U AS=0.06825P
+ AD=0.169P PS=0.86U PD=1.82U
* device instance $650 r0 *1 64.35,34.8 sky130_fd_pr__nfet_01v8
M$650 578 130 567 567 sky130_fd_pr__nfet_01v8 L=0.15U W=0.65U AS=0.169P
+ AD=0.10725P PS=1.82U PD=0.98U
* device instance $651 r0 *1 64.83,34.8 sky130_fd_pr__nfet_01v8
M$651 90 560 578 578 sky130_fd_pr__nfet_01v8 L=0.15U W=0.65U AS=0.10725P
+ AD=0.102375P PS=0.98U PD=0.965U
* device instance $652 r0 *1 65.295,34.8 sky130_fd_pr__nfet_01v8
M$652 577 567 90 90 sky130_fd_pr__nfet_01v8 L=0.15U W=0.65U AS=0.102375P
+ AD=0.169P PS=0.965U PD=1.82U
* device instance $653 r0 *1 8.75,35.92 sky130_fd_pr__nfet_01v8
M$653 90 605 586 586 sky130_fd_pr__nfet_01v8 L=0.15U W=0.65U AS=0.169P
+ AD=0.10725P PS=1.82U PD=0.98U
* device instance $654 r0 *1 9.23,35.92 sky130_fd_pr__nfet_01v8
M$654 609 606 90 90 sky130_fd_pr__nfet_01v8 L=0.15U W=0.65U AS=0.10725P
+ AD=0.06825P PS=0.98U PD=0.86U
* device instance $655 r0 *1 9.59,35.92 sky130_fd_pr__nfet_01v8
M$655 586 129 609 609 sky130_fd_pr__nfet_01v8 L=0.15U W=0.65U AS=0.06825P
+ AD=0.169P PS=0.86U PD=1.82U
* device instance $656 r0 *1 10.53,35.92 sky130_fd_pr__nfet_01v8
M$656 611 130 586 586 sky130_fd_pr__nfet_01v8 L=0.15U W=0.65U AS=0.169P
+ AD=0.10725P PS=1.82U PD=0.98U
* device instance $657 r0 *1 11.01,35.92 sky130_fd_pr__nfet_01v8
M$657 90 638 611 611 sky130_fd_pr__nfet_01v8 L=0.15U W=0.65U AS=0.10725P
+ AD=0.102375P PS=0.98U PD=0.965U
* device instance $658 r0 *1 11.475,35.92 sky130_fd_pr__nfet_01v8
M$658 587 586 90 90 sky130_fd_pr__nfet_01v8 L=0.15U W=0.65U AS=0.102375P
+ AD=0.169P PS=0.965U PD=1.82U
* device instance $659 r0 *1 12.53,35.805 sky130_fd_pr__nfet_01v8
M$659 601 576 588 588 sky130_fd_pr__nfet_01v8 L=0.15U W=0.42U AS=0.1092P
+ AD=0.0441P PS=1.36U PD=0.63U
* device instance $660 r0 *1 12.89,35.805 sky130_fd_pr__nfet_01v8
M$660 90 589 601 601 sky130_fd_pr__nfet_01v8 L=0.15U W=0.42U AS=0.0441P
+ AD=0.0567P PS=0.63U PD=0.69U
* device instance $661 r0 *1 13.31,35.805 sky130_fd_pr__nfet_01v8
M$661 602 589 90 90 sky130_fd_pr__nfet_01v8 L=0.15U W=0.42U AS=0.0567P
+ AD=0.0441P PS=0.69U PD=0.63U
* device instance $662 r0 *1 13.67,35.805 sky130_fd_pr__nfet_01v8
M$662 588 590 602 602 sky130_fd_pr__nfet_01v8 L=0.15U W=0.42U AS=0.0441P
+ AD=0.0567P PS=0.63U PD=0.69U
* device instance $663 r0 *1 14.09,35.805 sky130_fd_pr__nfet_01v8
M$663 603 590 588 588 sky130_fd_pr__nfet_01v8 L=0.15U W=0.42U AS=0.0567P
+ AD=0.0441P PS=0.69U PD=0.63U
* device instance $664 r0 *1 14.45,35.805 sky130_fd_pr__nfet_01v8
M$664 90 576 603 603 sky130_fd_pr__nfet_01v8 L=0.15U W=0.42U AS=0.0441P
+ AD=0.162225P PS=0.63U PD=1.25U
* device instance $665 r0 *1 15.2,35.92 sky130_fd_pr__nfet_01v8
M$665 335 588 90 90 sky130_fd_pr__nfet_01v8 L=0.15U W=1.3U AS=0.249975P
+ AD=0.26325P PS=2.17U PD=2.76U
* device instance $667 r0 *1 31.315,35.805 sky130_fd_pr__nfet_01v8
M$667 496 591 90 90 sky130_fd_pr__nfet_01v8 L=0.15U W=0.42U AS=0.1197P
+ AD=0.1092P PS=1.41U PD=1.36U
* device instance $668 r0 *1 34.505,35.92 sky130_fd_pr__nfet_01v8
M$668 613 607 497 497 sky130_fd_pr__nfet_01v8 L=0.15U W=0.65U AS=0.169P
+ AD=0.08775P PS=1.82U PD=0.92U
* device instance $669 r0 *1 34.925,35.92 sky130_fd_pr__nfet_01v8
M$669 90 592 613 613 sky130_fd_pr__nfet_01v8 L=0.15U W=0.65U AS=0.08775P
+ AD=0.10025P PS=0.92U PD=0.985U
* device instance $670 r0 *1 35.41,36.035 sky130_fd_pr__nfet_01v8
M$670 607 593 90 90 sky130_fd_pr__nfet_01v8 L=0.15U W=0.42U AS=0.10025P
+ AD=0.1092P PS=0.985U PD=1.36U
* device instance $671 r0 *1 59.67,35.805 sky130_fd_pr__nfet_01v8
M$671 90 594 575 575 sky130_fd_pr__nfet_01v8 L=0.15U W=0.42U AS=0.1113P
+ AD=0.0966P PS=1.37U PD=0.88U
* device instance $672 r0 *1 60.28,35.805 sky130_fd_pr__nfet_01v8
M$672 604 108 90 90 sky130_fd_pr__nfet_01v8 L=0.15U W=0.42U AS=0.0966P
+ AD=0.0441P PS=0.88U PD=0.63U
* device instance $673 r0 *1 60.64,35.805 sky130_fd_pr__nfet_01v8
M$673 594 595 604 604 sky130_fd_pr__nfet_01v8 L=0.15U W=0.42U AS=0.0441P
+ AD=0.1113P PS=0.63U PD=1.37U
* device instance $674 r0 *1 61.67,35.92 sky130_fd_pr__nfet_01v8
M$674 612 566 90 90 sky130_fd_pr__nfet_01v8 L=0.15U W=0.65U AS=0.169P
+ AD=0.08775P PS=1.82U PD=0.92U
* device instance $675 r0 *1 62.09,35.92 sky130_fd_pr__nfet_01v8
M$675 596 339 612 612 sky130_fd_pr__nfet_01v8 L=0.15U W=0.65U AS=0.08775P
+ AD=0.169P PS=0.92U PD=1.82U
* device instance $676 r0 *1 63.13,35.92 sky130_fd_pr__nfet_01v8
M$676 610 596 597 597 sky130_fd_pr__nfet_01v8 L=0.15U W=0.65U AS=0.169P
+ AD=0.06825P PS=1.82U PD=0.86U
* device instance $677 r0 *1 63.49,35.92 sky130_fd_pr__nfet_01v8
M$677 90 598 610 610 sky130_fd_pr__nfet_01v8 L=0.15U W=0.65U AS=0.06825P
+ AD=0.08775P PS=0.86U PD=0.92U
* device instance $678 r0 *1 63.91,35.92 sky130_fd_pr__nfet_01v8
M$678 599 598 90 90 sky130_fd_pr__nfet_01v8 L=0.15U W=0.65U AS=0.08775P
+ AD=0.169P PS=0.92U PD=1.82U
* device instance $679 r0 *1 64.85,35.92 sky130_fd_pr__nfet_01v8
M$679 599 596 90 90 sky130_fd_pr__nfet_01v8 L=0.15U W=0.65U AS=0.169P
+ AD=0.08775P PS=1.82U PD=0.92U
* device instance $680 r0 *1 65.27,35.92 sky130_fd_pr__nfet_01v8
M$680 560 597 599 599 sky130_fd_pr__nfet_01v8 L=0.15U W=0.65U AS=0.08775P
+ AD=0.195P PS=0.92U PD=1.9U
* device instance $681 r0 *1 67.375,35.805 sky130_fd_pr__nfet_01v8
M$681 608 645 90 90 sky130_fd_pr__nfet_01v8 L=0.15U W=0.42U AS=0.10025P
+ AD=0.1092P PS=0.985U PD=1.36U
* device instance $682 r0 *1 66.47,35.92 sky130_fd_pr__nfet_01v8
M$682 600 608 90 90 sky130_fd_pr__nfet_01v8 L=0.15U W=0.65U AS=0.169P
+ AD=0.08775P PS=1.82U PD=0.92U
* device instance $683 r0 *1 66.89,35.92 sky130_fd_pr__nfet_01v8
M$683 90 553 600 600 sky130_fd_pr__nfet_01v8 L=0.15U W=0.65U AS=0.08775P
+ AD=0.10025P PS=0.92U PD=0.985U
* device instance $684 r0 *1 6.91,40.24 sky130_fd_pr__nfet_01v8
M$684 90 624 623 623 sky130_fd_pr__nfet_01v8 L=0.15U W=0.65U AS=0.169P
+ AD=0.11285P PS=1.82U PD=1.045U
* device instance $685 r0 *1 7.455,40.355 sky130_fd_pr__nfet_01v8
M$685 666 55 90 90 sky130_fd_pr__nfet_01v8 L=0.15U W=0.42U AS=0.11285P
+ AD=0.0693P PS=1.045U PD=0.75U
* device instance $686 r0 *1 7.935,40.355 sky130_fd_pr__nfet_01v8
M$686 624 621 666 666 sky130_fd_pr__nfet_01v8 L=0.15U W=0.42U AS=0.0693P
+ AD=0.09975P PS=0.75U PD=0.895U
* device instance $687 r0 *1 8.56,40.355 sky130_fd_pr__nfet_01v8
M$687 667 590 624 624 sky130_fd_pr__nfet_01v8 L=0.15U W=0.42U AS=0.09975P
+ AD=0.0693P PS=0.895U PD=0.75U
* device instance $688 r0 *1 9.04,40.355 sky130_fd_pr__nfet_01v8
M$688 90 656 667 667 sky130_fd_pr__nfet_01v8 L=0.15U W=0.42U AS=0.0693P
+ AD=0.1449P PS=0.75U PD=1.11U
* device instance $689 r0 *1 9.88,40.355 sky130_fd_pr__nfet_01v8
M$689 656 55 90 90 sky130_fd_pr__nfet_01v8 L=0.15U W=0.42U AS=0.1449P
+ AD=0.1092P PS=1.11U PD=1.36U
* device instance $690 r0 *1 11.09,40.24 sky130_fd_pr__nfet_01v8
M$690 661 639 638 638 sky130_fd_pr__nfet_01v8 L=0.15U W=0.65U AS=0.195P
+ AD=0.08775P PS=1.9U PD=0.92U
* device instance $691 r0 *1 11.51,40.24 sky130_fd_pr__nfet_01v8
M$691 90 640 661 661 sky130_fd_pr__nfet_01v8 L=0.15U W=0.65U AS=0.08775P
+ AD=0.169P PS=0.92U PD=1.82U
* device instance $692 r0 *1 12.45,40.24 sky130_fd_pr__nfet_01v8
M$692 90 625 661 661 sky130_fd_pr__nfet_01v8 L=0.15U W=0.65U AS=0.169P
+ AD=0.08775P PS=1.82U PD=0.92U
* device instance $693 r0 *1 12.87,40.24 sky130_fd_pr__nfet_01v8
M$693 669 625 90 90 sky130_fd_pr__nfet_01v8 L=0.15U W=0.65U AS=0.08775P
+ AD=0.06825P PS=0.92U PD=0.86U
* device instance $694 r0 *1 13.23,40.24 sky130_fd_pr__nfet_01v8
M$694 639 640 669 669 sky130_fd_pr__nfet_01v8 L=0.15U W=0.65U AS=0.06825P
+ AD=0.169P PS=0.86U PD=1.82U
* device instance $695 r0 *1 14.33,40.24 sky130_fd_pr__nfet_01v8
M$695 640 626 90 90 sky130_fd_pr__nfet_01v8 L=0.15U W=0.65U AS=0.208P
+ AD=0.25025P PS=1.94U PD=1.42U
* device instance $696 r0 *1 15.25,40.24 sky130_fd_pr__nfet_01v8
M$696 671 590 640 640 sky130_fd_pr__nfet_01v8 L=0.15U W=0.65U AS=0.25025P
+ AD=0.08775P PS=1.42U PD=0.92U
* device instance $697 r0 *1 15.67,40.24 sky130_fd_pr__nfet_01v8
M$697 90 606 671 671 sky130_fd_pr__nfet_01v8 L=0.15U W=0.65U AS=0.08775P
+ AD=0.08775P PS=0.92U PD=0.92U
* device instance $698 r0 *1 16.09,40.24 sky130_fd_pr__nfet_01v8
M$698 626 606 90 90 sky130_fd_pr__nfet_01v8 L=0.15U W=0.65U AS=0.08775P
+ AD=0.08775P PS=0.92U PD=0.92U
* device instance $699 r0 *1 16.51,40.24 sky130_fd_pr__nfet_01v8
M$699 90 590 626 626 sky130_fd_pr__nfet_01v8 L=0.15U W=0.65U AS=0.08775P
+ AD=0.169P PS=0.92U PD=1.82U
* device instance $700 r0 *1 25.77,40.24 sky130_fd_pr__nfet_01v8
M$700 90 657 628 628 sky130_fd_pr__nfet_01v8 L=0.15U W=0.65U AS=0.169P
+ AD=0.10725P PS=1.82U PD=0.98U
* device instance $701 r0 *1 26.25,40.24 sky130_fd_pr__nfet_01v8
M$701 675 593 90 90 sky130_fd_pr__nfet_01v8 L=0.15U W=0.65U AS=0.10725P
+ AD=0.06825P PS=0.98U PD=0.86U
* device instance $702 r0 *1 26.61,40.24 sky130_fd_pr__nfet_01v8
M$702 628 129 675 675 sky130_fd_pr__nfet_01v8 L=0.15U W=0.65U AS=0.06825P
+ AD=0.169P PS=0.86U PD=1.82U
* device instance $703 r0 *1 27.55,40.24 sky130_fd_pr__nfet_01v8
M$703 676 136 628 628 sky130_fd_pr__nfet_01v8 L=0.15U W=0.65U AS=0.169P
+ AD=0.10725P PS=1.82U PD=0.98U
* device instance $704 r0 *1 28.03,40.24 sky130_fd_pr__nfet_01v8
M$704 90 561 676 676 sky130_fd_pr__nfet_01v8 L=0.15U W=0.65U AS=0.10725P
+ AD=0.102375P PS=0.98U PD=0.965U
* device instance $705 r0 *1 28.495,40.24 sky130_fd_pr__nfet_01v8
M$705 642 628 90 90 sky130_fd_pr__nfet_01v8 L=0.15U W=0.65U AS=0.102375P
+ AD=0.169P PS=0.965U PD=1.82U
* device instance $706 r0 *1 30.93,40.24 sky130_fd_pr__nfet_01v8
M$706 677 592 630 630 sky130_fd_pr__nfet_01v8 L=0.15U W=0.65U AS=0.169P
+ AD=0.06825P PS=1.82U PD=0.86U
* device instance $707 r0 *1 31.29,40.24 sky130_fd_pr__nfet_01v8
M$707 90 593 677 677 sky130_fd_pr__nfet_01v8 L=0.15U W=0.65U AS=0.06825P
+ AD=0.08775P PS=0.86U PD=0.92U
* device instance $708 r0 *1 31.71,40.24 sky130_fd_pr__nfet_01v8
M$708 658 593 90 90 sky130_fd_pr__nfet_01v8 L=0.15U W=0.65U AS=0.08775P
+ AD=0.169P PS=0.92U PD=1.82U
* device instance $709 r0 *1 32.65,40.24 sky130_fd_pr__nfet_01v8
M$709 658 592 90 90 sky130_fd_pr__nfet_01v8 L=0.15U W=0.65U AS=0.169P
+ AD=0.08775P PS=1.82U PD=0.92U
* device instance $710 r0 *1 33.07,40.24 sky130_fd_pr__nfet_01v8
M$710 591 630 658 658 sky130_fd_pr__nfet_01v8 L=0.15U W=0.65U AS=0.08775P
+ AD=0.195P PS=0.92U PD=1.9U
* device instance $711 r0 *1 55.67,40.24 sky130_fd_pr__nfet_01v8
M$711 673 566 90 90 sky130_fd_pr__nfet_01v8 L=0.15U W=0.65U AS=0.169P
+ AD=0.06825P PS=1.82U PD=0.86U
* device instance $712 r0 *1 56.03,40.24 sky130_fd_pr__nfet_01v8
M$712 674 339 673 673 sky130_fd_pr__nfet_01v8 L=0.15U W=0.65U AS=0.06825P
+ AD=0.118625P PS=0.86U PD=1.015U
* device instance $713 r0 *1 56.545,40.24 sky130_fd_pr__nfet_01v8
M$713 633 598 674 674 sky130_fd_pr__nfet_01v8 L=0.15U W=0.65U AS=0.118625P
+ AD=0.105625P PS=1.015U PD=0.975U
* device instance $714 r0 *1 57.02,40.24 sky130_fd_pr__nfet_01v8
M$714 90 600 633 633 sky130_fd_pr__nfet_01v8 L=0.15U W=0.65U AS=0.105625P
+ AD=0.1755P PS=0.975U PD=1.84U
* device instance $715 r0 *1 59.775,40.24 sky130_fd_pr__nfet_01v8
M$715 90 776 643 643 sky130_fd_pr__nfet_01v8 L=0.15U W=0.65U AS=0.169P
+ AD=0.112125P PS=1.82U PD=0.995U
* device instance $716 r0 *1 60.27,40.24 sky130_fd_pr__nfet_01v8
M$716 643 600 90 90 sky130_fd_pr__nfet_01v8 L=0.15U W=0.65U AS=0.112125P
+ AD=0.115375P PS=0.995U PD=1.005U
* device instance $717 r0 *1 60.775,40.24 sky130_fd_pr__nfet_01v8
M$717 672 598 643 643 sky130_fd_pr__nfet_01v8 L=0.15U W=0.65U AS=0.115375P
+ AD=0.091P PS=1.005U PD=0.93U
* device instance $718 r0 *1 61.205,40.24 sky130_fd_pr__nfet_01v8
M$718 670 306 672 672 sky130_fd_pr__nfet_01v8 L=0.15U W=0.65U AS=0.091P
+ AD=0.089375P PS=0.93U PD=0.925U
* device instance $719 r0 *1 61.63,40.24 sky130_fd_pr__nfet_01v8
M$719 90 339 670 670 sky130_fd_pr__nfet_01v8 L=0.15U W=0.65U AS=0.089375P
+ AD=0.169P PS=0.925U PD=1.82U
* device instance $720 r0 *1 64.45,40.24 sky130_fd_pr__nfet_01v8
M$720 662 644 598 598 sky130_fd_pr__nfet_01v8 L=0.15U W=0.65U AS=0.195P
+ AD=0.08775P PS=1.9U PD=0.92U
* device instance $721 r0 *1 64.87,40.24 sky130_fd_pr__nfet_01v8
M$721 90 645 662 662 sky130_fd_pr__nfet_01v8 L=0.15U W=0.65U AS=0.08775P
+ AD=0.169P PS=0.92U PD=1.82U
* device instance $722 r0 *1 65.81,40.24 sky130_fd_pr__nfet_01v8
M$722 90 553 662 662 sky130_fd_pr__nfet_01v8 L=0.15U W=0.65U AS=0.169P
+ AD=0.08775P PS=1.82U PD=0.92U
* device instance $723 r0 *1 66.23,40.24 sky130_fd_pr__nfet_01v8
M$723 668 553 90 90 sky130_fd_pr__nfet_01v8 L=0.15U W=0.65U AS=0.08775P
+ AD=0.06825P PS=0.92U PD=0.86U
* device instance $724 r0 *1 66.59,40.24 sky130_fd_pr__nfet_01v8
M$724 644 645 668 668 sky130_fd_pr__nfet_01v8 L=0.15U W=0.65U AS=0.06825P
+ AD=0.169P PS=0.86U PD=1.82U
* device instance $725 r0 *1 68.09,40.24 sky130_fd_pr__nfet_01v8
M$725 90 636 635 635 sky130_fd_pr__nfet_01v8 L=0.15U W=0.65U AS=0.169P
+ AD=0.11285P PS=1.82U PD=1.045U
* device instance $726 r0 *1 68.635,40.355 sky130_fd_pr__nfet_01v8
M$726 665 55 90 90 sky130_fd_pr__nfet_01v8 L=0.15U W=0.42U AS=0.11285P
+ AD=0.0693P PS=1.045U PD=0.75U
* device instance $727 r0 *1 69.115,40.355 sky130_fd_pr__nfet_01v8
M$727 636 646 665 665 sky130_fd_pr__nfet_01v8 L=0.15U W=0.42U AS=0.0693P
+ AD=0.09975P PS=0.75U PD=0.895U
* device instance $728 r0 *1 69.74,40.355 sky130_fd_pr__nfet_01v8
M$728 664 645 636 636 sky130_fd_pr__nfet_01v8 L=0.15U W=0.42U AS=0.09975P
+ AD=0.0693P PS=0.895U PD=0.75U
* device instance $729 r0 *1 70.22,40.355 sky130_fd_pr__nfet_01v8
M$729 90 660 664 664 sky130_fd_pr__nfet_01v8 L=0.15U W=0.42U AS=0.0693P
+ AD=0.1449P PS=0.75U PD=1.11U
* device instance $730 r0 *1 71.06,40.355 sky130_fd_pr__nfet_01v8
M$730 660 55 90 90 sky130_fd_pr__nfet_01v8 L=0.15U W=0.42U AS=0.1449P
+ AD=0.1092P PS=1.11U PD=1.36U
* device instance $731 r0 *1 2.77,41.245 sky130_fd_pr__nfet_01v8
M$731 90 939 678 678 sky130_fd_pr__nfet_01v8 L=0.15U W=0.42U AS=0.1092P
+ AD=0.0567P PS=1.36U PD=0.69U
* device instance $732 r0 *1 3.19,41.245 sky130_fd_pr__nfet_01v8
M$732 679 678 90 90 sky130_fd_pr__nfet_01v8 L=0.15U W=0.42U AS=0.0567P
+ AD=0.1092P PS=0.69U PD=1.36U
* device instance $733 r0 *1 4.13,41.245 sky130_fd_pr__nfet_01v8
M$733 713 623 680 680 sky130_fd_pr__nfet_01v8 L=0.15U W=0.42U AS=0.1092P
+ AD=0.0441P PS=1.36U PD=0.63U
* device instance $734 r0 *1 4.49,41.245 sky130_fd_pr__nfet_01v8
M$734 90 88 713 713 sky130_fd_pr__nfet_01v8 L=0.15U W=0.42U AS=0.0441P
+ AD=0.1092P PS=0.63U PD=1.36U
* device instance $735 r0 *1 4.68,40.355 sky130_fd_pr__nfet_01v8
M$735 663 637 622 622 sky130_fd_pr__nfet_01v8 L=0.15U W=0.42U AS=0.1113P
+ AD=0.0441P PS=1.37U PD=0.63U
* device instance $736 r0 *1 5.04,40.355 sky130_fd_pr__nfet_01v8
M$736 90 108 663 663 sky130_fd_pr__nfet_01v8 L=0.15U W=0.42U AS=0.0441P
+ AD=0.0966P PS=0.63U PD=0.88U
* device instance $737 r0 *1 5.65,40.355 sky130_fd_pr__nfet_01v8
M$737 605 622 90 90 sky130_fd_pr__nfet_01v8 L=0.15U W=0.42U AS=0.0966P
+ AD=0.1113P PS=0.88U PD=1.37U
* device instance $738 r0 *1 7.29,41.215 sky130_fd_pr__nfet_01v8
M$738 682 678 680 680 sky130_fd_pr__nfet_01v8 L=0.15U W=0.36U AS=0.1446P
+ AD=0.0522P PS=1.18U PD=0.65U
* device instance $739 r0 *1 7.73,41.215 sky130_fd_pr__nfet_01v8
M$739 716 679 682 682 sky130_fd_pr__nfet_01v8 L=0.15U W=0.36U AS=0.0522P
+ AD=0.0759P PS=0.65U PD=0.8U
* device instance $740 r0 *1 5.43,41.245 sky130_fd_pr__nfet_01v8
M$740 90 88 681 681 sky130_fd_pr__nfet_01v8 L=0.15U W=0.42U AS=0.1092P
+ AD=0.0609P PS=1.36U PD=0.71U
* device instance $741 r0 *1 5.87,41.245 sky130_fd_pr__nfet_01v8
M$741 714 681 90 90 sky130_fd_pr__nfet_01v8 L=0.15U W=0.42U AS=0.0609P
+ AD=0.0756P PS=0.71U PD=0.78U
* device instance $742 r0 *1 6.38,41.245 sky130_fd_pr__nfet_01v8
M$742 680 705 714 714 sky130_fd_pr__nfet_01v8 L=0.15U W=0.42U AS=0.0756P
+ AD=0.1446P PS=0.78U PD=1.18U
* device instance $743 r0 *1 8.26,41.245 sky130_fd_pr__nfet_01v8
M$743 90 683 716 716 sky130_fd_pr__nfet_01v8 L=0.15U W=0.42U AS=0.0759P
+ AD=0.12095P PS=0.8U PD=1.085U
* device instance $744 r0 *1 8.855,41.355 sky130_fd_pr__nfet_01v8
M$744 683 682 90 90 sky130_fd_pr__nfet_01v8 L=0.15U W=0.64U AS=0.12095P
+ AD=0.1664P PS=1.085U PD=1.8U
* device instance $745 r0 *1 10.28,41.215 sky130_fd_pr__nfet_01v8
M$745 684 679 718 718 sky130_fd_pr__nfet_01v8 L=0.15U W=0.36U AS=0.0678P
+ AD=0.0684P PS=0.755U PD=0.74U
* device instance $746 r0 *1 10.81,41.215 sky130_fd_pr__nfet_01v8
M$746 719 678 684 684 sky130_fd_pr__nfet_01v8 L=0.15U W=0.36U AS=0.0684P
+ AD=0.066P PS=0.74U PD=0.745U
* device instance $747 r0 *1 9.795,41.245 sky130_fd_pr__nfet_01v8
M$747 718 683 90 90 sky130_fd_pr__nfet_01v8 L=0.15U W=0.42U AS=0.1092P
+ AD=0.0678P PS=1.36U PD=0.755U
* device instance $748 r0 *1 11.285,41.245 sky130_fd_pr__nfet_01v8
M$748 90 705 719 719 sky130_fd_pr__nfet_01v8 L=0.15U W=0.42U AS=0.066P
+ AD=0.1092P PS=0.745U PD=1.36U
* device instance $749 r0 *1 12.225,41.245 sky130_fd_pr__nfet_01v8
M$749 90 684 705 705 sky130_fd_pr__nfet_01v8 L=0.15U W=0.42U AS=0.1092P
+ AD=0.10025P PS=1.36U PD=0.985U
* device instance $750 r0 *1 12.71,41.36 sky130_fd_pr__nfet_01v8
M$750 574 684 90 90 sky130_fd_pr__nfet_01v8 L=0.15U W=0.65U AS=0.10025P
+ AD=0.182P PS=0.985U PD=1.86U
* device instance $751 r0 *1 13.81,41.36 sky130_fd_pr__nfet_01v8
M$751 90 574 706 706 sky130_fd_pr__nfet_01v8 L=0.15U W=0.65U AS=0.169P
+ AD=0.08775P PS=1.82U PD=0.92U
* device instance $752 r0 *1 14.23,41.36 sky130_fd_pr__nfet_01v8
M$752 606 706 90 90 sky130_fd_pr__nfet_01v8 L=0.15U W=2.6U AS=0.351P
+ AD=0.43225P PS=3.68U PD=4.58U
* device instance $756 r0 *1 17.03,41.36 sky130_fd_pr__nfet_01v8
M$756 90 589 707 707 sky130_fd_pr__nfet_01v8 L=0.15U W=0.65U AS=0.169P
+ AD=0.08775P PS=1.82U PD=0.92U
* device instance $757 r0 *1 17.45,41.36 sky130_fd_pr__nfet_01v8
M$757 625 707 90 90 sky130_fd_pr__nfet_01v8 L=0.15U W=2.6U AS=0.351P
+ AD=0.43225P PS=3.68U PD=4.58U
* device instance $761 r0 *1 19.71,41.245 sky130_fd_pr__nfet_01v8
M$761 722 732 685 685 sky130_fd_pr__nfet_01v8 L=0.15U W=0.42U AS=0.1113P
+ AD=0.0441P PS=1.37U PD=0.63U
* device instance $762 r0 *1 20.07,41.245 sky130_fd_pr__nfet_01v8
M$762 90 108 722 722 sky130_fd_pr__nfet_01v8 L=0.15U W=0.42U AS=0.0441P
+ AD=0.0966P PS=0.63U PD=0.88U
* device instance $763 r0 *1 20.68,41.245 sky130_fd_pr__nfet_01v8
M$763 657 685 90 90 sky130_fd_pr__nfet_01v8 L=0.15U W=0.42U AS=0.0966P
+ AD=0.1113P PS=0.88U PD=1.37U
* device instance $764 r0 *1 26.23,41.245 sky130_fd_pr__nfet_01v8
M$764 90 939 686 686 sky130_fd_pr__nfet_01v8 L=0.15U W=0.42U AS=0.1092P
+ AD=0.0567P PS=1.36U PD=0.69U
* device instance $765 r0 *1 26.65,41.245 sky130_fd_pr__nfet_01v8
M$765 687 686 90 90 sky130_fd_pr__nfet_01v8 L=0.15U W=0.42U AS=0.0567P
+ AD=0.1092P PS=0.69U PD=1.36U
* device instance $766 r0 *1 27.59,41.245 sky130_fd_pr__nfet_01v8
M$766 724 708 688 688 sky130_fd_pr__nfet_01v8 L=0.15U W=0.42U AS=0.1092P
+ AD=0.0441P PS=1.36U PD=0.63U
* device instance $767 r0 *1 27.95,41.245 sky130_fd_pr__nfet_01v8
M$767 90 88 724 724 sky130_fd_pr__nfet_01v8 L=0.15U W=0.42U AS=0.0441P
+ AD=0.1092P PS=0.63U PD=1.36U
* device instance $768 r0 *1 30.75,41.215 sky130_fd_pr__nfet_01v8
M$768 690 686 688 688 sky130_fd_pr__nfet_01v8 L=0.15U W=0.36U AS=0.1446P
+ AD=0.0522P PS=1.18U PD=0.65U
* device instance $769 r0 *1 31.19,41.215 sky130_fd_pr__nfet_01v8
M$769 726 687 690 690 sky130_fd_pr__nfet_01v8 L=0.15U W=0.36U AS=0.0522P
+ AD=0.0759P PS=0.65U PD=0.8U
* device instance $770 r0 *1 28.89,41.245 sky130_fd_pr__nfet_01v8
M$770 90 88 689 689 sky130_fd_pr__nfet_01v8 L=0.15U W=0.42U AS=0.1092P
+ AD=0.0609P PS=1.36U PD=0.71U
* device instance $771 r0 *1 29.33,41.245 sky130_fd_pr__nfet_01v8
M$771 725 689 90 90 sky130_fd_pr__nfet_01v8 L=0.15U W=0.42U AS=0.0609P
+ AD=0.0756P PS=0.71U PD=0.78U
* device instance $772 r0 *1 29.84,41.245 sky130_fd_pr__nfet_01v8
M$772 688 709 725 725 sky130_fd_pr__nfet_01v8 L=0.15U W=0.42U AS=0.0756P
+ AD=0.1446P PS=0.78U PD=1.18U
* device instance $773 r0 *1 31.72,41.245 sky130_fd_pr__nfet_01v8
M$773 90 691 726 726 sky130_fd_pr__nfet_01v8 L=0.15U W=0.42U AS=0.0759P
+ AD=0.12095P PS=0.8U PD=1.085U
* device instance $774 r0 *1 32.315,41.355 sky130_fd_pr__nfet_01v8
M$774 691 690 90 90 sky130_fd_pr__nfet_01v8 L=0.15U W=0.64U AS=0.12095P
+ AD=0.1664P PS=1.085U PD=1.8U
* device instance $775 r0 *1 33.74,41.215 sky130_fd_pr__nfet_01v8
M$775 692 687 727 727 sky130_fd_pr__nfet_01v8 L=0.15U W=0.36U AS=0.0678P
+ AD=0.0684P PS=0.755U PD=0.74U
* device instance $776 r0 *1 34.27,41.215 sky130_fd_pr__nfet_01v8
M$776 728 686 692 692 sky130_fd_pr__nfet_01v8 L=0.15U W=0.36U AS=0.0684P
+ AD=0.066P PS=0.74U PD=0.745U
* device instance $777 r0 *1 33.255,41.245 sky130_fd_pr__nfet_01v8
M$777 727 691 90 90 sky130_fd_pr__nfet_01v8 L=0.15U W=0.42U AS=0.1092P
+ AD=0.0678P PS=1.36U PD=0.755U
* device instance $778 r0 *1 34.745,41.245 sky130_fd_pr__nfet_01v8
M$778 90 709 728 728 sky130_fd_pr__nfet_01v8 L=0.15U W=0.42U AS=0.066P
+ AD=0.1092P PS=0.745U PD=1.36U
* device instance $779 r0 *1 35.435,40.355 sky130_fd_pr__nfet_01v8
M$779 631 659 90 90 sky130_fd_pr__nfet_01v8 L=0.15U W=1.68U AS=0.2877P
+ AD=0.2352P PS=3.47U PD=2.8U
* device instance $783 r0 *1 37.155,40.355 sky130_fd_pr__nfet_01v8
M$783 310 631 90 90 sky130_fd_pr__nfet_01v8 L=0.15U W=6.72U AS=0.93975P
+ AD=0.99225P PS=11.195U PD=11.865U
* device instance $799 r0 *1 35.685,41.245 sky130_fd_pr__nfet_01v8
M$799 90 692 709 709 sky130_fd_pr__nfet_01v8 L=0.15U W=0.42U AS=0.1092P
+ AD=0.10025P PS=1.36U PD=0.985U
* device instance $800 r0 *1 36.17,41.36 sky130_fd_pr__nfet_01v8
M$800 593 692 90 90 sky130_fd_pr__nfet_01v8 L=0.15U W=0.65U AS=0.10025P
+ AD=0.182P PS=0.985U PD=1.86U
* device instance $801 r0 *1 44.63,41.36 sky130_fd_pr__nfet_01v8
M$801 693 593 90 90 sky130_fd_pr__nfet_01v8 L=0.15U W=0.65U AS=0.169P
+ AD=0.118625P PS=1.82U PD=1.015U
* device instance $802 r0 *1 45.145,41.36 sky130_fd_pr__nfet_01v8
M$802 90 407 693 693 sky130_fd_pr__nfet_01v8 L=0.15U W=0.65U AS=0.118625P
+ AD=0.089375P PS=1.015U PD=0.925U
* device instance $803 r0 *1 45.57,41.36 sky130_fd_pr__nfet_01v8
M$803 693 710 90 90 sky130_fd_pr__nfet_01v8 L=0.15U W=0.65U AS=0.089375P
+ AD=0.08775P PS=0.925U PD=0.92U
* device instance $804 r0 *1 45.99,41.36 sky130_fd_pr__nfet_01v8
M$804 90 694 693 693 sky130_fd_pr__nfet_01v8 L=0.15U W=0.65U AS=0.08775P
+ AD=0.169P PS=0.92U PD=1.82U
* device instance $805 r0 *1 49.23,41.36 sky130_fd_pr__nfet_01v8
M$805 730 693 90 90 sky130_fd_pr__nfet_01v8 L=0.15U W=0.65U AS=0.169P
+ AD=0.08775P PS=1.82U PD=0.92U
* device instance $806 r0 *1 49.65,41.36 sky130_fd_pr__nfet_01v8
M$806 731 695 730 730 sky130_fd_pr__nfet_01v8 L=0.15U W=0.65U AS=0.08775P
+ AD=0.10725P PS=0.92U PD=0.98U
* device instance $807 r0 *1 50.13,41.36 sky130_fd_pr__nfet_01v8
M$807 876 384 731 731 sky130_fd_pr__nfet_01v8 L=0.15U W=0.65U AS=0.10725P
+ AD=0.169P PS=0.98U PD=1.82U
* device instance $808 r0 *1 57.61,41.36 sky130_fd_pr__nfet_01v8
M$808 729 711 696 696 sky130_fd_pr__nfet_01v8 L=0.15U W=0.65U AS=0.169P
+ AD=0.06825P PS=1.82U PD=0.86U
* device instance $809 r0 *1 57.97,41.36 sky130_fd_pr__nfet_01v8
M$809 90 633 729 729 sky130_fd_pr__nfet_01v8 L=0.15U W=0.65U AS=0.06825P
+ AD=0.08775P PS=0.86U PD=0.92U
* device instance $810 r0 *1 58.39,41.36 sky130_fd_pr__nfet_01v8
M$810 697 633 90 90 sky130_fd_pr__nfet_01v8 L=0.15U W=0.65U AS=0.08775P
+ AD=0.169P PS=0.92U PD=1.82U
* device instance $811 r0 *1 59.33,41.36 sky130_fd_pr__nfet_01v8
M$811 697 711 90 90 sky130_fd_pr__nfet_01v8 L=0.15U W=0.65U AS=0.169P
+ AD=0.08775P PS=1.82U PD=0.92U
* device instance $812 r0 *1 59.75,41.36 sky130_fd_pr__nfet_01v8
M$812 733 696 697 697 sky130_fd_pr__nfet_01v8 L=0.15U W=0.65U AS=0.08775P
+ AD=0.195P PS=0.92U PD=1.9U
* device instance $813 r0 *1 60.73,41.245 sky130_fd_pr__nfet_01v8
M$813 90 856 698 698 sky130_fd_pr__nfet_01v8 L=0.15U W=0.42U AS=0.1092P
+ AD=0.0567P PS=1.36U PD=0.69U
* device instance $814 r0 *1 61.15,41.245 sky130_fd_pr__nfet_01v8
M$814 699 698 90 90 sky130_fd_pr__nfet_01v8 L=0.15U W=0.42U AS=0.0567P
+ AD=0.1092P PS=0.69U PD=1.36U
* device instance $815 r0 *1 62.09,41.245 sky130_fd_pr__nfet_01v8
M$815 723 577 700 700 sky130_fd_pr__nfet_01v8 L=0.15U W=0.42U AS=0.1092P
+ AD=0.0441P PS=1.36U PD=0.63U
* device instance $816 r0 *1 62.45,41.245 sky130_fd_pr__nfet_01v8
M$816 90 311 723 723 sky130_fd_pr__nfet_01v8 L=0.15U W=0.42U AS=0.0441P
+ AD=0.1092P PS=0.63U PD=1.36U
* device instance $817 r0 *1 65.25,41.215 sky130_fd_pr__nfet_01v8
M$817 702 698 700 700 sky130_fd_pr__nfet_01v8 L=0.15U W=0.36U AS=0.1446P
+ AD=0.0522P PS=1.18U PD=0.65U
* device instance $818 r0 *1 65.69,41.215 sky130_fd_pr__nfet_01v8
M$818 720 699 702 702 sky130_fd_pr__nfet_01v8 L=0.15U W=0.36U AS=0.0522P
+ AD=0.0759P PS=0.65U PD=0.8U
* device instance $819 r0 *1 63.39,41.245 sky130_fd_pr__nfet_01v8
M$819 90 311 701 701 sky130_fd_pr__nfet_01v8 L=0.15U W=0.42U AS=0.1092P
+ AD=0.0609P PS=1.36U PD=0.71U
* device instance $820 r0 *1 63.83,41.245 sky130_fd_pr__nfet_01v8
M$820 721 701 90 90 sky130_fd_pr__nfet_01v8 L=0.15U W=0.42U AS=0.0609P
+ AD=0.0756P PS=0.71U PD=0.78U
* device instance $821 r0 *1 64.34,41.245 sky130_fd_pr__nfet_01v8
M$821 700 712 721 721 sky130_fd_pr__nfet_01v8 L=0.15U W=0.42U AS=0.0756P
+ AD=0.1446P PS=0.78U PD=1.18U
* device instance $822 r0 *1 66.22,41.245 sky130_fd_pr__nfet_01v8
M$822 90 703 720 720 sky130_fd_pr__nfet_01v8 L=0.15U W=0.42U AS=0.0759P
+ AD=0.12095P PS=0.8U PD=1.085U
* device instance $823 r0 *1 66.815,41.355 sky130_fd_pr__nfet_01v8
M$823 703 702 90 90 sky130_fd_pr__nfet_01v8 L=0.15U W=0.64U AS=0.12095P
+ AD=0.1664P PS=1.085U PD=1.8U
* device instance $824 r0 *1 68.24,41.215 sky130_fd_pr__nfet_01v8
M$824 704 699 717 717 sky130_fd_pr__nfet_01v8 L=0.15U W=0.36U AS=0.0678P
+ AD=0.0684P PS=0.755U PD=0.74U
* device instance $825 r0 *1 68.77,41.215 sky130_fd_pr__nfet_01v8
M$825 715 698 704 704 sky130_fd_pr__nfet_01v8 L=0.15U W=0.36U AS=0.0684P
+ AD=0.066P PS=0.74U PD=0.745U
* device instance $826 r0 *1 67.755,41.245 sky130_fd_pr__nfet_01v8
M$826 717 703 90 90 sky130_fd_pr__nfet_01v8 L=0.15U W=0.42U AS=0.1092P
+ AD=0.0678P PS=1.36U PD=0.755U
* device instance $827 r0 *1 69.245,41.245 sky130_fd_pr__nfet_01v8
M$827 90 712 715 715 sky130_fd_pr__nfet_01v8 L=0.15U W=0.42U AS=0.066P
+ AD=0.1092P PS=0.745U PD=1.36U
* device instance $828 r0 *1 70.185,41.245 sky130_fd_pr__nfet_01v8
M$828 90 704 712 712 sky130_fd_pr__nfet_01v8 L=0.15U W=0.42U AS=0.1092P
+ AD=0.10025P PS=1.36U PD=0.985U
* device instance $829 r0 *1 70.67,41.36 sky130_fd_pr__nfet_01v8
M$829 645 704 90 90 sky130_fd_pr__nfet_01v8 L=0.15U W=0.65U AS=0.10025P
+ AD=0.182P PS=0.985U PD=1.86U
* device instance $830 r0 *1 7.83,46.8 sky130_fd_pr__nfet_01v8
M$830 90 851 831 831 sky130_fd_pr__nfet_01v8 L=0.15U W=0.65U AS=0.169P
+ AD=0.10725P PS=1.82U PD=0.98U
* device instance $831 r0 *1 8.31,46.8 sky130_fd_pr__nfet_01v8
M$831 858 852 90 90 sky130_fd_pr__nfet_01v8 L=0.15U W=0.65U AS=0.10725P
+ AD=0.06825P PS=0.98U PD=0.86U
* device instance $832 r0 *1 8.67,46.8 sky130_fd_pr__nfet_01v8
M$832 831 129 858 858 sky130_fd_pr__nfet_01v8 L=0.15U W=0.65U AS=0.06825P
+ AD=0.169P PS=0.86U PD=1.82U
* device instance $833 r0 *1 9.21,45.795 sky130_fd_pr__nfet_01v8
M$833 90 939 761 761 sky130_fd_pr__nfet_01v8 L=0.15U W=0.42U AS=0.1092P
+ AD=0.0567P PS=1.36U PD=0.69U
* device instance $834 r0 *1 9.63,45.795 sky130_fd_pr__nfet_01v8
M$834 762 761 90 90 sky130_fd_pr__nfet_01v8 L=0.15U W=0.42U AS=0.0567P
+ AD=0.1092P PS=0.69U PD=1.36U
* device instance $835 r0 *1 9.61,46.8 sky130_fd_pr__nfet_01v8
M$835 860 130 831 831 sky130_fd_pr__nfet_01v8 L=0.15U W=0.65U AS=0.169P
+ AD=0.10725P PS=1.82U PD=0.98U
* device instance $836 r0 *1 10.09,46.8 sky130_fd_pr__nfet_01v8
M$836 90 853 860 860 sky130_fd_pr__nfet_01v8 L=0.15U W=0.65U AS=0.10725P
+ AD=0.102375P PS=0.98U PD=0.965U
* device instance $837 r0 *1 10.555,46.8 sky130_fd_pr__nfet_01v8
M$837 873 831 90 90 sky130_fd_pr__nfet_01v8 L=0.15U W=0.65U AS=0.102375P
+ AD=0.169P PS=0.965U PD=1.82U
* device instance $838 r0 *1 10.57,45.795 sky130_fd_pr__nfet_01v8
M$838 813 587 763 763 sky130_fd_pr__nfet_01v8 L=0.15U W=0.42U AS=0.1092P
+ AD=0.0441P PS=1.36U PD=0.63U
* device instance $839 r0 *1 10.93,45.795 sky130_fd_pr__nfet_01v8
M$839 90 311 813 813 sky130_fd_pr__nfet_01v8 L=0.15U W=0.42U AS=0.0441P
+ AD=0.1092P PS=0.63U PD=1.36U
* device instance $840 r0 *1 11.735,46.8 sky130_fd_pr__nfet_01v8
M$840 90 854 832 832 sky130_fd_pr__nfet_01v8 L=0.15U W=2.6U AS=0.51675P
+ AD=0.355875P PS=4.84U PD=3.695U
* device instance $844 r0 *1 13.43,46.8 sky130_fd_pr__nfet_01v8
M$844 589 833 832 832 sky130_fd_pr__nfet_01v8 L=0.15U W=2.6U AS=0.355875P
+ AD=0.43225P PS=3.695U PD=4.58U
* device instance $848 r0 *1 11.87,45.795 sky130_fd_pr__nfet_01v8
M$848 90 311 734 734 sky130_fd_pr__nfet_01v8 L=0.15U W=0.42U AS=0.1092P
+ AD=0.0609P PS=1.36U PD=0.71U
* device instance $849 r0 *1 12.31,45.795 sky130_fd_pr__nfet_01v8
M$849 815 734 90 90 sky130_fd_pr__nfet_01v8 L=0.15U W=0.42U AS=0.0609P
+ AD=0.0756P PS=0.71U PD=0.78U
* device instance $850 r0 *1 12.82,45.795 sky130_fd_pr__nfet_01v8
M$850 763 735 815 815 sky130_fd_pr__nfet_01v8 L=0.15U W=0.42U AS=0.0756P
+ AD=0.1446P PS=0.78U PD=1.18U
* device instance $851 r0 *1 13.73,45.825 sky130_fd_pr__nfet_01v8
M$851 764 761 763 763 sky130_fd_pr__nfet_01v8 L=0.15U W=0.36U AS=0.1446P
+ AD=0.0522P PS=1.18U PD=0.65U
* device instance $852 r0 *1 14.17,45.825 sky130_fd_pr__nfet_01v8
M$852 764 762 816 816 sky130_fd_pr__nfet_01v8 L=0.15U W=0.36U AS=0.0759P
+ AD=0.0522P PS=0.8U PD=0.65U
* device instance $853 r0 *1 14.7,45.795 sky130_fd_pr__nfet_01v8
M$853 816 765 90 90 sky130_fd_pr__nfet_01v8 L=0.15U W=0.42U AS=0.12095P
+ AD=0.0759P PS=1.085U PD=0.8U
* device instance $854 r0 *1 15.295,45.685 sky130_fd_pr__nfet_01v8
M$854 765 764 90 90 sky130_fd_pr__nfet_01v8 L=0.15U W=0.64U AS=0.12095P
+ AD=0.1664P PS=1.085U PD=1.8U
* device instance $855 r0 *1 15.63,46.8 sky130_fd_pr__nfet_01v8
M$855 833 937 90 90 sky130_fd_pr__nfet_01v8 L=0.15U W=0.65U AS=0.169P AD=0.169P
+ PS=1.82U PD=1.82U
* device instance $856 r0 *1 16.235,45.795 sky130_fd_pr__nfet_01v8
M$856 819 765 90 90 sky130_fd_pr__nfet_01v8 L=0.15U W=0.42U AS=0.1092P
+ AD=0.0678P PS=1.36U PD=0.755U
* device instance $857 r0 *1 16.72,45.825 sky130_fd_pr__nfet_01v8
M$857 766 762 819 819 sky130_fd_pr__nfet_01v8 L=0.15U W=0.36U AS=0.0678P
+ AD=0.0684P PS=0.755U PD=0.74U
* device instance $858 r0 *1 17.25,45.825 sky130_fd_pr__nfet_01v8
M$858 766 761 821 821 sky130_fd_pr__nfet_01v8 L=0.15U W=0.36U AS=0.066P
+ AD=0.0684P PS=0.745U PD=0.74U
* device instance $859 r0 *1 17.725,45.795 sky130_fd_pr__nfet_01v8
M$859 90 735 821 821 sky130_fd_pr__nfet_01v8 L=0.15U W=0.42U AS=0.066P
+ AD=0.1092P PS=0.745U PD=1.36U
* device instance $860 r0 *1 18.665,45.795 sky130_fd_pr__nfet_01v8
M$860 735 766 90 90 sky130_fd_pr__nfet_01v8 L=0.15U W=0.42U AS=0.10025P
+ AD=0.1092P PS=0.985U PD=1.36U
* device instance $861 r0 *1 19.15,45.68 sky130_fd_pr__nfet_01v8
M$861 590 766 90 90 sky130_fd_pr__nfet_01v8 L=0.15U W=0.65U AS=0.10025P
+ AD=0.182P PS=0.985U PD=1.86U
* device instance $862 r0 *1 25.77,46.685 sky130_fd_pr__nfet_01v8
M$862 90 939 834 834 sky130_fd_pr__nfet_01v8 L=0.15U W=0.42U AS=0.1092P
+ AD=0.0567P PS=1.36U PD=0.69U
* device instance $863 r0 *1 26.19,46.685 sky130_fd_pr__nfet_01v8
M$863 835 834 90 90 sky130_fd_pr__nfet_01v8 L=0.15U W=0.42U AS=0.0567P
+ AD=0.1092P PS=0.69U PD=1.36U
* device instance $864 r0 *1 26.23,45.68 sky130_fd_pr__nfet_01v8
M$864 90 759 708 708 sky130_fd_pr__nfet_01v8 L=0.15U W=0.65U AS=0.169P
+ AD=0.11285P PS=1.82U PD=1.045U
* device instance $865 r0 *1 26.775,45.795 sky130_fd_pr__nfet_01v8
M$865 822 55 90 90 sky130_fd_pr__nfet_01v8 L=0.15U W=0.42U AS=0.11285P
+ AD=0.0693P PS=1.045U PD=0.75U
* device instance $866 r0 *1 27.255,45.795 sky130_fd_pr__nfet_01v8
M$866 759 767 822 822 sky130_fd_pr__nfet_01v8 L=0.15U W=0.42U AS=0.0693P
+ AD=0.09975P PS=0.75U PD=0.895U
* device instance $867 r0 *1 27.88,45.795 sky130_fd_pr__nfet_01v8
M$867 823 592 759 759 sky130_fd_pr__nfet_01v8 L=0.15U W=0.42U AS=0.09975P
+ AD=0.0693P PS=0.895U PD=0.75U
* device instance $868 r0 *1 28.36,45.795 sky130_fd_pr__nfet_01v8
M$868 90 808 823 823 sky130_fd_pr__nfet_01v8 L=0.15U W=0.42U AS=0.0693P
+ AD=0.1449P PS=0.75U PD=1.11U
* device instance $869 r0 *1 29.2,45.795 sky130_fd_pr__nfet_01v8
M$869 808 55 90 90 sky130_fd_pr__nfet_01v8 L=0.15U W=0.42U AS=0.1449P
+ AD=0.1092P PS=1.11U PD=1.36U
* device instance $870 r0 *1 27.13,46.685 sky130_fd_pr__nfet_01v8
M$870 865 642 836 836 sky130_fd_pr__nfet_01v8 L=0.15U W=0.42U AS=0.1092P
+ AD=0.0441P PS=1.36U PD=0.63U
* device instance $871 r0 *1 27.49,46.685 sky130_fd_pr__nfet_01v8
M$871 90 311 865 865 sky130_fd_pr__nfet_01v8 L=0.15U W=0.42U AS=0.0441P
+ AD=0.1092P PS=0.63U PD=1.36U
* device instance $872 r0 *1 30.29,46.655 sky130_fd_pr__nfet_01v8
M$872 838 834 836 836 sky130_fd_pr__nfet_01v8 L=0.15U W=0.36U AS=0.1446P
+ AD=0.0522P PS=1.18U PD=0.65U
* device instance $873 r0 *1 30.73,46.655 sky130_fd_pr__nfet_01v8
M$873 868 835 838 838 sky130_fd_pr__nfet_01v8 L=0.15U W=0.36U AS=0.0522P
+ AD=0.0759P PS=0.65U PD=0.8U
* device instance $874 r0 *1 28.43,46.685 sky130_fd_pr__nfet_01v8
M$874 90 311 837 837 sky130_fd_pr__nfet_01v8 L=0.15U W=0.42U AS=0.1092P
+ AD=0.0609P PS=1.36U PD=0.71U
* device instance $875 r0 *1 28.87,46.685 sky130_fd_pr__nfet_01v8
M$875 866 837 90 90 sky130_fd_pr__nfet_01v8 L=0.15U W=0.42U AS=0.0609P
+ AD=0.0756P PS=0.71U PD=0.78U
* device instance $876 r0 *1 29.38,46.685 sky130_fd_pr__nfet_01v8
M$876 836 855 866 866 sky130_fd_pr__nfet_01v8 L=0.15U W=0.42U AS=0.0756P
+ AD=0.1446P PS=0.78U PD=1.18U
* device instance $877 r0 *1 31.26,46.685 sky130_fd_pr__nfet_01v8
M$877 90 839 868 868 sky130_fd_pr__nfet_01v8 L=0.15U W=0.42U AS=0.0759P
+ AD=0.12095P PS=0.8U PD=1.085U
* device instance $878 r0 *1 31.855,46.795 sky130_fd_pr__nfet_01v8
M$878 839 838 90 90 sky130_fd_pr__nfet_01v8 L=0.15U W=0.64U AS=0.12095P
+ AD=0.1664P PS=1.085U PD=1.8U
* device instance $879 r0 *1 33.28,46.655 sky130_fd_pr__nfet_01v8
M$879 840 835 869 869 sky130_fd_pr__nfet_01v8 L=0.15U W=0.36U AS=0.0678P
+ AD=0.0684P PS=0.755U PD=0.74U
* device instance $880 r0 *1 33.81,46.655 sky130_fd_pr__nfet_01v8
M$880 867 834 840 840 sky130_fd_pr__nfet_01v8 L=0.15U W=0.36U AS=0.0684P
+ AD=0.066P PS=0.74U PD=0.745U
* device instance $881 r0 *1 32.795,46.685 sky130_fd_pr__nfet_01v8
M$881 869 839 90 90 sky130_fd_pr__nfet_01v8 L=0.15U W=0.42U AS=0.1092P
+ AD=0.0678P PS=1.36U PD=0.755U
* device instance $882 r0 *1 34.285,46.685 sky130_fd_pr__nfet_01v8
M$882 90 855 867 867 sky130_fd_pr__nfet_01v8 L=0.15U W=0.42U AS=0.066P
+ AD=0.1092P PS=0.745U PD=1.36U
* device instance $883 r0 *1 33.59,45.795 sky130_fd_pr__nfet_01v8
M$883 90 939 768 768 sky130_fd_pr__nfet_01v8 L=0.15U W=0.42U AS=0.1092P
+ AD=0.0567P PS=1.36U PD=0.69U
* device instance $884 r0 *1 34.01,45.795 sky130_fd_pr__nfet_01v8
M$884 769 768 90 90 sky130_fd_pr__nfet_01v8 L=0.15U W=0.42U AS=0.0567P
+ AD=0.1092P PS=0.69U PD=1.36U
* device instance $885 r0 *1 34.95,45.795 sky130_fd_pr__nfet_01v8
M$885 824 801 770 770 sky130_fd_pr__nfet_01v8 L=0.15U W=0.42U AS=0.1092P
+ AD=0.0441P PS=1.36U PD=0.63U
* device instance $886 r0 *1 35.31,45.795 sky130_fd_pr__nfet_01v8
M$886 90 88 824 824 sky130_fd_pr__nfet_01v8 L=0.15U W=0.42U AS=0.0441P
+ AD=0.1092P PS=0.63U PD=1.36U
* device instance $887 r0 *1 35.225,46.685 sky130_fd_pr__nfet_01v8
M$887 90 840 855 855 sky130_fd_pr__nfet_01v8 L=0.15U W=0.42U AS=0.1092P
+ AD=0.10025P PS=1.36U PD=0.985U
* device instance $888 r0 *1 35.71,46.8 sky130_fd_pr__nfet_01v8
M$888 592 840 90 90 sky130_fd_pr__nfet_01v8 L=0.15U W=0.65U AS=0.10025P
+ AD=0.182P PS=0.985U PD=1.86U
* device instance $889 r0 *1 36.25,45.795 sky130_fd_pr__nfet_01v8
M$889 90 88 736 736 sky130_fd_pr__nfet_01v8 L=0.15U W=0.42U AS=0.1092P
+ AD=0.0609P PS=1.36U PD=0.71U
* device instance $890 r0 *1 36.69,45.795 sky130_fd_pr__nfet_01v8
M$890 825 736 90 90 sky130_fd_pr__nfet_01v8 L=0.15U W=0.42U AS=0.0609P
+ AD=0.0756P PS=0.71U PD=0.78U
* device instance $891 r0 *1 37.2,45.795 sky130_fd_pr__nfet_01v8
M$891 770 737 825 825 sky130_fd_pr__nfet_01v8 L=0.15U W=0.42U AS=0.0756P
+ AD=0.1446P PS=0.78U PD=1.18U
* device instance $892 r0 *1 38.11,45.825 sky130_fd_pr__nfet_01v8
M$892 771 768 770 770 sky130_fd_pr__nfet_01v8 L=0.15U W=0.36U AS=0.1446P
+ AD=0.0522P PS=1.18U PD=0.65U
* device instance $893 r0 *1 38.55,45.825 sky130_fd_pr__nfet_01v8
M$893 771 769 826 826 sky130_fd_pr__nfet_01v8 L=0.15U W=0.36U AS=0.0759P
+ AD=0.0522P PS=0.8U PD=0.65U
* device instance $894 r0 *1 39.08,45.795 sky130_fd_pr__nfet_01v8
M$894 826 772 90 90 sky130_fd_pr__nfet_01v8 L=0.15U W=0.42U AS=0.12095P
+ AD=0.0759P PS=1.085U PD=0.8U
* device instance $895 r0 *1 39.675,45.685 sky130_fd_pr__nfet_01v8
M$895 772 771 90 90 sky130_fd_pr__nfet_01v8 L=0.15U W=0.64U AS=0.12095P
+ AD=0.1664P PS=1.085U PD=1.8U
* device instance $896 r0 *1 40.615,45.795 sky130_fd_pr__nfet_01v8
M$896 827 772 90 90 sky130_fd_pr__nfet_01v8 L=0.15U W=0.42U AS=0.1092P
+ AD=0.0678P PS=1.36U PD=0.755U
* device instance $897 r0 *1 41.1,45.825 sky130_fd_pr__nfet_01v8
M$897 773 769 827 827 sky130_fd_pr__nfet_01v8 L=0.15U W=0.36U AS=0.0678P
+ AD=0.0684P PS=0.755U PD=0.74U
* device instance $898 r0 *1 41.63,45.825 sky130_fd_pr__nfet_01v8
M$898 773 768 828 828 sky130_fd_pr__nfet_01v8 L=0.15U W=0.36U AS=0.066P
+ AD=0.0684P PS=0.745U PD=0.74U
* device instance $899 r0 *1 42.105,45.795 sky130_fd_pr__nfet_01v8
M$899 90 737 828 828 sky130_fd_pr__nfet_01v8 L=0.15U W=0.42U AS=0.066P
+ AD=0.1092P PS=0.745U PD=1.36U
* device instance $900 r0 *1 40.96,46.685 sky130_fd_pr__nfet_01v8
M$900 841 870 801 801 sky130_fd_pr__nfet_01v8 L=0.15U W=0.42U AS=0.1113P
+ AD=0.0588P PS=1.37U PD=0.7U
* device instance $901 r0 *1 41.39,46.685 sky130_fd_pr__nfet_01v8
M$901 90 55 841 841 sky130_fd_pr__nfet_01v8 L=0.15U W=0.42U AS=0.0588P
+ AD=0.0588P PS=0.7U PD=0.7U
* device instance $902 r0 *1 41.82,46.685 sky130_fd_pr__nfet_01v8
M$902 841 811 90 90 sky130_fd_pr__nfet_01v8 L=0.15U W=0.42U AS=0.0588P
+ AD=0.1113P PS=0.7U PD=1.37U
* device instance $903 r0 *1 43.045,45.795 sky130_fd_pr__nfet_01v8
M$903 737 773 90 90 sky130_fd_pr__nfet_01v8 L=0.15U W=0.42U AS=0.10025P
+ AD=0.1092P PS=0.985U PD=1.36U
* device instance $904 r0 *1 43.53,45.68 sky130_fd_pr__nfet_01v8
M$904 710 773 90 90 sky130_fd_pr__nfet_01v8 L=0.15U W=0.65U AS=0.10025P
+ AD=0.182P PS=0.985U PD=1.86U
* device instance $905 r0 *1 44.63,45.68 sky130_fd_pr__nfet_01v8
M$905 90 809 774 774 sky130_fd_pr__nfet_01v8 L=0.15U W=0.65U AS=0.169P
+ AD=0.10725P PS=1.82U PD=0.98U
* device instance $906 r0 *1 45.11,45.68 sky130_fd_pr__nfet_01v8
M$906 830 710 90 90 sky130_fd_pr__nfet_01v8 L=0.15U W=0.65U AS=0.10725P
+ AD=0.06825P PS=0.98U PD=0.86U
* device instance $907 r0 *1 45.47,45.68 sky130_fd_pr__nfet_01v8
M$907 774 129 830 830 sky130_fd_pr__nfet_01v8 L=0.15U W=0.65U AS=0.06825P
+ AD=0.169P PS=0.86U PD=1.82U
* device instance $908 r0 *1 44.63,46.685 sky130_fd_pr__nfet_01v8
M$908 90 856 842 842 sky130_fd_pr__nfet_01v8 L=0.15U W=0.42U AS=0.1092P
+ AD=0.0567P PS=1.36U PD=0.69U
* device instance $909 r0 *1 45.05,46.685 sky130_fd_pr__nfet_01v8
M$909 843 842 90 90 sky130_fd_pr__nfet_01v8 L=0.15U W=0.42U AS=0.0567P
+ AD=0.1092P PS=0.69U PD=1.36U
* device instance $910 r0 *1 45.99,46.685 sky130_fd_pr__nfet_01v8
M$910 864 810 844 844 sky130_fd_pr__nfet_01v8 L=0.15U W=0.42U AS=0.1092P
+ AD=0.0441P PS=1.36U PD=0.63U
* device instance $911 r0 *1 46.35,46.685 sky130_fd_pr__nfet_01v8
M$911 90 311 864 864 sky130_fd_pr__nfet_01v8 L=0.15U W=0.42U AS=0.0441P
+ AD=0.1092P PS=0.63U PD=1.36U
* device instance $912 r0 *1 46.41,45.68 sky130_fd_pr__nfet_01v8
M$912 829 136 774 774 sky130_fd_pr__nfet_01v8 L=0.15U W=0.65U AS=0.169P
+ AD=0.10725P PS=1.82U PD=0.98U
* device instance $913 r0 *1 46.89,45.68 sky130_fd_pr__nfet_01v8
M$913 90 733 829 829 sky130_fd_pr__nfet_01v8 L=0.15U W=0.65U AS=0.10725P
+ AD=0.102375P PS=0.98U PD=0.965U
* device instance $914 r0 *1 47.355,45.68 sky130_fd_pr__nfet_01v8
M$914 810 774 90 90 sky130_fd_pr__nfet_01v8 L=0.15U W=0.65U AS=0.102375P
+ AD=0.169P PS=0.965U PD=1.82U
* device instance $915 r0 *1 49.15,46.655 sky130_fd_pr__nfet_01v8
M$915 846 842 844 844 sky130_fd_pr__nfet_01v8 L=0.15U W=0.36U AS=0.1446P
+ AD=0.0522P PS=1.18U PD=0.65U
* device instance $916 r0 *1 49.59,46.655 sky130_fd_pr__nfet_01v8
M$916 862 843 846 846 sky130_fd_pr__nfet_01v8 L=0.15U W=0.36U AS=0.0522P
+ AD=0.0759P PS=0.65U PD=0.8U
* device instance $917 r0 *1 47.29,46.685 sky130_fd_pr__nfet_01v8
M$917 90 311 845 845 sky130_fd_pr__nfet_01v8 L=0.15U W=0.42U AS=0.1092P
+ AD=0.0609P PS=1.36U PD=0.71U
* device instance $918 r0 *1 47.73,46.685 sky130_fd_pr__nfet_01v8
M$918 863 845 90 90 sky130_fd_pr__nfet_01v8 L=0.15U W=0.42U AS=0.0609P
+ AD=0.0756P PS=0.71U PD=0.78U
* device instance $919 r0 *1 48.24,46.685 sky130_fd_pr__nfet_01v8
M$919 844 857 863 863 sky130_fd_pr__nfet_01v8 L=0.15U W=0.42U AS=0.0756P
+ AD=0.1446P PS=0.78U PD=1.18U
* device instance $920 r0 *1 50.12,46.685 sky130_fd_pr__nfet_01v8
M$920 90 847 862 862 sky130_fd_pr__nfet_01v8 L=0.15U W=0.42U AS=0.0759P
+ AD=0.12095P PS=0.8U PD=1.085U
* device instance $921 r0 *1 50.715,46.795 sky130_fd_pr__nfet_01v8
M$921 847 846 90 90 sky130_fd_pr__nfet_01v8 L=0.15U W=0.64U AS=0.12095P
+ AD=0.1664P PS=1.085U PD=1.8U
* device instance $922 r0 *1 48.335,45.795 sky130_fd_pr__nfet_01v8
M$922 811 802 90 90 sky130_fd_pr__nfet_01v8 L=0.15U W=0.42U AS=0.1197P
+ AD=0.1092P PS=1.41U PD=1.36U
* device instance $923 r0 *1 49.69,45.68 sky130_fd_pr__nfet_01v8
M$923 776 811 90 90 sky130_fd_pr__nfet_01v8 L=0.15U W=0.65U AS=0.169P
+ AD=0.08775P PS=1.82U PD=0.92U
* device instance $924 r0 *1 50.11,45.68 sky130_fd_pr__nfet_01v8
M$924 90 710 776 776 sky130_fd_pr__nfet_01v8 L=0.15U W=0.65U AS=0.08775P
+ AD=0.169P PS=0.92U PD=1.82U
* device instance $925 r0 *1 51.305,45.795 sky130_fd_pr__nfet_01v8
M$925 777 710 90 90 sky130_fd_pr__nfet_01v8 L=0.15U W=0.42U AS=0.10025P
+ AD=0.1092P PS=0.985U PD=1.36U
* device instance $926 r0 *1 51.79,45.68 sky130_fd_pr__nfet_01v8
M$926 803 802 90 90 sky130_fd_pr__nfet_01v8 L=0.15U W=0.65U AS=0.10025P
+ AD=0.08775P PS=0.985U PD=0.92U
* device instance $927 r0 *1 52.21,45.68 sky130_fd_pr__nfet_01v8
M$927 90 777 803 803 sky130_fd_pr__nfet_01v8 L=0.15U W=0.65U AS=0.08775P
+ AD=0.169P PS=0.92U PD=1.82U
* device instance $928 r0 *1 52.14,46.655 sky130_fd_pr__nfet_01v8
M$928 848 843 861 861 sky130_fd_pr__nfet_01v8 L=0.15U W=0.36U AS=0.0678P
+ AD=0.0684P PS=0.755U PD=0.74U
* device instance $929 r0 *1 52.67,46.655 sky130_fd_pr__nfet_01v8
M$929 859 842 848 848 sky130_fd_pr__nfet_01v8 L=0.15U W=0.36U AS=0.0684P
+ AD=0.066P PS=0.74U PD=0.745U
* device instance $930 r0 *1 51.655,46.685 sky130_fd_pr__nfet_01v8
M$930 861 847 90 90 sky130_fd_pr__nfet_01v8 L=0.15U W=0.42U AS=0.1092P
+ AD=0.0678P PS=1.36U PD=0.755U
* device instance $931 r0 *1 53.145,46.685 sky130_fd_pr__nfet_01v8
M$931 90 857 859 859 sky130_fd_pr__nfet_01v8 L=0.15U W=0.42U AS=0.066P
+ AD=0.1092P PS=0.745U PD=1.36U
* device instance $932 r0 *1 54.085,46.685 sky130_fd_pr__nfet_01v8
M$932 90 848 857 857 sky130_fd_pr__nfet_01v8 L=0.15U W=0.42U AS=0.1092P
+ AD=0.10025P PS=1.36U PD=0.985U
* device instance $933 r0 *1 54.57,46.8 sky130_fd_pr__nfet_01v8
M$933 802 848 90 90 sky130_fd_pr__nfet_01v8 L=0.15U W=0.65U AS=0.10025P
+ AD=0.182P PS=0.985U PD=1.86U
* device instance $934 r0 *1 56.61,45.68 sky130_fd_pr__nfet_01v8
M$934 711 776 90 90 sky130_fd_pr__nfet_01v8 L=0.15U W=0.65U AS=0.169P
+ AD=0.08775P PS=1.82U PD=0.92U
* device instance $935 r0 *1 57.03,45.68 sky130_fd_pr__nfet_01v8
M$935 90 803 711 711 sky130_fd_pr__nfet_01v8 L=0.15U W=0.65U AS=0.08775P
+ AD=0.169P PS=0.92U PD=1.82U
* device instance $936 r0 *1 61.21,45.68 sky130_fd_pr__nfet_01v8
M$936 695 989 90 90 sky130_fd_pr__nfet_01v8 L=0.15U W=0.65U AS=0.169P
+ AD=0.08775P PS=1.82U PD=0.92U
* device instance $937 r0 *1 61.63,45.68 sky130_fd_pr__nfet_01v8
M$937 90 553 695 695 sky130_fd_pr__nfet_01v8 L=0.15U W=0.65U AS=0.08775P
+ AD=0.169P PS=0.92U PD=1.82U
* device instance $938 r0 *1 61.65,46.8 sky130_fd_pr__nfet_01v8
M$938 90 643 849 849 sky130_fd_pr__nfet_01v8 L=0.15U W=0.65U AS=0.169P
+ AD=0.08775P PS=1.82U PD=0.92U
* device instance $939 r0 *1 62.07,46.8 sky130_fd_pr__nfet_01v8
M$939 850 849 90 90 sky130_fd_pr__nfet_01v8 L=0.15U W=2.6U AS=0.351P
+ AD=0.43225P PS=3.68U PD=4.58U
* device instance $943 r0 *1 64.87,45.795 sky130_fd_pr__nfet_01v8
M$943 90 856 778 778 sky130_fd_pr__nfet_01v8 L=0.15U W=0.42U AS=0.1092P
+ AD=0.0567P PS=1.36U PD=0.69U
* device instance $944 r0 *1 65.29,45.795 sky130_fd_pr__nfet_01v8
M$944 779 778 90 90 sky130_fd_pr__nfet_01v8 L=0.15U W=0.42U AS=0.0567P
+ AD=0.1092P PS=0.69U PD=1.36U
* device instance $945 r0 *1 66.23,45.795 sky130_fd_pr__nfet_01v8
M$945 820 635 780 780 sky130_fd_pr__nfet_01v8 L=0.15U W=0.42U AS=0.1092P
+ AD=0.0441P PS=1.36U PD=0.63U
* device instance $946 r0 *1 66.59,45.795 sky130_fd_pr__nfet_01v8
M$946 90 1134 820 820 sky130_fd_pr__nfet_01v8 L=0.15U W=0.42U AS=0.0441P
+ AD=0.1092P PS=0.63U PD=1.36U
* device instance $947 r0 *1 67.53,45.795 sky130_fd_pr__nfet_01v8
M$947 90 1134 738 738 sky130_fd_pr__nfet_01v8 L=0.15U W=0.42U AS=0.1092P
+ AD=0.0609P PS=1.36U PD=0.71U
* device instance $948 r0 *1 67.97,45.795 sky130_fd_pr__nfet_01v8
M$948 818 738 90 90 sky130_fd_pr__nfet_01v8 L=0.15U W=0.42U AS=0.0609P
+ AD=0.0756P PS=0.71U PD=0.78U
* device instance $949 r0 *1 68.48,45.795 sky130_fd_pr__nfet_01v8
M$949 780 739 818 818 sky130_fd_pr__nfet_01v8 L=0.15U W=0.42U AS=0.0756P
+ AD=0.1446P PS=0.78U PD=1.18U
* device instance $950 r0 *1 69.39,45.825 sky130_fd_pr__nfet_01v8
M$950 781 778 780 780 sky130_fd_pr__nfet_01v8 L=0.15U W=0.36U AS=0.1446P
+ AD=0.0522P PS=1.18U PD=0.65U
* device instance $951 r0 *1 69.83,45.825 sky130_fd_pr__nfet_01v8
M$951 781 779 817 817 sky130_fd_pr__nfet_01v8 L=0.15U W=0.36U AS=0.0759P
+ AD=0.0522P PS=0.8U PD=0.65U
* device instance $952 r0 *1 70.36,45.795 sky130_fd_pr__nfet_01v8
M$952 817 782 90 90 sky130_fd_pr__nfet_01v8 L=0.15U W=0.42U AS=0.12095P
+ AD=0.0759P PS=1.085U PD=0.8U
* device instance $953 r0 *1 70.955,45.685 sky130_fd_pr__nfet_01v8
M$953 782 781 90 90 sky130_fd_pr__nfet_01v8 L=0.15U W=0.64U AS=0.12095P
+ AD=0.1664P PS=1.085U PD=1.8U
* device instance $954 r0 *1 71.895,45.795 sky130_fd_pr__nfet_01v8
M$954 814 782 90 90 sky130_fd_pr__nfet_01v8 L=0.15U W=0.42U AS=0.1092P
+ AD=0.0678P PS=1.36U PD=0.755U
* device instance $955 r0 *1 72.38,45.825 sky130_fd_pr__nfet_01v8
M$955 783 779 814 814 sky130_fd_pr__nfet_01v8 L=0.15U W=0.36U AS=0.0678P
+ AD=0.0684P PS=0.755U PD=0.74U
* device instance $956 r0 *1 72.91,45.825 sky130_fd_pr__nfet_01v8
M$956 783 778 812 812 sky130_fd_pr__nfet_01v8 L=0.15U W=0.36U AS=0.066P
+ AD=0.0684P PS=0.745U PD=0.74U
* device instance $957 r0 *1 73.385,45.795 sky130_fd_pr__nfet_01v8
M$957 90 739 812 812 sky130_fd_pr__nfet_01v8 L=0.15U W=0.42U AS=0.066P
+ AD=0.1092P PS=0.745U PD=1.36U
* device instance $958 r0 *1 74.325,45.795 sky130_fd_pr__nfet_01v8
M$958 739 783 90 90 sky130_fd_pr__nfet_01v8 L=0.15U W=0.42U AS=0.10025P
+ AD=0.1092P PS=0.985U PD=1.36U
* device instance $959 r0 *1 74.81,45.68 sky130_fd_pr__nfet_01v8
M$959 553 783 90 90 sky130_fd_pr__nfet_01v8 L=0.15U W=0.65U AS=0.10025P
+ AD=0.182P PS=0.985U PD=1.86U
* device instance $960 r0 *1 2.77,52.125 sky130_fd_pr__nfet_01v8
M$960 90 939 929 929 sky130_fd_pr__nfet_01v8 L=0.15U W=0.42U AS=0.1092P
+ AD=0.0567P PS=1.36U PD=0.69U
* device instance $961 r0 *1 3.19,52.125 sky130_fd_pr__nfet_01v8
M$961 930 929 90 90 sky130_fd_pr__nfet_01v8 L=0.15U W=0.42U AS=0.0567P
+ AD=0.1092P PS=0.69U PD=1.36U
* device instance $962 r0 *1 4.13,52.125 sky130_fd_pr__nfet_01v8
M$962 950 891 931 931 sky130_fd_pr__nfet_01v8 L=0.15U W=0.42U AS=0.1092P
+ AD=0.0441P PS=1.36U PD=0.63U
* device instance $963 r0 *1 4.49,52.125 sky130_fd_pr__nfet_01v8
M$963 90 88 950 950 sky130_fd_pr__nfet_01v8 L=0.15U W=0.42U AS=0.0441P
+ AD=0.1092P PS=0.63U PD=1.36U
* device instance $964 r0 *1 4.68,51.235 sky130_fd_pr__nfet_01v8
M$964 919 907 890 890 sky130_fd_pr__nfet_01v8 L=0.15U W=0.42U AS=0.1113P
+ AD=0.0441P PS=1.37U PD=0.63U
* device instance $965 r0 *1 5.04,51.235 sky130_fd_pr__nfet_01v8
M$965 90 108 919 919 sky130_fd_pr__nfet_01v8 L=0.15U W=0.42U AS=0.0441P
+ AD=0.0966P PS=0.63U PD=0.88U
* device instance $966 r0 *1 5.65,51.235 sky130_fd_pr__nfet_01v8
M$966 851 890 90 90 sky130_fd_pr__nfet_01v8 L=0.15U W=0.42U AS=0.0966P
+ AD=0.1113P PS=0.88U PD=1.37U
* device instance $967 r0 *1 7.29,52.095 sky130_fd_pr__nfet_01v8
M$967 933 929 931 931 sky130_fd_pr__nfet_01v8 L=0.15U W=0.36U AS=0.1446P
+ AD=0.0522P PS=1.18U PD=0.65U
* device instance $968 r0 *1 7.73,52.095 sky130_fd_pr__nfet_01v8
M$968 953 930 933 933 sky130_fd_pr__nfet_01v8 L=0.15U W=0.36U AS=0.0522P
+ AD=0.0759P PS=0.65U PD=0.8U
* device instance $969 r0 *1 5.43,52.125 sky130_fd_pr__nfet_01v8
M$969 90 88 946 946 sky130_fd_pr__nfet_01v8 L=0.15U W=0.42U AS=0.1092P
+ AD=0.0609P PS=1.36U PD=0.71U
* device instance $970 r0 *1 5.87,52.125 sky130_fd_pr__nfet_01v8
M$970 951 946 90 90 sky130_fd_pr__nfet_01v8 L=0.15U W=0.42U AS=0.0609P
+ AD=0.0756P PS=0.71U PD=0.78U
* device instance $971 r0 *1 6.38,52.125 sky130_fd_pr__nfet_01v8
M$971 931 932 951 951 sky130_fd_pr__nfet_01v8 L=0.15U W=0.42U AS=0.0756P
+ AD=0.1446P PS=0.78U PD=1.18U
* device instance $972 r0 *1 8.26,52.125 sky130_fd_pr__nfet_01v8
M$972 90 934 953 953 sky130_fd_pr__nfet_01v8 L=0.15U W=0.42U AS=0.0759P
+ AD=0.12095P PS=0.8U PD=1.085U
* device instance $973 r0 *1 8.855,52.235 sky130_fd_pr__nfet_01v8
M$973 934 933 90 90 sky130_fd_pr__nfet_01v8 L=0.15U W=0.64U AS=0.12095P
+ AD=0.1664P PS=1.085U PD=1.8U
* device instance $974 r0 *1 6.91,51.12 sky130_fd_pr__nfet_01v8
M$974 90 874 891 891 sky130_fd_pr__nfet_01v8 L=0.15U W=0.65U AS=0.169P
+ AD=0.11285P PS=1.82U PD=1.045U
* device instance $975 r0 *1 7.455,51.235 sky130_fd_pr__nfet_01v8
M$975 921 55 90 90 sky130_fd_pr__nfet_01v8 L=0.15U W=0.42U AS=0.11285P
+ AD=0.0693P PS=1.045U PD=0.75U
* device instance $976 r0 *1 7.935,51.235 sky130_fd_pr__nfet_01v8
M$976 874 917 921 921 sky130_fd_pr__nfet_01v8 L=0.15U W=0.42U AS=0.0693P
+ AD=0.09975P PS=0.75U PD=0.895U
* device instance $977 r0 *1 8.56,51.235 sky130_fd_pr__nfet_01v8
M$977 923 908 874 874 sky130_fd_pr__nfet_01v8 L=0.15U W=0.42U AS=0.09975P
+ AD=0.0693P PS=0.895U PD=0.75U
* device instance $978 r0 *1 9.04,51.235 sky130_fd_pr__nfet_01v8
M$978 90 918 923 923 sky130_fd_pr__nfet_01v8 L=0.15U W=0.42U AS=0.0693P
+ AD=0.1449P PS=0.75U PD=1.11U
* device instance $979 r0 *1 9.88,51.235 sky130_fd_pr__nfet_01v8
M$979 918 55 90 90 sky130_fd_pr__nfet_01v8 L=0.15U W=0.42U AS=0.1449P
+ AD=0.1092P PS=1.11U PD=1.36U
* device instance $980 r0 *1 10.28,52.095 sky130_fd_pr__nfet_01v8
M$980 935 930 954 954 sky130_fd_pr__nfet_01v8 L=0.15U W=0.36U AS=0.0678P
+ AD=0.0684P PS=0.755U PD=0.74U
* device instance $981 r0 *1 10.81,52.095 sky130_fd_pr__nfet_01v8
M$981 956 929 935 935 sky130_fd_pr__nfet_01v8 L=0.15U W=0.36U AS=0.0684P
+ AD=0.066P PS=0.74U PD=0.745U
* device instance $982 r0 *1 9.795,52.125 sky130_fd_pr__nfet_01v8
M$982 954 934 90 90 sky130_fd_pr__nfet_01v8 L=0.15U W=0.42U AS=0.1092P
+ AD=0.0678P PS=1.36U PD=0.755U
* device instance $983 r0 *1 11.285,52.125 sky130_fd_pr__nfet_01v8
M$983 90 932 956 956 sky130_fd_pr__nfet_01v8 L=0.15U W=0.42U AS=0.066P
+ AD=0.1092P PS=0.745U PD=1.36U
* device instance $984 r0 *1 11.11,51.12 sky130_fd_pr__nfet_01v8
M$984 853 875 90 90 sky130_fd_pr__nfet_01v8 L=0.15U W=0.65U AS=0.208P
+ AD=0.25025P PS=1.94U PD=1.42U
* device instance $985 r0 *1 12.03,51.12 sky130_fd_pr__nfet_01v8
M$985 925 852 853 853 sky130_fd_pr__nfet_01v8 L=0.15U W=0.65U AS=0.25025P
+ AD=0.08775P PS=1.42U PD=0.92U
* device instance $986 r0 *1 12.45,51.12 sky130_fd_pr__nfet_01v8
M$986 90 908 925 925 sky130_fd_pr__nfet_01v8 L=0.15U W=0.65U AS=0.08775P
+ AD=0.08775P PS=0.92U PD=0.92U
* device instance $987 r0 *1 12.87,51.12 sky130_fd_pr__nfet_01v8
M$987 875 908 90 90 sky130_fd_pr__nfet_01v8 L=0.15U W=0.65U AS=0.08775P
+ AD=0.08775P PS=0.92U PD=0.92U
* device instance $988 r0 *1 13.29,51.12 sky130_fd_pr__nfet_01v8
M$988 90 852 875 875 sky130_fd_pr__nfet_01v8 L=0.15U W=0.65U AS=0.08775P
+ AD=0.169P PS=0.92U PD=1.82U
* device instance $989 r0 *1 12.225,52.125 sky130_fd_pr__nfet_01v8
M$989 90 935 932 932 sky130_fd_pr__nfet_01v8 L=0.15U W=0.42U AS=0.1092P
+ AD=0.10025P PS=1.36U PD=0.985U
* device instance $990 r0 *1 12.71,52.24 sky130_fd_pr__nfet_01v8
M$990 854 935 90 90 sky130_fd_pr__nfet_01v8 L=0.15U W=0.65U AS=0.10025P
+ AD=0.182P PS=0.985U PD=1.86U
* device instance $991 r0 *1 13.95,52.24 sky130_fd_pr__nfet_01v8
M$991 908 936 90 90 sky130_fd_pr__nfet_01v8 L=0.15U W=2.6U AS=0.43225P
+ AD=0.351P PS=4.58U PD=3.68U
* device instance $995 r0 *1 15.63,52.24 sky130_fd_pr__nfet_01v8
M$995 936 937 90 90 sky130_fd_pr__nfet_01v8 L=0.15U W=0.65U AS=0.08775P
+ AD=0.169P PS=0.92U PD=1.82U
* device instance $996 r0 *1 19.64,52.125 sky130_fd_pr__nfet_01v8
M$996 939 938 90 90 sky130_fd_pr__nfet_01v8 L=0.15U W=6.72U AS=1.103975P
+ AD=0.93975P PS=11.925U PD=11.195U
* device instance $1012 r0 *1 26.515,52.125 sky130_fd_pr__nfet_01v8
M$1012 938 310 90 90 sky130_fd_pr__nfet_01v8 L=0.15U W=1.68U AS=0.2352P
+ AD=0.2877P PS=2.8U PD=3.47U
* device instance $1016 r0 *1 17.03,52.24 sky130_fd_pr__nfet_01v8
M$1016 90 854 947 947 sky130_fd_pr__nfet_01v8 L=0.15U W=0.65U AS=0.169P
+ AD=0.08775P PS=1.82U PD=0.92U
* device instance $1017 r0 *1 17.45,52.24 sky130_fd_pr__nfet_01v8
M$1017 852 947 90 90 sky130_fd_pr__nfet_01v8 L=0.15U W=2.6U AS=0.351P
+ AD=0.486275P PS=3.68U PD=4.19U
* device instance $1021 r0 *1 21.21,51.12 sky130_fd_pr__nfet_01v8
M$1021 894 406 90 90 sky130_fd_pr__nfet_01v8 L=0.15U W=2.6U AS=0.43225P
+ AD=0.351P PS=4.58U PD=3.68U
* device instance $1025 r0 *1 22.89,51.12 sky130_fd_pr__nfet_01v8
M$1025 894 876 90 90 sky130_fd_pr__nfet_01v8 L=0.15U W=2.6U AS=0.351P AD=0.52P
+ PS=3.68U PD=4.2U
* device instance $1029 r0 *1 25.09,51.12 sky130_fd_pr__nfet_01v8
M$1029 894 909 90 90 sky130_fd_pr__nfet_01v8 L=0.15U W=2.6U AS=0.52P AD=0.351P
+ PS=4.2U PD=3.68U
* device instance $1033 r0 *1 26.77,51.12 sky130_fd_pr__nfet_01v8
M$1033 894 852 90 90 sky130_fd_pr__nfet_01v8 L=0.15U W=2.6U AS=0.351P
+ AD=0.44525P PS=3.68U PD=4.62U
* device instance $1037 r0 *1 43.32,51.235 sky130_fd_pr__nfet_01v8
M$1037 928 910 897 897 sky130_fd_pr__nfet_01v8 L=0.15U W=0.42U AS=0.1113P
+ AD=0.0441P PS=1.37U PD=0.63U
* device instance $1038 r0 *1 43.68,51.235 sky130_fd_pr__nfet_01v8
M$1038 90 108 928 928 sky130_fd_pr__nfet_01v8 L=0.15U W=0.42U AS=0.0441P
+ AD=0.0966P PS=0.63U PD=0.88U
* device instance $1039 r0 *1 44.29,51.235 sky130_fd_pr__nfet_01v8
M$1039 809 897 90 90 sky130_fd_pr__nfet_01v8 L=0.15U W=0.42U AS=0.0966P
+ AD=0.1113P PS=0.88U PD=1.37U
* device instance $1040 r0 *1 56.13,52.24 sky130_fd_pr__nfet_01v8
M$1040 90 948 940 940 sky130_fd_pr__nfet_01v8 L=0.15U W=0.65U AS=0.169P
+ AD=0.08775P PS=1.82U PD=0.92U
* device instance $1041 r0 *1 56.55,52.24 sky130_fd_pr__nfet_01v8
M$1041 940 803 90 90 sky130_fd_pr__nfet_01v8 L=0.15U W=0.65U AS=0.08775P
+ AD=0.08775P PS=0.92U PD=0.92U
* device instance $1042 r0 *1 56.97,52.24 sky130_fd_pr__nfet_01v8
M$1042 90 982 940 940 sky130_fd_pr__nfet_01v8 L=0.15U W=0.65U AS=0.08775P
+ AD=0.26P PS=0.92U PD=1.45U
* device instance $1043 r0 *1 57.92,52.24 sky130_fd_pr__nfet_01v8
M$1043 941 940 90 90 sky130_fd_pr__nfet_01v8 L=0.15U W=2.6U AS=0.52325P
+ AD=0.5655P PS=4.21U PD=4.34U
* device instance $1047 r0 *1 60.26,52.24 sky130_fd_pr__nfet_01v8
M$1047 948 942 90 90 sky130_fd_pr__nfet_01v8 L=0.15U W=2.6U AS=0.5655P
+ AD=0.351P PS=4.34U PD=3.68U
* device instance $1051 r0 *1 61.94,52.24 sky130_fd_pr__nfet_01v8
M$1051 942 850 90 90 sky130_fd_pr__nfet_01v8 L=0.15U W=0.65U AS=0.08775P
+ AD=0.169P PS=0.92U PD=1.82U
* device instance $1052 r0 *1 64.87,51.235 sky130_fd_pr__nfet_01v8
M$1052 90 856 898 898 sky130_fd_pr__nfet_01v8 L=0.15U W=0.42U AS=0.1092P
+ AD=0.0567P PS=1.36U PD=0.69U
* device instance $1053 r0 *1 65.29,51.235 sky130_fd_pr__nfet_01v8
M$1053 899 898 90 90 sky130_fd_pr__nfet_01v8 L=0.15U W=0.42U AS=0.0567P
+ AD=0.1092P PS=0.69U PD=1.36U
* device instance $1054 r0 *1 66.23,51.235 sky130_fd_pr__nfet_01v8
M$1054 927 911 900 900 sky130_fd_pr__nfet_01v8 L=0.15U W=0.42U AS=0.1092P
+ AD=0.0441P PS=1.36U PD=0.63U
* device instance $1055 r0 *1 66.59,51.235 sky130_fd_pr__nfet_01v8
M$1055 90 1134 927 927 sky130_fd_pr__nfet_01v8 L=0.15U W=0.42U AS=0.0441P
+ AD=0.1092P PS=0.63U PD=1.36U
* device instance $1056 r0 *1 67.53,51.235 sky130_fd_pr__nfet_01v8
M$1056 90 1134 877 877 sky130_fd_pr__nfet_01v8 L=0.15U W=0.42U AS=0.1092P
+ AD=0.0609P PS=1.36U PD=0.71U
* device instance $1057 r0 *1 67.97,51.235 sky130_fd_pr__nfet_01v8
M$1057 926 877 90 90 sky130_fd_pr__nfet_01v8 L=0.15U W=0.42U AS=0.0609P
+ AD=0.0756P PS=0.71U PD=0.78U
* device instance $1058 r0 *1 68.48,51.235 sky130_fd_pr__nfet_01v8
M$1058 900 878 926 926 sky130_fd_pr__nfet_01v8 L=0.15U W=0.42U AS=0.0756P
+ AD=0.1446P PS=0.78U PD=1.18U
* device instance $1059 r0 *1 69.39,51.265 sky130_fd_pr__nfet_01v8
M$1059 901 898 900 900 sky130_fd_pr__nfet_01v8 L=0.15U W=0.36U AS=0.1446P
+ AD=0.0522P PS=1.18U PD=0.65U
* device instance $1060 r0 *1 69.83,51.265 sky130_fd_pr__nfet_01v8
M$1060 901 899 924 924 sky130_fd_pr__nfet_01v8 L=0.15U W=0.36U AS=0.0759P
+ AD=0.0522P PS=0.8U PD=0.65U
* device instance $1061 r0 *1 70.36,51.235 sky130_fd_pr__nfet_01v8
M$1061 924 902 90 90 sky130_fd_pr__nfet_01v8 L=0.15U W=0.42U AS=0.12095P
+ AD=0.0759P PS=1.085U PD=0.8U
* device instance $1062 r0 *1 70.955,51.125 sky130_fd_pr__nfet_01v8
M$1062 902 901 90 90 sky130_fd_pr__nfet_01v8 L=0.15U W=0.64U AS=0.12095P
+ AD=0.1664P PS=1.085U PD=1.8U
* device instance $1063 r0 *1 68.175,52.125 sky130_fd_pr__nfet_01v8
M$1063 955 55 90 90 sky130_fd_pr__nfet_01v8 L=0.15U W=0.42U AS=0.11285P
+ AD=0.0693P PS=1.045U PD=0.75U
* device instance $1064 r0 *1 68.655,52.125 sky130_fd_pr__nfet_01v8
M$1064 943 944 955 955 sky130_fd_pr__nfet_01v8 L=0.15U W=0.42U AS=0.0693P
+ AD=0.09975P PS=0.75U PD=0.895U
* device instance $1065 r0 *1 69.28,52.125 sky130_fd_pr__nfet_01v8
M$1065 952 949 943 943 sky130_fd_pr__nfet_01v8 L=0.15U W=0.42U AS=0.09975P
+ AD=0.0693P PS=0.895U PD=0.75U
* device instance $1066 r0 *1 69.76,52.125 sky130_fd_pr__nfet_01v8
M$1066 90 945 952 952 sky130_fd_pr__nfet_01v8 L=0.15U W=0.42U AS=0.0693P
+ AD=0.1449P PS=0.75U PD=1.11U
* device instance $1067 r0 *1 70.6,52.125 sky130_fd_pr__nfet_01v8
M$1067 945 55 90 90 sky130_fd_pr__nfet_01v8 L=0.15U W=0.42U AS=0.1449P
+ AD=0.1092P PS=1.11U PD=1.36U
* device instance $1068 r0 *1 67.63,52.24 sky130_fd_pr__nfet_01v8
M$1068 90 943 911 911 sky130_fd_pr__nfet_01v8 L=0.15U W=0.65U AS=0.169P
+ AD=0.11285P PS=1.82U PD=1.045U
* device instance $1069 r0 *1 71.895,51.235 sky130_fd_pr__nfet_01v8
M$1069 922 902 90 90 sky130_fd_pr__nfet_01v8 L=0.15U W=0.42U AS=0.1092P
+ AD=0.0678P PS=1.36U PD=0.755U
* device instance $1070 r0 *1 72.38,51.265 sky130_fd_pr__nfet_01v8
M$1070 903 899 922 922 sky130_fd_pr__nfet_01v8 L=0.15U W=0.36U AS=0.0678P
+ AD=0.0684P PS=0.755U PD=0.74U
* device instance $1071 r0 *1 72.91,51.265 sky130_fd_pr__nfet_01v8
M$1071 903 898 920 920 sky130_fd_pr__nfet_01v8 L=0.15U W=0.36U AS=0.066P
+ AD=0.0684P PS=0.745U PD=0.74U
* device instance $1072 r0 *1 73.385,51.235 sky130_fd_pr__nfet_01v8
M$1072 90 878 920 920 sky130_fd_pr__nfet_01v8 L=0.15U W=0.42U AS=0.066P
+ AD=0.1092P PS=0.745U PD=1.36U
* device instance $1073 r0 *1 74.325,51.235 sky130_fd_pr__nfet_01v8
M$1073 878 903 90 90 sky130_fd_pr__nfet_01v8 L=0.15U W=0.42U AS=0.10025P
+ AD=0.1092P PS=0.985U PD=1.36U
* device instance $1074 r0 *1 74.81,51.12 sky130_fd_pr__nfet_01v8
M$1074 989 903 90 90 sky130_fd_pr__nfet_01v8 L=0.15U W=0.65U AS=0.10025P
+ AD=0.182P PS=0.985U PD=1.86U
* device instance $1075 r0 *1 9.21,56.675 sky130_fd_pr__nfet_01v8
M$1075 90 939 966 966 sky130_fd_pr__nfet_01v8 L=0.15U W=0.42U AS=0.1092P
+ AD=0.0567P PS=1.36U PD=0.69U
* device instance $1076 r0 *1 9.63,56.675 sky130_fd_pr__nfet_01v8
M$1076 967 966 90 90 sky130_fd_pr__nfet_01v8 L=0.15U W=0.42U AS=0.0567P
+ AD=0.1092P PS=0.69U PD=1.36U
* device instance $1077 r0 *1 10.57,56.675 sky130_fd_pr__nfet_01v8
M$1077 1003 873 968 968 sky130_fd_pr__nfet_01v8 L=0.15U W=0.42U AS=0.1092P
+ AD=0.0441P PS=1.36U PD=0.63U
* device instance $1078 r0 *1 10.93,56.675 sky130_fd_pr__nfet_01v8
M$1078 90 311 1003 1003 sky130_fd_pr__nfet_01v8 L=0.15U W=0.42U AS=0.0441P
+ AD=0.1092P PS=0.63U PD=1.36U
* device instance $1079 r0 *1 11.87,56.675 sky130_fd_pr__nfet_01v8
M$1079 90 311 969 969 sky130_fd_pr__nfet_01v8 L=0.15U W=0.42U AS=0.1092P
+ AD=0.0609P PS=1.36U PD=0.71U
* device instance $1080 r0 *1 12.31,56.675 sky130_fd_pr__nfet_01v8
M$1080 1004 969 90 90 sky130_fd_pr__nfet_01v8 L=0.15U W=0.42U AS=0.0609P
+ AD=0.0756P PS=0.71U PD=0.78U
* device instance $1081 r0 *1 12.82,56.675 sky130_fd_pr__nfet_01v8
M$1081 968 973 1004 1004 sky130_fd_pr__nfet_01v8 L=0.15U W=0.42U AS=0.0756P
+ AD=0.1446P PS=0.78U PD=1.18U
* device instance $1082 r0 *1 13.73,56.705 sky130_fd_pr__nfet_01v8
M$1082 970 966 968 968 sky130_fd_pr__nfet_01v8 L=0.15U W=0.36U AS=0.1446P
+ AD=0.0522P PS=1.18U PD=0.65U
* device instance $1083 r0 *1 14.17,56.705 sky130_fd_pr__nfet_01v8
M$1083 970 967 1005 1005 sky130_fd_pr__nfet_01v8 L=0.15U W=0.36U AS=0.0759P
+ AD=0.0522P PS=0.8U PD=0.65U
* device instance $1084 r0 *1 14.7,56.675 sky130_fd_pr__nfet_01v8
M$1084 1005 971 90 90 sky130_fd_pr__nfet_01v8 L=0.15U W=0.42U AS=0.12095P
+ AD=0.0759P PS=1.085U PD=0.8U
* device instance $1085 r0 *1 15.295,56.565 sky130_fd_pr__nfet_01v8
M$1085 971 970 90 90 sky130_fd_pr__nfet_01v8 L=0.15U W=0.64U AS=0.12095P
+ AD=0.1664P PS=1.085U PD=1.8U
* device instance $1086 r0 *1 16.235,56.675 sky130_fd_pr__nfet_01v8
M$1086 1006 971 90 90 sky130_fd_pr__nfet_01v8 L=0.15U W=0.42U AS=0.1092P
+ AD=0.0678P PS=1.36U PD=0.755U
* device instance $1087 r0 *1 16.72,56.705 sky130_fd_pr__nfet_01v8
M$1087 972 967 1006 1006 sky130_fd_pr__nfet_01v8 L=0.15U W=0.36U AS=0.0678P
+ AD=0.0684P PS=0.755U PD=0.74U
* device instance $1088 r0 *1 17.25,56.705 sky130_fd_pr__nfet_01v8
M$1088 972 966 1007 1007 sky130_fd_pr__nfet_01v8 L=0.15U W=0.36U AS=0.066P
+ AD=0.0684P PS=0.745U PD=0.74U
* device instance $1089 r0 *1 17.725,56.675 sky130_fd_pr__nfet_01v8
M$1089 90 973 1007 1007 sky130_fd_pr__nfet_01v8 L=0.15U W=0.42U AS=0.066P
+ AD=0.1092P PS=0.745U PD=1.36U
* device instance $1090 r0 *1 18.665,56.675 sky130_fd_pr__nfet_01v8
M$1090 973 972 90 90 sky130_fd_pr__nfet_01v8 L=0.15U W=0.42U AS=0.10025P
+ AD=0.1092P PS=0.985U PD=1.36U
* device instance $1091 r0 *1 19.15,56.56 sky130_fd_pr__nfet_01v8
M$1091 937 972 90 90 sky130_fd_pr__nfet_01v8 L=0.15U W=0.65U AS=0.10025P
+ AD=0.182P PS=0.985U PD=1.86U
* device instance $1092 r0 *1 28.29,56.56 sky130_fd_pr__nfet_01v8
M$1092 977 986 90 90 sky130_fd_pr__nfet_01v8 L=0.15U W=0.65U AS=0.169P
+ AD=0.08775P PS=1.82U PD=0.92U
* device instance $1093 r0 *1 28.71,56.56 sky130_fd_pr__nfet_01v8
M$1093 90 974 977 977 sky130_fd_pr__nfet_01v8 L=0.15U W=0.65U AS=0.08775P
+ AD=0.10025P PS=0.92U PD=0.985U
* device instance $1094 r0 *1 29.195,56.675 sky130_fd_pr__nfet_01v8
M$1094 986 909 90 90 sky130_fd_pr__nfet_01v8 L=0.15U W=0.42U AS=0.10025P
+ AD=0.1092P PS=0.985U PD=1.36U
* device instance $1095 r0 *1 31.23,56.56 sky130_fd_pr__nfet_01v8
M$1095 987 108 90 90 sky130_fd_pr__nfet_01v8 L=0.15U W=2.6U AS=0.43225P
+ AD=0.351P PS=4.58U PD=3.68U
* device instance $1096 r0 *1 31.65,56.56 sky130_fd_pr__nfet_01v8
M$1096 90 977 987 987 sky130_fd_pr__nfet_01v8 L=0.15U W=2.6U AS=0.351P
+ AD=0.351P PS=3.68U PD=3.68U
* device instance $1103 r0 *1 34.59,56.56 sky130_fd_pr__nfet_01v8
M$1103 987 978 90 90 sky130_fd_pr__nfet_01v8 L=0.15U W=2.6U AS=0.351P
+ AD=0.44525P PS=3.68U PD=4.62U
* device instance $1107 r0 *1 43.26,56.675 sky130_fd_pr__nfet_01v8
M$1107 979 856 90 90 sky130_fd_pr__nfet_01v8 L=0.15U W=0.84U AS=0.1701P
+ AD=0.168P PS=2.07U PD=2.06U
* device instance $1109 r0 *1 44.635,56.675 sky130_fd_pr__nfet_01v8
M$1109 980 310 90 90 sky130_fd_pr__nfet_01v8 L=0.15U W=1.68U AS=0.2877P
+ AD=0.2352P PS=3.47U PD=2.8U
* device instance $1113 r0 *1 46.355,56.675 sky130_fd_pr__nfet_01v8
M$1113 856 980 90 90 sky130_fd_pr__nfet_01v8 L=0.15U W=6.72U AS=0.93975P
+ AD=0.99225P PS=11.195U PD=11.865U
* device instance $1129 r0 *1 59.38,56.675 sky130_fd_pr__nfet_01v8
M$1129 90 803 999 999 sky130_fd_pr__nfet_01v8 L=0.15U W=0.42U AS=0.1113P
+ AD=0.0588P PS=1.37U PD=0.7U
* device instance $1130 r0 *1 59.81,56.675 sky130_fd_pr__nfet_01v8
M$1130 999 948 90 90 sky130_fd_pr__nfet_01v8 L=0.15U W=0.42U AS=0.0588P
+ AD=0.0588P PS=0.7U PD=0.7U
* device instance $1131 r0 *1 60.24,56.675 sky130_fd_pr__nfet_01v8
M$1131 981 982 999 999 sky130_fd_pr__nfet_01v8 L=0.15U W=0.42U AS=0.0588P
+ AD=0.1113P PS=0.7U PD=1.37U
* device instance $1132 r0 *1 62.115,56.56 sky130_fd_pr__nfet_01v8
M$1132 1009 941 983 983 sky130_fd_pr__nfet_01v8 L=0.15U W=0.65U AS=0.17225P
+ AD=0.06825P PS=1.83U PD=0.86U
* device instance $1133 r0 *1 62.475,56.56 sky130_fd_pr__nfet_01v8
M$1133 90 981 1009 1009 sky130_fd_pr__nfet_01v8 L=0.15U W=0.65U AS=0.06825P
+ AD=0.138125P PS=0.86U PD=1.075U
* device instance $1134 r0 *1 63.05,56.56 sky130_fd_pr__nfet_01v8
M$1134 984 983 90 90 sky130_fd_pr__nfet_01v8 L=0.15U W=2.6U AS=0.411125P
+ AD=0.45825P PS=3.865U PD=4.66U
* device instance $1138 r0 *1 65.355,56.675 sky130_fd_pr__nfet_01v8
M$1138 982 985 90 90 sky130_fd_pr__nfet_01v8 L=0.15U W=0.42U AS=0.1197P
+ AD=0.1092P PS=1.41U PD=1.36U
* device instance $1139 r0 *1 68.07,56.445 sky130_fd_pr__nfet_01v8
M$1139 988 989 90 90 sky130_fd_pr__nfet_01v8 L=0.15U W=0.42U AS=0.10025P
+ AD=0.1092P PS=0.985U PD=1.36U
* device instance $1140 r0 *1 67.165,56.56 sky130_fd_pr__nfet_01v8
M$1140 1008 988 1000 1000 sky130_fd_pr__nfet_01v8 L=0.15U W=0.65U AS=0.169P
+ AD=0.08775P PS=1.82U PD=0.92U
* device instance $1141 r0 *1 67.585,56.56 sky130_fd_pr__nfet_01v8
M$1141 90 949 1008 1008 sky130_fd_pr__nfet_01v8 L=0.15U W=0.65U AS=0.08775P
+ AD=0.10025P PS=0.92U PD=0.985U
* device instance $1142 r0 *1 69.05,56.56 sky130_fd_pr__nfet_01v8
M$1142 1001 990 985 985 sky130_fd_pr__nfet_01v8 L=0.15U W=0.65U AS=0.195P
+ AD=0.08775P PS=1.9U PD=0.92U
* device instance $1143 r0 *1 69.47,56.56 sky130_fd_pr__nfet_01v8
M$1143 90 949 1001 1001 sky130_fd_pr__nfet_01v8 L=0.15U W=0.65U AS=0.08775P
+ AD=0.169P PS=0.92U PD=1.82U
* device instance $1144 r0 *1 70.41,56.56 sky130_fd_pr__nfet_01v8
M$1144 90 989 1001 1001 sky130_fd_pr__nfet_01v8 L=0.15U W=0.65U AS=0.169P
+ AD=0.08775P PS=1.82U PD=0.92U
* device instance $1145 r0 *1 70.83,56.56 sky130_fd_pr__nfet_01v8
M$1145 1002 989 90 90 sky130_fd_pr__nfet_01v8 L=0.15U W=0.65U AS=0.08775P
+ AD=0.06825P PS=0.92U PD=0.86U
* device instance $1146 r0 *1 71.19,56.56 sky130_fd_pr__nfet_01v8
M$1146 990 949 1002 1002 sky130_fd_pr__nfet_01v8 L=0.15U W=0.65U AS=0.06825P
+ AD=0.169P PS=0.86U PD=1.82U
* device instance $1147 r0 *1 15.665,62 sky130_fd_pr__nfet_01v8
M$1147 90 1061 1046 1046 sky130_fd_pr__nfet_01v8 L=0.15U W=0.65U AS=0.169P
+ AD=0.105625P PS=1.82U PD=0.975U
* device instance $1148 r0 *1 16.14,62 sky130_fd_pr__nfet_01v8
M$1148 55 1046 90 90 sky130_fd_pr__nfet_01v8 L=0.15U W=2.6U AS=0.37375P
+ AD=0.453375P PS=3.75U PD=4.645U
* device instance $1152 r0 *1 20.73,62 sky130_fd_pr__nfet_01v8
M$1152 1062 1102 90 90 sky130_fd_pr__nfet_01v8 L=0.15U W=2.6U AS=0.44525P
+ AD=0.351P PS=4.62U PD=3.68U
* device instance $1156 r0 *1 22.41,62 sky130_fd_pr__nfet_01v8
M$1156 1062 1010 90 90 sky130_fd_pr__nfet_01v8 L=0.15U W=2.6U AS=0.351P
+ AD=0.59475P PS=3.68U PD=4.43U
* device instance $1160 r0 *1 24.84,62 sky130_fd_pr__nfet_01v8
M$1160 88 1048 90 90 sky130_fd_pr__nfet_01v8 L=0.15U W=5.2U AS=0.94575P
+ AD=0.702P PS=8.11U PD=7.36U
* device instance $1168 r0 *1 28.2,62 sky130_fd_pr__nfet_01v8
M$1168 1048 1062 90 90 sky130_fd_pr__nfet_01v8 L=0.15U W=1.95U AS=0.26325P
+ AD=0.3445P PS=2.76U PD=3.66U
* device instance $1171 r0 *1 24.87,57.68 sky130_fd_pr__nfet_01v8
M$1171 1010 55 90 90 sky130_fd_pr__nfet_01v8 L=0.15U W=1.3U AS=0.2665P
+ AD=0.1755P PS=2.77U PD=1.84U
* device instance $1173 r0 *1 25.71,57.68 sky130_fd_pr__nfet_01v8
M$1173 1010 977 90 90 sky130_fd_pr__nfet_01v8 L=0.15U W=1.3U AS=0.1755P
+ AD=0.25675P PS=1.84U PD=2.74U
* device instance $1175 r0 *1 27.09,57.68 sky130_fd_pr__nfet_01v8
M$1175 1010 1025 90 90 sky130_fd_pr__nfet_01v8 L=0.15U W=1.3U AS=0.25675P
+ AD=0.25675P PS=2.74U PD=2.74U
* device instance $1177 r0 *1 28.73,57.68 sky130_fd_pr__nfet_01v8
M$1177 90 977 1011 1011 sky130_fd_pr__nfet_01v8 L=0.15U W=1.3U AS=0.26975P
+ AD=0.1755P PS=2.78U PD=1.84U
* device instance $1179 r0 *1 29.57,57.68 sky130_fd_pr__nfet_01v8
M$1179 90 1025 1011 1011 sky130_fd_pr__nfet_01v8 L=0.15U W=1.3U AS=0.1755P
+ AD=0.1755P PS=1.84U PD=1.84U
* device instance $1181 r0 *1 30.41,57.68 sky130_fd_pr__nfet_01v8
M$1181 1012 1013 1011 1011 sky130_fd_pr__nfet_01v8 L=0.15U W=1.3U AS=0.1755P
+ AD=0.25675P PS=1.84U PD=2.74U
* device instance $1183 r0 *1 31.77,57.68 sky130_fd_pr__nfet_01v8
M$1183 129 1012 90 90 sky130_fd_pr__nfet_01v8 L=0.15U W=2.6U AS=0.43225P
+ AD=0.351P PS=4.58U PD=3.68U
* device instance $1187 r0 *1 33.45,57.68 sky130_fd_pr__nfet_01v8
M$1187 1013 108 90 90 sky130_fd_pr__nfet_01v8 L=0.15U W=0.65U AS=0.08775P
+ AD=0.19825P PS=0.92U PD=1.91U
* device instance $1188 r0 *1 32.21,62 sky130_fd_pr__nfet_01v8
M$1188 1049 977 90 90 sky130_fd_pr__nfet_01v8 L=0.15U W=0.65U AS=0.169P
+ AD=0.08775P PS=1.82U PD=0.92U
* device instance $1189 r0 *1 32.63,62 sky130_fd_pr__nfet_01v8
M$1189 90 1063 1049 1049 sky130_fd_pr__nfet_01v8 L=0.15U W=0.65U AS=0.08775P
+ AD=0.169P PS=0.92U PD=1.82U
* device instance $1190 r0 *1 33.825,62.115 sky130_fd_pr__nfet_01v8
M$1190 1064 974 90 90 sky130_fd_pr__nfet_01v8 L=0.15U W=0.42U AS=0.10025P
+ AD=0.1092P PS=0.985U PD=1.36U
* device instance $1191 r0 *1 34.31,62 sky130_fd_pr__nfet_01v8
M$1191 1063 909 90 90 sky130_fd_pr__nfet_01v8 L=0.15U W=0.65U AS=0.10025P
+ AD=0.08775P PS=0.985U PD=0.92U
* device instance $1192 r0 *1 34.73,62 sky130_fd_pr__nfet_01v8
M$1192 90 1064 1063 1063 sky130_fd_pr__nfet_01v8 L=0.15U W=0.65U AS=0.08775P
+ AD=0.169P PS=0.92U PD=1.82U
* device instance $1193 r0 *1 34.97,57.68 sky130_fd_pr__nfet_01v8
M$1193 90 978 1014 1014 sky130_fd_pr__nfet_01v8 L=0.15U W=0.65U AS=0.169P
+ AD=0.08775P PS=1.82U PD=0.92U
* device instance $1194 r0 *1 35.39,57.68 sky130_fd_pr__nfet_01v8
M$1194 1025 1014 90 90 sky130_fd_pr__nfet_01v8 L=0.15U W=2.6U AS=0.351P
+ AD=0.4615P PS=3.68U PD=4.02U
* device instance $1198 r0 *1 37.41,57.68 sky130_fd_pr__nfet_01v8
M$1198 1015 987 90 90 sky130_fd_pr__nfet_01v8 L=0.15U W=1.3U AS=0.286P
+ AD=0.1755P PS=2.18U PD=1.84U
* device instance $1200 r0 *1 38.25,57.68 sky130_fd_pr__nfet_01v8
M$1200 130 1015 90 90 sky130_fd_pr__nfet_01v8 L=0.15U W=3.9U AS=0.5265P
+ AD=0.60775P PS=5.52U PD=6.42U
* device instance $1206 r0 *1 40.03,62 sky130_fd_pr__nfet_01v8
M$1206 90 1065 1066 1066 sky130_fd_pr__nfet_01v8 L=0.15U W=1.3U AS=0.25675P
+ AD=0.25675P PS=2.74U PD=2.09U
* device instance $1208 r0 *1 41.12,62 sky130_fd_pr__nfet_01v8
M$1208 90 1063 1066 1066 sky130_fd_pr__nfet_01v8 L=0.15U W=1.3U AS=0.25675P
+ AD=0.18525P PS=2.09U PD=1.87U
* device instance $1210 r0 *1 41.99,62 sky130_fd_pr__nfet_01v8
M$1210 1085 1083 1066 1066 sky130_fd_pr__nfet_01v8 L=0.15U W=1.3U AS=0.18525P
+ AD=0.25675P PS=1.87U PD=2.74U
* device instance $1212 r0 *1 42.35,57.68 sky130_fd_pr__nfet_01v8
M$1212 1016 1027 90 90 sky130_fd_pr__nfet_01v8 L=0.15U W=0.65U AS=0.169P
+ AD=0.08775P PS=1.82U PD=0.92U
* device instance $1213 r0 *1 42.77,57.68 sky130_fd_pr__nfet_01v8
M$1213 90 1017 1016 1016 sky130_fd_pr__nfet_01v8 L=0.15U W=0.65U AS=0.08775P
+ AD=0.169P PS=0.92U PD=1.82U
* device instance $1214 r0 *1 43.35,62 sky130_fd_pr__nfet_01v8
M$1214 1085 1033 1082 1082 sky130_fd_pr__nfet_01v8 L=0.15U W=1.3U AS=0.25675P
+ AD=0.1755P PS=2.74U PD=1.84U
* device instance $1216 r0 *1 44.19,62 sky130_fd_pr__nfet_01v8
M$1216 90 1069 1082 1082 sky130_fd_pr__nfet_01v8 L=0.15U W=1.3U AS=0.1755P
+ AD=0.25675P PS=1.84U PD=2.74U
* device instance $1218 r0 *1 45.57,62 sky130_fd_pr__nfet_01v8
M$1218 1027 1083 90 90 sky130_fd_pr__nfet_01v8 L=0.15U W=0.65U AS=0.17225P
+ AD=0.091P PS=1.83U PD=0.93U
* device instance $1219 r0 *1 46,62 sky130_fd_pr__nfet_01v8
M$1219 1096 1069 1027 1027 sky130_fd_pr__nfet_01v8 L=0.15U W=0.65U AS=0.091P
+ AD=0.095875P PS=0.93U PD=0.945U
* device instance $1220 r0 *1 46.445,62 sky130_fd_pr__nfet_01v8
M$1220 90 1070 1096 1096 sky130_fd_pr__nfet_01v8 L=0.15U W=0.65U AS=0.095875P
+ AD=0.17225P PS=0.945U PD=1.83U
* device instance $1221 r0 *1 46.01,57.68 sky130_fd_pr__nfet_01v8
M$1221 90 987 1018 1018 sky130_fd_pr__nfet_01v8 L=0.15U W=0.65U AS=0.169P
+ AD=0.08775P PS=1.82U PD=0.92U
* device instance $1222 r0 *1 46.43,57.68 sky130_fd_pr__nfet_01v8
M$1222 1019 1018 90 90 sky130_fd_pr__nfet_01v8 L=0.15U W=2.6U AS=0.351P
+ AD=0.54275P PS=3.68U PD=4.27U
* device instance $1226 r0 *1 48.7,57.68 sky130_fd_pr__nfet_01v8
M$1226 1020 850 90 90 sky130_fd_pr__nfet_01v8 L=0.15U W=2.6U AS=0.54275P
+ AD=0.351P PS=4.27U PD=3.68U
* device instance $1230 r0 *1 50.38,57.68 sky130_fd_pr__nfet_01v8
M$1230 1020 803 90 90 sky130_fd_pr__nfet_01v8 L=0.15U W=2.6U AS=0.351P
+ AD=0.3575P PS=3.68U PD=3.7U
* device instance $1234 r0 *1 52.08,57.68 sky130_fd_pr__nfet_01v8
M$1234 1020 982 90 90 sky130_fd_pr__nfet_01v8 L=0.15U W=2.6U AS=0.3575P
+ AD=0.44525P PS=3.7U PD=4.62U
* device instance $1238 r0 *1 47.39,62 sky130_fd_pr__nfet_01v8
M$1238 90 1068 1017 1017 sky130_fd_pr__nfet_01v8 L=0.15U W=0.65U AS=0.169P
+ AD=0.13165P PS=1.82U PD=1.14U
* device instance $1239 r0 *1 48.03,62.115 sky130_fd_pr__nfet_01v8
M$1239 1095 1070 90 90 sky130_fd_pr__nfet_01v8 L=0.15U W=0.42U AS=0.13165P
+ AD=0.0441P PS=1.14U PD=0.63U
* device instance $1240 r0 *1 48.39,62.115 sky130_fd_pr__nfet_01v8
M$1240 1094 1069 1095 1095 sky130_fd_pr__nfet_01v8 L=0.15U W=0.42U AS=0.0441P
+ AD=0.0441P PS=0.63U PD=0.63U
* device instance $1241 r0 *1 48.75,62.115 sky130_fd_pr__nfet_01v8
M$1241 1068 1083 1094 1094 sky130_fd_pr__nfet_01v8 L=0.15U W=0.42U AS=0.0441P
+ AD=0.1092P PS=0.63U PD=1.36U
* device instance $1242 r0 *1 49.69,62 sky130_fd_pr__nfet_01v8
M$1242 90 1065 1071 1071 sky130_fd_pr__nfet_01v8 L=0.15U W=1.3U AS=0.28275P
+ AD=0.23075P PS=2.82U PD=2.01U
* device instance $1244 r0 *1 50.7,62 sky130_fd_pr__nfet_01v8
M$1244 1086 1083 1071 1071 sky130_fd_pr__nfet_01v8 L=0.15U W=1.3U AS=0.2145P
+ AD=0.2665P PS=1.96U PD=2.77U
* device instance $1246 r0 *1 52.09,62 sky130_fd_pr__nfet_01v8
M$1246 1086 1070 1084 1084 sky130_fd_pr__nfet_01v8 L=0.15U W=1.3U AS=0.25675P
+ AD=0.1755P PS=2.74U PD=1.84U
* device instance $1248 r0 *1 52.93,62 sky130_fd_pr__nfet_01v8
M$1248 90 1069 1084 1084 sky130_fd_pr__nfet_01v8 L=0.15U W=1.3U AS=0.1755P
+ AD=0.25675P PS=1.84U PD=2.74U
* device instance $1250 r0 *1 54.32,57.68 sky130_fd_pr__nfet_01v8
M$1250 1020 1000 1021 1021 sky130_fd_pr__nfet_01v8 L=0.15U W=2.6U AS=0.44525P
+ AD=0.351P PS=4.62U PD=3.68U
* device instance $1254 r0 *1 56,57.68 sky130_fd_pr__nfet_01v8
M$1254 1033 1022 1021 1021 sky130_fd_pr__nfet_01v8 L=0.15U W=2.6U AS=0.351P
+ AD=0.44525P PS=3.68U PD=4.62U
* device instance $1258 r0 *1 60.27,57.68 sky130_fd_pr__nfet_01v8
M$1258 90 1028 1023 1023 sky130_fd_pr__nfet_01v8 L=0.15U W=0.65U AS=0.169P
+ AD=0.10725P PS=1.82U PD=0.98U
* device instance $1259 r0 *1 60.75,57.68 sky130_fd_pr__nfet_01v8
M$1259 1031 989 90 90 sky130_fd_pr__nfet_01v8 L=0.15U W=0.65U AS=0.10725P
+ AD=0.06825P PS=0.98U PD=0.86U
* device instance $1260 r0 *1 61.11,57.68 sky130_fd_pr__nfet_01v8
M$1260 1023 129 1031 1031 sky130_fd_pr__nfet_01v8 L=0.15U W=0.65U AS=0.06825P
+ AD=0.169P PS=0.86U PD=1.82U
* device instance $1261 r0 *1 62.05,57.68 sky130_fd_pr__nfet_01v8
M$1261 1030 1019 1023 1023 sky130_fd_pr__nfet_01v8 L=0.15U W=0.65U AS=0.169P
+ AD=0.10725P PS=1.82U PD=0.98U
* device instance $1262 r0 *1 62.53,57.68 sky130_fd_pr__nfet_01v8
M$1262 90 984 1030 1030 sky130_fd_pr__nfet_01v8 L=0.15U W=0.65U AS=0.10725P
+ AD=0.102375P PS=0.98U PD=0.965U
* device instance $1263 r0 *1 62.995,57.68 sky130_fd_pr__nfet_01v8
M$1263 1038 1023 90 90 sky130_fd_pr__nfet_01v8 L=0.15U W=0.65U AS=0.102375P
+ AD=0.169P PS=0.965U PD=1.82U
* device instance $1264 r0 *1 63.97,57.68 sky130_fd_pr__nfet_01v8
M$1264 1029 941 90 90 sky130_fd_pr__nfet_01v8 L=0.15U W=0.65U AS=0.169P
+ AD=0.08775P PS=1.82U PD=0.92U
* device instance $1265 r0 *1 64.39,57.68 sky130_fd_pr__nfet_01v8
M$1265 1039 1000 1029 1029 sky130_fd_pr__nfet_01v8 L=0.15U W=0.65U AS=0.08775P
+ AD=0.169P PS=0.92U PD=1.82U
* device instance $1266 r0 *1 72.945,62.115 sky130_fd_pr__nfet_01v8
M$1266 1060 1059 90 90 sky130_fd_pr__nfet_01v8 L=0.15U W=0.42U AS=0.10025P
+ AD=0.1092P PS=0.985U PD=1.36U
* device instance $1267 r0 *1 73.43,62 sky130_fd_pr__nfet_01v8
M$1267 949 1059 90 90 sky130_fd_pr__nfet_01v8 L=0.15U W=0.65U AS=0.10025P
+ AD=0.182P PS=0.985U PD=1.86U
* device instance $1268 r0 *1 8.245,63.005 sky130_fd_pr__nfet_01v8
M$1268 90 1118 1097 1097 sky130_fd_pr__nfet_01v8 L=0.15U W=0.42U AS=0.1092P
+ AD=0.1197P PS=1.36U PD=1.41U
* device instance $1269 r0 *1 9.21,63.12 sky130_fd_pr__nfet_01v8
M$1269 1099 1135 1098 1098 sky130_fd_pr__nfet_01v8 L=0.15U W=0.65U AS=0.169P
+ AD=0.092625P PS=1.82U PD=0.935U
* device instance $1270 r0 *1 9.645,63.12 sky130_fd_pr__nfet_01v8
M$1270 1098 1118 1099 1099 sky130_fd_pr__nfet_01v8 L=0.15U W=0.65U AS=0.092625P
+ AD=0.115375P PS=0.935U PD=1.005U
* device instance $1271 r0 *1 10.15,63.12 sky130_fd_pr__nfet_01v8
M$1271 90 1100 1098 1098 sky130_fd_pr__nfet_01v8 L=0.15U W=0.65U AS=0.115375P
+ AD=0.08775P PS=1.005U PD=0.92U
* device instance $1272 r0 *1 10.57,63.12 sky130_fd_pr__nfet_01v8
M$1272 1098 894 90 90 sky130_fd_pr__nfet_01v8 L=0.15U W=0.65U AS=0.08775P
+ AD=0.169P PS=0.92U PD=1.82U
* device instance $1273 r0 *1 9.67,62.115 sky130_fd_pr__nfet_01v8
M$1273 90 939 1041 1041 sky130_fd_pr__nfet_01v8 L=0.15U W=0.42U AS=0.1092P
+ AD=0.0567P PS=1.36U PD=0.69U
* device instance $1274 r0 *1 10.09,62.115 sky130_fd_pr__nfet_01v8
M$1274 1043 1041 90 90 sky130_fd_pr__nfet_01v8 L=0.15U W=0.42U AS=0.0567P
+ AD=0.1092P PS=0.69U PD=1.36U
* device instance $1275 r0 *1 11.03,62.115 sky130_fd_pr__nfet_01v8
M$1275 1042 1081 90 90 sky130_fd_pr__nfet_01v8 L=0.15U W=0.42U AS=0.1092P
+ AD=0.066P PS=1.36U PD=0.745U
* device instance $1276 r0 *1 11.505,62.145 sky130_fd_pr__nfet_01v8
M$1276 1044 1041 1042 1042 sky130_fd_pr__nfet_01v8 L=0.15U W=0.36U AS=0.066P
+ AD=0.0594P PS=0.745U PD=0.69U
* device instance $1277 r0 *1 11.985,62.145 sky130_fd_pr__nfet_01v8
M$1277 1044 1043 1089 1089 sky130_fd_pr__nfet_01v8 L=0.15U W=0.36U AS=0.0687P
+ AD=0.0594P PS=0.76U PD=0.69U
* device instance $1278 r0 *1 12.475,62.115 sky130_fd_pr__nfet_01v8
M$1278 1089 1045 90 90 sky130_fd_pr__nfet_01v8 L=0.15U W=0.42U AS=0.1493P
+ AD=0.0687P PS=1.22U PD=0.76U
* device instance $1279 r0 *1 13.205,62.005 sky130_fd_pr__nfet_01v8
M$1279 1045 1044 90 90 sky130_fd_pr__nfet_01v8 L=0.15U W=0.64U AS=0.1493P
+ AD=0.0989P PS=1.22U PD=0.995U
* device instance $1280 r0 *1 13.71,62.145 sky130_fd_pr__nfet_01v8
M$1280 1061 1043 1045 1045 sky130_fd_pr__nfet_01v8 L=0.15U W=0.36U AS=0.0989P
+ AD=0.0657P PS=0.995U PD=0.725U
* device instance $1281 r0 *1 14.225,62.145 sky130_fd_pr__nfet_01v8
M$1281 1061 1041 1091 1091 sky130_fd_pr__nfet_01v8 L=0.15U W=0.36U AS=0.066P
+ AD=0.0657P PS=0.745U PD=0.725U
* device instance $1282 r0 *1 14.7,62.115 sky130_fd_pr__nfet_01v8
M$1282 90 1046 1091 1091 sky130_fd_pr__nfet_01v8 L=0.15U W=0.42U AS=0.066P
+ AD=0.1197P PS=0.745U PD=1.41U
* device instance $1283 r0 *1 11.53,63.12 sky130_fd_pr__nfet_01v8
M$1283 1126 1119 90 90 sky130_fd_pr__nfet_01v8 L=0.15U W=0.65U AS=0.169P
+ AD=0.08775P PS=1.82U PD=0.92U
* device instance $1284 r0 *1 11.95,63.12 sky130_fd_pr__nfet_01v8
M$1284 108 1101 1126 1126 sky130_fd_pr__nfet_01v8 L=0.15U W=0.65U AS=0.08775P
+ AD=0.169P PS=0.92U PD=1.82U
* device instance $1285 r0 *1 12.915,63.005 sky130_fd_pr__nfet_01v8
M$1285 1101 55 90 90 sky130_fd_pr__nfet_01v8 L=0.15U W=0.42U AS=0.1197P
+ AD=0.1092P PS=1.41U PD=1.36U
* device instance $1286 r0 *1 17.05,63.12 sky130_fd_pr__nfet_01v8
M$1286 1102 1119 90 90 sky130_fd_pr__nfet_01v8 L=0.15U W=2.6U AS=0.44525P
+ AD=0.351P PS=4.62U PD=3.68U
* device instance $1290 r0 *1 18.73,63.12 sky130_fd_pr__nfet_01v8
M$1290 1102 55 90 90 sky130_fd_pr__nfet_01v8 L=0.15U W=2.6U AS=0.351P
+ AD=0.43225P PS=3.68U PD=4.58U
* device instance $1294 r0 *1 22.255,63.12 sky130_fd_pr__nfet_01v8
M$1294 311 1102 90 90 sky130_fd_pr__nfet_01v8 L=0.15U W=5.2U AS=0.78325P
+ AD=0.923P PS=8.26U PD=8.04U
* device instance $1302 r0 *1 26.295,63.12 sky130_fd_pr__nfet_01v8
M$1302 1103 1062 90 90 sky130_fd_pr__nfet_01v8 L=0.15U W=1.3U AS=0.3965P
+ AD=0.1755P PS=2.52U PD=1.84U
* device instance $1304 r0 *1 27.135,63.12 sky130_fd_pr__nfet_01v8
M$1304 1134 1103 90 90 sky130_fd_pr__nfet_01v8 L=0.15U W=3.9U AS=0.5265P
+ AD=0.60775P PS=5.52U PD=6.42U
* device instance $1310 r0 *1 30.37,63.005 sky130_fd_pr__nfet_01v8
M$1310 90 939 1104 1104 sky130_fd_pr__nfet_01v8 L=0.15U W=0.42U AS=0.1092P
+ AD=0.0567P PS=1.36U PD=0.69U
* device instance $1311 r0 *1 30.79,63.005 sky130_fd_pr__nfet_01v8
M$1311 1105 1104 90 90 sky130_fd_pr__nfet_01v8 L=0.15U W=0.42U AS=0.0567P
+ AD=0.1092P PS=0.69U PD=1.36U
* device instance $1312 r0 *1 31.73,63.005 sky130_fd_pr__nfet_01v8
M$1312 1132 1120 1106 1106 sky130_fd_pr__nfet_01v8 L=0.15U W=0.42U AS=0.1092P
+ AD=0.0441P PS=1.36U PD=0.63U
* device instance $1313 r0 *1 32.09,63.005 sky130_fd_pr__nfet_01v8
M$1313 90 311 1132 1132 sky130_fd_pr__nfet_01v8 L=0.15U W=0.42U AS=0.0441P
+ AD=0.1092P PS=0.63U PD=1.36U
* device instance $1314 r0 *1 34.89,62.975 sky130_fd_pr__nfet_01v8
M$1314 1108 1104 1106 1106 sky130_fd_pr__nfet_01v8 L=0.15U W=0.36U AS=0.1446P
+ AD=0.0522P PS=1.18U PD=0.65U
* device instance $1315 r0 *1 35.33,62.975 sky130_fd_pr__nfet_01v8
M$1315 1130 1105 1108 1108 sky130_fd_pr__nfet_01v8 L=0.15U W=0.36U AS=0.0522P
+ AD=0.0759P PS=0.65U PD=0.8U
* device instance $1316 r0 *1 33.03,63.005 sky130_fd_pr__nfet_01v8
M$1316 90 311 1107 1107 sky130_fd_pr__nfet_01v8 L=0.15U W=0.42U AS=0.1092P
+ AD=0.0609P PS=1.36U PD=0.71U
* device instance $1317 r0 *1 33.47,63.005 sky130_fd_pr__nfet_01v8
M$1317 1131 1107 90 90 sky130_fd_pr__nfet_01v8 L=0.15U W=0.42U AS=0.0609P
+ AD=0.0756P PS=0.71U PD=0.78U
* device instance $1318 r0 *1 33.98,63.005 sky130_fd_pr__nfet_01v8
M$1318 1106 1121 1131 1131 sky130_fd_pr__nfet_01v8 L=0.15U W=0.42U AS=0.0756P
+ AD=0.1446P PS=0.78U PD=1.18U
* device instance $1319 r0 *1 35.86,63.005 sky130_fd_pr__nfet_01v8
M$1319 90 1109 1130 1130 sky130_fd_pr__nfet_01v8 L=0.15U W=0.42U AS=0.0759P
+ AD=0.12095P PS=0.8U PD=1.085U
* device instance $1320 r0 *1 36.455,63.115 sky130_fd_pr__nfet_01v8
M$1320 1109 1108 90 90 sky130_fd_pr__nfet_01v8 L=0.15U W=0.64U AS=0.12095P
+ AD=0.1664P PS=1.085U PD=1.8U
* device instance $1321 r0 *1 37.88,62.975 sky130_fd_pr__nfet_01v8
M$1321 1110 1105 1129 1129 sky130_fd_pr__nfet_01v8 L=0.15U W=0.36U AS=0.0678P
+ AD=0.0684P PS=0.755U PD=0.74U
* device instance $1322 r0 *1 38.41,62.975 sky130_fd_pr__nfet_01v8
M$1322 1128 1104 1110 1110 sky130_fd_pr__nfet_01v8 L=0.15U W=0.36U AS=0.0684P
+ AD=0.066P PS=0.74U PD=0.745U
* device instance $1323 r0 *1 37.395,63.005 sky130_fd_pr__nfet_01v8
M$1323 1129 1109 90 90 sky130_fd_pr__nfet_01v8 L=0.15U W=0.42U AS=0.1092P
+ AD=0.0678P PS=1.36U PD=0.755U
* device instance $1324 r0 *1 38.885,63.005 sky130_fd_pr__nfet_01v8
M$1324 90 1121 1128 1128 sky130_fd_pr__nfet_01v8 L=0.15U W=0.42U AS=0.066P
+ AD=0.1092P PS=0.745U PD=1.36U
* device instance $1325 r0 *1 39.825,63.005 sky130_fd_pr__nfet_01v8
M$1325 90 1110 1121 1121 sky130_fd_pr__nfet_01v8 L=0.15U W=0.42U AS=0.1092P
+ AD=0.10025P PS=1.36U PD=0.985U
* device instance $1326 r0 *1 40.31,63.12 sky130_fd_pr__nfet_01v8
M$1326 974 1110 90 90 sky130_fd_pr__nfet_01v8 L=0.15U W=0.65U AS=0.10025P
+ AD=0.182P PS=0.985U PD=1.86U
* device instance $1327 r0 *1 41.41,63.12 sky130_fd_pr__nfet_01v8
M$1327 90 1066 1111 1111 sky130_fd_pr__nfet_01v8 L=0.15U W=0.65U AS=0.169P
+ AD=0.08775P PS=1.82U PD=0.92U
* device instance $1328 r0 *1 41.83,63.12 sky130_fd_pr__nfet_01v8
M$1328 978 1111 90 90 sky130_fd_pr__nfet_01v8 L=0.15U W=2.6U AS=0.351P
+ AD=0.43225P PS=3.68U PD=4.58U
* device instance $1332 r0 *1 45.59,63.12 sky130_fd_pr__nfet_01v8
M$1332 1113 1112 1083 1083 sky130_fd_pr__nfet_01v8 L=0.15U W=0.65U AS=0.195P
+ AD=0.08775P PS=1.9U PD=0.92U
* device instance $1333 r0 *1 46.01,63.12 sky130_fd_pr__nfet_01v8
M$1333 90 694 1113 1113 sky130_fd_pr__nfet_01v8 L=0.15U W=0.65U AS=0.08775P
+ AD=0.169P PS=0.92U PD=1.82U
* device instance $1334 r0 *1 46.95,63.12 sky130_fd_pr__nfet_01v8
M$1334 90 1122 1113 1113 sky130_fd_pr__nfet_01v8 L=0.15U W=0.65U AS=0.169P
+ AD=0.08775P PS=1.82U PD=0.92U
* device instance $1335 r0 *1 47.37,63.12 sky130_fd_pr__nfet_01v8
M$1335 1127 1122 90 90 sky130_fd_pr__nfet_01v8 L=0.15U W=0.65U AS=0.08775P
+ AD=0.06825P PS=0.92U PD=0.86U
* device instance $1336 r0 *1 47.73,63.12 sky130_fd_pr__nfet_01v8
M$1336 1112 694 1127 1127 sky130_fd_pr__nfet_01v8 L=0.15U W=0.65U AS=0.06825P
+ AD=0.169P PS=0.86U PD=1.82U
* device instance $1337 r0 *1 48.76,63.12 sky130_fd_pr__nfet_01v8
M$1337 1070 1114 90 90 sky130_fd_pr__nfet_01v8 L=0.15U W=2.6U AS=0.43225P
+ AD=0.351P PS=4.58U PD=3.68U
* device instance $1341 r0 *1 50.44,63.12 sky130_fd_pr__nfet_01v8
M$1341 1114 1033 90 90 sky130_fd_pr__nfet_01v8 L=0.15U W=0.65U AS=0.08775P
+ AD=0.169P PS=0.92U PD=1.82U
* device instance $1342 r0 *1 51.765,63.005 sky130_fd_pr__nfet_01v8
M$1342 90 1122 1115 1115 sky130_fd_pr__nfet_01v8 L=0.15U W=0.42U AS=0.1092P
+ AD=0.10025P PS=1.36U PD=0.985U
* device instance $1343 r0 *1 52.25,63.12 sky130_fd_pr__nfet_01v8
M$1343 1065 694 90 90 sky130_fd_pr__nfet_01v8 L=0.15U W=0.65U AS=0.10025P
+ AD=0.08775P PS=0.985U PD=0.92U
* device instance $1344 r0 *1 52.67,63.12 sky130_fd_pr__nfet_01v8
M$1344 90 1115 1065 1065 sky130_fd_pr__nfet_01v8 L=0.15U W=0.65U AS=0.08775P
+ AD=0.169P PS=0.92U PD=1.82U
* device instance $1345 r0 *1 63.49,62.115 sky130_fd_pr__nfet_01v8
M$1345 90 856 1053 1053 sky130_fd_pr__nfet_01v8 L=0.15U W=0.42U AS=0.1092P
+ AD=0.0567P PS=1.36U PD=0.69U
* device instance $1346 r0 *1 63.91,62.115 sky130_fd_pr__nfet_01v8
M$1346 1054 1053 90 90 sky130_fd_pr__nfet_01v8 L=0.15U W=0.42U AS=0.0567P
+ AD=0.1092P PS=0.69U PD=1.36U
* device instance $1347 r0 *1 64.85,62.115 sky130_fd_pr__nfet_01v8
M$1347 1093 1038 1055 1055 sky130_fd_pr__nfet_01v8 L=0.15U W=0.42U AS=0.1092P
+ AD=0.0441P PS=1.36U PD=0.63U
* device instance $1348 r0 *1 65.21,62.115 sky130_fd_pr__nfet_01v8
M$1348 90 311 1093 1093 sky130_fd_pr__nfet_01v8 L=0.15U W=0.42U AS=0.0441P
+ AD=0.1092P PS=0.63U PD=1.36U
* device instance $1349 r0 *1 64.41,63.235 sky130_fd_pr__nfet_01v8
M$1349 1116 1123 90 90 sky130_fd_pr__nfet_01v8 L=0.15U W=0.42U AS=0.10025P
+ AD=0.1092P PS=0.985U PD=1.36U
* device instance $1350 r0 *1 64.895,63.12 sky130_fd_pr__nfet_01v8
M$1350 1125 1124 90 90 sky130_fd_pr__nfet_01v8 L=0.15U W=0.65U AS=0.10025P
+ AD=0.08775P PS=0.985U PD=0.92U
* device instance $1351 r0 *1 65.315,63.12 sky130_fd_pr__nfet_01v8
M$1351 1069 1116 1125 1125 sky130_fd_pr__nfet_01v8 L=0.15U W=0.65U AS=0.08775P
+ AD=0.169P PS=0.92U PD=1.82U
* device instance $1352 r0 *1 66.15,62.115 sky130_fd_pr__nfet_01v8
M$1352 90 311 1056 1056 sky130_fd_pr__nfet_01v8 L=0.15U W=0.42U AS=0.1092P
+ AD=0.0609P PS=1.36U PD=0.71U
* device instance $1353 r0 *1 66.59,62.115 sky130_fd_pr__nfet_01v8
M$1353 1092 1056 90 90 sky130_fd_pr__nfet_01v8 L=0.15U W=0.42U AS=0.0609P
+ AD=0.0756P PS=0.71U PD=0.78U
* device instance $1354 r0 *1 67.1,62.115 sky130_fd_pr__nfet_01v8
M$1354 1055 1060 1092 1092 sky130_fd_pr__nfet_01v8 L=0.15U W=0.42U AS=0.0756P
+ AD=0.1446P PS=0.78U PD=1.18U
* device instance $1355 r0 *1 68.01,62.145 sky130_fd_pr__nfet_01v8
M$1355 1057 1053 1055 1055 sky130_fd_pr__nfet_01v8 L=0.15U W=0.36U AS=0.1446P
+ AD=0.0522P PS=1.18U PD=0.65U
* device instance $1356 r0 *1 68.45,62.145 sky130_fd_pr__nfet_01v8
M$1356 1057 1054 1090 1090 sky130_fd_pr__nfet_01v8 L=0.15U W=0.36U AS=0.0759P
+ AD=0.0522P PS=0.8U PD=0.65U
* device instance $1357 r0 *1 68.98,62.115 sky130_fd_pr__nfet_01v8
M$1357 1090 1058 90 90 sky130_fd_pr__nfet_01v8 L=0.15U W=0.42U AS=0.12095P
+ AD=0.0759P PS=1.085U PD=0.8U
* device instance $1358 r0 *1 69.575,62.005 sky130_fd_pr__nfet_01v8
M$1358 1058 1057 90 90 sky130_fd_pr__nfet_01v8 L=0.15U W=0.64U AS=0.12095P
+ AD=0.1664P PS=1.085U PD=1.8U
* device instance $1359 r0 *1 66.655,63.12 sky130_fd_pr__nfet_01v8
M$1359 366 1117 90 90 sky130_fd_pr__nfet_01v8 L=0.15U W=2.6U AS=0.43225P
+ AD=0.351P PS=4.58U PD=3.68U
* device instance $1363 r0 *1 68.335,63.12 sky130_fd_pr__nfet_01v8
M$1363 1117 1124 90 90 sky130_fd_pr__nfet_01v8 L=0.15U W=0.65U AS=0.08775P
+ AD=0.169P PS=0.92U PD=1.82U
* device instance $1364 r0 *1 70.515,62.115 sky130_fd_pr__nfet_01v8
M$1364 1088 1058 90 90 sky130_fd_pr__nfet_01v8 L=0.15U W=0.42U AS=0.1092P
+ AD=0.0678P PS=1.36U PD=0.755U
* device instance $1365 r0 *1 71,62.145 sky130_fd_pr__nfet_01v8
M$1365 1059 1054 1088 1088 sky130_fd_pr__nfet_01v8 L=0.15U W=0.36U AS=0.0678P
+ AD=0.0684P PS=0.755U PD=0.74U
* device instance $1366 r0 *1 71.53,62.145 sky130_fd_pr__nfet_01v8
M$1366 1059 1053 1087 1087 sky130_fd_pr__nfet_01v8 L=0.15U W=0.36U AS=0.066P
+ AD=0.0684P PS=0.745U PD=0.74U
* device instance $1367 r0 *1 72.005,62.115 sky130_fd_pr__nfet_01v8
M$1367 90 1060 1087 1087 sky130_fd_pr__nfet_01v8 L=0.15U W=0.42U AS=0.066P
+ AD=0.1092P PS=0.745U PD=1.36U
* device instance $1368 r0 *1 5.09,67.44 sky130_fd_pr__nfet_01v8
M$1368 1205 1145 90 90 sky130_fd_pr__nfet_01v8 L=0.15U W=0.65U AS=0.169P
+ AD=0.08775P PS=1.82U PD=0.92U
* device instance $1369 r0 *1 5.51,67.44 sky130_fd_pr__nfet_01v8
M$1369 1135 55 1205 1205 sky130_fd_pr__nfet_01v8 L=0.15U W=0.65U AS=0.08775P
+ AD=0.169P PS=0.92U PD=1.82U
* device instance $1370 r0 *1 8.76,67.555 sky130_fd_pr__nfet_01v8
M$1370 1203 1178 1081 1081 sky130_fd_pr__nfet_01v8 L=0.15U W=0.42U AS=0.1113P
+ AD=0.0588P PS=1.37U PD=0.7U
* device instance $1371 r0 *1 9.19,67.555 sky130_fd_pr__nfet_01v8
M$1371 90 1145 1203 1203 sky130_fd_pr__nfet_01v8 L=0.15U W=0.42U AS=0.0588P
+ AD=0.0588P PS=0.7U PD=0.7U
* device instance $1372 r0 *1 9.62,67.555 sky130_fd_pr__nfet_01v8
M$1372 1203 1101 90 90 sky130_fd_pr__nfet_01v8 L=0.15U W=0.42U AS=0.0588P
+ AD=0.1113P PS=0.7U PD=1.37U
* device instance $1373 r0 *1 10.61,67.44 sky130_fd_pr__nfet_01v8
M$1373 1209 1097 90 90 sky130_fd_pr__nfet_01v8 L=0.15U W=0.65U AS=0.169P
+ AD=0.08775P PS=1.82U PD=0.92U
* device instance $1374 r0 *1 11.03,67.44 sky130_fd_pr__nfet_01v8
M$1374 1100 1119 1209 1209 sky130_fd_pr__nfet_01v8 L=0.15U W=0.65U AS=0.08775P
+ AD=0.169P PS=0.92U PD=1.82U
* device instance $1375 r0 *1 12.04,67.44 sky130_fd_pr__nfet_01v8
M$1375 90 1179 1146 1146 sky130_fd_pr__nfet_01v8 L=0.15U W=0.65U AS=0.2145P
+ AD=0.167375P PS=1.96U PD=1.165U
* device instance $1376 r0 *1 12.705,67.44 sky130_fd_pr__nfet_01v8
M$1376 1211 894 90 90 sky130_fd_pr__nfet_01v8 L=0.15U W=0.65U AS=0.167375P
+ AD=0.0975P PS=1.165U PD=0.95U
* device instance $1377 r0 *1 13.155,67.44 sky130_fd_pr__nfet_01v8
M$1377 1212 1097 1211 1211 sky130_fd_pr__nfet_01v8 L=0.15U W=0.65U AS=0.0975P
+ AD=0.14625P PS=0.95U PD=1.1U
* device instance $1378 r0 *1 13.755,67.44 sky130_fd_pr__nfet_01v8
M$1378 1179 1119 1212 1212 sky130_fd_pr__nfet_01v8 L=0.15U W=0.65U AS=0.14625P
+ AD=0.143P PS=1.1U PD=1.09U
* device instance $1379 r0 *1 14.345,67.44 sky130_fd_pr__nfet_01v8
M$1379 1213 1178 1179 1179 sky130_fd_pr__nfet_01v8 L=0.15U W=0.65U AS=0.143P
+ AD=0.06825P PS=1.09U PD=0.86U
* device instance $1380 r0 *1 14.705,67.44 sky130_fd_pr__nfet_01v8
M$1380 90 1148 1213 1213 sky130_fd_pr__nfet_01v8 L=0.15U W=0.65U AS=0.06825P
+ AD=0.17225P PS=0.86U PD=1.83U
* device instance $1381 r0 *1 15.83,67.415 sky130_fd_pr__nfet_01v8
M$1381 1215 1148 1180 1180 sky130_fd_pr__nfet_01v8 L=0.15U W=0.42U AS=0.1176P
+ AD=0.0567P PS=1.4U PD=0.69U
* device instance $1382 r0 *1 16.25,67.415 sky130_fd_pr__nfet_01v8
M$1382 1215 1102 90 90 sky130_fd_pr__nfet_01v8 L=0.15U W=0.42U AS=0.1118P
+ AD=0.0567P PS=1.04U PD=0.69U
* device instance $1383 r0 *1 16.79,67.44 sky130_fd_pr__nfet_01v8
M$1383 1149 1180 90 90 sky130_fd_pr__nfet_01v8 L=0.15U W=0.65U AS=0.1118P
+ AD=0.182P PS=1.04U PD=1.86U
* device instance $1384 r0 *1 24.71,67.555 sky130_fd_pr__nfet_01v8
M$1384 90 1151 1150 1150 sky130_fd_pr__nfet_01v8 L=0.15U W=0.42U AS=0.1113P
+ AD=0.0966P PS=1.37U PD=0.88U
* device instance $1385 r0 *1 25.32,67.555 sky130_fd_pr__nfet_01v8
M$1385 1217 108 90 90 sky130_fd_pr__nfet_01v8 L=0.15U W=0.42U AS=0.0966P
+ AD=0.0441P PS=0.88U PD=0.63U
* device instance $1386 r0 *1 25.68,67.555 sky130_fd_pr__nfet_01v8
M$1386 1151 1152 1217 1217 sky130_fd_pr__nfet_01v8 L=0.15U W=0.42U AS=0.0441P
+ AD=0.1113P PS=0.63U PD=1.37U
* device instance $1387 r0 *1 26.69,67.44 sky130_fd_pr__nfet_01v8
M$1387 90 1150 1153 1153 sky130_fd_pr__nfet_01v8 L=0.15U W=0.65U AS=0.169P
+ AD=0.10725P PS=1.82U PD=0.98U
* device instance $1388 r0 *1 27.17,67.44 sky130_fd_pr__nfet_01v8
M$1388 1219 909 90 90 sky130_fd_pr__nfet_01v8 L=0.15U W=0.65U AS=0.10725P
+ AD=0.06825P PS=0.98U PD=0.86U
* device instance $1389 r0 *1 27.53,67.44 sky130_fd_pr__nfet_01v8
M$1389 1153 129 1219 1219 sky130_fd_pr__nfet_01v8 L=0.15U W=0.65U AS=0.06825P
+ AD=0.169P PS=0.86U PD=1.82U
* device instance $1390 r0 *1 28.47,67.44 sky130_fd_pr__nfet_01v8
M$1390 1220 1182 1153 1153 sky130_fd_pr__nfet_01v8 L=0.15U W=0.65U AS=0.169P
+ AD=0.10725P PS=1.82U PD=0.98U
* device instance $1391 r0 *1 28.95,67.44 sky130_fd_pr__nfet_01v8
M$1391 90 987 1220 1220 sky130_fd_pr__nfet_01v8 L=0.15U W=0.65U AS=0.10725P
+ AD=0.102375P PS=0.98U PD=0.965U
* device instance $1392 r0 *1 29.415,67.44 sky130_fd_pr__nfet_01v8
M$1392 1120 1153 90 90 sky130_fd_pr__nfet_01v8 L=0.15U W=0.65U AS=0.102375P
+ AD=0.169P PS=0.965U PD=1.82U
* device instance $1393 r0 *1 32.25,67.44 sky130_fd_pr__nfet_01v8
M$1393 1204 1183 1182 1182 sky130_fd_pr__nfet_01v8 L=0.15U W=0.65U AS=0.195P
+ AD=0.08775P PS=1.9U PD=0.92U
* device instance $1394 r0 *1 32.67,67.44 sky130_fd_pr__nfet_01v8
M$1394 90 1071 1204 1204 sky130_fd_pr__nfet_01v8 L=0.15U W=0.65U AS=0.08775P
+ AD=0.169P PS=0.92U PD=1.82U
* device instance $1395 r0 *1 33.61,67.44 sky130_fd_pr__nfet_01v8
M$1395 90 1049 1204 1204 sky130_fd_pr__nfet_01v8 L=0.15U W=0.65U AS=0.169P
+ AD=0.08775P PS=1.82U PD=0.92U
* device instance $1396 r0 *1 34.03,67.44 sky130_fd_pr__nfet_01v8
M$1396 1224 1049 90 90 sky130_fd_pr__nfet_01v8 L=0.15U W=0.65U AS=0.08775P
+ AD=0.06825P PS=0.92U PD=0.86U
* device instance $1397 r0 *1 34.39,67.44 sky130_fd_pr__nfet_01v8
M$1397 1183 1071 1224 1224 sky130_fd_pr__nfet_01v8 L=0.15U W=0.65U AS=0.06825P
+ AD=0.169P PS=0.86U PD=1.82U
* device instance $1398 r0 *1 36.825,67.44 sky130_fd_pr__nfet_01v8
M$1398 90 1184 1155 1155 sky130_fd_pr__nfet_01v8 L=0.15U W=0.65U AS=0.169P
+ AD=0.102375P PS=1.82U PD=0.965U
* device instance $1399 r0 *1 37.29,67.44 sky130_fd_pr__nfet_01v8
M$1399 1225 1016 90 90 sky130_fd_pr__nfet_01v8 L=0.15U W=0.65U AS=0.102375P
+ AD=0.10725P PS=0.965U PD=0.98U
* device instance $1400 r0 *1 37.77,67.44 sky130_fd_pr__nfet_01v8
M$1400 1184 1287 1225 1225 sky130_fd_pr__nfet_01v8 L=0.15U W=0.65U AS=0.10725P
+ AD=0.169P PS=0.98U PD=1.82U
* device instance $1401 r0 *1 38.71,67.44 sky130_fd_pr__nfet_01v8
M$1401 1228 129 1184 1184 sky130_fd_pr__nfet_01v8 L=0.15U W=0.65U AS=0.169P
+ AD=0.06825P PS=1.82U PD=0.86U
* device instance $1402 r0 *1 39.07,67.44 sky130_fd_pr__nfet_01v8
M$1402 90 694 1228 1228 sky130_fd_pr__nfet_01v8 L=0.15U W=0.65U AS=0.06825P
+ AD=0.10725P PS=0.86U PD=0.98U
* device instance $1403 r0 *1 39.55,67.44 sky130_fd_pr__nfet_01v8
M$1403 1184 1158 90 90 sky130_fd_pr__nfet_01v8 L=0.15U W=0.65U AS=0.10725P
+ AD=0.169P PS=0.98U PD=1.82U
* device instance $1404 r0 *1 40.65,67.44 sky130_fd_pr__nfet_01v8
M$1404 90 1159 694 694 sky130_fd_pr__nfet_01v8 L=0.15U W=0.65U AS=0.182P
+ AD=0.10025P PS=1.86U PD=0.985U
* device instance $1405 r0 *1 41.135,67.555 sky130_fd_pr__nfet_01v8
M$1405 1160 1159 90 90 sky130_fd_pr__nfet_01v8 L=0.15U W=0.42U AS=0.10025P
+ AD=0.1092P PS=0.985U PD=1.36U
* device instance $1406 r0 *1 42.075,67.555 sky130_fd_pr__nfet_01v8
M$1406 1227 1160 90 90 sky130_fd_pr__nfet_01v8 L=0.15U W=0.42U AS=0.1092P
+ AD=0.066P PS=1.36U PD=0.745U
* device instance $1407 r0 *1 42.55,67.585 sky130_fd_pr__nfet_01v8
M$1407 1159 1186 1227 1227 sky130_fd_pr__nfet_01v8 L=0.15U W=0.36U AS=0.066P
+ AD=0.0684P PS=0.745U PD=0.74U
* device instance $1408 r0 *1 43.08,67.585 sky130_fd_pr__nfet_01v8
M$1408 1159 1185 1226 1226 sky130_fd_pr__nfet_01v8 L=0.15U W=0.36U AS=0.0678P
+ AD=0.0684P PS=0.755U PD=0.74U
* device instance $1409 r0 *1 43.565,67.555 sky130_fd_pr__nfet_01v8
M$1409 90 1161 1226 1226 sky130_fd_pr__nfet_01v8 L=0.15U W=0.42U AS=0.0678P
+ AD=0.1092P PS=0.755U PD=1.36U
* device instance $1410 r0 *1 44.505,67.445 sky130_fd_pr__nfet_01v8
M$1410 90 1162 1161 1161 sky130_fd_pr__nfet_01v8 L=0.15U W=0.64U AS=0.1664P
+ AD=0.12095P PS=1.8U PD=1.085U
* device instance $1411 r0 *1 45.1,67.555 sky130_fd_pr__nfet_01v8
M$1411 1223 1161 90 90 sky130_fd_pr__nfet_01v8 L=0.15U W=0.42U AS=0.12095P
+ AD=0.0759P PS=1.085U PD=0.8U
* device instance $1412 r0 *1 45.63,67.585 sky130_fd_pr__nfet_01v8
M$1412 1162 1185 1223 1223 sky130_fd_pr__nfet_01v8 L=0.15U W=0.36U AS=0.0759P
+ AD=0.0522P PS=0.8U PD=0.65U
* device instance $1413 r0 *1 46.07,67.585 sky130_fd_pr__nfet_01v8
M$1413 1162 1186 1163 1163 sky130_fd_pr__nfet_01v8 L=0.15U W=0.36U AS=0.1446P
+ AD=0.0522P PS=1.18U PD=0.65U
* device instance $1414 r0 *1 46.98,67.555 sky130_fd_pr__nfet_01v8
M$1414 1222 1160 1163 1163 sky130_fd_pr__nfet_01v8 L=0.15U W=0.42U AS=0.1446P
+ AD=0.0756P PS=1.18U PD=0.78U
* device instance $1415 r0 *1 47.49,67.555 sky130_fd_pr__nfet_01v8
M$1415 90 1164 1222 1222 sky130_fd_pr__nfet_01v8 L=0.15U W=0.42U AS=0.0756P
+ AD=0.0609P PS=0.78U PD=0.71U
* device instance $1416 r0 *1 47.93,67.555 sky130_fd_pr__nfet_01v8
M$1416 1164 1134 90 90 sky130_fd_pr__nfet_01v8 L=0.15U W=0.42U AS=0.0609P
+ AD=0.1092P PS=0.71U PD=1.36U
* device instance $1417 r0 *1 48.87,67.555 sky130_fd_pr__nfet_01v8
M$1417 1221 1134 90 90 sky130_fd_pr__nfet_01v8 L=0.15U W=0.42U AS=0.1092P
+ AD=0.0441P PS=1.36U PD=0.63U
* device instance $1418 r0 *1 49.23,67.555 sky130_fd_pr__nfet_01v8
M$1418 1163 1165 1221 1221 sky130_fd_pr__nfet_01v8 L=0.15U W=0.42U AS=0.0441P
+ AD=0.1092P PS=0.63U PD=1.36U
* device instance $1419 r0 *1 50.17,67.555 sky130_fd_pr__nfet_01v8
M$1419 90 1186 1185 1185 sky130_fd_pr__nfet_01v8 L=0.15U W=0.42U AS=0.1092P
+ AD=0.0567P PS=1.36U PD=0.69U
* device instance $1420 r0 *1 50.59,67.555 sky130_fd_pr__nfet_01v8
M$1420 1186 856 90 90 sky130_fd_pr__nfet_01v8 L=0.15U W=0.42U AS=0.0567P
+ AD=0.1092P PS=0.69U PD=1.36U
* device instance $1421 r0 *1 60.34,67.555 sky130_fd_pr__nfet_01v8
M$1421 1218 1022 1166 1166 sky130_fd_pr__nfet_01v8 L=0.15U W=0.42U AS=0.1113P
+ AD=0.0441P PS=1.37U PD=0.63U
* device instance $1422 r0 *1 60.7,67.555 sky130_fd_pr__nfet_01v8
M$1422 90 1069 1218 1218 sky130_fd_pr__nfet_01v8 L=0.15U W=0.42U AS=0.0441P
+ AD=0.0966P PS=0.63U PD=0.88U
* device instance $1423 r0 *1 61.31,67.555 sky130_fd_pr__nfet_01v8
M$1423 1167 1166 90 90 sky130_fd_pr__nfet_01v8 L=0.15U W=0.42U AS=0.0966P
+ AD=0.1113P PS=0.88U PD=1.37U
* device instance $1424 r0 *1 62.61,67.44 sky130_fd_pr__nfet_01v8
M$1424 1168 1039 90 90 sky130_fd_pr__nfet_01v8 L=0.15U W=0.65U AS=0.169P
+ AD=0.08775P PS=1.82U PD=0.92U
* device instance $1425 r0 *1 63.03,67.44 sky130_fd_pr__nfet_01v8
M$1425 90 1167 1168 1168 sky130_fd_pr__nfet_01v8 L=0.15U W=0.65U AS=0.08775P
+ AD=0.08775P PS=0.92U PD=0.92U
* device instance $1426 r0 *1 63.45,67.44 sky130_fd_pr__nfet_01v8
M$1426 1216 1167 90 90 sky130_fd_pr__nfet_01v8 L=0.15U W=0.65U AS=0.08775P
+ AD=0.08775P PS=0.92U PD=0.92U
* device instance $1427 r0 *1 63.87,67.44 sky130_fd_pr__nfet_01v8
M$1427 1187 1039 1216 1216 sky130_fd_pr__nfet_01v8 L=0.15U W=0.65U AS=0.08775P
+ AD=0.25025P PS=0.92U PD=1.42U
* device instance $1428 r0 *1 64.79,67.44 sky130_fd_pr__nfet_01v8
M$1428 90 1168 1187 1187 sky130_fd_pr__nfet_01v8 L=0.15U W=0.65U AS=0.25025P
+ AD=0.208P PS=1.42U PD=1.94U
* device instance $1429 r0 *1 65.79,67.555 sky130_fd_pr__nfet_01v8
M$1429 90 856 1170 1170 sky130_fd_pr__nfet_01v8 L=0.15U W=0.42U AS=0.1092P
+ AD=0.0567P PS=1.36U PD=0.69U
* device instance $1430 r0 *1 66.21,67.555 sky130_fd_pr__nfet_01v8
M$1430 1171 1170 90 90 sky130_fd_pr__nfet_01v8 L=0.15U W=0.42U AS=0.0567P
+ AD=0.1092P PS=0.69U PD=1.36U
* device instance $1431 r0 *1 67.15,67.555 sky130_fd_pr__nfet_01v8
M$1431 1214 1188 1172 1172 sky130_fd_pr__nfet_01v8 L=0.15U W=0.42U AS=0.1092P
+ AD=0.0441P PS=1.36U PD=0.63U
* device instance $1432 r0 *1 67.51,67.555 sky130_fd_pr__nfet_01v8
M$1432 90 1134 1214 1214 sky130_fd_pr__nfet_01v8 L=0.15U W=0.42U AS=0.0441P
+ AD=0.1092P PS=0.63U PD=1.36U
* device instance $1433 r0 *1 68.45,67.555 sky130_fd_pr__nfet_01v8
M$1433 90 1134 1173 1173 sky130_fd_pr__nfet_01v8 L=0.15U W=0.42U AS=0.1092P
+ AD=0.0609P PS=1.36U PD=0.71U
* device instance $1434 r0 *1 68.89,67.555 sky130_fd_pr__nfet_01v8
M$1434 1210 1173 90 90 sky130_fd_pr__nfet_01v8 L=0.15U W=0.42U AS=0.0609P
+ AD=0.0756P PS=0.71U PD=0.78U
* device instance $1435 r0 *1 69.4,67.555 sky130_fd_pr__nfet_01v8
M$1435 1172 1177 1210 1210 sky130_fd_pr__nfet_01v8 L=0.15U W=0.42U AS=0.0756P
+ AD=0.1446P PS=0.78U PD=1.18U
* device instance $1436 r0 *1 70.31,67.585 sky130_fd_pr__nfet_01v8
M$1436 1174 1170 1172 1172 sky130_fd_pr__nfet_01v8 L=0.15U W=0.36U AS=0.1446P
+ AD=0.0522P PS=1.18U PD=0.65U
* device instance $1437 r0 *1 70.75,67.585 sky130_fd_pr__nfet_01v8
M$1437 1174 1171 1208 1208 sky130_fd_pr__nfet_01v8 L=0.15U W=0.36U AS=0.0759P
+ AD=0.0522P PS=0.8U PD=0.65U
* device instance $1438 r0 *1 71.28,67.555 sky130_fd_pr__nfet_01v8
M$1438 1208 1175 90 90 sky130_fd_pr__nfet_01v8 L=0.15U W=0.42U AS=0.12095P
+ AD=0.0759P PS=1.085U PD=0.8U
* device instance $1439 r0 *1 71.875,67.445 sky130_fd_pr__nfet_01v8
M$1439 1175 1174 90 90 sky130_fd_pr__nfet_01v8 L=0.15U W=0.64U AS=0.12095P
+ AD=0.1664P PS=1.085U PD=1.8U
* device instance $1440 r0 *1 72.815,67.555 sky130_fd_pr__nfet_01v8
M$1440 1207 1175 90 90 sky130_fd_pr__nfet_01v8 L=0.15U W=0.42U AS=0.1092P
+ AD=0.0678P PS=1.36U PD=0.755U
* device instance $1441 r0 *1 73.3,67.585 sky130_fd_pr__nfet_01v8
M$1441 1176 1171 1207 1207 sky130_fd_pr__nfet_01v8 L=0.15U W=0.36U AS=0.0678P
+ AD=0.0684P PS=0.755U PD=0.74U
* device instance $1442 r0 *1 73.83,67.585 sky130_fd_pr__nfet_01v8
M$1442 1176 1170 1206 1206 sky130_fd_pr__nfet_01v8 L=0.15U W=0.36U AS=0.066P
+ AD=0.0684P PS=0.745U PD=0.74U
* device instance $1443 r0 *1 74.305,67.555 sky130_fd_pr__nfet_01v8
M$1443 90 1177 1206 1206 sky130_fd_pr__nfet_01v8 L=0.15U W=0.42U AS=0.066P
+ AD=0.1092P PS=0.745U PD=1.36U
* device instance $1444 r0 *1 75.245,67.555 sky130_fd_pr__nfet_01v8
M$1444 1177 1176 90 90 sky130_fd_pr__nfet_01v8 L=0.15U W=0.42U AS=0.10025P
+ AD=0.1092P PS=0.985U PD=1.36U
* device instance $1445 r0 *1 75.73,67.44 sky130_fd_pr__nfet_01v8
M$1445 1124 1176 90 90 sky130_fd_pr__nfet_01v8 L=0.15U W=0.65U AS=0.10025P
+ AD=0.182P PS=0.985U PD=1.86U
* device instance $1446 r0 *1 5.555,68.56 sky130_fd_pr__nfet_01v8
M$1446 1264 1202 90 90 sky130_fd_pr__nfet_01v8 L=0.15U W=0.65U AS=0.18525P
+ AD=0.089375P PS=1.87U PD=0.925U
* device instance $1447 r0 *1 5.98,68.56 sky130_fd_pr__nfet_01v8
M$1447 1178 1149 1264 1264 sky130_fd_pr__nfet_01v8 L=0.15U W=0.65U AS=0.089375P
+ AD=0.091P PS=0.925U PD=0.93U
* device instance $1448 r0 *1 6.41,68.56 sky130_fd_pr__nfet_01v8
M$1448 1267 1149 1178 1178 sky130_fd_pr__nfet_01v8 L=0.15U W=0.65U AS=0.091P
+ AD=0.06825P PS=0.93U PD=0.86U
* device instance $1449 r0 *1 6.77,68.56 sky130_fd_pr__nfet_01v8
M$1449 90 1202 1267 1267 sky130_fd_pr__nfet_01v8 L=0.15U W=0.65U AS=0.06825P
+ AD=0.10725P PS=0.86U PD=0.98U
* device instance $1450 r0 *1 7.25,68.56 sky130_fd_pr__nfet_01v8
M$1450 1178 1118 90 90 sky130_fd_pr__nfet_01v8 L=0.15U W=1.3U AS=0.195P
+ AD=0.34775P PS=1.9U PD=3.02U
* device instance $1452 r0 *1 8.75,68.445 sky130_fd_pr__nfet_01v8
M$1452 90 939 1229 1229 sky130_fd_pr__nfet_01v8 L=0.15U W=0.42U AS=0.1092P
+ AD=0.0567P PS=1.36U PD=0.69U
* device instance $1453 r0 *1 9.17,68.445 sky130_fd_pr__nfet_01v8
M$1453 1230 1229 90 90 sky130_fd_pr__nfet_01v8 L=0.15U W=0.42U AS=0.0567P
+ AD=0.1092P PS=0.69U PD=1.36U
* device instance $1454 r0 *1 10.67,68.415 sky130_fd_pr__nfet_01v8
M$1454 1232 1229 1231 1231 sky130_fd_pr__nfet_01v8 L=0.15U W=0.36U AS=0.0813P
+ AD=0.0621P PS=0.83U PD=0.705U
* device instance $1455 r0 *1 11.165,68.415 sky130_fd_pr__nfet_01v8
M$1455 1270 1230 1232 1232 sky130_fd_pr__nfet_01v8 L=0.15U W=0.36U AS=0.0621P
+ AD=0.0696P PS=0.705U PD=0.765U
* device instance $1456 r0 *1 12.76,68.415 sky130_fd_pr__nfet_01v8
M$1456 1234 1230 1233 1233 sky130_fd_pr__nfet_01v8 L=0.15U W=0.36U AS=0.0989P
+ AD=0.0684P PS=0.995U PD=0.74U
* device instance $1457 r0 *1 13.29,68.415 sky130_fd_pr__nfet_01v8
M$1457 1271 1229 1234 1234 sky130_fd_pr__nfet_01v8 L=0.15U W=0.36U AS=0.0684P
+ AD=0.066P PS=0.74U PD=0.745U
* device instance $1458 r0 *1 10.11,68.445 sky130_fd_pr__nfet_01v8
M$1458 1231 1146 90 90 sky130_fd_pr__nfet_01v8 L=0.15U W=0.42U AS=0.1092P
+ AD=0.0813P PS=1.36U PD=0.83U
* device instance $1459 r0 *1 11.66,68.445 sky130_fd_pr__nfet_01v8
M$1459 90 1233 1270 1270 sky130_fd_pr__nfet_01v8 L=0.15U W=0.42U AS=0.0696P
+ AD=0.12095P PS=0.765U PD=1.085U
* device instance $1460 r0 *1 13.765,68.445 sky130_fd_pr__nfet_01v8
M$1460 90 1235 1271 1271 sky130_fd_pr__nfet_01v8 L=0.15U W=0.42U AS=0.066P
+ AD=0.1092P PS=0.745U PD=1.36U
* device instance $1461 r0 *1 12.255,68.555 sky130_fd_pr__nfet_01v8
M$1461 1233 1232 90 90 sky130_fd_pr__nfet_01v8 L=0.15U W=0.64U AS=0.12095P
+ AD=0.0989P PS=1.085U PD=0.995U
* device instance $1462 r0 *1 14.71,68.56 sky130_fd_pr__nfet_01v8
M$1462 90 1234 1235 1235 sky130_fd_pr__nfet_01v8 L=0.15U W=0.65U AS=0.169P
+ AD=0.08775P PS=1.82U PD=0.92U
* device instance $1463 r0 *1 15.13,68.56 sky130_fd_pr__nfet_01v8
M$1463 1148 1235 90 90 sky130_fd_pr__nfet_01v8 L=0.15U W=0.65U AS=0.08775P
+ AD=0.169P PS=0.92U PD=1.82U
* device instance $1464 r0 *1 22.09,68.445 sky130_fd_pr__nfet_01v8
M$1464 90 939 1236 1236 sky130_fd_pr__nfet_01v8 L=0.15U W=0.42U AS=0.1092P
+ AD=0.0567P PS=1.36U PD=0.69U
* device instance $1465 r0 *1 22.51,68.445 sky130_fd_pr__nfet_01v8
M$1465 1237 1236 90 90 sky130_fd_pr__nfet_01v8 L=0.15U W=0.42U AS=0.0567P
+ AD=0.1092P PS=0.69U PD=1.36U
* device instance $1466 r0 *1 23.45,68.445 sky130_fd_pr__nfet_01v8
M$1466 1274 1255 1238 1238 sky130_fd_pr__nfet_01v8 L=0.15U W=0.42U AS=0.1092P
+ AD=0.0441P PS=1.36U PD=0.63U
* device instance $1467 r0 *1 23.81,68.445 sky130_fd_pr__nfet_01v8
M$1467 90 1134 1274 1274 sky130_fd_pr__nfet_01v8 L=0.15U W=0.42U AS=0.0441P
+ AD=0.1092P PS=0.63U PD=1.36U
* device instance $1468 r0 *1 26.61,68.415 sky130_fd_pr__nfet_01v8
M$1468 1240 1236 1238 1238 sky130_fd_pr__nfet_01v8 L=0.15U W=0.36U AS=0.1446P
+ AD=0.0522P PS=1.18U PD=0.65U
* device instance $1469 r0 *1 27.05,68.415 sky130_fd_pr__nfet_01v8
M$1469 1278 1237 1240 1240 sky130_fd_pr__nfet_01v8 L=0.15U W=0.36U AS=0.0522P
+ AD=0.0759P PS=0.65U PD=0.8U
* device instance $1470 r0 *1 24.75,68.445 sky130_fd_pr__nfet_01v8
M$1470 90 1134 1239 1239 sky130_fd_pr__nfet_01v8 L=0.15U W=0.42U AS=0.1092P
+ AD=0.0609P PS=1.36U PD=0.71U
* device instance $1471 r0 *1 25.19,68.445 sky130_fd_pr__nfet_01v8
M$1471 1276 1239 90 90 sky130_fd_pr__nfet_01v8 L=0.15U W=0.42U AS=0.0609P
+ AD=0.0756P PS=0.71U PD=0.78U
* device instance $1472 r0 *1 25.7,68.445 sky130_fd_pr__nfet_01v8
M$1472 1238 1256 1276 1276 sky130_fd_pr__nfet_01v8 L=0.15U W=0.42U AS=0.0756P
+ AD=0.1446P PS=0.78U PD=1.18U
* device instance $1473 r0 *1 27.58,68.445 sky130_fd_pr__nfet_01v8
M$1473 90 1241 1278 1278 sky130_fd_pr__nfet_01v8 L=0.15U W=0.42U AS=0.0759P
+ AD=0.12095P PS=0.8U PD=1.085U
* device instance $1474 r0 *1 28.175,68.555 sky130_fd_pr__nfet_01v8
M$1474 1241 1240 90 90 sky130_fd_pr__nfet_01v8 L=0.15U W=0.64U AS=0.12095P
+ AD=0.1664P PS=1.085U PD=1.8U
* device instance $1475 r0 *1 29.6,68.415 sky130_fd_pr__nfet_01v8
M$1475 1242 1237 1280 1280 sky130_fd_pr__nfet_01v8 L=0.15U W=0.36U AS=0.0678P
+ AD=0.0684P PS=0.755U PD=0.74U
* device instance $1476 r0 *1 30.13,68.415 sky130_fd_pr__nfet_01v8
M$1476 1281 1236 1242 1242 sky130_fd_pr__nfet_01v8 L=0.15U W=0.36U AS=0.0684P
+ AD=0.066P PS=0.74U PD=0.745U
* device instance $1477 r0 *1 29.115,68.445 sky130_fd_pr__nfet_01v8
M$1477 1280 1241 90 90 sky130_fd_pr__nfet_01v8 L=0.15U W=0.42U AS=0.1092P
+ AD=0.0678P PS=1.36U PD=0.755U
* device instance $1478 r0 *1 30.605,68.445 sky130_fd_pr__nfet_01v8
M$1478 90 1256 1281 1281 sky130_fd_pr__nfet_01v8 L=0.15U W=0.42U AS=0.066P
+ AD=0.1092P PS=0.745U PD=1.36U
* device instance $1479 r0 *1 31.545,68.445 sky130_fd_pr__nfet_01v8
M$1479 90 1242 1256 1256 sky130_fd_pr__nfet_01v8 L=0.15U W=0.42U AS=0.1092P
+ AD=0.10025P PS=1.36U PD=0.985U
* device instance $1480 r0 *1 32.03,68.56 sky130_fd_pr__nfet_01v8
M$1480 909 1242 90 90 sky130_fd_pr__nfet_01v8 L=0.15U W=0.65U AS=0.10025P
+ AD=0.182P PS=0.985U PD=1.86U
* device instance $1481 r0 *1 33.13,68.56 sky130_fd_pr__nfet_01v8
M$1481 90 987 1257 1257 sky130_fd_pr__nfet_01v8 L=0.15U W=0.65U AS=0.169P
+ AD=0.08775P PS=1.82U PD=0.92U
* device instance $1482 r0 *1 33.55,68.56 sky130_fd_pr__nfet_01v8
M$1482 1287 1257 90 90 sky130_fd_pr__nfet_01v8 L=0.15U W=2.6U AS=0.351P
+ AD=0.43225P PS=3.68U PD=4.58U
* device instance $1486 r0 *1 35.91,68.56 sky130_fd_pr__nfet_01v8
M$1486 1284 1258 90 90 sky130_fd_pr__nfet_01v8 L=0.15U W=0.65U AS=0.169P
+ AD=0.08775P PS=1.82U PD=0.92U
* device instance $1487 r0 *1 36.33,68.56 sky130_fd_pr__nfet_01v8
M$1487 870 55 1284 1284 sky130_fd_pr__nfet_01v8 L=0.15U W=0.65U AS=0.08775P
+ AD=0.169P PS=0.92U PD=1.82U
* device instance $1488 r0 *1 42.19,68.445 sky130_fd_pr__nfet_01v8
M$1488 90 1259 1158 1158 sky130_fd_pr__nfet_01v8 L=0.15U W=0.42U AS=0.1113P
+ AD=0.0966P PS=1.37U PD=0.88U
* device instance $1489 r0 *1 42.8,68.445 sky130_fd_pr__nfet_01v8
M$1489 1285 108 90 90 sky130_fd_pr__nfet_01v8 L=0.15U W=0.42U AS=0.0966P
+ AD=0.0441P PS=0.88U PD=0.63U
* device instance $1490 r0 *1 43.16,68.445 sky130_fd_pr__nfet_01v8
M$1490 1259 1288 1285 1285 sky130_fd_pr__nfet_01v8 L=0.15U W=0.42U AS=0.0441P
+ AD=0.1113P PS=0.63U PD=1.37U
* device instance $1491 r0 *1 44.63,68.445 sky130_fd_pr__nfet_01v8
M$1491 90 856 1243 1243 sky130_fd_pr__nfet_01v8 L=0.15U W=0.42U AS=0.1092P
+ AD=0.0567P PS=1.36U PD=0.69U
* device instance $1492 r0 *1 45.05,68.445 sky130_fd_pr__nfet_01v8
M$1492 1244 1243 90 90 sky130_fd_pr__nfet_01v8 L=0.15U W=0.42U AS=0.0567P
+ AD=0.1092P PS=0.69U PD=1.36U
* device instance $1493 r0 *1 45.99,68.445 sky130_fd_pr__nfet_01v8
M$1493 1283 1155 1245 1245 sky130_fd_pr__nfet_01v8 L=0.15U W=0.42U AS=0.1092P
+ AD=0.0441P PS=1.36U PD=0.63U
* device instance $1494 r0 *1 46.35,68.445 sky130_fd_pr__nfet_01v8
M$1494 90 311 1283 1283 sky130_fd_pr__nfet_01v8 L=0.15U W=0.42U AS=0.0441P
+ AD=0.1092P PS=0.63U PD=1.36U
* device instance $1495 r0 *1 49.15,68.415 sky130_fd_pr__nfet_01v8
M$1495 1247 1243 1245 1245 sky130_fd_pr__nfet_01v8 L=0.15U W=0.36U AS=0.1446P
+ AD=0.0522P PS=1.18U PD=0.65U
* device instance $1496 r0 *1 49.59,68.415 sky130_fd_pr__nfet_01v8
M$1496 1279 1244 1247 1247 sky130_fd_pr__nfet_01v8 L=0.15U W=0.36U AS=0.0522P
+ AD=0.0759P PS=0.65U PD=0.8U
* device instance $1497 r0 *1 47.29,68.445 sky130_fd_pr__nfet_01v8
M$1497 90 311 1246 1246 sky130_fd_pr__nfet_01v8 L=0.15U W=0.42U AS=0.1092P
+ AD=0.0609P PS=1.36U PD=0.71U
* device instance $1498 r0 *1 47.73,68.445 sky130_fd_pr__nfet_01v8
M$1498 1282 1246 90 90 sky130_fd_pr__nfet_01v8 L=0.15U W=0.42U AS=0.0609P
+ AD=0.0756P PS=0.71U PD=0.78U
* device instance $1499 r0 *1 48.24,68.445 sky130_fd_pr__nfet_01v8
M$1499 1245 1260 1282 1282 sky130_fd_pr__nfet_01v8 L=0.15U W=0.42U AS=0.0756P
+ AD=0.1446P PS=0.78U PD=1.18U
* device instance $1500 r0 *1 50.12,68.445 sky130_fd_pr__nfet_01v8
M$1500 90 1248 1279 1279 sky130_fd_pr__nfet_01v8 L=0.15U W=0.42U AS=0.0759P
+ AD=0.12095P PS=0.8U PD=1.085U
* device instance $1501 r0 *1 50.715,68.555 sky130_fd_pr__nfet_01v8
M$1501 1248 1247 90 90 sky130_fd_pr__nfet_01v8 L=0.15U W=0.64U AS=0.12095P
+ AD=0.1664P PS=1.085U PD=1.8U
* device instance $1502 r0 *1 52.14,68.415 sky130_fd_pr__nfet_01v8
M$1502 1249 1244 1277 1277 sky130_fd_pr__nfet_01v8 L=0.15U W=0.36U AS=0.0678P
+ AD=0.0684P PS=0.755U PD=0.74U
* device instance $1503 r0 *1 52.67,68.415 sky130_fd_pr__nfet_01v8
M$1503 1275 1243 1249 1249 sky130_fd_pr__nfet_01v8 L=0.15U W=0.36U AS=0.0684P
+ AD=0.066P PS=0.74U PD=0.745U
* device instance $1504 r0 *1 51.655,68.445 sky130_fd_pr__nfet_01v8
M$1504 1277 1248 90 90 sky130_fd_pr__nfet_01v8 L=0.15U W=0.42U AS=0.1092P
+ AD=0.0678P PS=1.36U PD=0.755U
* device instance $1505 r0 *1 53.145,68.445 sky130_fd_pr__nfet_01v8
M$1505 90 1260 1275 1275 sky130_fd_pr__nfet_01v8 L=0.15U W=0.42U AS=0.066P
+ AD=0.1092P PS=0.745U PD=1.36U
* device instance $1506 r0 *1 54.085,68.445 sky130_fd_pr__nfet_01v8
M$1506 90 1249 1260 1260 sky130_fd_pr__nfet_01v8 L=0.15U W=0.42U AS=0.1092P
+ AD=0.10025P PS=1.36U PD=0.985U
* device instance $1507 r0 *1 54.57,68.56 sky130_fd_pr__nfet_01v8
M$1507 1122 1249 90 90 sky130_fd_pr__nfet_01v8 L=0.15U W=0.65U AS=0.10025P
+ AD=0.182P PS=0.985U PD=1.86U
* device instance $1508 r0 *1 57.12,68.445 sky130_fd_pr__nfet_01v8
M$1508 1273 1289 1250 1250 sky130_fd_pr__nfet_01v8 L=0.15U W=0.42U AS=0.1113P
+ AD=0.0441P PS=1.37U PD=0.63U
* device instance $1509 r0 *1 57.48,68.445 sky130_fd_pr__nfet_01v8
M$1509 90 108 1273 1273 sky130_fd_pr__nfet_01v8 L=0.15U W=0.42U AS=0.0441P
+ AD=0.0966P PS=0.63U PD=0.88U
* device instance $1510 r0 *1 58.09,68.445 sky130_fd_pr__nfet_01v8
M$1510 1028 1250 90 90 sky130_fd_pr__nfet_01v8 L=0.15U W=0.42U AS=0.0966P
+ AD=0.1113P PS=0.88U PD=1.37U
* device instance $1511 r0 *1 60.27,68.56 sky130_fd_pr__nfet_01v8
M$1511 90 1261 1251 1251 sky130_fd_pr__nfet_01v8 L=0.15U W=0.65U AS=0.169P
+ AD=0.10725P PS=1.82U PD=0.98U
* device instance $1512 r0 *1 60.75,68.56 sky130_fd_pr__nfet_01v8
M$1512 1272 1262 90 90 sky130_fd_pr__nfet_01v8 L=0.15U W=0.65U AS=0.10725P
+ AD=0.06825P PS=0.98U PD=0.86U
* device instance $1513 r0 *1 61.11,68.56 sky130_fd_pr__nfet_01v8
M$1513 1251 129 1272 1272 sky130_fd_pr__nfet_01v8 L=0.15U W=0.65U AS=0.06825P
+ AD=0.169P PS=0.86U PD=1.82U
* device instance $1514 r0 *1 62.05,68.56 sky130_fd_pr__nfet_01v8
M$1514 1269 1019 1251 1251 sky130_fd_pr__nfet_01v8 L=0.15U W=0.65U AS=0.169P
+ AD=0.10725P PS=1.82U PD=0.98U
* device instance $1515 r0 *1 62.53,68.56 sky130_fd_pr__nfet_01v8
M$1515 90 1187 1269 1269 sky130_fd_pr__nfet_01v8 L=0.15U W=0.65U AS=0.10725P
+ AD=0.102375P PS=0.98U PD=0.965U
* device instance $1516 r0 *1 62.995,68.56 sky130_fd_pr__nfet_01v8
M$1516 1252 1251 90 90 sky130_fd_pr__nfet_01v8 L=0.15U W=0.65U AS=0.102375P
+ AD=0.169P PS=0.965U PD=1.82U
* device instance $1517 r0 *1 64.405,68.56 sky130_fd_pr__nfet_01v8
M$1517 1268 1263 1022 1022 sky130_fd_pr__nfet_01v8 L=0.15U W=0.65U AS=0.169P
+ AD=0.08775P PS=1.82U PD=0.92U
* device instance $1518 r0 *1 64.825,68.56 sky130_fd_pr__nfet_01v8
M$1518 90 1123 1268 1268 sky130_fd_pr__nfet_01v8 L=0.15U W=0.65U AS=0.08775P
+ AD=0.10025P PS=0.92U PD=0.985U
* device instance $1519 r0 *1 65.31,68.675 sky130_fd_pr__nfet_01v8
M$1519 1263 1124 90 90 sky130_fd_pr__nfet_01v8 L=0.15U W=0.42U AS=0.10025P
+ AD=0.1092P PS=0.985U PD=1.36U
* device instance $1520 r0 *1 68.175,68.445 sky130_fd_pr__nfet_01v8
M$1520 1266 55 90 90 sky130_fd_pr__nfet_01v8 L=0.15U W=0.42U AS=0.11285P
+ AD=0.0693P PS=1.045U PD=0.75U
* device instance $1521 r0 *1 68.655,68.445 sky130_fd_pr__nfet_01v8
M$1521 1253 1292 1266 1266 sky130_fd_pr__nfet_01v8 L=0.15U W=0.42U AS=0.0693P
+ AD=0.09975P PS=0.75U PD=0.895U
* device instance $1522 r0 *1 69.28,68.445 sky130_fd_pr__nfet_01v8
M$1522 1265 1123 1253 1253 sky130_fd_pr__nfet_01v8 L=0.15U W=0.42U AS=0.09975P
+ AD=0.0693P PS=0.895U PD=0.75U
* device instance $1523 r0 *1 69.76,68.445 sky130_fd_pr__nfet_01v8
M$1523 90 1254 1265 1265 sky130_fd_pr__nfet_01v8 L=0.15U W=0.42U AS=0.0693P
+ AD=0.1449P PS=0.75U PD=1.11U
* device instance $1524 r0 *1 70.6,68.445 sky130_fd_pr__nfet_01v8
M$1524 1254 55 90 90 sky130_fd_pr__nfet_01v8 L=0.15U W=0.42U AS=0.1449P
+ AD=0.1092P PS=1.11U PD=1.36U
* device instance $1525 r0 *1 67.63,68.56 sky130_fd_pr__nfet_01v8
M$1525 90 1253 1188 1188 sky130_fd_pr__nfet_01v8 L=0.15U W=0.65U AS=0.169P
+ AD=0.11285P PS=1.82U PD=1.045U
* device instance $1526 r0 *1 8.29,72.995 sky130_fd_pr__nfet_01v8
M$1526 90 939 1307 1307 sky130_fd_pr__nfet_01v8 L=0.15U W=0.42U AS=0.1092P
+ AD=0.0567P PS=1.36U PD=0.69U
* device instance $1527 r0 *1 8.71,72.995 sky130_fd_pr__nfet_01v8
M$1527 1308 1307 90 90 sky130_fd_pr__nfet_01v8 L=0.15U W=0.42U AS=0.0567P
+ AD=0.1092P PS=0.69U PD=1.36U
* device instance $1528 r0 *1 9.65,72.995 sky130_fd_pr__nfet_01v8
M$1528 1309 1099 90 90 sky130_fd_pr__nfet_01v8 L=0.15U W=0.42U AS=0.1092P
+ AD=0.0813P PS=1.36U PD=0.83U
* device instance $1529 r0 *1 10.21,73.025 sky130_fd_pr__nfet_01v8
M$1529 1310 1307 1309 1309 sky130_fd_pr__nfet_01v8 L=0.15U W=0.36U AS=0.0813P
+ AD=0.0621P PS=0.83U PD=0.705U
* device instance $1530 r0 *1 10.705,73.025 sky130_fd_pr__nfet_01v8
M$1530 1310 1308 1341 1341 sky130_fd_pr__nfet_01v8 L=0.15U W=0.36U AS=0.0696P
+ AD=0.0621P PS=0.765U PD=0.705U
* device instance $1531 r0 *1 11.2,72.995 sky130_fd_pr__nfet_01v8
M$1531 1341 1311 90 90 sky130_fd_pr__nfet_01v8 L=0.15U W=0.42U AS=0.12095P
+ AD=0.0696P PS=1.085U PD=0.765U
* device instance $1532 r0 *1 11.795,72.885 sky130_fd_pr__nfet_01v8
M$1532 1311 1310 90 90 sky130_fd_pr__nfet_01v8 L=0.15U W=0.64U AS=0.12095P
+ AD=0.0989P PS=1.085U PD=0.995U
* device instance $1533 r0 *1 12.3,73.025 sky130_fd_pr__nfet_01v8
M$1533 1312 1308 1311 1311 sky130_fd_pr__nfet_01v8 L=0.15U W=0.36U AS=0.0989P
+ AD=0.0684P PS=0.995U PD=0.74U
* device instance $1534 r0 *1 12.83,73.025 sky130_fd_pr__nfet_01v8
M$1534 1312 1307 1342 1342 sky130_fd_pr__nfet_01v8 L=0.15U W=0.36U AS=0.066P
+ AD=0.0684P PS=0.745U PD=0.74U
* device instance $1535 r0 *1 13.305,72.995 sky130_fd_pr__nfet_01v8
M$1535 90 1313 1342 1342 sky130_fd_pr__nfet_01v8 L=0.15U W=0.42U AS=0.066P
+ AD=0.1092P PS=0.745U PD=1.36U
* device instance $1536 r0 *1 14.25,72.88 sky130_fd_pr__nfet_01v8
M$1536 90 1312 1313 1313 sky130_fd_pr__nfet_01v8 L=0.15U W=0.65U AS=0.169P
+ AD=0.08775P PS=1.82U PD=0.92U
* device instance $1537 r0 *1 14.67,72.88 sky130_fd_pr__nfet_01v8
M$1537 1119 1313 90 90 sky130_fd_pr__nfet_01v8 L=0.15U W=0.65U AS=0.08775P
+ AD=0.169P PS=0.92U PD=1.82U
* device instance $1538 r0 *1 26.23,72.88 sky130_fd_pr__nfet_01v8
M$1538 90 1314 1255 1255 sky130_fd_pr__nfet_01v8 L=0.15U W=0.65U AS=0.169P
+ AD=0.11285P PS=1.82U PD=1.045U
* device instance $1539 r0 *1 26.775,72.995 sky130_fd_pr__nfet_01v8
M$1539 1347 55 90 90 sky130_fd_pr__nfet_01v8 L=0.15U W=0.42U AS=0.11285P
+ AD=0.0693P PS=1.045U PD=0.75U
* device instance $1540 r0 *1 27.255,72.995 sky130_fd_pr__nfet_01v8
M$1540 1314 1332 1347 1347 sky130_fd_pr__nfet_01v8 L=0.15U W=0.42U AS=0.0693P
+ AD=0.09975P PS=0.75U PD=0.895U
* device instance $1541 r0 *1 27.88,72.995 sky130_fd_pr__nfet_01v8
M$1541 1348 974 1314 1314 sky130_fd_pr__nfet_01v8 L=0.15U W=0.42U AS=0.09975P
+ AD=0.0693P PS=0.895U PD=0.75U
* device instance $1542 r0 *1 28.36,72.995 sky130_fd_pr__nfet_01v8
M$1542 90 1340 1348 1348 sky130_fd_pr__nfet_01v8 L=0.15U W=0.42U AS=0.0693P
+ AD=0.1449P PS=0.75U PD=1.11U
* device instance $1543 r0 *1 29.2,72.995 sky130_fd_pr__nfet_01v8
M$1543 1340 55 90 90 sky130_fd_pr__nfet_01v8 L=0.15U W=0.42U AS=0.1449P
+ AD=0.1092P PS=1.11U PD=1.36U
* device instance $1544 r0 *1 44.86,72.995 sky130_fd_pr__nfet_01v8
M$1544 90 55 1315 1315 sky130_fd_pr__nfet_01v8 L=0.15U W=0.42U AS=0.1092P
+ AD=0.1449P PS=1.36U PD=1.11U
* device instance $1545 r0 *1 45.7,72.995 sky130_fd_pr__nfet_01v8
M$1545 1351 1315 90 90 sky130_fd_pr__nfet_01v8 L=0.15U W=0.42U AS=0.1449P
+ AD=0.0693P PS=1.11U PD=0.75U
* device instance $1546 r0 *1 46.18,72.995 sky130_fd_pr__nfet_01v8
M$1546 1317 1122 1351 1351 sky130_fd_pr__nfet_01v8 L=0.15U W=0.42U AS=0.0693P
+ AD=0.09975P PS=0.75U PD=0.895U
* device instance $1547 r0 *1 46.805,72.995 sky130_fd_pr__nfet_01v8
M$1547 1352 1316 1317 1317 sky130_fd_pr__nfet_01v8 L=0.15U W=0.42U AS=0.09975P
+ AD=0.0693P PS=0.895U PD=0.75U
* device instance $1548 r0 *1 47.285,72.995 sky130_fd_pr__nfet_01v8
M$1548 1352 55 90 90 sky130_fd_pr__nfet_01v8 L=0.15U W=0.42U AS=0.11285P
+ AD=0.0693P PS=1.045U PD=0.75U
* device instance $1549 r0 *1 47.83,72.88 sky130_fd_pr__nfet_01v8
M$1549 1165 1317 90 90 sky130_fd_pr__nfet_01v8 L=0.15U W=0.65U AS=0.11285P
+ AD=0.169P PS=1.045U PD=1.82U
* device instance $1550 r0 *1 58.5,72.995 sky130_fd_pr__nfet_01v8
M$1550 1350 1333 1318 1318 sky130_fd_pr__nfet_01v8 L=0.15U W=0.42U AS=0.1113P
+ AD=0.0441P PS=1.37U PD=0.63U
* device instance $1551 r0 *1 58.86,72.995 sky130_fd_pr__nfet_01v8
M$1551 90 108 1350 1350 sky130_fd_pr__nfet_01v8 L=0.15U W=0.42U AS=0.0441P
+ AD=0.0966P PS=0.63U PD=0.88U
* device instance $1552 r0 *1 59.47,72.995 sky130_fd_pr__nfet_01v8
M$1552 1261 1318 90 90 sky130_fd_pr__nfet_01v8 L=0.15U W=0.42U AS=0.0966P
+ AD=0.1113P PS=0.88U PD=1.37U
* device instance $1553 r0 *1 60.73,72.995 sky130_fd_pr__nfet_01v8
M$1553 90 856 1319 1319 sky130_fd_pr__nfet_01v8 L=0.15U W=0.42U AS=0.1092P
+ AD=0.0567P PS=1.36U PD=0.69U
* device instance $1554 r0 *1 61.15,72.995 sky130_fd_pr__nfet_01v8
M$1554 1320 1319 90 90 sky130_fd_pr__nfet_01v8 L=0.15U W=0.42U AS=0.0567P
+ AD=0.1092P PS=0.69U PD=1.36U
* device instance $1555 r0 *1 62.09,72.995 sky130_fd_pr__nfet_01v8
M$1555 1349 1252 1322 1322 sky130_fd_pr__nfet_01v8 L=0.15U W=0.42U AS=0.1092P
+ AD=0.0441P PS=1.36U PD=0.63U
* device instance $1556 r0 *1 62.45,72.995 sky130_fd_pr__nfet_01v8
M$1556 90 311 1349 1349 sky130_fd_pr__nfet_01v8 L=0.15U W=0.42U AS=0.0441P
+ AD=0.1092P PS=0.63U PD=1.36U
* device instance $1557 r0 *1 63.39,72.995 sky130_fd_pr__nfet_01v8
M$1557 90 311 1321 1321 sky130_fd_pr__nfet_01v8 L=0.15U W=0.42U AS=0.1092P
+ AD=0.0609P PS=1.36U PD=0.71U
* device instance $1558 r0 *1 63.83,72.995 sky130_fd_pr__nfet_01v8
M$1558 1346 1321 90 90 sky130_fd_pr__nfet_01v8 L=0.15U W=0.42U AS=0.0609P
+ AD=0.0756P PS=0.71U PD=0.78U
* device instance $1559 r0 *1 64.34,72.995 sky130_fd_pr__nfet_01v8
M$1559 1322 1326 1346 1346 sky130_fd_pr__nfet_01v8 L=0.15U W=0.42U AS=0.0756P
+ AD=0.1446P PS=0.78U PD=1.18U
* device instance $1560 r0 *1 65.25,73.025 sky130_fd_pr__nfet_01v8
M$1560 1323 1319 1322 1322 sky130_fd_pr__nfet_01v8 L=0.15U W=0.36U AS=0.1446P
+ AD=0.0522P PS=1.18U PD=0.65U
* device instance $1561 r0 *1 65.69,73.025 sky130_fd_pr__nfet_01v8
M$1561 1323 1320 1345 1345 sky130_fd_pr__nfet_01v8 L=0.15U W=0.36U AS=0.0759P
+ AD=0.0522P PS=0.8U PD=0.65U
* device instance $1562 r0 *1 66.22,72.995 sky130_fd_pr__nfet_01v8
M$1562 1345 1324 90 90 sky130_fd_pr__nfet_01v8 L=0.15U W=0.42U AS=0.12095P
+ AD=0.0759P PS=1.085U PD=0.8U
* device instance $1563 r0 *1 66.815,72.885 sky130_fd_pr__nfet_01v8
M$1563 1324 1323 90 90 sky130_fd_pr__nfet_01v8 L=0.15U W=0.64U AS=0.12095P
+ AD=0.1664P PS=1.085U PD=1.8U
* device instance $1564 r0 *1 65.93,74 sky130_fd_pr__nfet_01v8
M$1564 1262 1353 90 90 sky130_fd_pr__nfet_01v8 L=0.15U W=2.6U AS=0.43225P
+ AD=0.351P PS=4.58U PD=3.68U
* device instance $1568 r0 *1 67.61,74 sky130_fd_pr__nfet_01v8
M$1568 1353 1124 90 90 sky130_fd_pr__nfet_01v8 L=0.15U W=0.65U AS=0.08775P
+ AD=0.169P PS=0.92U PD=1.82U
* device instance $1569 r0 *1 67.755,72.995 sky130_fd_pr__nfet_01v8
M$1569 1344 1324 90 90 sky130_fd_pr__nfet_01v8 L=0.15U W=0.42U AS=0.1092P
+ AD=0.0678P PS=1.36U PD=0.755U
* device instance $1570 r0 *1 68.24,73.025 sky130_fd_pr__nfet_01v8
M$1570 1325 1320 1344 1344 sky130_fd_pr__nfet_01v8 L=0.15U W=0.36U AS=0.0678P
+ AD=0.0684P PS=0.755U PD=0.74U
* device instance $1571 r0 *1 68.77,73.025 sky130_fd_pr__nfet_01v8
M$1571 1325 1319 1343 1343 sky130_fd_pr__nfet_01v8 L=0.15U W=0.36U AS=0.066P
+ AD=0.0684P PS=0.745U PD=0.74U
* device instance $1572 r0 *1 69.245,72.995 sky130_fd_pr__nfet_01v8
M$1572 90 1326 1343 1343 sky130_fd_pr__nfet_01v8 L=0.15U W=0.42U AS=0.066P
+ AD=0.1092P PS=0.745U PD=1.36U
* device instance $1573 r0 *1 70.185,72.995 sky130_fd_pr__nfet_01v8
M$1573 1326 1325 90 90 sky130_fd_pr__nfet_01v8 L=0.15U W=0.42U AS=0.10025P
+ AD=0.1092P PS=0.985U PD=1.36U
* device instance $1574 r0 *1 70.67,72.88 sky130_fd_pr__nfet_01v8
M$1574 1123 1325 90 90 sky130_fd_pr__nfet_01v8 L=0.15U W=0.65U AS=0.10025P
+ AD=0.182P PS=0.985U PD=1.86U
* device instance $1575 r0 *1 14.525,4.885 sky130_fd_pr__pfet_01v8
M$1575 12 13 162 162 sky130_fd_pr__pfet_01v8 L=0.15U W=0.64U AS=0.154P
+ AD=0.1728P PS=1.335U PD=1.82U
* device instance $1576 r0 *1 15.01,4.705 sky130_fd_pr__pfet_01v8
M$1576 128 13 162 162 sky130_fd_pr__pfet_01v8 L=0.15U W=1U AS=0.154P AD=0.28P
+ PS=1.335U PD=2.56U
* device instance $1577 r0 *1 70.185,4.885 sky130_fd_pr__pfet_01v8
M$1577 18 19 162 162 sky130_fd_pr__pfet_01v8 L=0.15U W=0.64U AS=0.154P
+ AD=0.1728P PS=1.335U PD=1.82U
* device instance $1578 r0 *1 70.67,4.705 sky130_fd_pr__pfet_01v8
M$1578 20 19 162 162 sky130_fd_pr__pfet_01v8 L=0.15U W=1U AS=0.154P AD=0.28P
+ PS=1.335U PD=2.56U
* device instance $1579 r0 *1 5.07,4.855 sky130_fd_pr__pfet_01v8
M$1579 162 31 8 8 sky130_fd_pr__pfet_01v8 L=0.15U W=0.64U AS=0.1664P AD=0.0864P
+ PS=1.8U PD=0.91U
* device instance $1580 r0 *1 5.49,4.855 sky130_fd_pr__pfet_01v8
M$1580 9 8 162 162 sky130_fd_pr__pfet_01v8 L=0.15U W=0.64U AS=0.0864P
+ AD=0.1664P PS=0.91U PD=1.8U
* device instance $1581 r0 *1 6.43,4.885 sky130_fd_pr__pfet_01v8
M$1581 33 32 10 10 sky130_fd_pr__pfet_01v8 L=0.15U W=0.64U AS=0.1664P
+ AD=0.0672P PS=1.8U PD=0.85U
* device instance $1582 r0 *1 6.79,4.885 sky130_fd_pr__pfet_01v8
M$1582 162 11 33 33 sky130_fd_pr__pfet_01v8 L=0.15U W=0.64U AS=0.0672P
+ AD=0.1664P PS=0.85U PD=1.8U
* device instance $1583 r0 *1 7.73,4.885 sky130_fd_pr__pfet_01v8
M$1583 162 88 11 11 sky130_fd_pr__pfet_01v8 L=0.15U W=0.64U AS=0.1664P
+ AD=0.0928P PS=1.8U PD=0.93U
* device instance $1584 r0 *1 8.17,4.885 sky130_fd_pr__pfet_01v8
M$1584 34 88 162 162 sky130_fd_pr__pfet_01v8 L=0.15U W=0.64U AS=0.0928P
+ AD=0.1152P PS=0.93U PD=1U
* device instance $1585 r0 *1 8.68,4.885 sky130_fd_pr__pfet_01v8
M$1585 10 12 34 34 sky130_fd_pr__pfet_01v8 L=0.15U W=0.64U AS=0.1152P
+ AD=0.15985P PS=1U PD=1.265U
* device instance $1586 r0 *1 9.455,4.995 sky130_fd_pr__pfet_01v8
M$1586 3 9 10 10 sky130_fd_pr__pfet_01v8 L=0.15U W=0.42U AS=0.15985P
+ AD=0.06405P PS=1.265U PD=0.725U
* device instance $1587 r0 *1 9.91,4.995 sky130_fd_pr__pfet_01v8
M$1587 36 8 3 3 sky130_fd_pr__pfet_01v8 L=0.15U W=0.42U AS=0.06405P AD=0.07665P
+ PS=0.725U PD=0.785U
* device instance $1588 r0 *1 10.425,4.995 sky130_fd_pr__pfet_01v8
M$1588 36 4 162 162 sky130_fd_pr__pfet_01v8 L=0.15U W=0.42U AS=0.178875P
+ AD=0.07665P PS=1.26U PD=0.785U
* device instance $1589 r0 *1 11.085,4.83 sky130_fd_pr__pfet_01v8
M$1589 4 3 162 162 sky130_fd_pr__pfet_01v8 L=0.15U W=0.75U AS=0.178875P
+ AD=0.195P PS=1.26U PD=2.02U
* device instance $1590 r0 *1 60.73,4.855 sky130_fd_pr__pfet_01v8
M$1590 162 329 14 14 sky130_fd_pr__pfet_01v8 L=0.15U W=0.64U AS=0.1664P
+ AD=0.0864P PS=1.8U PD=0.91U
* device instance $1591 r0 *1 61.15,4.855 sky130_fd_pr__pfet_01v8
M$1591 16 14 162 162 sky130_fd_pr__pfet_01v8 L=0.15U W=0.64U AS=0.0864P
+ AD=0.1664P PS=0.91U PD=1.8U
* device instance $1592 r0 *1 62.09,4.885 sky130_fd_pr__pfet_01v8
M$1592 42 15 5 5 sky130_fd_pr__pfet_01v8 L=0.15U W=0.64U AS=0.1664P AD=0.0672P
+ PS=1.8U PD=0.85U
* device instance $1593 r0 *1 62.45,4.885 sky130_fd_pr__pfet_01v8
M$1593 162 17 42 42 sky130_fd_pr__pfet_01v8 L=0.15U W=0.64U AS=0.0672P
+ AD=0.1664P PS=0.85U PD=1.8U
* device instance $1594 r0 *1 63.39,4.885 sky130_fd_pr__pfet_01v8
M$1594 162 311 17 17 sky130_fd_pr__pfet_01v8 L=0.15U W=0.64U AS=0.1664P
+ AD=0.0928P PS=1.8U PD=0.93U
* device instance $1595 r0 *1 63.83,4.885 sky130_fd_pr__pfet_01v8
M$1595 41 311 162 162 sky130_fd_pr__pfet_01v8 L=0.15U W=0.64U AS=0.0928P
+ AD=0.1152P PS=0.93U PD=1U
* device instance $1596 r0 *1 64.34,4.885 sky130_fd_pr__pfet_01v8
M$1596 5 18 41 41 sky130_fd_pr__pfet_01v8 L=0.15U W=0.64U AS=0.1152P
+ AD=0.15985P PS=1U PD=1.265U
* device instance $1597 r0 *1 65.115,4.995 sky130_fd_pr__pfet_01v8
M$1597 6 16 5 5 sky130_fd_pr__pfet_01v8 L=0.15U W=0.42U AS=0.15985P AD=0.06405P
+ PS=1.265U PD=0.725U
* device instance $1598 r0 *1 65.57,4.995 sky130_fd_pr__pfet_01v8
M$1598 39 14 6 6 sky130_fd_pr__pfet_01v8 L=0.15U W=0.42U AS=0.06405P
+ AD=0.07665P PS=0.725U PD=0.785U
* device instance $1599 r0 *1 66.085,4.995 sky130_fd_pr__pfet_01v8
M$1599 39 7 162 162 sky130_fd_pr__pfet_01v8 L=0.15U W=0.42U AS=0.178875P
+ AD=0.07665P PS=1.26U PD=0.785U
* device instance $1600 r0 *1 66.745,4.83 sky130_fd_pr__pfet_01v8
M$1600 7 6 162 162 sky130_fd_pr__pfet_01v8 L=0.15U W=0.75U AS=0.178875P
+ AD=0.195P PS=1.26U PD=2.02U
* device instance $1601 r0 *1 6.175,5.995 sky130_fd_pr__pfet_01v8
M$1601 45 44 162 162 sky130_fd_pr__pfet_01v8 L=0.15U W=0.64U AS=0.154P
+ AD=0.1728P PS=1.335U PD=1.82U
* device instance $1602 r0 *1 5.69,6.175 sky130_fd_pr__pfet_01v8
M$1602 162 44 43 43 sky130_fd_pr__pfet_01v8 L=0.15U W=1U AS=0.28P AD=0.154P
+ PS=2.56U PD=1.335U
* device instance $1603 r0 *1 7.23,5.885 sky130_fd_pr__pfet_01v8
M$1603 75 45 162 162 sky130_fd_pr__pfet_01v8 L=0.15U W=0.42U AS=0.1113P
+ AD=0.0882P PS=1.37U PD=0.84U
* device instance $1604 r0 *1 7.8,5.885 sky130_fd_pr__pfet_01v8
M$1604 44 67 75 75 sky130_fd_pr__pfet_01v8 L=0.15U W=0.42U AS=0.0882P
+ AD=0.0567P PS=0.84U PD=0.69U
* device instance $1605 r0 *1 8.22,5.885 sky130_fd_pr__pfet_01v8
M$1605 76 68 44 44 sky130_fd_pr__pfet_01v8 L=0.15U W=0.42U AS=0.0567P
+ AD=0.06405P PS=0.69U PD=0.725U
* device instance $1606 r0 *1 8.675,5.885 sky130_fd_pr__pfet_01v8
M$1606 162 46 76 76 sky130_fd_pr__pfet_01v8 L=0.15U W=0.42U AS=0.06405P
+ AD=0.1092P PS=0.725U PD=1.36U
* device instance $1607 r0 *1 10.275,5.885 sky130_fd_pr__pfet_01v8
M$1607 78 46 162 162 sky130_fd_pr__pfet_01v8 L=0.15U W=0.42U AS=0.178875P
+ AD=0.07665P PS=1.26U PD=0.785U
* device instance $1608 r0 *1 10.79,5.885 sky130_fd_pr__pfet_01v8
M$1608 47 68 78 78 sky130_fd_pr__pfet_01v8 L=0.15U W=0.42U AS=0.07665P
+ AD=0.06405P PS=0.785U PD=0.725U
* device instance $1609 r0 *1 11.245,5.885 sky130_fd_pr__pfet_01v8
M$1609 48 67 47 47 sky130_fd_pr__pfet_01v8 L=0.15U W=0.42U AS=0.06405P
+ AD=0.15985P PS=0.725U PD=1.265U
* device instance $1610 r0 *1 12.02,5.995 sky130_fd_pr__pfet_01v8
M$1610 80 45 48 48 sky130_fd_pr__pfet_01v8 L=0.15U W=0.64U AS=0.15985P
+ AD=0.1152P PS=1.265U PD=1U
* device instance $1611 r0 *1 12.53,5.995 sky130_fd_pr__pfet_01v8
M$1611 162 311 80 80 sky130_fd_pr__pfet_01v8 L=0.15U W=0.64U AS=0.1152P
+ AD=0.0928P PS=1U PD=0.93U
* device instance $1612 r0 *1 12.97,5.995 sky130_fd_pr__pfet_01v8
M$1612 49 311 162 162 sky130_fd_pr__pfet_01v8 L=0.15U W=0.64U AS=0.0928P
+ AD=0.1664P PS=0.93U PD=1.8U
* device instance $1613 r0 *1 9.615,6.05 sky130_fd_pr__pfet_01v8
M$1613 162 47 46 46 sky130_fd_pr__pfet_01v8 L=0.15U W=0.75U AS=0.195P
+ AD=0.178875P PS=2.02U PD=1.26U
* device instance $1614 r0 *1 12.025,4.995 sky130_fd_pr__pfet_01v8
M$1614 38 4 162 162 sky130_fd_pr__pfet_01v8 L=0.15U W=0.42U AS=0.1092P
+ AD=0.06405P PS=1.36U PD=0.725U
* device instance $1615 r0 *1 12.48,4.995 sky130_fd_pr__pfet_01v8
M$1615 13 8 38 38 sky130_fd_pr__pfet_01v8 L=0.15U W=0.42U AS=0.06405P
+ AD=0.0567P PS=0.725U PD=0.69U
* device instance $1616 r0 *1 12.9,4.995 sky130_fd_pr__pfet_01v8
M$1616 40 9 13 13 sky130_fd_pr__pfet_01v8 L=0.15U W=0.42U AS=0.0567P AD=0.0882P
+ PS=0.69U PD=0.84U
* device instance $1617 r0 *1 13.47,4.995 sky130_fd_pr__pfet_01v8
M$1617 162 12 40 40 sky130_fd_pr__pfet_01v8 L=0.15U W=0.42U AS=0.0882P
+ AD=0.1113P PS=0.84U PD=1.37U
* device instance $1618 r0 *1 13.91,5.995 sky130_fd_pr__pfet_01v8
M$1618 82 49 162 162 sky130_fd_pr__pfet_01v8 L=0.15U W=0.64U AS=0.1664P
+ AD=0.0672P PS=1.8U PD=0.85U
* device instance $1619 r0 *1 14.27,5.995 sky130_fd_pr__pfet_01v8
M$1619 48 50 82 82 sky130_fd_pr__pfet_01v8 L=0.15U W=0.64U AS=0.0672P
+ AD=0.1664P PS=0.85U PD=1.8U
* device instance $1620 r0 *1 23.485,6.175 sky130_fd_pr__pfet_01v8
M$1620 162 69 51 51 sky130_fd_pr__pfet_01v8 L=0.15U W=1U AS=0.26P AD=0.1575P
+ PS=2.52U PD=1.315U
* device instance $1621 r0 *1 23.95,6.175 sky130_fd_pr__pfet_01v8
M$1621 52 1 162 162 sky130_fd_pr__pfet_01v8 L=0.15U W=1U AS=0.1575P AD=0.165P
+ PS=1.315U PD=1.33U
* device instance $1622 r0 *1 24.43,6.175 sky130_fd_pr__pfet_01v8
M$1622 162 130 52 52 sky130_fd_pr__pfet_01v8 L=0.15U W=1U AS=0.165P AD=0.26P
+ PS=1.33U PD=2.52U
* device instance $1623 r0 *1 25.37,6.175 sky130_fd_pr__pfet_01v8
M$1623 52 129 53 53 sky130_fd_pr__pfet_01v8 L=0.15U W=1U AS=0.26P AD=0.135P
+ PS=2.52U PD=1.27U
* device instance $1624 r0 *1 25.79,6.175 sky130_fd_pr__pfet_01v8
M$1624 53 164 52 52 sky130_fd_pr__pfet_01v8 L=0.15U W=1U AS=0.135P AD=0.135P
+ PS=1.27U PD=1.27U
* device instance $1625 r0 *1 26.21,6.175 sky130_fd_pr__pfet_01v8
M$1625 69 54 53 53 sky130_fd_pr__pfet_01v8 L=0.15U W=1U AS=0.135P AD=0.26P
+ PS=1.27U PD=2.52U
* device instance $1626 r0 *1 27.635,5.995 sky130_fd_pr__pfet_01v8
M$1626 70 71 162 162 sky130_fd_pr__pfet_01v8 L=0.15U W=0.64U AS=0.1824P
+ AD=0.0896P PS=1.85U PD=0.92U
* device instance $1627 r0 *1 28.065,5.995 sky130_fd_pr__pfet_01v8
M$1627 84 55 70 70 sky130_fd_pr__pfet_01v8 L=0.15U W=0.64U AS=0.0896P
+ AD=0.0768P PS=0.92U PD=0.88U
* device instance $1628 r0 *1 28.455,5.995 sky130_fd_pr__pfet_01v8
M$1628 162 56 84 84 sky130_fd_pr__pfet_01v8 L=0.15U W=0.64U AS=0.0768P
+ AD=0.1696P PS=0.88U PD=1.81U
* device instance $1629 r0 *1 44.67,6.175 sky130_fd_pr__pfet_01v8
M$1629 59 58 57 57 sky130_fd_pr__pfet_01v8 L=0.15U W=1U AS=0.3P AD=0.26P
+ PS=2.6U PD=2.52U
* device instance $1630 r0 *1 45.61,6.175 sky130_fd_pr__pfet_01v8
M$1630 59 72 162 162 sky130_fd_pr__pfet_01v8 L=0.15U W=1U AS=0.26P AD=0.135P
+ PS=2.52U PD=1.27U
* device instance $1631 r0 *1 46.03,6.175 sky130_fd_pr__pfet_01v8
M$1631 162 87 59 59 sky130_fd_pr__pfet_01v8 L=0.15U W=1U AS=0.135P AD=0.135P
+ PS=1.27U PD=1.27U
* device instance $1632 r0 *1 46.45,6.175 sky130_fd_pr__pfet_01v8
M$1632 86 87 162 162 sky130_fd_pr__pfet_01v8 L=0.15U W=1U AS=0.135P AD=0.135P
+ PS=1.27U PD=1.27U
* device instance $1633 r0 *1 46.87,6.175 sky130_fd_pr__pfet_01v8
M$1633 58 72 86 86 sky130_fd_pr__pfet_01v8 L=0.15U W=1U AS=0.135P AD=0.26P
+ PS=1.27U PD=2.52U
* device instance $1634 r0 *1 66.23,5.995 sky130_fd_pr__pfet_01v8
M$1634 85 73 63 63 sky130_fd_pr__pfet_01v8 L=0.15U W=0.64U AS=0.1664P
+ AD=0.0672P PS=1.8U PD=0.85U
* device instance $1635 r0 *1 66.59,5.995 sky130_fd_pr__pfet_01v8
M$1635 162 62 85 85 sky130_fd_pr__pfet_01v8 L=0.15U W=0.64U AS=0.0672P
+ AD=0.1664P PS=0.85U PD=1.8U
* device instance $1636 r0 *1 69.255,5.885 sky130_fd_pr__pfet_01v8
M$1636 64 61 63 63 sky130_fd_pr__pfet_01v8 L=0.15U W=0.42U AS=0.15985P
+ AD=0.06405P PS=1.265U PD=0.725U
* device instance $1637 r0 *1 69.71,5.885 sky130_fd_pr__pfet_01v8
M$1637 81 60 64 64 sky130_fd_pr__pfet_01v8 L=0.15U W=0.42U AS=0.06405P
+ AD=0.07665P PS=0.725U PD=0.785U
* device instance $1638 r0 *1 70.225,5.885 sky130_fd_pr__pfet_01v8
M$1638 162 65 81 81 sky130_fd_pr__pfet_01v8 L=0.15U W=0.42U AS=0.07665P
+ AD=0.178875P PS=0.785U PD=1.26U
* device instance $1639 r0 *1 67.53,5.995 sky130_fd_pr__pfet_01v8
M$1639 162 88 62 62 sky130_fd_pr__pfet_01v8 L=0.15U W=0.64U AS=0.1664P
+ AD=0.0928P PS=1.8U PD=0.93U
* device instance $1640 r0 *1 67.97,5.995 sky130_fd_pr__pfet_01v8
M$1640 83 88 162 162 sky130_fd_pr__pfet_01v8 L=0.15U W=0.64U AS=0.0928P
+ AD=0.1152P PS=0.93U PD=1U
* device instance $1641 r0 *1 68.48,5.995 sky130_fd_pr__pfet_01v8
M$1641 63 66 83 83 sky130_fd_pr__pfet_01v8 L=0.15U W=0.64U AS=0.1152P
+ AD=0.15985P PS=1U PD=1.265U
* device instance $1642 r0 *1 70.885,6.05 sky130_fd_pr__pfet_01v8
M$1642 65 64 162 162 sky130_fd_pr__pfet_01v8 L=0.15U W=0.75U AS=0.178875P
+ AD=0.195P PS=1.26U PD=2.02U
* device instance $1643 r0 *1 67.685,4.995 sky130_fd_pr__pfet_01v8
M$1643 37 7 162 162 sky130_fd_pr__pfet_01v8 L=0.15U W=0.42U AS=0.1092P
+ AD=0.06405P PS=1.36U PD=0.725U
* device instance $1644 r0 *1 68.14,4.995 sky130_fd_pr__pfet_01v8
M$1644 19 14 37 37 sky130_fd_pr__pfet_01v8 L=0.15U W=0.42U AS=0.06405P
+ AD=0.0567P PS=0.725U PD=0.69U
* device instance $1645 r0 *1 68.56,4.995 sky130_fd_pr__pfet_01v8
M$1645 35 16 19 19 sky130_fd_pr__pfet_01v8 L=0.15U W=0.42U AS=0.0567P
+ AD=0.0882P PS=0.69U PD=0.84U
* device instance $1646 r0 *1 69.13,4.995 sky130_fd_pr__pfet_01v8
M$1646 162 18 35 35 sky130_fd_pr__pfet_01v8 L=0.15U W=0.42U AS=0.0882P
+ AD=0.1113P PS=0.84U PD=1.37U
* device instance $1647 r0 *1 71.825,5.885 sky130_fd_pr__pfet_01v8
M$1647 79 65 162 162 sky130_fd_pr__pfet_01v8 L=0.15U W=0.42U AS=0.1092P
+ AD=0.06405P PS=1.36U PD=0.725U
* device instance $1648 r0 *1 72.28,5.885 sky130_fd_pr__pfet_01v8
M$1648 74 60 79 79 sky130_fd_pr__pfet_01v8 L=0.15U W=0.42U AS=0.06405P
+ AD=0.0567P PS=0.725U PD=0.69U
* device instance $1649 r0 *1 72.7,5.885 sky130_fd_pr__pfet_01v8
M$1649 77 61 74 74 sky130_fd_pr__pfet_01v8 L=0.15U W=0.42U AS=0.0567P
+ AD=0.0882P PS=0.69U PD=0.84U
* device instance $1650 r0 *1 73.27,5.885 sky130_fd_pr__pfet_01v8
M$1650 162 66 77 77 sky130_fd_pr__pfet_01v8 L=0.15U W=0.42U AS=0.0882P
+ AD=0.1113P PS=0.84U PD=1.37U
* device instance $1651 r0 *1 74.325,5.995 sky130_fd_pr__pfet_01v8
M$1651 162 74 66 66 sky130_fd_pr__pfet_01v8 L=0.15U W=0.64U AS=0.1728P
+ AD=0.154P PS=1.82U PD=1.335U
* device instance $1652 r0 *1 74.81,6.175 sky130_fd_pr__pfet_01v8
M$1652 135 74 162 162 sky130_fd_pr__pfet_01v8 L=0.15U W=1U AS=0.154P AD=0.28P
+ PS=1.335U PD=2.56U
* device instance $1653 r0 *1 9.21,10.145 sky130_fd_pr__pfet_01v8
M$1653 163 105 106 106 sky130_fd_pr__pfet_01v8 L=0.15U W=1U AS=0.26P AD=0.135P
+ PS=2.52U PD=1.27U
* device instance $1654 r0 *1 9.63,10.145 sky130_fd_pr__pfet_01v8
M$1654 156 128 163 163 sky130_fd_pr__pfet_01v8 L=0.15U W=1U AS=0.135P AD=0.135P
+ PS=1.27U PD=1.27U
* device instance $1655 r0 *1 10.05,10.145 sky130_fd_pr__pfet_01v8
M$1655 163 129 156 156 sky130_fd_pr__pfet_01v8 L=0.15U W=1U AS=0.135P AD=0.26P
+ PS=1.27U PD=2.52U
* device instance $1656 r0 *1 10.99,10.145 sky130_fd_pr__pfet_01v8
M$1656 156 130 162 162 sky130_fd_pr__pfet_01v8 L=0.15U W=1U AS=0.26P AD=0.165P
+ PS=2.52U PD=1.33U
* device instance $1657 r0 *1 11.47,10.145 sky130_fd_pr__pfet_01v8
M$1657 162 131 156 156 sky130_fd_pr__pfet_01v8 L=0.15U W=1U AS=0.165P
+ AD=0.1575P PS=1.33U PD=1.315U
* device instance $1658 r0 *1 11.935,10.145 sky130_fd_pr__pfet_01v8
M$1658 50 106 162 162 sky130_fd_pr__pfet_01v8 L=0.15U W=1U AS=0.1575P AD=0.26P
+ PS=1.315U PD=2.52U
* device instance $1659 r0 *1 15.21,6.025 sky130_fd_pr__pfet_01v8
M$1659 162 68 67 67 sky130_fd_pr__pfet_01v8 L=0.15U W=0.64U AS=0.1664P
+ AD=0.0864P PS=1.8U PD=0.91U
* device instance $1660 r0 *1 15.63,6.025 sky130_fd_pr__pfet_01v8
M$1660 68 31 162 162 sky130_fd_pr__pfet_01v8 L=0.15U W=0.64U AS=0.0864P
+ AD=0.1664P PS=0.91U PD=1.8U
* device instance $1661 r0 *1 25.31,10.295 sky130_fd_pr__pfet_01v8
M$1661 162 31 109 109 sky130_fd_pr__pfet_01v8 L=0.15U W=0.64U AS=0.1664P
+ AD=0.0864P PS=1.8U PD=0.91U
* device instance $1662 r0 *1 25.73,10.295 sky130_fd_pr__pfet_01v8
M$1662 110 109 162 162 sky130_fd_pr__pfet_01v8 L=0.15U W=0.64U AS=0.0864P
+ AD=0.1664P PS=0.91U PD=1.8U
* device instance $1663 r0 *1 26.67,10.325 sky130_fd_pr__pfet_01v8
M$1663 170 70 111 111 sky130_fd_pr__pfet_01v8 L=0.15U W=0.64U AS=0.1664P
+ AD=0.0672P PS=1.8U PD=0.85U
* device instance $1664 r0 *1 27.03,10.325 sky130_fd_pr__pfet_01v8
M$1664 162 112 170 170 sky130_fd_pr__pfet_01v8 L=0.15U W=0.64U AS=0.0672P
+ AD=0.1664P PS=0.85U PD=1.8U
* device instance $1665 r0 *1 27.97,10.325 sky130_fd_pr__pfet_01v8
M$1665 162 88 112 112 sky130_fd_pr__pfet_01v8 L=0.15U W=0.64U AS=0.1664P
+ AD=0.0928P PS=1.8U PD=0.93U
* device instance $1666 r0 *1 28.41,10.325 sky130_fd_pr__pfet_01v8
M$1666 172 88 162 162 sky130_fd_pr__pfet_01v8 L=0.15U W=0.64U AS=0.0928P
+ AD=0.1152P PS=0.93U PD=1U
* device instance $1667 r0 *1 28.92,10.325 sky130_fd_pr__pfet_01v8
M$1667 111 132 172 172 sky130_fd_pr__pfet_01v8 L=0.15U W=0.64U AS=0.1152P
+ AD=0.15985P PS=1U PD=1.265U
* device instance $1668 r0 *1 29.695,10.435 sky130_fd_pr__pfet_01v8
M$1668 113 110 111 111 sky130_fd_pr__pfet_01v8 L=0.15U W=0.42U AS=0.15985P
+ AD=0.06405P PS=1.265U PD=0.725U
* device instance $1669 r0 *1 30.15,10.435 sky130_fd_pr__pfet_01v8
M$1669 173 109 113 113 sky130_fd_pr__pfet_01v8 L=0.15U W=0.42U AS=0.06405P
+ AD=0.07665P PS=0.725U PD=0.785U
* device instance $1670 r0 *1 30.665,10.435 sky130_fd_pr__pfet_01v8
M$1670 173 114 162 162 sky130_fd_pr__pfet_01v8 L=0.15U W=0.42U AS=0.178875P
+ AD=0.07665P PS=1.26U PD=0.785U
* device instance $1671 r0 *1 31.325,10.27 sky130_fd_pr__pfet_01v8
M$1671 114 113 162 162 sky130_fd_pr__pfet_01v8 L=0.15U W=0.75U AS=0.178875P
+ AD=0.195P PS=1.26U PD=2.02U
* device instance $1672 r0 *1 34.765,10.325 sky130_fd_pr__pfet_01v8
M$1672 132 115 162 162 sky130_fd_pr__pfet_01v8 L=0.15U W=0.64U AS=0.154P
+ AD=0.1728P PS=1.335U PD=1.82U
* device instance $1673 r0 *1 35.25,10.145 sky130_fd_pr__pfet_01v8
M$1673 164 115 162 162 sky130_fd_pr__pfet_01v8 L=0.15U W=1U AS=0.154P AD=0.28P
+ PS=1.335U PD=2.56U
* device instance $1674 r0 *1 44.71,10.325 sky130_fd_pr__pfet_01v8
M$1674 162 133 117 117 sky130_fd_pr__pfet_01v8 L=0.15U W=0.64U AS=0.1696P
+ AD=0.1841P PS=1.81U PD=1.26U
* device instance $1675 r0 *1 45.48,10.435 sky130_fd_pr__pfet_01v8
M$1675 133 108 162 162 sky130_fd_pr__pfet_01v8 L=0.15U W=0.42U AS=0.1841P
+ AD=0.0609P PS=1.26U PD=0.71U
* device instance $1676 r0 *1 45.92,10.435 sky130_fd_pr__pfet_01v8
M$1676 162 159 133 133 sky130_fd_pr__pfet_01v8 L=0.15U W=0.42U AS=0.0609P
+ AD=0.1113P PS=0.71U PD=1.37U
* device instance $1677 r0 *1 47.475,10.24 sky130_fd_pr__pfet_01v8
M$1677 171 55 162 162 sky130_fd_pr__pfet_01v8 L=0.15U W=0.42U AS=0.15835P
+ AD=0.07665P PS=1.395U PD=0.785U
* device instance $1678 r0 *1 47.99,10.24 sky130_fd_pr__pfet_01v8
M$1678 119 134 171 171 sky130_fd_pr__pfet_01v8 L=0.15U W=0.42U AS=0.07665P
+ AD=0.1932P PS=0.785U PD=1.34U
* device instance $1679 r0 *1 49.06,10.24 sky130_fd_pr__pfet_01v8
M$1679 169 120 119 119 sky130_fd_pr__pfet_01v8 L=0.15U W=0.42U AS=0.1932P
+ AD=0.0441P PS=1.34U PD=0.63U
* device instance $1680 r0 *1 49.42,10.24 sky130_fd_pr__pfet_01v8
M$1680 162 121 169 169 sky130_fd_pr__pfet_01v8 L=0.15U W=0.42U AS=0.0441P
+ AD=0.0693P PS=0.63U PD=0.75U
* device instance $1681 r0 *1 49.9,10.24 sky130_fd_pr__pfet_01v8
M$1681 121 55 162 162 sky130_fd_pr__pfet_01v8 L=0.15U W=0.42U AS=0.0693P
+ AD=0.1176P PS=0.75U PD=1.4U
* device instance $1682 r0 *1 46.93,10.145 sky130_fd_pr__pfet_01v8
M$1682 162 119 118 118 sky130_fd_pr__pfet_01v8 L=0.15U W=1U AS=0.26P
+ AD=0.15835P PS=2.52U PD=1.395U
* device instance $1683 r0 *1 59.81,10.145 sky130_fd_pr__pfet_01v8
M$1683 166 123 124 124 sky130_fd_pr__pfet_01v8 L=0.15U W=1U AS=0.26P AD=0.135P
+ PS=2.52U PD=1.27U
* device instance $1684 r0 *1 60.23,10.145 sky130_fd_pr__pfet_01v8
M$1684 161 135 166 166 sky130_fd_pr__pfet_01v8 L=0.15U W=1U AS=0.135P AD=0.135P
+ PS=1.27U PD=1.27U
* device instance $1685 r0 *1 60.65,10.145 sky130_fd_pr__pfet_01v8
M$1685 166 129 161 161 sky130_fd_pr__pfet_01v8 L=0.15U W=1U AS=0.135P AD=0.26P
+ PS=1.27U PD=2.52U
* device instance $1686 r0 *1 61.59,10.145 sky130_fd_pr__pfet_01v8
M$1686 161 136 162 162 sky130_fd_pr__pfet_01v8 L=0.15U W=1U AS=0.26P AD=0.165P
+ PS=2.52U PD=1.33U
* device instance $1687 r0 *1 62.07,10.145 sky130_fd_pr__pfet_01v8
M$1687 162 2 161 161 sky130_fd_pr__pfet_01v8 L=0.15U W=1U AS=0.165P AD=0.1575P
+ PS=1.33U PD=1.315U
* device instance $1688 r0 *1 62.535,10.145 sky130_fd_pr__pfet_01v8
M$1688 15 124 162 162 sky130_fd_pr__pfet_01v8 L=0.15U W=1U AS=0.1575P AD=0.26P
+ PS=1.315U PD=2.52U
* device instance $1689 r0 *1 64.87,6.025 sky130_fd_pr__pfet_01v8
M$1689 162 329 60 60 sky130_fd_pr__pfet_01v8 L=0.15U W=0.64U AS=0.1664P
+ AD=0.0864P PS=1.8U PD=0.91U
* device instance $1690 r0 *1 65.29,6.025 sky130_fd_pr__pfet_01v8
M$1690 61 60 162 162 sky130_fd_pr__pfet_01v8 L=0.15U W=0.64U AS=0.0864P
+ AD=0.1664P PS=0.91U PD=1.8U
* device instance $1691 r0 *1 68.175,10.24 sky130_fd_pr__pfet_01v8
M$1691 168 55 162 162 sky130_fd_pr__pfet_01v8 L=0.15U W=0.42U AS=0.15835P
+ AD=0.07665P PS=1.395U PD=0.785U
* device instance $1692 r0 *1 68.69,10.24 sky130_fd_pr__pfet_01v8
M$1692 125 20 168 168 sky130_fd_pr__pfet_01v8 L=0.15U W=0.42U AS=0.07665P
+ AD=0.1932P PS=0.785U PD=1.34U
* device instance $1693 r0 *1 69.76,10.24 sky130_fd_pr__pfet_01v8
M$1693 167 126 125 125 sky130_fd_pr__pfet_01v8 L=0.15U W=0.42U AS=0.1932P
+ AD=0.0441P PS=1.34U PD=0.63U
* device instance $1694 r0 *1 70.12,10.24 sky130_fd_pr__pfet_01v8
M$1694 162 127 167 167 sky130_fd_pr__pfet_01v8 L=0.15U W=0.42U AS=0.0441P
+ AD=0.0693P PS=0.63U PD=0.75U
* device instance $1695 r0 *1 70.6,10.24 sky130_fd_pr__pfet_01v8
M$1695 127 55 162 162 sky130_fd_pr__pfet_01v8 L=0.15U W=0.42U AS=0.0693P
+ AD=0.1176P PS=0.75U PD=1.4U
* device instance $1696 r0 *1 67.63,10.145 sky130_fd_pr__pfet_01v8
M$1696 162 125 73 73 sky130_fd_pr__pfet_01v8 L=0.15U W=1U AS=0.26P AD=0.15835P
+ PS=2.52U PD=1.395U
* device instance $1697 r0 *1 6.98,10.435 sky130_fd_pr__pfet_01v8
M$1697 104 155 162 162 sky130_fd_pr__pfet_01v8 L=0.15U W=0.42U AS=0.1113P
+ AD=0.0609P PS=1.37U PD=0.71U
* device instance $1698 r0 *1 7.42,10.435 sky130_fd_pr__pfet_01v8
M$1698 104 108 162 162 sky130_fd_pr__pfet_01v8 L=0.15U W=0.42U AS=0.1841P
+ AD=0.0609P PS=1.26U PD=0.71U
* device instance $1699 r0 *1 8.19,10.325 sky130_fd_pr__pfet_01v8
M$1699 105 104 162 162 sky130_fd_pr__pfet_01v8 L=0.15U W=0.64U AS=0.1841P
+ AD=0.1696P PS=1.26U PD=1.81U
* device instance $1700 r0 *1 8.375,11.52 sky130_fd_pr__pfet_01v8
M$1700 212 55 162 162 sky130_fd_pr__pfet_01v8 L=0.15U W=0.42U AS=0.15835P
+ AD=0.07665P PS=1.395U PD=0.785U
* device instance $1701 r0 *1 8.89,11.52 sky130_fd_pr__pfet_01v8
M$1701 176 43 212 212 sky130_fd_pr__pfet_01v8 L=0.15U W=0.42U AS=0.07665P
+ AD=0.1932P PS=0.785U PD=1.34U
* device instance $1702 r0 *1 9.96,11.52 sky130_fd_pr__pfet_01v8
M$1702 213 205 176 176 sky130_fd_pr__pfet_01v8 L=0.15U W=0.42U AS=0.1932P
+ AD=0.0441P PS=1.34U PD=0.63U
* device instance $1703 r0 *1 10.32,11.52 sky130_fd_pr__pfet_01v8
M$1703 162 232 213 213 sky130_fd_pr__pfet_01v8 L=0.15U W=0.42U AS=0.0441P
+ AD=0.0693P PS=0.63U PD=0.75U
* device instance $1704 r0 *1 10.8,11.52 sky130_fd_pr__pfet_01v8
M$1704 232 55 162 162 sky130_fd_pr__pfet_01v8 L=0.15U W=0.42U AS=0.0693P
+ AD=0.1176P PS=0.75U PD=1.4U
* device instance $1705 r0 *1 7.83,11.615 sky130_fd_pr__pfet_01v8
M$1705 162 176 32 32 sky130_fd_pr__pfet_01v8 L=0.15U W=1U AS=0.26P AD=0.15835P
+ PS=2.52U PD=1.395U
* device instance $1706 r0 *1 12.53,11.615 sky130_fd_pr__pfet_01v8
M$1706 131 206 162 162 sky130_fd_pr__pfet_01v8 L=0.15U W=1U AS=0.36P AD=0.165P
+ PS=2.72U PD=1.33U
* device instance $1707 r0 *1 13.01,11.615 sky130_fd_pr__pfet_01v8
M$1707 214 207 131 131 sky130_fd_pr__pfet_01v8 L=0.15U W=1U AS=0.165P AD=0.105P
+ PS=1.33U PD=1.21U
* device instance $1708 r0 *1 13.37,11.615 sky130_fd_pr__pfet_01v8
M$1708 162 228 214 214 sky130_fd_pr__pfet_01v8 L=0.15U W=1U AS=0.105P AD=0.365P
+ PS=1.21U PD=1.73U
* device instance $1709 r0 *1 14.25,11.615 sky130_fd_pr__pfet_01v8
M$1709 206 228 162 162 sky130_fd_pr__pfet_01v8 L=0.15U W=1U AS=0.365P AD=0.135P
+ PS=1.73U PD=1.27U
* device instance $1710 r0 *1 14.67,11.615 sky130_fd_pr__pfet_01v8
M$1710 162 207 206 206 sky130_fd_pr__pfet_01v8 L=0.15U W=1U AS=0.135P AD=0.3P
+ PS=1.27U PD=2.6U
* device instance $1711 r0 *1 15.69,11.615 sky130_fd_pr__pfet_01v8
M$1711 178 177 207 207 sky130_fd_pr__pfet_01v8 L=0.15U W=1U AS=0.3P AD=0.26P
+ PS=2.6U PD=2.52U
* device instance $1712 r0 *1 16.63,11.615 sky130_fd_pr__pfet_01v8
M$1712 178 43 162 162 sky130_fd_pr__pfet_01v8 L=0.15U W=1U AS=0.26P AD=0.135P
+ PS=2.52U PD=1.27U
* device instance $1713 r0 *1 17.05,11.615 sky130_fd_pr__pfet_01v8
M$1713 162 128 178 178 sky130_fd_pr__pfet_01v8 L=0.15U W=1U AS=0.135P AD=0.135P
+ PS=1.27U PD=1.27U
* device instance $1714 r0 *1 17.47,11.615 sky130_fd_pr__pfet_01v8
M$1714 216 128 162 162 sky130_fd_pr__pfet_01v8 L=0.15U W=1U AS=0.135P AD=0.135P
+ PS=1.27U PD=1.27U
* device instance $1715 r0 *1 17.89,11.615 sky130_fd_pr__pfet_01v8
M$1715 177 43 216 216 sky130_fd_pr__pfet_01v8 L=0.15U W=1U AS=0.135P AD=0.26P
+ PS=1.27U PD=2.52U
* device instance $1716 r0 *1 20.69,11.435 sky130_fd_pr__pfet_01v8
M$1716 217 51 181 181 sky130_fd_pr__pfet_01v8 L=0.15U W=0.64U AS=0.1664P
+ AD=0.0672P PS=1.8U PD=0.85U
* device instance $1717 r0 *1 21.05,11.435 sky130_fd_pr__pfet_01v8
M$1717 162 182 217 217 sky130_fd_pr__pfet_01v8 L=0.15U W=0.64U AS=0.0672P
+ AD=0.1664P PS=0.85U PD=1.8U
* device instance $1718 r0 *1 23.715,11.325 sky130_fd_pr__pfet_01v8
M$1718 183 180 181 181 sky130_fd_pr__pfet_01v8 L=0.15U W=0.42U AS=0.15985P
+ AD=0.06405P PS=1.265U PD=0.725U
* device instance $1719 r0 *1 24.17,11.325 sky130_fd_pr__pfet_01v8
M$1719 219 179 183 183 sky130_fd_pr__pfet_01v8 L=0.15U W=0.42U AS=0.06405P
+ AD=0.07665P PS=0.725U PD=0.785U
* device instance $1720 r0 *1 24.685,11.325 sky130_fd_pr__pfet_01v8
M$1720 162 184 219 219 sky130_fd_pr__pfet_01v8 L=0.15U W=0.42U AS=0.07665P
+ AD=0.178875P PS=0.785U PD=1.26U
* device instance $1721 r0 *1 21.99,11.435 sky130_fd_pr__pfet_01v8
M$1721 162 311 182 182 sky130_fd_pr__pfet_01v8 L=0.15U W=0.64U AS=0.1664P
+ AD=0.0928P PS=1.8U PD=0.93U
* device instance $1722 r0 *1 22.43,11.435 sky130_fd_pr__pfet_01v8
M$1722 218 311 162 162 sky130_fd_pr__pfet_01v8 L=0.15U W=0.64U AS=0.0928P
+ AD=0.1152P PS=0.93U PD=1U
* device instance $1723 r0 *1 22.94,11.435 sky130_fd_pr__pfet_01v8
M$1723 181 186 218 218 sky130_fd_pr__pfet_01v8 L=0.15U W=0.64U AS=0.1152P
+ AD=0.15985P PS=1U PD=1.265U
* device instance $1724 r0 *1 25.345,11.49 sky130_fd_pr__pfet_01v8
M$1724 184 183 162 162 sky130_fd_pr__pfet_01v8 L=0.15U W=0.75U AS=0.178875P
+ AD=0.195P PS=1.26U PD=2.02U
* device instance $1725 r0 *1 23.08,10.435 sky130_fd_pr__pfet_01v8
M$1725 107 157 162 162 sky130_fd_pr__pfet_01v8 L=0.15U W=0.42U AS=0.1113P
+ AD=0.0609P PS=1.37U PD=0.71U
* device instance $1726 r0 *1 23.52,10.435 sky130_fd_pr__pfet_01v8
M$1726 107 108 162 162 sky130_fd_pr__pfet_01v8 L=0.15U W=0.42U AS=0.1841P
+ AD=0.0609P PS=1.26U PD=0.71U
* device instance $1727 r0 *1 24.29,10.325 sky130_fd_pr__pfet_01v8
M$1727 54 107 162 162 sky130_fd_pr__pfet_01v8 L=0.15U W=0.64U AS=0.1841P
+ AD=0.1696P PS=1.26U PD=1.81U
* device instance $1728 r0 *1 26.285,11.325 sky130_fd_pr__pfet_01v8
M$1728 221 184 162 162 sky130_fd_pr__pfet_01v8 L=0.15U W=0.42U AS=0.1092P
+ AD=0.06405P PS=1.36U PD=0.725U
* device instance $1729 r0 *1 26.74,11.325 sky130_fd_pr__pfet_01v8
M$1729 185 179 221 221 sky130_fd_pr__pfet_01v8 L=0.15U W=0.42U AS=0.06405P
+ AD=0.0567P PS=0.725U PD=0.69U
* device instance $1730 r0 *1 27.16,11.325 sky130_fd_pr__pfet_01v8
M$1730 222 180 185 185 sky130_fd_pr__pfet_01v8 L=0.15U W=0.42U AS=0.0567P
+ AD=0.0882P PS=0.69U PD=0.84U
* device instance $1731 r0 *1 27.73,11.325 sky130_fd_pr__pfet_01v8
M$1731 162 186 222 222 sky130_fd_pr__pfet_01v8 L=0.15U W=0.42U AS=0.0882P
+ AD=0.1113P PS=0.84U PD=1.37U
* device instance $1732 r0 *1 28.785,11.435 sky130_fd_pr__pfet_01v8
M$1732 162 185 186 186 sky130_fd_pr__pfet_01v8 L=0.15U W=0.64U AS=0.1728P
+ AD=0.154P PS=1.82U PD=1.335U
* device instance $1733 r0 *1 29.27,11.615 sky130_fd_pr__pfet_01v8
M$1733 187 185 162 162 sky130_fd_pr__pfet_01v8 L=0.15U W=1U AS=0.154P AD=0.28P
+ PS=1.335U PD=2.56U
* device instance $1734 r0 *1 30.85,11.615 sky130_fd_pr__pfet_01v8
M$1734 71 208 162 162 sky130_fd_pr__pfet_01v8 L=0.15U W=1U AS=0.26P AD=0.135P
+ PS=2.52U PD=1.27U
* device instance $1735 r0 *1 31.27,11.615 sky130_fd_pr__pfet_01v8
M$1735 162 55 71 71 sky130_fd_pr__pfet_01v8 L=0.15U W=1U AS=0.135P AD=0.26P
+ PS=1.27U PD=2.52U
* device instance $1736 r0 *1 32.21,11.535 sky130_fd_pr__pfet_01v8
M$1736 56 187 162 162 sky130_fd_pr__pfet_01v8 L=0.15U W=1.68U AS=0.3318P
+ AD=0.3486P PS=3.31U PD=3.35U
* device instance $1738 r0 *1 32.265,10.435 sky130_fd_pr__pfet_01v8
M$1738 174 114 162 162 sky130_fd_pr__pfet_01v8 L=0.15U W=0.42U AS=0.1092P
+ AD=0.06405P PS=1.36U PD=0.725U
* device instance $1739 r0 *1 32.72,10.435 sky130_fd_pr__pfet_01v8
M$1739 115 109 174 174 sky130_fd_pr__pfet_01v8 L=0.15U W=0.42U AS=0.06405P
+ AD=0.0567P PS=0.725U PD=0.69U
* device instance $1740 r0 *1 33.14,10.435 sky130_fd_pr__pfet_01v8
M$1740 175 110 115 115 sky130_fd_pr__pfet_01v8 L=0.15U W=0.42U AS=0.0567P
+ AD=0.0882P PS=0.69U PD=0.84U
* device instance $1741 r0 *1 33.71,10.435 sky130_fd_pr__pfet_01v8
M$1741 162 132 175 175 sky130_fd_pr__pfet_01v8 L=0.15U W=0.42U AS=0.0882P
+ AD=0.1113P PS=0.84U PD=1.37U
* device instance $1742 r0 *1 33.595,11.615 sky130_fd_pr__pfet_01v8
M$1742 72 229 162 162 sky130_fd_pr__pfet_01v8 L=0.15U W=2U AS=0.405P AD=0.3P
+ PS=3.81U PD=2.6U
* device instance $1744 r0 *1 34.495,11.615 sky130_fd_pr__pfet_01v8
M$1744 188 164 162 162 sky130_fd_pr__pfet_01v8 L=0.15U W=2U AS=0.3P AD=0.44P
+ PS=2.6U PD=3.88U
* device instance $1745 r0 *1 34.995,11.615 sky130_fd_pr__pfet_01v8
M$1745 72 56 188 188 sky130_fd_pr__pfet_01v8 L=0.15U W=2U AS=0.315P AD=0.28P
+ PS=2.63U PD=2.56U
* device instance $1748 r0 *1 37.34,10.435 sky130_fd_pr__pfet_01v8
M$1748 116 158 162 162 sky130_fd_pr__pfet_01v8 L=0.15U W=0.42U AS=0.1113P
+ AD=0.0609P PS=1.37U PD=0.71U
* device instance $1749 r0 *1 37.78,10.435 sky130_fd_pr__pfet_01v8
M$1749 116 108 162 162 sky130_fd_pr__pfet_01v8 L=0.15U W=0.42U AS=0.1841P
+ AD=0.0609P PS=1.26U PD=0.71U
* device instance $1750 r0 *1 38.55,10.325 sky130_fd_pr__pfet_01v8
M$1750 165 116 162 162 sky130_fd_pr__pfet_01v8 L=0.15U W=0.64U AS=0.1841P
+ AD=0.1696P PS=1.26U PD=1.81U
* device instance $1751 r0 *1 40.965,11.615 sky130_fd_pr__pfet_01v8
M$1751 162 209 189 189 sky130_fd_pr__pfet_01v8 L=0.15U W=1U AS=0.26P AD=0.1575P
+ PS=2.52U PD=1.315U
* device instance $1752 r0 *1 41.43,11.615 sky130_fd_pr__pfet_01v8
M$1752 190 57 162 162 sky130_fd_pr__pfet_01v8 L=0.15U W=1U AS=0.1575P AD=0.165P
+ PS=1.315U PD=1.33U
* device instance $1753 r0 *1 41.91,11.615 sky130_fd_pr__pfet_01v8
M$1753 162 136 190 190 sky130_fd_pr__pfet_01v8 L=0.15U W=1U AS=0.165P AD=0.26P
+ PS=1.33U PD=2.52U
* device instance $1754 r0 *1 42.85,11.615 sky130_fd_pr__pfet_01v8
M$1754 190 129 191 191 sky130_fd_pr__pfet_01v8 L=0.15U W=1U AS=0.26P AD=0.135P
+ PS=2.52U PD=1.27U
* device instance $1755 r0 *1 43.27,11.615 sky130_fd_pr__pfet_01v8
M$1755 191 230 190 190 sky130_fd_pr__pfet_01v8 L=0.15U W=1U AS=0.135P AD=0.135P
+ PS=1.27U PD=1.27U
* device instance $1756 r0 *1 43.69,11.615 sky130_fd_pr__pfet_01v8
M$1756 209 117 191 191 sky130_fd_pr__pfet_01v8 L=0.15U W=1U AS=0.135P AD=0.26P
+ PS=1.27U PD=2.52U
* device instance $1757 r0 *1 48.29,11.435 sky130_fd_pr__pfet_01v8
M$1757 224 118 194 194 sky130_fd_pr__pfet_01v8 L=0.15U W=0.64U AS=0.1664P
+ AD=0.0672P PS=1.8U PD=0.85U
* device instance $1758 r0 *1 48.65,11.435 sky130_fd_pr__pfet_01v8
M$1758 162 195 224 224 sky130_fd_pr__pfet_01v8 L=0.15U W=0.64U AS=0.0672P
+ AD=0.1664P PS=0.85U PD=1.8U
* device instance $1759 r0 *1 51.315,11.325 sky130_fd_pr__pfet_01v8
M$1759 196 193 194 194 sky130_fd_pr__pfet_01v8 L=0.15U W=0.42U AS=0.15985P
+ AD=0.06405P PS=1.265U PD=0.725U
* device instance $1760 r0 *1 51.77,11.325 sky130_fd_pr__pfet_01v8
M$1760 227 192 196 196 sky130_fd_pr__pfet_01v8 L=0.15U W=0.42U AS=0.06405P
+ AD=0.07665P PS=0.725U PD=0.785U
* device instance $1761 r0 *1 52.285,11.325 sky130_fd_pr__pfet_01v8
M$1761 162 197 227 227 sky130_fd_pr__pfet_01v8 L=0.15U W=0.42U AS=0.07665P
+ AD=0.178875P PS=0.785U PD=1.26U
* device instance $1762 r0 *1 49.59,11.435 sky130_fd_pr__pfet_01v8
M$1762 162 88 195 195 sky130_fd_pr__pfet_01v8 L=0.15U W=0.64U AS=0.1664P
+ AD=0.0928P PS=1.8U PD=0.93U
* device instance $1763 r0 *1 50.03,11.435 sky130_fd_pr__pfet_01v8
M$1763 226 88 162 162 sky130_fd_pr__pfet_01v8 L=0.15U W=0.64U AS=0.0928P
+ AD=0.1152P PS=0.93U PD=1U
* device instance $1764 r0 *1 50.54,11.435 sky130_fd_pr__pfet_01v8
M$1764 194 199 226 226 sky130_fd_pr__pfet_01v8 L=0.15U W=0.64U AS=0.1152P
+ AD=0.15985P PS=1U PD=1.265U
* device instance $1765 r0 *1 52.945,11.49 sky130_fd_pr__pfet_01v8
M$1765 197 196 162 162 sky130_fd_pr__pfet_01v8 L=0.15U W=0.75U AS=0.178875P
+ AD=0.195P PS=1.26U PD=2.02U
* device instance $1766 r0 *1 53.885,11.325 sky130_fd_pr__pfet_01v8
M$1766 225 197 162 162 sky130_fd_pr__pfet_01v8 L=0.15U W=0.42U AS=0.1092P
+ AD=0.06405P PS=1.36U PD=0.725U
* device instance $1767 r0 *1 54.34,11.325 sky130_fd_pr__pfet_01v8
M$1767 198 192 225 225 sky130_fd_pr__pfet_01v8 L=0.15U W=0.42U AS=0.06405P
+ AD=0.0567P PS=0.725U PD=0.69U
* device instance $1768 r0 *1 54.76,11.325 sky130_fd_pr__pfet_01v8
M$1768 223 193 198 198 sky130_fd_pr__pfet_01v8 L=0.15U W=0.42U AS=0.0567P
+ AD=0.0882P PS=0.69U PD=0.84U
* device instance $1769 r0 *1 55.33,11.325 sky130_fd_pr__pfet_01v8
M$1769 162 199 223 223 sky130_fd_pr__pfet_01v8 L=0.15U W=0.42U AS=0.0882P
+ AD=0.1113P PS=0.84U PD=1.37U
* device instance $1770 r0 *1 56.385,11.435 sky130_fd_pr__pfet_01v8
M$1770 162 198 199 199 sky130_fd_pr__pfet_01v8 L=0.15U W=0.64U AS=0.1728P
+ AD=0.154P PS=1.82U PD=1.335U
* device instance $1771 r0 *1 56.87,11.615 sky130_fd_pr__pfet_01v8
M$1771 230 198 162 162 sky130_fd_pr__pfet_01v8 L=0.15U W=1U AS=0.154P AD=0.28P
+ PS=1.335U PD=2.56U
* device instance $1772 r0 *1 57.58,10.435 sky130_fd_pr__pfet_01v8
M$1772 122 160 162 162 sky130_fd_pr__pfet_01v8 L=0.15U W=0.42U AS=0.1113P
+ AD=0.0609P PS=1.37U PD=0.71U
* device instance $1773 r0 *1 58.02,10.435 sky130_fd_pr__pfet_01v8
M$1773 122 108 162 162 sky130_fd_pr__pfet_01v8 L=0.15U W=0.42U AS=0.1841P
+ AD=0.0609P PS=1.26U PD=0.71U
* device instance $1774 r0 *1 58.79,10.325 sky130_fd_pr__pfet_01v8
M$1774 123 122 162 162 sky130_fd_pr__pfet_01v8 L=0.15U W=0.64U AS=0.1841P
+ AD=0.1696P PS=1.26U PD=1.81U
* device instance $1775 r0 *1 61.69,11.615 sky130_fd_pr__pfet_01v8
M$1775 201 200 2 2 sky130_fd_pr__pfet_01v8 L=0.15U W=1U AS=0.3P AD=0.26P
+ PS=2.6U PD=2.52U
* device instance $1776 r0 *1 62.63,11.615 sky130_fd_pr__pfet_01v8
M$1776 201 210 162 162 sky130_fd_pr__pfet_01v8 L=0.15U W=1U AS=0.26P AD=0.135P
+ PS=2.52U PD=1.27U
* device instance $1777 r0 *1 63.05,11.615 sky130_fd_pr__pfet_01v8
M$1777 162 231 201 201 sky130_fd_pr__pfet_01v8 L=0.15U W=1U AS=0.135P AD=0.135P
+ PS=1.27U PD=1.27U
* device instance $1778 r0 *1 63.47,11.615 sky130_fd_pr__pfet_01v8
M$1778 220 231 162 162 sky130_fd_pr__pfet_01v8 L=0.15U W=1U AS=0.135P AD=0.135P
+ PS=1.27U PD=1.27U
* device instance $1779 r0 *1 63.89,11.615 sky130_fd_pr__pfet_01v8
M$1779 200 210 220 220 sky130_fd_pr__pfet_01v8 L=0.15U W=1U AS=0.135P AD=0.26P
+ PS=1.27U PD=2.52U
* device instance $1780 r0 *1 66.29,11.615 sky130_fd_pr__pfet_01v8
M$1780 203 202 231 231 sky130_fd_pr__pfet_01v8 L=0.15U W=1U AS=0.3P AD=0.26P
+ PS=2.6U PD=2.52U
* device instance $1781 r0 *1 67.23,11.615 sky130_fd_pr__pfet_01v8
M$1781 203 20 162 162 sky130_fd_pr__pfet_01v8 L=0.15U W=1U AS=0.26P AD=0.135P
+ PS=2.52U PD=1.27U
* device instance $1782 r0 *1 67.65,11.615 sky130_fd_pr__pfet_01v8
M$1782 162 135 203 203 sky130_fd_pr__pfet_01v8 L=0.15U W=1U AS=0.135P AD=0.135P
+ PS=1.27U PD=1.27U
* device instance $1783 r0 *1 68.07,11.615 sky130_fd_pr__pfet_01v8
M$1783 215 135 162 162 sky130_fd_pr__pfet_01v8 L=0.15U W=1U AS=0.135P AD=0.135P
+ PS=1.27U PD=1.27U
* device instance $1784 r0 *1 68.49,11.615 sky130_fd_pr__pfet_01v8
M$1784 202 20 215 215 sky130_fd_pr__pfet_01v8 L=0.15U W=1U AS=0.135P AD=0.26P
+ PS=1.27U PD=2.52U
* device instance $1785 r0 *1 69.925,11.615 sky130_fd_pr__pfet_01v8
M$1785 204 211 162 162 sky130_fd_pr__pfet_01v8 L=0.15U W=1U AS=0.265P AD=0.135P
+ PS=2.53U PD=1.27U
* device instance $1786 r0 *1 70.345,11.615 sky130_fd_pr__pfet_01v8
M$1786 162 20 204 204 sky130_fd_pr__pfet_01v8 L=0.15U W=1U AS=0.135P
+ AD=0.14575P PS=1.27U PD=1.335U
* device instance $1787 r0 *1 70.83,11.905 sky130_fd_pr__pfet_01v8
M$1787 211 135 162 162 sky130_fd_pr__pfet_01v8 L=0.15U W=0.42U AS=0.14575P
+ AD=0.1092P PS=1.335U PD=1.36U
* device instance $1788 r0 *1 12.67,15.295 sky130_fd_pr__pfet_01v8
M$1788 162 43 255 255 sky130_fd_pr__pfet_01v8 L=0.15U W=0.42U AS=0.1092P
+ AD=0.1573P PS=1.36U PD=1.39U
* device instance $1789 r0 *1 13.21,15.585 sky130_fd_pr__pfet_01v8
M$1789 284 128 162 162 sky130_fd_pr__pfet_01v8 L=0.15U W=1U AS=0.1573P
+ AD=0.105P PS=1.39U PD=1.21U
* device instance $1790 r0 *1 13.57,15.585 sky130_fd_pr__pfet_01v8
M$1790 280 255 284 284 sky130_fd_pr__pfet_01v8 L=0.15U W=1U AS=0.105P AD=0.26P
+ PS=1.21U PD=2.52U
* device instance $1791 r0 *1 13.82,17.055 sky130_fd_pr__pfet_01v8
M$1791 162 293 292 292 sky130_fd_pr__pfet_01v8 L=0.15U W=1U AS=0.26P AD=0.26P
+ PS=2.52U PD=2.52U
* device instance $1792 r0 *1 14.73,15.665 sky130_fd_pr__pfet_01v8
M$1792 256 207 162 162 sky130_fd_pr__pfet_01v8 L=0.15U W=1.68U AS=0.3318P
+ AD=0.3486P PS=3.31U PD=3.35U
* device instance $1794 r0 *1 14.76,17.055 sky130_fd_pr__pfet_01v8
M$1794 294 280 293 293 sky130_fd_pr__pfet_01v8 L=0.15U W=1U AS=0.26P AD=0.1375P
+ PS=2.52U PD=1.275U
* device instance $1795 r0 *1 15.185,17.055 sky130_fd_pr__pfet_01v8
M$1795 162 228 294 294 sky130_fd_pr__pfet_01v8 L=0.15U W=1U AS=0.1375P AD=0.14P
+ PS=1.275U PD=1.28U
* device instance $1796 r0 *1 15.615,17.055 sky130_fd_pr__pfet_01v8
M$1796 294 256 162 162 sky130_fd_pr__pfet_01v8 L=0.15U W=1U AS=0.14P AD=0.265P
+ PS=1.28U PD=2.53U
* device instance $1797 r0 *1 19.33,11.465 sky130_fd_pr__pfet_01v8
M$1797 162 31 179 179 sky130_fd_pr__pfet_01v8 L=0.15U W=0.64U AS=0.1664P
+ AD=0.0864P PS=1.8U PD=0.91U
* device instance $1798 r0 *1 19.75,11.465 sky130_fd_pr__pfet_01v8
M$1798 180 179 162 162 sky130_fd_pr__pfet_01v8 L=0.15U W=0.64U AS=0.0864P
+ AD=0.1664P PS=0.91U PD=1.8U
* device instance $1799 r0 *1 28.57,15.585 sky130_fd_pr__pfet_01v8
M$1799 257 187 162 162 sky130_fd_pr__pfet_01v8 L=0.15U W=1U AS=0.3P AD=0.135P
+ PS=2.6U PD=1.27U
* device instance $1800 r0 *1 28.99,15.585 sky130_fd_pr__pfet_01v8
M$1800 162 164 257 257 sky130_fd_pr__pfet_01v8 L=0.15U W=1U AS=0.135P AD=0.365P
+ PS=1.27U PD=1.73U
* device instance $1801 r0 *1 29.87,15.585 sky130_fd_pr__pfet_01v8
M$1801 285 164 162 162 sky130_fd_pr__pfet_01v8 L=0.15U W=1U AS=0.365P AD=0.105P
+ PS=1.73U PD=1.21U
* device instance $1802 r0 *1 30.23,15.585 sky130_fd_pr__pfet_01v8
M$1802 274 187 285 285 sky130_fd_pr__pfet_01v8 L=0.15U W=1U AS=0.105P AD=0.165P
+ PS=1.21U PD=1.33U
* device instance $1803 r0 *1 30.71,15.585 sky130_fd_pr__pfet_01v8
M$1803 162 257 274 274 sky130_fd_pr__pfet_01v8 L=0.15U W=1U AS=0.165P AD=0.36P
+ PS=1.33U PD=2.72U
* device instance $1804 r0 *1 32.87,15.295 sky130_fd_pr__pfet_01v8
M$1804 273 229 162 162 sky130_fd_pr__pfet_01v8 L=0.15U W=0.42U AS=0.1573P
+ AD=0.1092P PS=1.39U PD=1.36U
* device instance $1805 r0 *1 31.97,15.585 sky130_fd_pr__pfet_01v8
M$1805 286 273 1 1 sky130_fd_pr__pfet_01v8 L=0.15U W=1U AS=0.26P AD=0.105P
+ PS=2.52U PD=1.21U
* device instance $1806 r0 *1 32.33,15.585 sky130_fd_pr__pfet_01v8
M$1806 162 259 286 286 sky130_fd_pr__pfet_01v8 L=0.15U W=1U AS=0.105P
+ AD=0.1573P PS=1.21U PD=1.39U
* device instance $1807 r0 *1 34.05,15.585 sky130_fd_pr__pfet_01v8
M$1807 229 274 162 162 sky130_fd_pr__pfet_01v8 L=0.15U W=2U AS=0.395P AD=0.27P
+ PS=3.79U PD=2.54U
* device instance $1809 r0 *1 34.89,15.585 sky130_fd_pr__pfet_01v8
M$1809 229 261 162 162 sky130_fd_pr__pfet_01v8 L=0.15U W=2U AS=0.27P AD=0.395P
+ PS=2.54U PD=3.79U
* device instance $1811 r0 *1 34.07,17.055 sky130_fd_pr__pfet_01v8
M$1811 295 274 259 259 sky130_fd_pr__pfet_01v8 L=0.15U W=1U AS=0.265P AD=0.14P
+ PS=2.53U PD=1.28U
* device instance $1812 r0 *1 34.5,17.055 sky130_fd_pr__pfet_01v8
M$1812 162 261 295 295 sky130_fd_pr__pfet_01v8 L=0.15U W=1U AS=0.14P AD=0.1475P
+ PS=1.28U PD=1.295U
* device instance $1813 r0 *1 34.945,17.055 sky130_fd_pr__pfet_01v8
M$1813 295 275 162 162 sky130_fd_pr__pfet_01v8 L=0.15U W=1U AS=0.1475P
+ AD=0.265P PS=1.295U PD=2.53U
* device instance $1814 r0 *1 35.97,17.055 sky130_fd_pr__pfet_01v8
M$1814 312 164 162 162 sky130_fd_pr__pfet_01v8 L=0.15U W=1U AS=0.26P AD=0.105P
+ PS=2.52U PD=1.21U
* device instance $1815 r0 *1 36.33,17.055 sky130_fd_pr__pfet_01v8
M$1815 277 56 312 312 sky130_fd_pr__pfet_01v8 L=0.15U W=1U AS=0.105P AD=0.26P
+ PS=1.21U PD=2.52U
* device instance $1816 r0 *1 36.25,15.585 sky130_fd_pr__pfet_01v8
M$1816 229 275 162 162 sky130_fd_pr__pfet_01v8 L=0.15U W=2U AS=0.395P AD=0.445P
+ PS=3.79U PD=3.89U
* device instance $1818 r0 *1 37.73,15.585 sky130_fd_pr__pfet_01v8
M$1818 281 261 162 162 sky130_fd_pr__pfet_01v8 L=0.15U W=2U AS=0.395P AD=0.27P
+ PS=3.79U PD=2.54U
* device instance $1820 r0 *1 38.57,15.585 sky130_fd_pr__pfet_01v8
M$1820 281 276 162 162 sky130_fd_pr__pfet_01v8 L=0.15U W=2U AS=0.275P AD=0.285P
+ PS=2.55U PD=2.57U
* device instance $1822 r0 *1 39.44,15.585 sky130_fd_pr__pfet_01v8
M$1822 281 274 162 162 sky130_fd_pr__pfet_01v8 L=0.15U W=2U AS=0.28P AD=0.395P
+ PS=2.56U PD=3.79U
* device instance $1824 r0 *1 40.8,15.585 sky130_fd_pr__pfet_01v8
M$1824 281 277 282 282 sky130_fd_pr__pfet_01v8 L=0.15U W=2U AS=0.395P AD=0.395P
+ PS=3.79U PD=2.79U
* device instance $1826 r0 *1 41.89,15.585 sky130_fd_pr__pfet_01v8
M$1826 265 266 282 282 sky130_fd_pr__pfet_01v8 L=0.15U W=2U AS=0.395P AD=0.395P
+ PS=2.79U PD=3.79U
* device instance $1828 r0 *1 46.21,15.295 sky130_fd_pr__pfet_01v8
M$1828 278 134 162 162 sky130_fd_pr__pfet_01v8 L=0.15U W=0.42U AS=0.1573P
+ AD=0.1092P PS=1.39U PD=1.36U
* device instance $1829 r0 *1 45.31,15.585 sky130_fd_pr__pfet_01v8
M$1829 288 278 266 266 sky130_fd_pr__pfet_01v8 L=0.15U W=1U AS=0.26P AD=0.105P
+ PS=2.52U PD=1.21U
* device instance $1830 r0 *1 45.67,15.585 sky130_fd_pr__pfet_01v8
M$1830 162 230 288 288 sky130_fd_pr__pfet_01v8 L=0.15U W=1U AS=0.105P
+ AD=0.1573P PS=1.21U PD=1.39U
* device instance $1831 r0 *1 45.53,16.875 sky130_fd_pr__pfet_01v8
M$1831 314 189 298 298 sky130_fd_pr__pfet_01v8 L=0.15U W=0.64U AS=0.1664P
+ AD=0.0672P PS=1.8U PD=0.85U
* device instance $1832 r0 *1 45.89,16.875 sky130_fd_pr__pfet_01v8
M$1832 162 299 314 314 sky130_fd_pr__pfet_01v8 L=0.15U W=0.64U AS=0.0672P
+ AD=0.1664P PS=0.85U PD=1.8U
* device instance $1833 r0 *1 48.555,16.765 sky130_fd_pr__pfet_01v8
M$1833 300 297 298 298 sky130_fd_pr__pfet_01v8 L=0.15U W=0.42U AS=0.15985P
+ AD=0.06405P PS=1.265U PD=0.725U
* device instance $1834 r0 *1 49.01,16.765 sky130_fd_pr__pfet_01v8
M$1834 307 296 300 300 sky130_fd_pr__pfet_01v8 L=0.15U W=0.42U AS=0.06405P
+ AD=0.07665P PS=0.725U PD=0.785U
* device instance $1835 r0 *1 49.525,16.765 sky130_fd_pr__pfet_01v8
M$1835 162 301 307 307 sky130_fd_pr__pfet_01v8 L=0.15U W=0.42U AS=0.07665P
+ AD=0.178875P PS=0.785U PD=1.26U
* device instance $1836 r0 *1 46.83,16.875 sky130_fd_pr__pfet_01v8
M$1836 162 311 299 299 sky130_fd_pr__pfet_01v8 L=0.15U W=0.64U AS=0.1664P
+ AD=0.0928P PS=1.8U PD=0.93U
* device instance $1837 r0 *1 47.27,16.875 sky130_fd_pr__pfet_01v8
M$1837 313 311 162 162 sky130_fd_pr__pfet_01v8 L=0.15U W=0.64U AS=0.0928P
+ AD=0.1152P PS=0.93U PD=1U
* device instance $1838 r0 *1 47.78,16.875 sky130_fd_pr__pfet_01v8
M$1838 298 303 313 313 sky130_fd_pr__pfet_01v8 L=0.15U W=0.64U AS=0.1152P
+ AD=0.15985P PS=1U PD=1.265U
* device instance $1839 r0 *1 50.185,16.93 sky130_fd_pr__pfet_01v8
M$1839 301 300 162 162 sky130_fd_pr__pfet_01v8 L=0.15U W=0.75U AS=0.178875P
+ AD=0.195P PS=1.26U PD=2.02U
* device instance $1840 r0 *1 46.93,11.465 sky130_fd_pr__pfet_01v8
M$1840 162 329 192 192 sky130_fd_pr__pfet_01v8 L=0.15U W=0.64U AS=0.1664P
+ AD=0.0864P PS=1.8U PD=0.91U
* device instance $1841 r0 *1 47.35,11.465 sky130_fd_pr__pfet_01v8
M$1841 193 192 162 162 sky130_fd_pr__pfet_01v8 L=0.15U W=0.64U AS=0.0864P
+ AD=0.1664P PS=0.91U PD=1.8U
* device instance $1842 r0 *1 47.47,15.585 sky130_fd_pr__pfet_01v8
M$1842 289 266 162 162 sky130_fd_pr__pfet_01v8 L=0.15U W=1U AS=0.26P AD=0.105P
+ PS=2.52U PD=1.21U
* device instance $1843 r0 *1 47.83,15.585 sky130_fd_pr__pfet_01v8
M$1843 87 267 289 289 sky130_fd_pr__pfet_01v8 L=0.15U W=1U AS=0.105P AD=0.26P
+ PS=1.21U PD=2.52U
* device instance $1844 r0 *1 50.39,15.295 sky130_fd_pr__pfet_01v8
M$1844 162 230 268 268 sky130_fd_pr__pfet_01v8 L=0.15U W=0.42U AS=0.1092P
+ AD=0.1573P PS=1.36U PD=1.39U
* device instance $1845 r0 *1 50.93,15.585 sky130_fd_pr__pfet_01v8
M$1845 290 134 162 162 sky130_fd_pr__pfet_01v8 L=0.15U W=1U AS=0.1573P
+ AD=0.105P PS=1.39U PD=1.21U
* device instance $1846 r0 *1 51.29,15.585 sky130_fd_pr__pfet_01v8
M$1846 267 268 290 290 sky130_fd_pr__pfet_01v8 L=0.15U W=1U AS=0.105P AD=0.26P
+ PS=1.21U PD=2.52U
* device instance $1847 r0 *1 51.125,16.765 sky130_fd_pr__pfet_01v8
M$1847 308 301 162 162 sky130_fd_pr__pfet_01v8 L=0.15U W=0.42U AS=0.1092P
+ AD=0.06405P PS=1.36U PD=0.725U
* device instance $1848 r0 *1 51.58,16.765 sky130_fd_pr__pfet_01v8
M$1848 302 296 308 308 sky130_fd_pr__pfet_01v8 L=0.15U W=0.42U AS=0.06405P
+ AD=0.0567P PS=0.725U PD=0.69U
* device instance $1849 r0 *1 52,16.765 sky130_fd_pr__pfet_01v8
M$1849 309 297 302 302 sky130_fd_pr__pfet_01v8 L=0.15U W=0.42U AS=0.0567P
+ AD=0.0882P PS=0.69U PD=0.84U
* device instance $1850 r0 *1 52.57,16.765 sky130_fd_pr__pfet_01v8
M$1850 162 303 309 309 sky130_fd_pr__pfet_01v8 L=0.15U W=0.42U AS=0.0882P
+ AD=0.1113P PS=0.84U PD=1.37U
* device instance $1851 r0 *1 53.625,16.875 sky130_fd_pr__pfet_01v8
M$1851 162 302 303 303 sky130_fd_pr__pfet_01v8 L=0.15U W=0.64U AS=0.1728P
+ AD=0.154P PS=1.82U PD=1.335U
* device instance $1852 r0 *1 54.11,17.055 sky130_fd_pr__pfet_01v8
M$1852 134 302 162 162 sky130_fd_pr__pfet_01v8 L=0.15U W=1U AS=0.154P AD=0.28P
+ PS=1.335U PD=2.56U
* device instance $1853 r0 *1 57.715,15.295 sky130_fd_pr__pfet_01v8
M$1853 291 267 269 269 sky130_fd_pr__pfet_01v8 L=0.15U W=0.42U AS=0.1092P
+ AD=0.0441P PS=1.36U PD=0.63U
* device instance $1854 r0 *1 58.075,15.295 sky130_fd_pr__pfet_01v8
M$1854 162 265 291 291 sky130_fd_pr__pfet_01v8 L=0.15U W=0.42U AS=0.0441P
+ AD=0.14575P PS=0.63U PD=1.335U
* device instance $1855 r0 *1 58.56,15.585 sky130_fd_pr__pfet_01v8
M$1855 270 269 162 162 sky130_fd_pr__pfet_01v8 L=0.15U W=1U AS=0.14575P
+ AD=0.34P PS=1.335U PD=2.68U
* device instance $1856 r0 *1 59.93,17.055 sky130_fd_pr__pfet_01v8
M$1856 162 231 304 304 sky130_fd_pr__pfet_01v8 L=0.15U W=2U AS=0.395P AD=0.27P
+ PS=3.79U PD=2.54U
* device instance $1858 r0 *1 60.77,17.055 sky130_fd_pr__pfet_01v8
M$1858 305 265 304 304 sky130_fd_pr__pfet_01v8 L=0.15U W=2U AS=0.27P AD=0.395P
+ PS=2.54U PD=3.79U
* device instance $1860 r0 *1 62.13,17.055 sky130_fd_pr__pfet_01v8
M$1860 305 267 306 306 sky130_fd_pr__pfet_01v8 L=0.15U W=2U AS=0.395P AD=0.27P
+ PS=3.79U PD=2.54U
* device instance $1862 r0 *1 62.97,17.055 sky130_fd_pr__pfet_01v8
M$1862 162 204 306 306 sky130_fd_pr__pfet_01v8 L=0.15U W=2U AS=0.44P AD=0.51P
+ PS=2.88U PD=3.02U
* device instance $1864 r0 *1 64.29,17.055 sky130_fd_pr__pfet_01v8
M$1864 162 316 306 306 sky130_fd_pr__pfet_01v8 L=0.15U W=2U AS=0.34P AD=0.395P
+ PS=2.68U PD=3.79U
* device instance $1866 r0 *1 63.64,15.585 sky130_fd_pr__pfet_01v8
M$1866 162 270 271 271 sky130_fd_pr__pfet_01v8 L=0.15U W=1U AS=0.26P AD=0.135P
+ PS=2.52U PD=1.27U
* device instance $1867 r0 *1 64.06,15.585 sky130_fd_pr__pfet_01v8
M$1867 210 271 162 162 sky130_fd_pr__pfet_01v8 L=0.15U W=4U AS=0.54P AD=0.719P
+ PS=5.08U PD=5.645U
* device instance $1871 r0 *1 66.305,15.765 sky130_fd_pr__pfet_01v8
M$1871 287 231 162 162 sky130_fd_pr__pfet_01v8 L=0.15U W=0.64U AS=0.314P
+ AD=0.0768P PS=1.835U PD=0.88U
* device instance $1872 r0 *1 66.695,15.765 sky130_fd_pr__pfet_01v8
M$1872 283 270 287 287 sky130_fd_pr__pfet_01v8 L=0.15U W=0.64U AS=0.0768P
+ AD=0.0896P PS=0.88U PD=0.92U
* device instance $1873 r0 *1 67.125,15.765 sky130_fd_pr__pfet_01v8
M$1873 162 204 283 283 sky130_fd_pr__pfet_01v8 L=0.15U W=0.64U AS=0.0896P
+ AD=0.1824P PS=0.92U PD=1.85U
* device instance $1874 r0 *1 17.03,21.025 sky130_fd_pr__pfet_01v8
M$1874 162 335 336 336 sky130_fd_pr__pfet_01v8 L=0.15U W=1U AS=0.26P AD=0.135P
+ PS=2.52U PD=1.27U
* device instance $1875 r0 *1 17.45,21.025 sky130_fd_pr__pfet_01v8
M$1875 228 336 162 162 sky130_fd_pr__pfet_01v8 L=0.15U W=4U AS=0.54P AD=0.665P
+ PS=5.08U PD=6.33U
* device instance $1879 r0 *1 19.65,21.025 sky130_fd_pr__pfet_01v8
M$1879 162 335 344 344 sky130_fd_pr__pfet_01v8 L=0.15U W=4U AS=0.665P AD=0.54P
+ PS=6.33U PD=5.08U
* device instance $1882 r0 *1 20.91,21.025 sky130_fd_pr__pfet_01v8
M$1882 344 256 162 162 sky130_fd_pr__pfet_01v8 L=0.15U W=4U AS=0.54P AD=0.54P
+ PS=5.08U PD=5.08U
* device instance $1887 r0 *1 23.01,21.025 sky130_fd_pr__pfet_01v8
M$1887 345 338 344 344 sky130_fd_pr__pfet_01v8 L=0.15U W=2U AS=0.27P AD=0.27P
+ PS=2.54U PD=2.54U
* device instance $1889 r0 *1 23.85,21.025 sky130_fd_pr__pfet_01v8
M$1889 349 338 344 344 sky130_fd_pr__pfet_01v8 L=0.15U W=1U AS=0.135P AD=0.15P
+ PS=1.27U PD=1.3U
* device instance $1890 r0 *1 24.3,21.025 sky130_fd_pr__pfet_01v8
M$1890 337 280 349 349 sky130_fd_pr__pfet_01v8 L=0.15U W=1U AS=0.15P AD=0.14P
+ PS=1.3U PD=1.28U
* device instance $1891 r0 *1 24.73,21.025 sky130_fd_pr__pfet_01v8
M$1891 345 280 337 337 sky130_fd_pr__pfet_01v8 L=0.15U W=2U AS=0.28P AD=0.29P
+ PS=2.56U PD=2.58U
* device instance $1893 r0 *1 25.61,21.025 sky130_fd_pr__pfet_01v8
M$1893 350 280 337 337 sky130_fd_pr__pfet_01v8 L=0.15U W=1U AS=0.15P AD=0.155P
+ PS=1.3U PD=1.31U
* device instance $1894 r0 *1 26.07,21.025 sky130_fd_pr__pfet_01v8
M$1894 344 338 350 350 sky130_fd_pr__pfet_01v8 L=0.15U W=1U AS=0.155P AD=0.26P
+ PS=1.31U PD=2.52U
* device instance $1895 r0 *1 27.155,21.025 sky130_fd_pr__pfet_01v8
M$1895 326 310 162 162 sky130_fd_pr__pfet_01v8 L=0.15U W=4U AS=0.685P AD=0.56P
+ PS=6.37U PD=5.12U
* device instance $1899 r0 *1 28.875,21.025 sky130_fd_pr__pfet_01v8
M$1899 31 326 162 162 sky130_fd_pr__pfet_01v8 L=0.15U W=16U AS=2.2375P
+ AD=2.4875P PS=20.475U PD=20.975U
* device instance $1915 r0 *1 36.25,21.025 sky130_fd_pr__pfet_01v8
M$1915 275 327 162 162 sky130_fd_pr__pfet_01v8 L=0.15U W=4U AS=0.795P AD=0.54P
+ PS=5.59U PD=5.08U
* device instance $1919 r0 *1 37.93,21.025 sky130_fd_pr__pfet_01v8
M$1919 327 276 162 162 sky130_fd_pr__pfet_01v8 L=0.15U W=1U AS=0.135P AD=0.26P
+ PS=1.27U PD=2.52U
* device instance $1920 r0 *1 44.17,16.905 sky130_fd_pr__pfet_01v8
M$1920 162 329 296 296 sky130_fd_pr__pfet_01v8 L=0.15U W=0.64U AS=0.1664P
+ AD=0.0864P PS=1.8U PD=0.91U
* device instance $1921 r0 *1 44.59,16.905 sky130_fd_pr__pfet_01v8
M$1921 297 296 162 162 sky130_fd_pr__pfet_01v8 L=0.15U W=0.64U AS=0.0864P
+ AD=0.1664P PS=0.91U PD=1.8U
* device instance $1922 r0 *1 46.475,21.025 sky130_fd_pr__pfet_01v8
M$1922 328 310 162 162 sky130_fd_pr__pfet_01v8 L=0.15U W=4U AS=0.685P AD=0.56P
+ PS=6.37U PD=5.12U
* device instance $1926 r0 *1 48.195,21.025 sky130_fd_pr__pfet_01v8
M$1926 329 328 162 162 sky130_fd_pr__pfet_01v8 L=0.15U W=16U AS=2.2375P
+ AD=2.3625P PS=20.475U PD=21.725U
* device instance $1942 r0 *1 63.51,21.025 sky130_fd_pr__pfet_01v8
M$1942 330 339 162 162 sky130_fd_pr__pfet_01v8 L=0.15U W=1U AS=0.26P AD=0.135P
+ PS=2.52U PD=1.27U
* device instance $1943 r0 *1 63.93,21.025 sky130_fd_pr__pfet_01v8
M$1943 162 316 330 330 sky130_fd_pr__pfet_01v8 L=0.15U W=1U AS=0.135P AD=0.26P
+ PS=1.27U PD=2.52U
* device instance $1944 r0 *1 64.91,21.025 sky130_fd_pr__pfet_01v8
M$1944 331 283 162 162 sky130_fd_pr__pfet_01v8 L=0.15U W=1U AS=0.3P AD=0.135P
+ PS=2.6U PD=1.27U
* device instance $1945 r0 *1 65.33,21.025 sky130_fd_pr__pfet_01v8
M$1945 162 330 331 331 sky130_fd_pr__pfet_01v8 L=0.15U W=1U AS=0.135P AD=0.365P
+ PS=1.27U PD=1.73U
* device instance $1946 r0 *1 66.21,21.025 sky130_fd_pr__pfet_01v8
M$1946 348 330 162 162 sky130_fd_pr__pfet_01v8 L=0.15U W=1U AS=0.365P AD=0.105P
+ PS=1.73U PD=1.21U
* device instance $1947 r0 *1 66.57,21.025 sky130_fd_pr__pfet_01v8
M$1947 346 283 348 348 sky130_fd_pr__pfet_01v8 L=0.15U W=1U AS=0.105P AD=0.165P
+ PS=1.21U PD=1.33U
* device instance $1948 r0 *1 67.05,21.025 sky130_fd_pr__pfet_01v8
M$1948 162 331 346 346 sky130_fd_pr__pfet_01v8 L=0.15U W=1U AS=0.165P AD=0.36P
+ PS=1.33U PD=2.72U
* device instance $1949 r0 *1 69.21,20.735 sky130_fd_pr__pfet_01v8
M$1949 340 341 162 162 sky130_fd_pr__pfet_01v8 L=0.15U W=0.42U AS=0.1573P
+ AD=0.1092P PS=1.39U PD=1.36U
* device instance $1950 r0 *1 68.31,21.025 sky130_fd_pr__pfet_01v8
M$1950 347 340 333 333 sky130_fd_pr__pfet_01v8 L=0.15U W=1U AS=0.26P AD=0.105P
+ PS=2.52U PD=1.21U
* device instance $1951 r0 *1 68.67,21.025 sky130_fd_pr__pfet_01v8
M$1951 162 334 347 347 sky130_fd_pr__pfet_01v8 L=0.15U W=1U AS=0.105P
+ AD=0.1573P PS=1.21U PD=1.39U
* device instance $1952 r0 *1 6.98,22.205 sky130_fd_pr__pfet_01v8
M$1952 351 377 162 162 sky130_fd_pr__pfet_01v8 L=0.15U W=0.42U AS=0.1113P
+ AD=0.0609P PS=1.37U PD=0.71U
* device instance $1953 r0 *1 7.42,22.205 sky130_fd_pr__pfet_01v8
M$1953 162 108 351 351 sky130_fd_pr__pfet_01v8 L=0.15U W=0.42U AS=0.0609P
+ AD=0.1841P PS=0.71U PD=1.26U
* device instance $1954 r0 *1 8.19,22.315 sky130_fd_pr__pfet_01v8
M$1954 352 351 162 162 sky130_fd_pr__pfet_01v8 L=0.15U W=0.64U AS=0.1841P
+ AD=0.1696P PS=1.26U PD=1.81U
* device instance $1955 r0 *1 9.21,22.495 sky130_fd_pr__pfet_01v8
M$1955 354 352 353 353 sky130_fd_pr__pfet_01v8 L=0.15U W=1U AS=0.26P AD=0.135P
+ PS=2.52U PD=1.27U
* device instance $1956 r0 *1 9.63,22.495 sky130_fd_pr__pfet_01v8
M$1956 379 378 354 354 sky130_fd_pr__pfet_01v8 L=0.15U W=1U AS=0.135P AD=0.135P
+ PS=1.27U PD=1.27U
* device instance $1957 r0 *1 10.05,22.495 sky130_fd_pr__pfet_01v8
M$1957 354 129 379 379 sky130_fd_pr__pfet_01v8 L=0.15U W=1U AS=0.135P AD=0.26P
+ PS=1.27U PD=2.52U
* device instance $1958 r0 *1 10.99,22.495 sky130_fd_pr__pfet_01v8
M$1958 379 130 162 162 sky130_fd_pr__pfet_01v8 L=0.15U W=1U AS=0.26P AD=0.165P
+ PS=2.52U PD=1.33U
* device instance $1959 r0 *1 11.47,22.495 sky130_fd_pr__pfet_01v8
M$1959 162 403 379 379 sky130_fd_pr__pfet_01v8 L=0.15U W=1U AS=0.165P
+ AD=0.1575P PS=1.33U PD=1.315U
* device instance $1960 r0 *1 11.935,22.495 sky130_fd_pr__pfet_01v8
M$1960 405 353 162 162 sky130_fd_pr__pfet_01v8 L=0.15U W=1U AS=0.1575P AD=0.26P
+ PS=1.315U PD=2.52U
* device instance $1961 r0 *1 12.93,22.495 sky130_fd_pr__pfet_01v8
M$1961 356 355 403 403 sky130_fd_pr__pfet_01v8 L=0.15U W=1U AS=0.3P AD=0.26P
+ PS=2.6U PD=2.52U
* device instance $1962 r0 *1 13.87,22.495 sky130_fd_pr__pfet_01v8
M$1962 356 380 162 162 sky130_fd_pr__pfet_01v8 L=0.15U W=1U AS=0.26P AD=0.135P
+ PS=2.52U PD=1.27U
* device instance $1963 r0 *1 14.29,22.495 sky130_fd_pr__pfet_01v8
M$1963 162 292 356 356 sky130_fd_pr__pfet_01v8 L=0.15U W=1U AS=0.135P AD=0.135P
+ PS=1.27U PD=1.27U
* device instance $1964 r0 *1 14.71,22.495 sky130_fd_pr__pfet_01v8
M$1964 392 292 162 162 sky130_fd_pr__pfet_01v8 L=0.15U W=1U AS=0.135P AD=0.135P
+ PS=1.27U PD=1.27U
* device instance $1965 r0 *1 15.13,22.495 sky130_fd_pr__pfet_01v8
M$1965 355 380 392 392 sky130_fd_pr__pfet_01v8 L=0.15U W=1U AS=0.135P AD=0.26P
+ PS=1.27U PD=2.52U
* device instance $1966 r0 *1 27.195,22.495 sky130_fd_pr__pfet_01v8
M$1966 357 31 162 162 sky130_fd_pr__pfet_01v8 L=0.15U W=6U AS=1.005P AD=1.045P
+ PS=9.01U PD=9.09U
* device instance $1972 r0 *1 42.055,22.315 sky130_fd_pr__pfet_01v8
M$1972 359 358 162 162 sky130_fd_pr__pfet_01v8 L=0.15U W=0.64U AS=0.154P
+ AD=0.1728P PS=1.335U PD=1.82U
* device instance $1973 r0 *1 41.57,22.495 sky130_fd_pr__pfet_01v8
M$1973 162 358 407 407 sky130_fd_pr__pfet_01v8 L=0.15U W=1U AS=0.28P AD=0.154P
+ PS=2.56U PD=1.335U
* device instance $1974 r0 *1 43.11,22.205 sky130_fd_pr__pfet_01v8
M$1974 397 359 162 162 sky130_fd_pr__pfet_01v8 L=0.15U W=0.42U AS=0.1113P
+ AD=0.0882P PS=1.37U PD=0.84U
* device instance $1975 r0 *1 43.68,22.205 sky130_fd_pr__pfet_01v8
M$1975 358 382 397 397 sky130_fd_pr__pfet_01v8 L=0.15U W=0.42U AS=0.0882P
+ AD=0.0567P PS=0.84U PD=0.69U
* device instance $1976 r0 *1 44.1,22.205 sky130_fd_pr__pfet_01v8
M$1976 399 383 358 358 sky130_fd_pr__pfet_01v8 L=0.15U W=0.42U AS=0.0567P
+ AD=0.06405P PS=0.69U PD=0.725U
* device instance $1977 r0 *1 44.555,22.205 sky130_fd_pr__pfet_01v8
M$1977 162 360 399 399 sky130_fd_pr__pfet_01v8 L=0.15U W=0.42U AS=0.06405P
+ AD=0.1092P PS=0.725U PD=1.36U
* device instance $1978 r0 *1 46.155,22.205 sky130_fd_pr__pfet_01v8
M$1978 400 360 162 162 sky130_fd_pr__pfet_01v8 L=0.15U W=0.42U AS=0.178875P
+ AD=0.07665P PS=1.26U PD=0.785U
* device instance $1979 r0 *1 46.67,22.205 sky130_fd_pr__pfet_01v8
M$1979 361 383 400 400 sky130_fd_pr__pfet_01v8 L=0.15U W=0.42U AS=0.07665P
+ AD=0.06405P PS=0.785U PD=0.725U
* device instance $1980 r0 *1 47.125,22.205 sky130_fd_pr__pfet_01v8
M$1980 362 382 361 361 sky130_fd_pr__pfet_01v8 L=0.15U W=0.42U AS=0.06405P
+ AD=0.15985P PS=0.725U PD=1.265U
* device instance $1981 r0 *1 47.9,22.315 sky130_fd_pr__pfet_01v8
M$1981 401 359 362 362 sky130_fd_pr__pfet_01v8 L=0.15U W=0.64U AS=0.15985P
+ AD=0.1152P PS=1.265U PD=1U
* device instance $1982 r0 *1 48.41,22.315 sky130_fd_pr__pfet_01v8
M$1982 162 88 401 401 sky130_fd_pr__pfet_01v8 L=0.15U W=0.64U AS=0.1152P
+ AD=0.0928P PS=1U PD=0.93U
* device instance $1983 r0 *1 48.85,22.315 sky130_fd_pr__pfet_01v8
M$1983 363 88 162 162 sky130_fd_pr__pfet_01v8 L=0.15U W=0.64U AS=0.0928P
+ AD=0.1664P PS=0.93U PD=1.8U
* device instance $1984 r0 *1 45.495,22.37 sky130_fd_pr__pfet_01v8
M$1984 162 361 360 360 sky130_fd_pr__pfet_01v8 L=0.15U W=0.75U AS=0.195P
+ AD=0.178875P PS=2.02U PD=1.26U
* device instance $1985 r0 *1 49.79,22.315 sky130_fd_pr__pfet_01v8
M$1985 402 363 162 162 sky130_fd_pr__pfet_01v8 L=0.15U W=0.64U AS=0.1664P
+ AD=0.0672P PS=1.8U PD=0.85U
* device instance $1986 r0 *1 50.15,22.315 sky130_fd_pr__pfet_01v8
M$1986 362 404 402 402 sky130_fd_pr__pfet_01v8 L=0.15U W=0.64U AS=0.0672P
+ AD=0.1664P PS=0.85U PD=1.8U
* device instance $1987 r0 *1 51.09,22.345 sky130_fd_pr__pfet_01v8
M$1987 162 383 382 382 sky130_fd_pr__pfet_01v8 L=0.15U W=0.64U AS=0.1664P
+ AD=0.0864P PS=1.8U PD=0.91U
* device instance $1988 r0 *1 51.51,22.345 sky130_fd_pr__pfet_01v8
M$1988 383 329 162 162 sky130_fd_pr__pfet_01v8 L=0.15U W=0.64U AS=0.0864P
+ AD=0.1664P PS=0.91U PD=1.8U
* device instance $1989 r0 *1 53.51,22.495 sky130_fd_pr__pfet_01v8
M$1989 384 230 364 364 sky130_fd_pr__pfet_01v8 L=0.15U W=2U AS=0.395P AD=0.27P
+ PS=3.79U PD=2.54U
* device instance $1991 r0 *1 54.35,22.495 sky130_fd_pr__pfet_01v8
M$1991 365 135 364 364 sky130_fd_pr__pfet_01v8 L=0.15U W=2U AS=0.27P AD=0.415P
+ PS=2.54U PD=3.83U
* device instance $1993 r0 *1 55.75,22.495 sky130_fd_pr__pfet_01v8
M$1993 365 334 385 385 sky130_fd_pr__pfet_01v8 L=0.15U W=2U AS=0.415P AD=0.27P
+ PS=3.83U PD=2.54U
* device instance $1995 r0 *1 56.59,22.495 sky130_fd_pr__pfet_01v8
M$1995 162 366 385 385 sky130_fd_pr__pfet_01v8 L=0.15U W=2U AS=0.27P AD=0.415P
+ PS=2.54U PD=3.83U
* device instance $1997 r0 *1 60.73,22.495 sky130_fd_pr__pfet_01v8
M$1997 368 386 367 367 sky130_fd_pr__pfet_01v8 L=0.15U W=1U AS=0.26P AD=0.135P
+ PS=2.52U PD=1.27U
* device instance $1998 r0 *1 61.15,22.495 sky130_fd_pr__pfet_01v8
M$1998 387 334 368 368 sky130_fd_pr__pfet_01v8 L=0.15U W=1U AS=0.135P AD=0.135P
+ PS=1.27U PD=1.27U
* device instance $1999 r0 *1 61.57,22.495 sky130_fd_pr__pfet_01v8
M$1999 368 129 387 387 sky130_fd_pr__pfet_01v8 L=0.15U W=1U AS=0.135P AD=0.26P
+ PS=1.27U PD=2.52U
* device instance $2000 r0 *1 62.51,22.495 sky130_fd_pr__pfet_01v8
M$2000 387 136 162 162 sky130_fd_pr__pfet_01v8 L=0.15U W=1U AS=0.26P AD=0.165P
+ PS=2.52U PD=1.33U
* device instance $2001 r0 *1 62.99,22.495 sky130_fd_pr__pfet_01v8
M$2001 162 346 387 387 sky130_fd_pr__pfet_01v8 L=0.15U W=1U AS=0.165P
+ AD=0.1575P PS=1.33U PD=1.315U
* device instance $2002 r0 *1 63.455,22.495 sky130_fd_pr__pfet_01v8
M$2002 408 367 162 162 sky130_fd_pr__pfet_01v8 L=0.15U W=1U AS=0.1575P AD=0.26P
+ PS=1.315U PD=2.52U
* device instance $2003 r0 *1 64.41,22.345 sky130_fd_pr__pfet_01v8
M$2003 162 329 369 369 sky130_fd_pr__pfet_01v8 L=0.15U W=0.64U AS=0.1664P
+ AD=0.0864P PS=1.8U PD=0.91U
* device instance $2004 r0 *1 64.83,22.345 sky130_fd_pr__pfet_01v8
M$2004 370 369 162 162 sky130_fd_pr__pfet_01v8 L=0.15U W=0.64U AS=0.0864P
+ AD=0.1664P PS=0.91U PD=1.8U
* device instance $2005 r0 *1 65.77,22.315 sky130_fd_pr__pfet_01v8
M$2005 398 388 371 371 sky130_fd_pr__pfet_01v8 L=0.15U W=0.64U AS=0.1664P
+ AD=0.0672P PS=1.8U PD=0.85U
* device instance $2006 r0 *1 66.13,22.315 sky130_fd_pr__pfet_01v8
M$2006 162 372 398 398 sky130_fd_pr__pfet_01v8 L=0.15U W=0.64U AS=0.0672P
+ AD=0.1664P PS=0.85U PD=1.8U
* device instance $2007 r0 *1 68.795,22.205 sky130_fd_pr__pfet_01v8
M$2007 373 370 371 371 sky130_fd_pr__pfet_01v8 L=0.15U W=0.42U AS=0.15985P
+ AD=0.06405P PS=1.265U PD=0.725U
* device instance $2008 r0 *1 69.25,22.205 sky130_fd_pr__pfet_01v8
M$2008 391 369 373 373 sky130_fd_pr__pfet_01v8 L=0.15U W=0.42U AS=0.06405P
+ AD=0.07665P PS=0.725U PD=0.785U
* device instance $2009 r0 *1 69.765,22.205 sky130_fd_pr__pfet_01v8
M$2009 162 374 391 391 sky130_fd_pr__pfet_01v8 L=0.15U W=0.42U AS=0.07665P
+ AD=0.178875P PS=0.785U PD=1.26U
* device instance $2010 r0 *1 67.07,22.315 sky130_fd_pr__pfet_01v8
M$2010 162 1134 372 372 sky130_fd_pr__pfet_01v8 L=0.15U W=0.64U AS=0.1664P
+ AD=0.0928P PS=1.8U PD=0.93U
* device instance $2011 r0 *1 67.51,22.315 sky130_fd_pr__pfet_01v8
M$2011 396 1134 162 162 sky130_fd_pr__pfet_01v8 L=0.15U W=0.64U AS=0.0928P
+ AD=0.1152P PS=0.93U PD=1U
* device instance $2012 r0 *1 68.02,22.315 sky130_fd_pr__pfet_01v8
M$2012 371 376 396 396 sky130_fd_pr__pfet_01v8 L=0.15U W=0.64U AS=0.1152P
+ AD=0.15985P PS=1U PD=1.265U
* device instance $2013 r0 *1 70.425,22.37 sky130_fd_pr__pfet_01v8
M$2013 374 373 162 162 sky130_fd_pr__pfet_01v8 L=0.15U W=0.75U AS=0.178875P
+ AD=0.195P PS=1.26U PD=2.02U
* device instance $2014 r0 *1 71.365,22.205 sky130_fd_pr__pfet_01v8
M$2014 390 374 162 162 sky130_fd_pr__pfet_01v8 L=0.15U W=0.42U AS=0.1092P
+ AD=0.06405P PS=1.36U PD=0.725U
* device instance $2015 r0 *1 71.82,22.205 sky130_fd_pr__pfet_01v8
M$2015 375 369 390 390 sky130_fd_pr__pfet_01v8 L=0.15U W=0.42U AS=0.06405P
+ AD=0.0567P PS=0.725U PD=0.69U
* device instance $2016 r0 *1 72.24,22.205 sky130_fd_pr__pfet_01v8
M$2016 389 370 375 375 sky130_fd_pr__pfet_01v8 L=0.15U W=0.42U AS=0.0567P
+ AD=0.0882P PS=0.69U PD=0.84U
* device instance $2017 r0 *1 72.81,22.205 sky130_fd_pr__pfet_01v8
M$2017 162 376 389 389 sky130_fd_pr__pfet_01v8 L=0.15U W=0.42U AS=0.0882P
+ AD=0.1113P PS=0.84U PD=1.37U
* device instance $2018 r0 *1 73.865,22.315 sky130_fd_pr__pfet_01v8
M$2018 162 375 376 376 sky130_fd_pr__pfet_01v8 L=0.15U W=0.64U AS=0.1728P
+ AD=0.154P PS=1.82U PD=1.335U
* device instance $2019 r0 *1 74.35,22.495 sky130_fd_pr__pfet_01v8
M$2019 334 375 162 162 sky130_fd_pr__pfet_01v8 L=0.15U W=1U AS=0.154P AD=0.28P
+ PS=1.335U PD=2.56U
* device instance $2020 r0 *1 4.61,26.615 sky130_fd_pr__pfet_01v8
M$2020 162 31 425 425 sky130_fd_pr__pfet_01v8 L=0.15U W=0.64U AS=0.1664P
+ AD=0.0864P PS=1.8U PD=0.91U
* device instance $2021 r0 *1 5.03,26.615 sky130_fd_pr__pfet_01v8
M$2021 426 425 162 162 sky130_fd_pr__pfet_01v8 L=0.15U W=0.64U AS=0.0864P
+ AD=0.1664P PS=0.91U PD=1.8U
* device instance $2022 r0 *1 5.97,26.645 sky130_fd_pr__pfet_01v8
M$2022 464 447 427 427 sky130_fd_pr__pfet_01v8 L=0.15U W=0.64U AS=0.1664P
+ AD=0.0672P PS=1.8U PD=0.85U
* device instance $2023 r0 *1 6.33,26.645 sky130_fd_pr__pfet_01v8
M$2023 162 428 464 464 sky130_fd_pr__pfet_01v8 L=0.15U W=0.64U AS=0.0672P
+ AD=0.1664P PS=0.85U PD=1.8U
* device instance $2024 r0 *1 7.27,26.645 sky130_fd_pr__pfet_01v8
M$2024 162 88 428 428 sky130_fd_pr__pfet_01v8 L=0.15U W=0.64U AS=0.1664P
+ AD=0.0928P PS=1.8U PD=0.93U
* device instance $2025 r0 *1 7.71,26.645 sky130_fd_pr__pfet_01v8
M$2025 465 88 162 162 sky130_fd_pr__pfet_01v8 L=0.15U W=0.64U AS=0.0928P
+ AD=0.1152P PS=0.93U PD=1U
* device instance $2026 r0 *1 8.22,26.645 sky130_fd_pr__pfet_01v8
M$2026 427 448 465 465 sky130_fd_pr__pfet_01v8 L=0.15U W=0.64U AS=0.1152P
+ AD=0.15985P PS=1U PD=1.265U
* device instance $2027 r0 *1 8.995,26.755 sky130_fd_pr__pfet_01v8
M$2027 429 426 427 427 sky130_fd_pr__pfet_01v8 L=0.15U W=0.42U AS=0.15985P
+ AD=0.06405P PS=1.265U PD=0.725U
* device instance $2028 r0 *1 9.45,26.755 sky130_fd_pr__pfet_01v8
M$2028 466 425 429 429 sky130_fd_pr__pfet_01v8 L=0.15U W=0.42U AS=0.06405P
+ AD=0.07665P PS=0.725U PD=0.785U
* device instance $2029 r0 *1 9.965,26.755 sky130_fd_pr__pfet_01v8
M$2029 466 430 162 162 sky130_fd_pr__pfet_01v8 L=0.15U W=0.42U AS=0.178875P
+ AD=0.07665P PS=1.26U PD=0.785U
* device instance $2030 r0 *1 10.625,26.59 sky130_fd_pr__pfet_01v8
M$2030 430 429 162 162 sky130_fd_pr__pfet_01v8 L=0.15U W=0.75U AS=0.178875P
+ AD=0.195P PS=1.26U PD=2.02U
* device instance $2031 r0 *1 11.565,26.755 sky130_fd_pr__pfet_01v8
M$2031 467 430 162 162 sky130_fd_pr__pfet_01v8 L=0.15U W=0.42U AS=0.1092P
+ AD=0.06405P PS=1.36U PD=0.725U
* device instance $2032 r0 *1 12.02,26.755 sky130_fd_pr__pfet_01v8
M$2032 431 425 467 467 sky130_fd_pr__pfet_01v8 L=0.15U W=0.42U AS=0.06405P
+ AD=0.0567P PS=0.725U PD=0.69U
* device instance $2033 r0 *1 12.44,26.755 sky130_fd_pr__pfet_01v8
M$2033 468 426 431 431 sky130_fd_pr__pfet_01v8 L=0.15U W=0.42U AS=0.0567P
+ AD=0.0882P PS=0.69U PD=0.84U
* device instance $2034 r0 *1 13.01,26.755 sky130_fd_pr__pfet_01v8
M$2034 162 448 468 468 sky130_fd_pr__pfet_01v8 L=0.15U W=0.42U AS=0.0882P
+ AD=0.1113P PS=0.84U PD=1.37U
* device instance $2035 r0 *1 14.065,26.645 sky130_fd_pr__pfet_01v8
M$2035 448 431 162 162 sky130_fd_pr__pfet_01v8 L=0.15U W=0.64U AS=0.154P
+ AD=0.1728P PS=1.335U PD=1.82U
* device instance $2036 r0 *1 14.55,26.465 sky130_fd_pr__pfet_01v8
M$2036 378 431 162 162 sky130_fd_pr__pfet_01v8 L=0.15U W=1U AS=0.154P AD=0.28P
+ PS=1.335U PD=2.56U
* device instance $2037 r0 *1 17.49,22.785 sky130_fd_pr__pfet_01v8
M$2037 393 606 381 381 sky130_fd_pr__pfet_01v8 L=0.15U W=0.42U AS=0.1092P
+ AD=0.0693P PS=1.36U PD=0.75U
* device instance $2038 r0 *1 17.97,22.785 sky130_fd_pr__pfet_01v8
M$2038 394 128 393 393 sky130_fd_pr__pfet_01v8 L=0.15U W=0.42U AS=0.0693P
+ AD=0.0441P PS=0.75U PD=0.63U
* device instance $2039 r0 *1 18.33,22.785 sky130_fd_pr__pfet_01v8
M$2039 395 378 394 394 sky130_fd_pr__pfet_01v8 L=0.15U W=0.42U AS=0.0441P
+ AD=0.0693P PS=0.63U PD=0.75U
* device instance $2040 r0 *1 18.81,22.785 sky130_fd_pr__pfet_01v8
M$2040 395 164 162 162 sky130_fd_pr__pfet_01v8 L=0.15U W=0.42U AS=0.14825P
+ AD=0.0693P PS=1.34U PD=0.75U
* device instance $2041 r0 *1 19.3,22.495 sky130_fd_pr__pfet_01v8
M$2041 406 381 162 162 sky130_fd_pr__pfet_01v8 L=0.15U W=1U AS=0.14825P
+ AD=0.27P PS=1.34U PD=2.54U
* device instance $2042 r0 *1 18.19,26.175 sky130_fd_pr__pfet_01v8
M$2042 162 378 432 432 sky130_fd_pr__pfet_01v8 L=0.15U W=0.42U AS=0.1092P
+ AD=0.1573P PS=1.36U PD=1.39U
* device instance $2043 r0 *1 18.73,26.465 sky130_fd_pr__pfet_01v8
M$2043 469 449 162 162 sky130_fd_pr__pfet_01v8 L=0.15U W=1U AS=0.1573P
+ AD=0.105P PS=1.39U PD=1.21U
* device instance $2044 r0 *1 19.09,26.465 sky130_fd_pr__pfet_01v8
M$2044 433 432 469 469 sky130_fd_pr__pfet_01v8 L=0.15U W=1U AS=0.105P AD=0.26P
+ PS=1.21U PD=2.52U
* device instance $2045 r0 *1 20.25,26.465 sky130_fd_pr__pfet_01v8
M$2045 470 433 380 380 sky130_fd_pr__pfet_01v8 L=0.15U W=1U AS=0.26P AD=0.105P
+ PS=2.52U PD=1.21U
* device instance $2046 r0 *1 20.61,26.465 sky130_fd_pr__pfet_01v8
M$2046 162 338 470 470 sky130_fd_pr__pfet_01v8 L=0.15U W=1U AS=0.105P AD=0.26P
+ PS=1.21U PD=2.52U
* device instance $2047 r0 *1 21.87,26.175 sky130_fd_pr__pfet_01v8
M$2047 162 449 434 434 sky130_fd_pr__pfet_01v8 L=0.15U W=0.42U AS=0.1092P
+ AD=0.1573P PS=1.36U PD=1.39U
* device instance $2048 r0 *1 22.41,26.465 sky130_fd_pr__pfet_01v8
M$2048 471 378 162 162 sky130_fd_pr__pfet_01v8 L=0.15U W=1U AS=0.1573P
+ AD=0.105P PS=1.39U PD=1.21U
* device instance $2049 r0 *1 22.77,26.465 sky130_fd_pr__pfet_01v8
M$2049 338 434 471 471 sky130_fd_pr__pfet_01v8 L=0.15U W=1U AS=0.105P AD=0.26P
+ PS=1.21U PD=2.52U
* device instance $2050 r0 *1 34.985,26.465 sky130_fd_pr__pfet_01v8
M$2050 162 436 450 450 sky130_fd_pr__pfet_01v8 L=0.15U W=2U AS=0.41P AD=0.27P
+ PS=3.82U PD=2.54U
* device instance $2052 r0 *1 35.825,26.465 sky130_fd_pr__pfet_01v8
M$2052 162 437 450 450 sky130_fd_pr__pfet_01v8 L=0.15U W=2U AS=0.27P AD=0.415P
+ PS=2.54U PD=3.83U
* device instance $2054 r0 *1 37.225,26.465 sky130_fd_pr__pfet_01v8
M$2054 162 437 463 463 sky130_fd_pr__pfet_01v8 L=0.15U W=2U AS=0.415P AD=0.27P
+ PS=3.83U PD=2.54U
* device instance $2056 r0 *1 38.065,26.465 sky130_fd_pr__pfet_01v8
M$2056 439 436 463 463 sky130_fd_pr__pfet_01v8 L=0.15U W=2U AS=0.2875P
+ AD=0.4125P PS=2.575U PD=3.825U
* device instance $2058 r0 *1 39.46,26.465 sky130_fd_pr__pfet_01v8
M$2058 439 450 162 162 sky130_fd_pr__pfet_01v8 L=0.15U W=2U AS=0.395P AD=0.415P
+ PS=3.79U PD=3.83U
* device instance $2060 r0 *1 46.47,26.465 sky130_fd_pr__pfet_01v8
M$2060 162 329 440 440 sky130_fd_pr__pfet_01v8 L=0.15U W=3U AS=0.53P AD=0.405P
+ PS=5.06U PD=3.81U
* device instance $2063 r0 *1 47.73,26.465 sky130_fd_pr__pfet_01v8
M$2063 441 440 162 162 sky130_fd_pr__pfet_01v8 L=0.15U W=6U AS=0.81P AD=0.81P
+ PS=7.62U PD=7.62U
* device instance $2069 r0 *1 50.25,26.465 sky130_fd_pr__pfet_01v8
M$2069 442 441 162 162 sky130_fd_pr__pfet_01v8 L=0.15U W=16U AS=2.16P AD=2.285P
+ PS=20.32U PD=21.57U
* device instance $2085 r0 *1 61.27,26.645 sky130_fd_pr__pfet_01v8
M$2085 162 451 386 386 sky130_fd_pr__pfet_01v8 L=0.15U W=0.64U AS=0.1696P
+ AD=0.1841P PS=1.81U PD=1.26U
* device instance $2086 r0 *1 62.04,26.755 sky130_fd_pr__pfet_01v8
M$2086 451 108 162 162 sky130_fd_pr__pfet_01v8 L=0.15U W=0.42U AS=0.1841P
+ AD=0.0609P PS=1.26U PD=0.71U
* device instance $2087 r0 *1 62.48,26.755 sky130_fd_pr__pfet_01v8
M$2087 162 443 451 451 sky130_fd_pr__pfet_01v8 L=0.15U W=0.42U AS=0.0609P
+ AD=0.1113P PS=0.71U PD=1.37U
* device instance $2088 r0 *1 63.97,26.545 sky130_fd_pr__pfet_01v8
M$2088 316 333 162 162 sky130_fd_pr__pfet_01v8 L=0.15U W=1.68U AS=0.3486P
+ AD=0.3318P PS=3.35U PD=3.31U
* device instance $2090 r0 *1 66.69,26.175 sky130_fd_pr__pfet_01v8
M$2090 452 341 162 162 sky130_fd_pr__pfet_01v8 L=0.15U W=0.42U AS=0.14575P
+ AD=0.1092P PS=1.335U PD=1.36U
* device instance $2091 r0 *1 65.785,26.465 sky130_fd_pr__pfet_01v8
M$2091 339 452 162 162 sky130_fd_pr__pfet_01v8 L=0.15U W=1U AS=0.265P AD=0.135P
+ PS=2.53U PD=1.27U
* device instance $2092 r0 *1 66.205,26.465 sky130_fd_pr__pfet_01v8
M$2092 162 334 339 339 sky130_fd_pr__pfet_01v8 L=0.15U W=1U AS=0.135P
+ AD=0.14575P PS=1.27U PD=1.335U
* device instance $2093 r0 *1 68.175,26.56 sky130_fd_pr__pfet_01v8
M$2093 473 55 162 162 sky130_fd_pr__pfet_01v8 L=0.15U W=0.42U AS=0.15835P
+ AD=0.07665P PS=1.395U PD=0.785U
* device instance $2094 r0 *1 68.69,26.56 sky130_fd_pr__pfet_01v8
M$2094 444 341 473 473 sky130_fd_pr__pfet_01v8 L=0.15U W=0.42U AS=0.07665P
+ AD=0.1932P PS=0.785U PD=1.34U
* device instance $2095 r0 *1 69.76,26.56 sky130_fd_pr__pfet_01v8
M$2095 472 445 444 444 sky130_fd_pr__pfet_01v8 L=0.15U W=0.42U AS=0.1932P
+ AD=0.0441P PS=1.34U PD=0.63U
* device instance $2096 r0 *1 70.12,26.56 sky130_fd_pr__pfet_01v8
M$2096 162 446 472 472 sky130_fd_pr__pfet_01v8 L=0.15U W=0.42U AS=0.0441P
+ AD=0.0693P PS=0.63U PD=0.75U
* device instance $2097 r0 *1 70.6,26.56 sky130_fd_pr__pfet_01v8
M$2097 446 55 162 162 sky130_fd_pr__pfet_01v8 L=0.15U W=0.42U AS=0.0693P
+ AD=0.1176P PS=0.75U PD=1.4U
* device instance $2098 r0 *1 67.63,26.465 sky130_fd_pr__pfet_01v8
M$2098 162 444 388 388 sky130_fd_pr__pfet_01v8 L=0.15U W=1U AS=0.26P
+ AD=0.15835P PS=2.52U PD=1.395U
* device instance $2099 r0 *1 5.615,27.84 sky130_fd_pr__pfet_01v8
M$2099 501 55 162 162 sky130_fd_pr__pfet_01v8 L=0.15U W=0.42U AS=0.15835P
+ AD=0.07665P PS=1.395U PD=0.785U
* device instance $2100 r0 *1 6.13,27.84 sky130_fd_pr__pfet_01v8
M$2100 474 449 501 501 sky130_fd_pr__pfet_01v8 L=0.15U W=0.42U AS=0.07665P
+ AD=0.1932P PS=0.785U PD=1.34U
* device instance $2101 r0 *1 7.2,27.84 sky130_fd_pr__pfet_01v8
M$2101 502 462 474 474 sky130_fd_pr__pfet_01v8 L=0.15U W=0.42U AS=0.1932P
+ AD=0.0441P PS=1.34U PD=0.63U
* device instance $2102 r0 *1 7.56,27.84 sky130_fd_pr__pfet_01v8
M$2102 162 515 502 502 sky130_fd_pr__pfet_01v8 L=0.15U W=0.42U AS=0.0441P
+ AD=0.0693P PS=0.63U PD=0.75U
* device instance $2103 r0 *1 8.04,27.84 sky130_fd_pr__pfet_01v8
M$2103 515 55 162 162 sky130_fd_pr__pfet_01v8 L=0.15U W=0.42U AS=0.0693P
+ AD=0.1176P PS=0.75U PD=1.4U
* device instance $2104 r0 *1 5.07,27.935 sky130_fd_pr__pfet_01v8
M$2104 162 474 447 447 sky130_fd_pr__pfet_01v8 L=0.15U W=1U AS=0.26P
+ AD=0.15835P PS=2.52U PD=1.395U
* device instance $2105 r0 *1 9.21,27.785 sky130_fd_pr__pfet_01v8
M$2105 162 31 475 475 sky130_fd_pr__pfet_01v8 L=0.15U W=0.64U AS=0.1664P
+ AD=0.0864P PS=1.8U PD=0.91U
* device instance $2106 r0 *1 9.63,27.785 sky130_fd_pr__pfet_01v8
M$2106 476 475 162 162 sky130_fd_pr__pfet_01v8 L=0.15U W=0.64U AS=0.0864P
+ AD=0.1664P PS=0.91U PD=1.8U
* device instance $2107 r0 *1 10.57,27.755 sky130_fd_pr__pfet_01v8
M$2107 505 405 478 478 sky130_fd_pr__pfet_01v8 L=0.15U W=0.64U AS=0.1664P
+ AD=0.0672P PS=1.8U PD=0.85U
* device instance $2108 r0 *1 10.93,27.755 sky130_fd_pr__pfet_01v8
M$2108 162 477 505 505 sky130_fd_pr__pfet_01v8 L=0.15U W=0.64U AS=0.0672P
+ AD=0.1664P PS=0.85U PD=1.8U
* device instance $2109 r0 *1 13.595,27.645 sky130_fd_pr__pfet_01v8
M$2109 479 476 478 478 sky130_fd_pr__pfet_01v8 L=0.15U W=0.42U AS=0.15985P
+ AD=0.06405P PS=1.265U PD=0.725U
* device instance $2110 r0 *1 14.05,27.645 sky130_fd_pr__pfet_01v8
M$2110 508 475 479 479 sky130_fd_pr__pfet_01v8 L=0.15U W=0.42U AS=0.06405P
+ AD=0.07665P PS=0.725U PD=0.785U
* device instance $2111 r0 *1 14.565,27.645 sky130_fd_pr__pfet_01v8
M$2111 162 480 508 508 sky130_fd_pr__pfet_01v8 L=0.15U W=0.42U AS=0.07665P
+ AD=0.178875P PS=0.785U PD=1.26U
* device instance $2112 r0 *1 11.87,27.755 sky130_fd_pr__pfet_01v8
M$2112 162 311 477 477 sky130_fd_pr__pfet_01v8 L=0.15U W=0.64U AS=0.1664P
+ AD=0.0928P PS=1.8U PD=0.93U
* device instance $2113 r0 *1 12.31,27.755 sky130_fd_pr__pfet_01v8
M$2113 507 311 162 162 sky130_fd_pr__pfet_01v8 L=0.15U W=0.64U AS=0.0928P
+ AD=0.1152P PS=0.93U PD=1U
* device instance $2114 r0 *1 12.82,27.755 sky130_fd_pr__pfet_01v8
M$2114 478 482 507 507 sky130_fd_pr__pfet_01v8 L=0.15U W=0.64U AS=0.1152P
+ AD=0.15985P PS=1U PD=1.265U
* device instance $2115 r0 *1 15.225,27.81 sky130_fd_pr__pfet_01v8
M$2115 480 479 162 162 sky130_fd_pr__pfet_01v8 L=0.15U W=0.75U AS=0.178875P
+ AD=0.195P PS=1.26U PD=2.02U
* device instance $2116 r0 *1 16.165,27.645 sky130_fd_pr__pfet_01v8
M$2116 509 480 162 162 sky130_fd_pr__pfet_01v8 L=0.15U W=0.42U AS=0.1092P
+ AD=0.06405P PS=1.36U PD=0.725U
* device instance $2117 r0 *1 16.62,27.645 sky130_fd_pr__pfet_01v8
M$2117 481 475 509 509 sky130_fd_pr__pfet_01v8 L=0.15U W=0.42U AS=0.06405P
+ AD=0.0567P PS=0.725U PD=0.69U
* device instance $2118 r0 *1 17.04,27.645 sky130_fd_pr__pfet_01v8
M$2118 511 476 481 481 sky130_fd_pr__pfet_01v8 L=0.15U W=0.42U AS=0.0567P
+ AD=0.0882P PS=0.69U PD=0.84U
* device instance $2119 r0 *1 17.61,27.645 sky130_fd_pr__pfet_01v8
M$2119 162 482 511 511 sky130_fd_pr__pfet_01v8 L=0.15U W=0.42U AS=0.0882P
+ AD=0.1113P PS=0.84U PD=1.37U
* device instance $2120 r0 *1 18.665,27.755 sky130_fd_pr__pfet_01v8
M$2120 162 481 482 482 sky130_fd_pr__pfet_01v8 L=0.15U W=0.64U AS=0.1728P
+ AD=0.154P PS=1.82U PD=1.335U
* device instance $2121 r0 *1 19.15,27.935 sky130_fd_pr__pfet_01v8
M$2121 449 481 162 162 sky130_fd_pr__pfet_01v8 L=0.15U W=1U AS=0.154P AD=0.28P
+ PS=1.335U PD=2.56U
* device instance $2122 r0 *1 28.08,31.615 sky130_fd_pr__pfet_01v8
M$2122 548 337 534 534 sky130_fd_pr__pfet_01v8 L=0.15U W=0.42U AS=0.1092P
+ AD=0.0441P PS=1.36U PD=0.63U
* device instance $2123 r0 *1 28.44,31.615 sky130_fd_pr__pfet_01v8
M$2123 549 433 548 548 sky130_fd_pr__pfet_01v8 L=0.15U W=0.42U AS=0.0441P
+ AD=0.0693P PS=0.63U PD=0.75U
* device instance $2124 r0 *1 28.92,31.615 sky130_fd_pr__pfet_01v8
M$2124 162 496 549 549 sky130_fd_pr__pfet_01v8 L=0.15U W=0.42U AS=0.0693P
+ AD=0.14825P PS=0.75U PD=1.34U
* device instance $2125 r0 *1 29.41,31.905 sky130_fd_pr__pfet_01v8
M$2125 544 534 162 162 sky130_fd_pr__pfet_01v8 L=0.15U W=1U AS=0.14825P
+ AD=0.28P PS=1.34U PD=2.56U
* device instance $2126 r0 *1 30.91,27.935 sky130_fd_pr__pfet_01v8
M$2126 162 337 495 495 sky130_fd_pr__pfet_01v8 L=0.15U W=4U AS=0.685P AD=0.54P
+ PS=6.37U PD=5.08U
* device instance $2130 r0 *1 32.59,27.935 sky130_fd_pr__pfet_01v8
M$2130 483 433 495 495 sky130_fd_pr__pfet_01v8 L=0.15U W=4U AS=0.54P AD=0.665P
+ PS=5.08U PD=6.33U
* device instance $2134 r0 *1 31.77,31.905 sky130_fd_pr__pfet_01v8
M$2134 437 544 162 162 sky130_fd_pr__pfet_01v8 L=0.15U W=1U AS=0.26P AD=0.135P
+ PS=2.52U PD=1.27U
* device instance $2135 r0 *1 32.19,31.905 sky130_fd_pr__pfet_01v8
M$2135 162 497 437 437 sky130_fd_pr__pfet_01v8 L=0.15U W=1U AS=0.135P AD=0.26P
+ PS=1.27U PD=2.52U
* device instance $2136 r0 *1 34.79,27.935 sky130_fd_pr__pfet_01v8
M$2136 483 496 276 276 sky130_fd_pr__pfet_01v8 L=0.15U W=4U AS=0.665P AD=0.55P
+ PS=6.33U PD=5.1U
* device instance $2140 r0 *1 36.49,27.935 sky130_fd_pr__pfet_01v8
M$2140 162 497 276 276 sky130_fd_pr__pfet_01v8 L=0.15U W=4U AS=0.55P AD=0.54P
+ PS=5.1U PD=5.08U
* device instance $2144 r0 *1 38.17,27.935 sky130_fd_pr__pfet_01v8
M$2144 162 484 276 276 sky130_fd_pr__pfet_01v8 L=0.15U W=4U AS=0.54P AD=0.665P
+ PS=5.08U PD=6.33U
* device instance $2148 r0 *1 35.91,31.905 sky130_fd_pr__pfet_01v8
M$2148 436 261 162 162 sky130_fd_pr__pfet_01v8 L=0.15U W=1U AS=0.26P AD=0.135P
+ PS=2.52U PD=1.27U
* device instance $2149 r0 *1 36.33,31.905 sky130_fd_pr__pfet_01v8
M$2149 162 484 436 436 sky130_fd_pr__pfet_01v8 L=0.15U W=1U AS=0.135P AD=0.26P
+ PS=1.27U PD=2.52U
* device instance $2150 r0 *1 38.19,31.905 sky130_fd_pr__pfet_01v8
M$2150 545 165 535 535 sky130_fd_pr__pfet_01v8 L=0.15U W=1U AS=0.26P AD=0.135P
+ PS=2.52U PD=1.27U
* device instance $2151 r0 *1 38.61,31.905 sky130_fd_pr__pfet_01v8
M$2151 546 407 545 545 sky130_fd_pr__pfet_01v8 L=0.15U W=1U AS=0.135P AD=0.135P
+ PS=1.27U PD=1.27U
* device instance $2152 r0 *1 39.03,31.905 sky130_fd_pr__pfet_01v8
M$2152 545 129 546 546 sky130_fd_pr__pfet_01v8 L=0.15U W=1U AS=0.135P AD=0.26P
+ PS=1.27U PD=2.52U
* device instance $2153 r0 *1 39.97,31.905 sky130_fd_pr__pfet_01v8
M$2153 546 136 162 162 sky130_fd_pr__pfet_01v8 L=0.15U W=1U AS=0.26P AD=0.165P
+ PS=2.52U PD=1.33U
* device instance $2154 r0 *1 40.45,31.905 sky130_fd_pr__pfet_01v8
M$2154 162 439 546 546 sky130_fd_pr__pfet_01v8 L=0.15U W=1U AS=0.165P
+ AD=0.1575P PS=1.33U PD=1.315U
* device instance $2155 r0 *1 40.915,31.905 sky130_fd_pr__pfet_01v8
M$2155 547 535 162 162 sky130_fd_pr__pfet_01v8 L=0.15U W=1U AS=0.1575P AD=0.26P
+ PS=1.315U PD=2.52U
* device instance $2156 r0 *1 42.325,27.935 sky130_fd_pr__pfet_01v8
M$2156 261 498 162 162 sky130_fd_pr__pfet_01v8 L=0.15U W=1U AS=0.265P AD=0.135P
+ PS=2.53U PD=1.27U
* device instance $2157 r0 *1 42.745,27.935 sky130_fd_pr__pfet_01v8
M$2157 162 407 261 261 sky130_fd_pr__pfet_01v8 L=0.15U W=1U AS=0.135P
+ AD=0.14575P PS=1.27U PD=1.335U
* device instance $2158 r0 *1 43.23,28.225 sky130_fd_pr__pfet_01v8
M$2158 498 499 162 162 sky130_fd_pr__pfet_01v8 L=0.15U W=0.42U AS=0.14575P
+ AD=0.1092P PS=1.335U PD=1.36U
* device instance $2159 r0 *1 44.4,27.84 sky130_fd_pr__pfet_01v8
M$2159 162 55 485 485 sky130_fd_pr__pfet_01v8 L=0.15U W=0.42U AS=0.1176P
+ AD=0.0693P PS=1.4U PD=0.75U
* device instance $2160 r0 *1 44.88,27.84 sky130_fd_pr__pfet_01v8
M$2160 514 485 162 162 sky130_fd_pr__pfet_01v8 L=0.15U W=0.42U AS=0.0693P
+ AD=0.0441P PS=0.75U PD=0.63U
* device instance $2161 r0 *1 45.24,27.84 sky130_fd_pr__pfet_01v8
M$2161 500 486 514 514 sky130_fd_pr__pfet_01v8 L=0.15U W=0.42U AS=0.0441P
+ AD=0.1932P PS=0.63U PD=1.34U
* device instance $2162 r0 *1 46.31,27.84 sky130_fd_pr__pfet_01v8
M$2162 513 499 500 500 sky130_fd_pr__pfet_01v8 L=0.15U W=0.42U AS=0.1932P
+ AD=0.07665P PS=1.34U PD=0.785U
* device instance $2163 r0 *1 46.825,27.84 sky130_fd_pr__pfet_01v8
M$2163 513 55 162 162 sky130_fd_pr__pfet_01v8 L=0.15U W=0.42U AS=0.15835P
+ AD=0.07665P PS=1.395U PD=0.785U
* device instance $2164 r0 *1 47.37,27.935 sky130_fd_pr__pfet_01v8
M$2164 404 500 162 162 sky130_fd_pr__pfet_01v8 L=0.15U W=1U AS=0.15835P
+ AD=0.26P PS=1.395U PD=2.52U
* device instance $2165 r0 *1 44.87,31.615 sky130_fd_pr__pfet_01v8
M$2165 162 499 537 537 sky130_fd_pr__pfet_01v8 L=0.15U W=0.42U AS=0.1092P
+ AD=0.1573P PS=1.36U PD=1.39U
* device instance $2166 r0 *1 45.41,31.905 sky130_fd_pr__pfet_01v8
M$2166 555 407 162 162 sky130_fd_pr__pfet_01v8 L=0.15U W=1U AS=0.1573P
+ AD=0.105P PS=1.39U PD=1.21U
* device instance $2167 r0 *1 45.77,31.905 sky130_fd_pr__pfet_01v8
M$2167 536 537 555 555 sky130_fd_pr__pfet_01v8 L=0.15U W=1U AS=0.105P AD=0.26P
+ PS=1.21U PD=2.52U
* device instance $2168 r0 *1 46.995,31.905 sky130_fd_pr__pfet_01v8
M$2168 538 987 162 162 sky130_fd_pr__pfet_01v8 L=0.15U W=2U AS=0.395P AD=0.27P
+ PS=3.79U PD=2.54U
* device instance $2170 r0 *1 47.835,31.905 sky130_fd_pr__pfet_01v8
M$2170 136 538 162 162 sky130_fd_pr__pfet_01v8 L=0.15U W=6U AS=0.81P AD=0.935P
+ PS=7.62U PD=8.87U
* device instance $2176 r0 *1 60.73,27.785 sky130_fd_pr__pfet_01v8
M$2176 162 329 487 487 sky130_fd_pr__pfet_01v8 L=0.15U W=0.64U AS=0.1664P
+ AD=0.0864P PS=1.8U PD=0.91U
* device instance $2177 r0 *1 61.15,27.785 sky130_fd_pr__pfet_01v8
M$2177 488 487 162 162 sky130_fd_pr__pfet_01v8 L=0.15U W=0.64U AS=0.0864P
+ AD=0.1664P PS=0.91U PD=1.8U
* device instance $2178 r0 *1 62.09,27.755 sky130_fd_pr__pfet_01v8
M$2178 512 408 490 490 sky130_fd_pr__pfet_01v8 L=0.15U W=0.64U AS=0.1664P
+ AD=0.0672P PS=1.8U PD=0.85U
* device instance $2179 r0 *1 62.45,27.755 sky130_fd_pr__pfet_01v8
M$2179 162 489 512 512 sky130_fd_pr__pfet_01v8 L=0.15U W=0.64U AS=0.0672P
+ AD=0.1664P PS=0.85U PD=1.8U
* device instance $2180 r0 *1 65.115,27.645 sky130_fd_pr__pfet_01v8
M$2180 491 488 490 490 sky130_fd_pr__pfet_01v8 L=0.15U W=0.42U AS=0.15985P
+ AD=0.06405P PS=1.265U PD=0.725U
* device instance $2181 r0 *1 65.57,27.645 sky130_fd_pr__pfet_01v8
M$2181 506 487 491 491 sky130_fd_pr__pfet_01v8 L=0.15U W=0.42U AS=0.06405P
+ AD=0.07665P PS=0.725U PD=0.785U
* device instance $2182 r0 *1 66.085,27.645 sky130_fd_pr__pfet_01v8
M$2182 162 492 506 506 sky130_fd_pr__pfet_01v8 L=0.15U W=0.42U AS=0.07665P
+ AD=0.178875P PS=0.785U PD=1.26U
* device instance $2183 r0 *1 63.39,27.755 sky130_fd_pr__pfet_01v8
M$2183 162 311 489 489 sky130_fd_pr__pfet_01v8 L=0.15U W=0.64U AS=0.1664P
+ AD=0.0928P PS=1.8U PD=0.93U
* device instance $2184 r0 *1 63.83,27.755 sky130_fd_pr__pfet_01v8
M$2184 510 311 162 162 sky130_fd_pr__pfet_01v8 L=0.15U W=0.64U AS=0.0928P
+ AD=0.1152P PS=0.93U PD=1U
* device instance $2185 r0 *1 64.34,27.755 sky130_fd_pr__pfet_01v8
M$2185 490 494 510 510 sky130_fd_pr__pfet_01v8 L=0.15U W=0.64U AS=0.1152P
+ AD=0.15985P PS=1U PD=1.265U
* device instance $2186 r0 *1 66.745,27.81 sky130_fd_pr__pfet_01v8
M$2186 492 491 162 162 sky130_fd_pr__pfet_01v8 L=0.15U W=0.75U AS=0.178875P
+ AD=0.195P PS=1.26U PD=2.02U
* device instance $2187 r0 *1 67.685,27.645 sky130_fd_pr__pfet_01v8
M$2187 504 492 162 162 sky130_fd_pr__pfet_01v8 L=0.15U W=0.42U AS=0.1092P
+ AD=0.06405P PS=1.36U PD=0.725U
* device instance $2188 r0 *1 68.14,27.645 sky130_fd_pr__pfet_01v8
M$2188 493 487 504 504 sky130_fd_pr__pfet_01v8 L=0.15U W=0.42U AS=0.06405P
+ AD=0.0567P PS=0.725U PD=0.69U
* device instance $2189 r0 *1 68.56,27.645 sky130_fd_pr__pfet_01v8
M$2189 503 488 493 493 sky130_fd_pr__pfet_01v8 L=0.15U W=0.42U AS=0.0567P
+ AD=0.0882P PS=0.69U PD=0.84U
* device instance $2190 r0 *1 69.13,27.645 sky130_fd_pr__pfet_01v8
M$2190 162 494 503 503 sky130_fd_pr__pfet_01v8 L=0.15U W=0.42U AS=0.0882P
+ AD=0.1113P PS=0.84U PD=1.37U
* device instance $2191 r0 *1 70.185,27.755 sky130_fd_pr__pfet_01v8
M$2191 162 493 494 494 sky130_fd_pr__pfet_01v8 L=0.15U W=0.64U AS=0.1728P
+ AD=0.154P PS=1.82U PD=1.335U
* device instance $2192 r0 *1 70.67,27.935 sky130_fd_pr__pfet_01v8
M$2192 341 493 162 162 sky130_fd_pr__pfet_01v8 L=0.15U W=1U AS=0.154P AD=0.28P
+ PS=1.335U PD=2.56U
* device instance $2193 r0 *1 13.35,33.295 sky130_fd_pr__pfet_01v8
M$2193 576 574 162 162 sky130_fd_pr__pfet_01v8 L=0.15U W=1.68U AS=0.3318P
+ AD=0.3486P PS=3.31U PD=3.35U
* device instance $2195 r0 *1 26.285,32.085 sky130_fd_pr__pfet_01v8
M$2195 554 433 162 162 sky130_fd_pr__pfet_01v8 L=0.15U W=0.64U AS=0.1696P
+ AD=0.0768P PS=1.81U PD=0.88U
* device instance $2196 r0 *1 26.675,32.085 sky130_fd_pr__pfet_01v8
M$2196 543 337 554 554 sky130_fd_pr__pfet_01v8 L=0.15U W=0.64U AS=0.0768P
+ AD=0.0896P PS=0.88U PD=0.92U
* device instance $2197 r0 *1 27.105,32.085 sky130_fd_pr__pfet_01v8
M$2197 162 496 543 543 sky130_fd_pr__pfet_01v8 L=0.15U W=0.64U AS=0.0896P
+ AD=0.1824P PS=0.92U PD=1.85U
* device instance $2198 r0 *1 27.2,33.375 sky130_fd_pr__pfet_01v8
M$2198 561 556 162 162 sky130_fd_pr__pfet_01v8 L=0.15U W=4U AS=0.705P
+ AD=0.5975P PS=6.41U PD=5.195U
* device instance $2202 r0 *1 28.995,33.375 sky130_fd_pr__pfet_01v8
M$2202 556 543 162 162 sky130_fd_pr__pfet_01v8 L=0.15U W=1U AS=0.1775P AD=0.14P
+ PS=1.355U PD=1.28U
* device instance $2203 r0 *1 29.425,33.375 sky130_fd_pr__pfet_01v8
M$2203 162 544 556 556 sky130_fd_pr__pfet_01v8 L=0.15U W=1U AS=0.14P AD=0.265P
+ PS=1.28U PD=2.53U
* device instance $2204 r0 *1 41.85,33.195 sky130_fd_pr__pfet_01v8
M$2204 569 547 557 557 sky130_fd_pr__pfet_01v8 L=0.15U W=0.64U AS=0.1664P
+ AD=0.0672P PS=1.8U PD=0.85U
* device instance $2205 r0 *1 42.21,33.195 sky130_fd_pr__pfet_01v8
M$2205 162 550 569 569 sky130_fd_pr__pfet_01v8 L=0.15U W=0.64U AS=0.0672P
+ AD=0.1664P PS=0.85U PD=1.8U
* device instance $2206 r0 *1 41.89,31.985 sky130_fd_pr__pfet_01v8
M$2206 484 536 162 162 sky130_fd_pr__pfet_01v8 L=0.15U W=1.68U AS=0.3486P
+ AD=0.3318P PS=3.35U PD=3.31U
* device instance $2208 r0 *1 44.875,33.085 sky130_fd_pr__pfet_01v8
M$2208 564 563 557 557 sky130_fd_pr__pfet_01v8 L=0.15U W=0.42U AS=0.15985P
+ AD=0.06405P PS=1.265U PD=0.725U
* device instance $2209 r0 *1 45.33,33.085 sky130_fd_pr__pfet_01v8
M$2209 571 562 564 564 sky130_fd_pr__pfet_01v8 L=0.15U W=0.42U AS=0.06405P
+ AD=0.07665P PS=0.725U PD=0.785U
* device instance $2210 r0 *1 45.845,33.085 sky130_fd_pr__pfet_01v8
M$2210 162 551 571 571 sky130_fd_pr__pfet_01v8 L=0.15U W=0.42U AS=0.07665P
+ AD=0.178875P PS=0.785U PD=1.26U
* device instance $2211 r0 *1 43.15,33.195 sky130_fd_pr__pfet_01v8
M$2211 162 311 550 550 sky130_fd_pr__pfet_01v8 L=0.15U W=0.64U AS=0.1664P
+ AD=0.0928P PS=1.8U PD=0.93U
* device instance $2212 r0 *1 43.59,33.195 sky130_fd_pr__pfet_01v8
M$2212 570 311 162 162 sky130_fd_pr__pfet_01v8 L=0.15U W=0.64U AS=0.0928P
+ AD=0.1152P PS=0.93U PD=1U
* device instance $2213 r0 *1 44.1,33.195 sky130_fd_pr__pfet_01v8
M$2213 557 552 570 570 sky130_fd_pr__pfet_01v8 L=0.15U W=0.64U AS=0.1152P
+ AD=0.15985P PS=1U PD=1.265U
* device instance $2214 r0 *1 46.505,33.25 sky130_fd_pr__pfet_01v8
M$2214 551 564 162 162 sky130_fd_pr__pfet_01v8 L=0.15U W=0.75U AS=0.178875P
+ AD=0.195P PS=1.26U PD=2.02U
* device instance $2215 r0 *1 47.445,33.085 sky130_fd_pr__pfet_01v8
M$2215 572 551 162 162 sky130_fd_pr__pfet_01v8 L=0.15U W=0.42U AS=0.1092P
+ AD=0.06405P PS=1.36U PD=0.725U
* device instance $2216 r0 *1 47.9,33.085 sky130_fd_pr__pfet_01v8
M$2216 565 562 572 572 sky130_fd_pr__pfet_01v8 L=0.15U W=0.42U AS=0.06405P
+ AD=0.0567P PS=0.725U PD=0.69U
* device instance $2217 r0 *1 48.32,33.085 sky130_fd_pr__pfet_01v8
M$2217 573 563 565 565 sky130_fd_pr__pfet_01v8 L=0.15U W=0.42U AS=0.0567P
+ AD=0.0882P PS=0.69U PD=0.84U
* device instance $2218 r0 *1 48.89,33.085 sky130_fd_pr__pfet_01v8
M$2218 162 552 573 573 sky130_fd_pr__pfet_01v8 L=0.15U W=0.42U AS=0.0882P
+ AD=0.1113P PS=0.84U PD=1.37U
* device instance $2219 r0 *1 49.945,33.195 sky130_fd_pr__pfet_01v8
M$2219 162 565 552 552 sky130_fd_pr__pfet_01v8 L=0.15U W=0.64U AS=0.1728P
+ AD=0.154P PS=1.82U PD=1.335U
* device instance $2220 r0 *1 50.43,33.375 sky130_fd_pr__pfet_01v8
M$2220 499 565 162 162 sky130_fd_pr__pfet_01v8 L=0.15U W=1U AS=0.154P AD=0.28P
+ PS=1.335U PD=2.56U
* device instance $2221 r0 *1 59.95,33.375 sky130_fd_pr__pfet_01v8
M$2221 566 558 162 162 sky130_fd_pr__pfet_01v8 L=0.15U W=4U AS=0.665P AD=0.54P
+ PS=6.33U PD=5.08U
* device instance $2225 r0 *1 61.63,33.375 sky130_fd_pr__pfet_01v8
M$2225 558 306 162 162 sky130_fd_pr__pfet_01v8 L=0.15U W=1U AS=0.135P AD=0.26P
+ PS=1.27U PD=2.52U
* device instance $2226 r0 *1 62.57,33.375 sky130_fd_pr__pfet_01v8
M$2226 559 575 567 567 sky130_fd_pr__pfet_01v8 L=0.15U W=1U AS=0.26P AD=0.135P
+ PS=2.52U PD=1.27U
* device instance $2227 r0 *1 62.99,33.375 sky130_fd_pr__pfet_01v8
M$2227 568 553 559 559 sky130_fd_pr__pfet_01v8 L=0.15U W=1U AS=0.135P AD=0.135P
+ PS=1.27U PD=1.27U
* device instance $2228 r0 *1 63.41,33.375 sky130_fd_pr__pfet_01v8
M$2228 559 129 568 568 sky130_fd_pr__pfet_01v8 L=0.15U W=1U AS=0.135P AD=0.26P
+ PS=1.27U PD=2.52U
* device instance $2229 r0 *1 64.35,33.375 sky130_fd_pr__pfet_01v8
M$2229 568 130 162 162 sky130_fd_pr__pfet_01v8 L=0.15U W=1U AS=0.26P AD=0.165P
+ PS=2.52U PD=1.33U
* device instance $2230 r0 *1 64.83,33.375 sky130_fd_pr__pfet_01v8
M$2230 162 560 568 568 sky130_fd_pr__pfet_01v8 L=0.15U W=1U AS=0.165P
+ AD=0.1575P PS=1.33U PD=1.315U
* device instance $2231 r0 *1 65.295,33.375 sky130_fd_pr__pfet_01v8
M$2231 577 567 162 162 sky130_fd_pr__pfet_01v8 L=0.15U W=1U AS=0.1575P AD=0.26P
+ PS=1.315U PD=2.52U
* device instance $2232 r0 *1 8.75,37.345 sky130_fd_pr__pfet_01v8
M$2232 614 605 586 586 sky130_fd_pr__pfet_01v8 L=0.15U W=1U AS=0.26P AD=0.135P
+ PS=2.52U PD=1.27U
* device instance $2233 r0 *1 9.17,37.345 sky130_fd_pr__pfet_01v8
M$2233 615 606 614 614 sky130_fd_pr__pfet_01v8 L=0.15U W=1U AS=0.135P AD=0.135P
+ PS=1.27U PD=1.27U
* device instance $2234 r0 *1 9.59,37.345 sky130_fd_pr__pfet_01v8
M$2234 614 129 615 615 sky130_fd_pr__pfet_01v8 L=0.15U W=1U AS=0.135P AD=0.26P
+ PS=1.27U PD=2.52U
* device instance $2235 r0 *1 10.53,37.345 sky130_fd_pr__pfet_01v8
M$2235 615 130 162 162 sky130_fd_pr__pfet_01v8 L=0.15U W=1U AS=0.26P AD=0.165P
+ PS=2.52U PD=1.33U
* device instance $2236 r0 *1 11.01,37.345 sky130_fd_pr__pfet_01v8
M$2236 162 638 615 615 sky130_fd_pr__pfet_01v8 L=0.15U W=1U AS=0.165P
+ AD=0.1575P PS=1.33U PD=1.315U
* device instance $2237 r0 *1 11.475,37.345 sky130_fd_pr__pfet_01v8
M$2237 587 586 162 162 sky130_fd_pr__pfet_01v8 L=0.15U W=1U AS=0.1575P AD=0.26P
+ PS=1.315U PD=2.52U
* device instance $2238 r0 *1 12.53,37.525 sky130_fd_pr__pfet_01v8
M$2238 618 576 588 588 sky130_fd_pr__pfet_01v8 L=0.15U W=0.64U AS=0.1664P
+ AD=0.0672P PS=1.8U PD=0.85U
* device instance $2239 r0 *1 12.89,37.525 sky130_fd_pr__pfet_01v8
M$2239 162 589 618 618 sky130_fd_pr__pfet_01v8 L=0.15U W=0.64U AS=0.0672P
+ AD=0.0864P PS=0.85U PD=0.91U
* device instance $2240 r0 *1 13.31,37.525 sky130_fd_pr__pfet_01v8
M$2240 619 589 162 162 sky130_fd_pr__pfet_01v8 L=0.15U W=0.64U AS=0.0864P
+ AD=0.0672P PS=0.91U PD=0.85U
* device instance $2241 r0 *1 13.67,37.525 sky130_fd_pr__pfet_01v8
M$2241 588 590 619 619 sky130_fd_pr__pfet_01v8 L=0.15U W=0.64U AS=0.0672P
+ AD=0.0864P PS=0.85U PD=0.91U
* device instance $2242 r0 *1 14.09,37.525 sky130_fd_pr__pfet_01v8
M$2242 620 590 588 588 sky130_fd_pr__pfet_01v8 L=0.15U W=0.64U AS=0.0864P
+ AD=0.0672P PS=0.91U PD=0.85U
* device instance $2243 r0 *1 14.45,37.525 sky130_fd_pr__pfet_01v8
M$2243 620 576 162 162 sky130_fd_pr__pfet_01v8 L=0.15U W=0.64U AS=0.237P
+ AD=0.0672P PS=1.6U PD=0.85U
* device instance $2244 r0 *1 15.2,37.345 sky130_fd_pr__pfet_01v8
M$2244 335 588 162 162 sky130_fd_pr__pfet_01v8 L=0.15U W=2U AS=0.372P AD=0.405P
+ PS=2.87U PD=3.81U
* device instance $2246 r0 *1 31.31,37.425 sky130_fd_pr__pfet_01v8
M$2246 496 591 162 162 sky130_fd_pr__pfet_01v8 L=0.15U W=1.68U AS=0.3486P
+ AD=0.3318P PS=3.35U PD=3.31U
* device instance $2248 r0 *1 35.41,37.055 sky130_fd_pr__pfet_01v8
M$2248 607 593 162 162 sky130_fd_pr__pfet_01v8 L=0.15U W=0.42U AS=0.14575P
+ AD=0.1092P PS=1.335U PD=1.36U
* device instance $2249 r0 *1 34.505,37.345 sky130_fd_pr__pfet_01v8
M$2249 497 607 162 162 sky130_fd_pr__pfet_01v8 L=0.15U W=1U AS=0.265P AD=0.135P
+ PS=2.53U PD=1.27U
* device instance $2250 r0 *1 34.925,37.345 sky130_fd_pr__pfet_01v8
M$2250 162 592 497 497 sky130_fd_pr__pfet_01v8 L=0.15U W=1U AS=0.135P
+ AD=0.14575P PS=1.27U PD=1.335U
* device instance $2251 r0 *1 40.49,33.225 sky130_fd_pr__pfet_01v8
M$2251 162 329 562 562 sky130_fd_pr__pfet_01v8 L=0.15U W=0.64U AS=0.1664P
+ AD=0.0864P PS=1.8U PD=0.91U
* device instance $2252 r0 *1 40.91,33.225 sky130_fd_pr__pfet_01v8
M$2252 563 562 162 162 sky130_fd_pr__pfet_01v8 L=0.15U W=0.64U AS=0.0864P
+ AD=0.1664P PS=0.91U PD=1.8U
* device instance $2253 r0 *1 59.43,37.525 sky130_fd_pr__pfet_01v8
M$2253 162 594 575 575 sky130_fd_pr__pfet_01v8 L=0.15U W=0.64U AS=0.1696P
+ AD=0.1841P PS=1.81U PD=1.26U
* device instance $2254 r0 *1 60.2,37.635 sky130_fd_pr__pfet_01v8
M$2254 594 108 162 162 sky130_fd_pr__pfet_01v8 L=0.15U W=0.42U AS=0.1841P
+ AD=0.0609P PS=1.26U PD=0.71U
* device instance $2255 r0 *1 60.64,37.635 sky130_fd_pr__pfet_01v8
M$2255 162 595 594 594 sky130_fd_pr__pfet_01v8 L=0.15U W=0.42U AS=0.0609P
+ AD=0.1113P PS=0.71U PD=1.37U
* device instance $2256 r0 *1 61.67,37.345 sky130_fd_pr__pfet_01v8
M$2256 596 566 162 162 sky130_fd_pr__pfet_01v8 L=0.15U W=1U AS=0.26P AD=0.135P
+ PS=2.52U PD=1.27U
* device instance $2257 r0 *1 62.09,37.345 sky130_fd_pr__pfet_01v8
M$2257 162 339 596 596 sky130_fd_pr__pfet_01v8 L=0.15U W=1U AS=0.135P AD=0.26P
+ PS=1.27U PD=2.52U
* device instance $2258 r0 *1 63.07,37.345 sky130_fd_pr__pfet_01v8
M$2258 597 596 162 162 sky130_fd_pr__pfet_01v8 L=0.15U W=1U AS=0.3P AD=0.135P
+ PS=2.6U PD=1.27U
* device instance $2259 r0 *1 63.49,37.345 sky130_fd_pr__pfet_01v8
M$2259 162 598 597 597 sky130_fd_pr__pfet_01v8 L=0.15U W=1U AS=0.135P AD=0.365P
+ PS=1.27U PD=1.73U
* device instance $2260 r0 *1 64.37,37.345 sky130_fd_pr__pfet_01v8
M$2260 617 598 162 162 sky130_fd_pr__pfet_01v8 L=0.15U W=1U AS=0.365P AD=0.105P
+ PS=1.73U PD=1.21U
* device instance $2261 r0 *1 64.73,37.345 sky130_fd_pr__pfet_01v8
M$2261 560 596 617 617 sky130_fd_pr__pfet_01v8 L=0.15U W=1U AS=0.105P AD=0.165P
+ PS=1.21U PD=1.33U
* device instance $2262 r0 *1 65.21,37.345 sky130_fd_pr__pfet_01v8
M$2262 162 597 560 560 sky130_fd_pr__pfet_01v8 L=0.15U W=1U AS=0.165P AD=0.36P
+ PS=1.33U PD=2.72U
* device instance $2263 r0 *1 67.37,37.055 sky130_fd_pr__pfet_01v8
M$2263 608 645 162 162 sky130_fd_pr__pfet_01v8 L=0.15U W=0.42U AS=0.1573P
+ AD=0.1092P PS=1.39U PD=1.36U
* device instance $2264 r0 *1 66.47,37.345 sky130_fd_pr__pfet_01v8
M$2264 616 608 600 600 sky130_fd_pr__pfet_01v8 L=0.15U W=1U AS=0.26P AD=0.105P
+ PS=2.52U PD=1.21U
* device instance $2265 r0 *1 66.83,37.345 sky130_fd_pr__pfet_01v8
M$2265 162 553 616 616 sky130_fd_pr__pfet_01v8 L=0.15U W=1U AS=0.105P
+ AD=0.1573P PS=1.21U PD=1.39U
* device instance $2266 r0 *1 4.68,38.525 sky130_fd_pr__pfet_01v8
M$2266 622 637 162 162 sky130_fd_pr__pfet_01v8 L=0.15U W=0.42U AS=0.1113P
+ AD=0.0609P PS=1.37U PD=0.71U
* device instance $2267 r0 *1 5.12,38.525 sky130_fd_pr__pfet_01v8
M$2267 162 108 622 622 sky130_fd_pr__pfet_01v8 L=0.15U W=0.42U AS=0.0609P
+ AD=0.1841P PS=0.71U PD=1.26U
* device instance $2268 r0 *1 5.89,38.635 sky130_fd_pr__pfet_01v8
M$2268 605 622 162 162 sky130_fd_pr__pfet_01v8 L=0.15U W=0.64U AS=0.1841P
+ AD=0.1696P PS=1.26U PD=1.81U
* device instance $2269 r0 *1 7.455,38.72 sky130_fd_pr__pfet_01v8
M$2269 648 55 162 162 sky130_fd_pr__pfet_01v8 L=0.15U W=0.42U AS=0.15835P
+ AD=0.07665P PS=1.395U PD=0.785U
* device instance $2270 r0 *1 7.97,38.72 sky130_fd_pr__pfet_01v8
M$2270 624 590 648 648 sky130_fd_pr__pfet_01v8 L=0.15U W=0.42U AS=0.07665P
+ AD=0.1932P PS=0.785U PD=1.34U
* device instance $2271 r0 *1 9.04,38.72 sky130_fd_pr__pfet_01v8
M$2271 649 621 624 624 sky130_fd_pr__pfet_01v8 L=0.15U W=0.42U AS=0.1932P
+ AD=0.0441P PS=1.34U PD=0.63U
* device instance $2272 r0 *1 9.4,38.72 sky130_fd_pr__pfet_01v8
M$2272 162 656 649 649 sky130_fd_pr__pfet_01v8 L=0.15U W=0.42U AS=0.0441P
+ AD=0.0693P PS=0.63U PD=0.75U
* device instance $2273 r0 *1 9.88,38.72 sky130_fd_pr__pfet_01v8
M$2273 656 55 162 162 sky130_fd_pr__pfet_01v8 L=0.15U W=0.42U AS=0.0693P
+ AD=0.1176P PS=0.75U PD=1.4U
* device instance $2274 r0 *1 6.91,38.815 sky130_fd_pr__pfet_01v8
M$2274 162 624 623 623 sky130_fd_pr__pfet_01v8 L=0.15U W=1U AS=0.26P
+ AD=0.15835P PS=2.52U PD=1.395U
* device instance $2275 r0 *1 11.15,38.815 sky130_fd_pr__pfet_01v8
M$2275 638 639 162 162 sky130_fd_pr__pfet_01v8 L=0.15U W=1U AS=0.36P AD=0.165P
+ PS=2.72U PD=1.33U
* device instance $2276 r0 *1 11.63,38.815 sky130_fd_pr__pfet_01v8
M$2276 651 640 638 638 sky130_fd_pr__pfet_01v8 L=0.15U W=1U AS=0.165P AD=0.105P
+ PS=1.33U PD=1.21U
* device instance $2277 r0 *1 11.99,38.815 sky130_fd_pr__pfet_01v8
M$2277 162 625 651 651 sky130_fd_pr__pfet_01v8 L=0.15U W=1U AS=0.105P AD=0.365P
+ PS=1.21U PD=1.73U
* device instance $2278 r0 *1 12.87,38.815 sky130_fd_pr__pfet_01v8
M$2278 639 625 162 162 sky130_fd_pr__pfet_01v8 L=0.15U W=1U AS=0.365P AD=0.135P
+ PS=1.73U PD=1.27U
* device instance $2279 r0 *1 13.29,38.815 sky130_fd_pr__pfet_01v8
M$2279 162 640 639 639 sky130_fd_pr__pfet_01v8 L=0.15U W=1U AS=0.135P AD=0.3P
+ PS=1.27U PD=2.6U
* device instance $2280 r0 *1 14.31,38.815 sky130_fd_pr__pfet_01v8
M$2280 627 626 640 640 sky130_fd_pr__pfet_01v8 L=0.15U W=1U AS=0.3P AD=0.26P
+ PS=2.6U PD=2.52U
* device instance $2281 r0 *1 15.25,38.815 sky130_fd_pr__pfet_01v8
M$2281 627 590 162 162 sky130_fd_pr__pfet_01v8 L=0.15U W=1U AS=0.26P AD=0.135P
+ PS=2.52U PD=1.27U
* device instance $2282 r0 *1 15.67,38.815 sky130_fd_pr__pfet_01v8
M$2282 162 606 627 627 sky130_fd_pr__pfet_01v8 L=0.15U W=1U AS=0.135P AD=0.135P
+ PS=1.27U PD=1.27U
* device instance $2283 r0 *1 16.09,38.815 sky130_fd_pr__pfet_01v8
M$2283 652 606 162 162 sky130_fd_pr__pfet_01v8 L=0.15U W=1U AS=0.135P AD=0.135P
+ PS=1.27U PD=1.27U
* device instance $2284 r0 *1 16.51,38.815 sky130_fd_pr__pfet_01v8
M$2284 626 590 652 652 sky130_fd_pr__pfet_01v8 L=0.15U W=1U AS=0.135P AD=0.26P
+ PS=1.27U PD=2.52U
* device instance $2285 r0 *1 25.77,38.815 sky130_fd_pr__pfet_01v8
M$2285 629 657 628 628 sky130_fd_pr__pfet_01v8 L=0.15U W=1U AS=0.26P AD=0.135P
+ PS=2.52U PD=1.27U
* device instance $2286 r0 *1 26.19,38.815 sky130_fd_pr__pfet_01v8
M$2286 641 593 629 629 sky130_fd_pr__pfet_01v8 L=0.15U W=1U AS=0.135P AD=0.135P
+ PS=1.27U PD=1.27U
* device instance $2287 r0 *1 26.61,38.815 sky130_fd_pr__pfet_01v8
M$2287 629 129 641 641 sky130_fd_pr__pfet_01v8 L=0.15U W=1U AS=0.135P AD=0.26P
+ PS=1.27U PD=2.52U
* device instance $2288 r0 *1 27.55,38.815 sky130_fd_pr__pfet_01v8
M$2288 641 136 162 162 sky130_fd_pr__pfet_01v8 L=0.15U W=1U AS=0.26P AD=0.165P
+ PS=2.52U PD=1.33U
* device instance $2289 r0 *1 28.03,38.815 sky130_fd_pr__pfet_01v8
M$2289 162 561 641 641 sky130_fd_pr__pfet_01v8 L=0.15U W=1U AS=0.165P
+ AD=0.1575P PS=1.33U PD=1.315U
* device instance $2290 r0 *1 28.495,38.815 sky130_fd_pr__pfet_01v8
M$2290 642 628 162 162 sky130_fd_pr__pfet_01v8 L=0.15U W=1U AS=0.1575P AD=0.26P
+ PS=1.315U PD=2.52U
* device instance $2291 r0 *1 30.87,38.815 sky130_fd_pr__pfet_01v8
M$2291 630 592 162 162 sky130_fd_pr__pfet_01v8 L=0.15U W=1U AS=0.3P AD=0.135P
+ PS=2.6U PD=1.27U
* device instance $2292 r0 *1 31.29,38.815 sky130_fd_pr__pfet_01v8
M$2292 162 593 630 630 sky130_fd_pr__pfet_01v8 L=0.15U W=1U AS=0.135P AD=0.365P
+ PS=1.27U PD=1.73U
* device instance $2293 r0 *1 32.17,38.815 sky130_fd_pr__pfet_01v8
M$2293 654 593 162 162 sky130_fd_pr__pfet_01v8 L=0.15U W=1U AS=0.365P AD=0.105P
+ PS=1.73U PD=1.21U
* device instance $2294 r0 *1 32.53,38.815 sky130_fd_pr__pfet_01v8
M$2294 591 592 654 654 sky130_fd_pr__pfet_01v8 L=0.15U W=1U AS=0.105P AD=0.165P
+ PS=1.21U PD=1.33U
* device instance $2295 r0 *1 33.01,38.815 sky130_fd_pr__pfet_01v8
M$2295 162 630 591 591 sky130_fd_pr__pfet_01v8 L=0.15U W=1U AS=0.165P AD=0.36P
+ PS=1.33U PD=2.72U
* device instance $2296 r0 *1 35.435,38.815 sky130_fd_pr__pfet_01v8
M$2296 631 659 162 162 sky130_fd_pr__pfet_01v8 L=0.15U W=4U AS=0.685P AD=0.56P
+ PS=6.37U PD=5.12U
* device instance $2300 r0 *1 37.155,38.815 sky130_fd_pr__pfet_01v8
M$2300 310 631 162 162 sky130_fd_pr__pfet_01v8 L=0.15U W=16U AS=2.2375P
+ AD=2.3625P PS=20.475U PD=21.725U
* device instance $2316 r0 *1 55.67,38.815 sky130_fd_pr__pfet_01v8
M$2316 632 566 162 162 sky130_fd_pr__pfet_01v8 L=0.15U W=1U AS=0.26P AD=0.135P
+ PS=2.52U PD=1.27U
* device instance $2317 r0 *1 56.09,38.815 sky130_fd_pr__pfet_01v8
M$2317 162 339 632 632 sky130_fd_pr__pfet_01v8 L=0.15U W=1U AS=0.135P
+ AD=0.1525P PS=1.27U PD=1.305U
* device instance $2318 r0 *1 56.545,38.815 sky130_fd_pr__pfet_01v8
M$2318 632 598 162 162 sky130_fd_pr__pfet_01v8 L=0.15U W=1U AS=0.1525P
+ AD=0.1625P PS=1.305U PD=1.325U
* device instance $2319 r0 *1 57.02,38.815 sky130_fd_pr__pfet_01v8
M$2319 633 600 632 632 sky130_fd_pr__pfet_01v8 L=0.15U W=1U AS=0.1625P AD=0.27P
+ PS=1.325U PD=2.54U
* device instance $2320 r0 *1 59.8,38.815 sky130_fd_pr__pfet_01v8
M$2320 655 776 643 643 sky130_fd_pr__pfet_01v8 L=0.15U W=1U AS=0.26P AD=0.1725P
+ PS=2.52U PD=1.345U
* device instance $2321 r0 *1 60.295,38.815 sky130_fd_pr__pfet_01v8
M$2321 634 600 655 655 sky130_fd_pr__pfet_01v8 L=0.15U W=1U AS=0.1725P
+ AD=0.165P PS=1.345U PD=1.33U
* device instance $2322 r0 *1 60.775,38.815 sky130_fd_pr__pfet_01v8
M$2322 162 598 634 634 sky130_fd_pr__pfet_01v8 L=0.15U W=1U AS=0.165P AD=0.14P
+ PS=1.33U PD=1.28U
* device instance $2323 r0 *1 61.205,38.815 sky130_fd_pr__pfet_01v8
M$2323 634 306 162 162 sky130_fd_pr__pfet_01v8 L=0.15U W=1U AS=0.14P AD=0.1375P
+ PS=1.28U PD=1.275U
* device instance $2324 r0 *1 61.63,38.815 sky130_fd_pr__pfet_01v8
M$2324 162 339 634 634 sky130_fd_pr__pfet_01v8 L=0.15U W=1U AS=0.1375P AD=0.26P
+ PS=1.275U PD=2.52U
* device instance $2325 r0 *1 64.51,38.815 sky130_fd_pr__pfet_01v8
M$2325 598 644 162 162 sky130_fd_pr__pfet_01v8 L=0.15U W=1U AS=0.36P AD=0.165P
+ PS=2.72U PD=1.33U
* device instance $2326 r0 *1 64.99,38.815 sky130_fd_pr__pfet_01v8
M$2326 653 645 598 598 sky130_fd_pr__pfet_01v8 L=0.15U W=1U AS=0.165P AD=0.105P
+ PS=1.33U PD=1.21U
* device instance $2327 r0 *1 65.35,38.815 sky130_fd_pr__pfet_01v8
M$2327 162 553 653 653 sky130_fd_pr__pfet_01v8 L=0.15U W=1U AS=0.105P AD=0.365P
+ PS=1.21U PD=1.73U
* device instance $2328 r0 *1 66.23,38.815 sky130_fd_pr__pfet_01v8
M$2328 644 553 162 162 sky130_fd_pr__pfet_01v8 L=0.15U W=1U AS=0.365P AD=0.135P
+ PS=1.73U PD=1.27U
* device instance $2329 r0 *1 66.65,38.815 sky130_fd_pr__pfet_01v8
M$2329 162 645 644 644 sky130_fd_pr__pfet_01v8 L=0.15U W=1U AS=0.135P AD=0.3P
+ PS=1.27U PD=2.6U
* device instance $2330 r0 *1 68.635,38.72 sky130_fd_pr__pfet_01v8
M$2330 650 55 162 162 sky130_fd_pr__pfet_01v8 L=0.15U W=0.42U AS=0.15835P
+ AD=0.07665P PS=1.395U PD=0.785U
* device instance $2331 r0 *1 69.15,38.72 sky130_fd_pr__pfet_01v8
M$2331 636 645 650 650 sky130_fd_pr__pfet_01v8 L=0.15U W=0.42U AS=0.07665P
+ AD=0.1932P PS=0.785U PD=1.34U
* device instance $2332 r0 *1 70.22,38.72 sky130_fd_pr__pfet_01v8
M$2332 647 646 636 636 sky130_fd_pr__pfet_01v8 L=0.15U W=0.42U AS=0.1932P
+ AD=0.0441P PS=1.34U PD=0.63U
* device instance $2333 r0 *1 70.58,38.72 sky130_fd_pr__pfet_01v8
M$2333 162 660 647 647 sky130_fd_pr__pfet_01v8 L=0.15U W=0.42U AS=0.0441P
+ AD=0.0693P PS=0.63U PD=0.75U
* device instance $2334 r0 *1 71.06,38.72 sky130_fd_pr__pfet_01v8
M$2334 660 55 162 162 sky130_fd_pr__pfet_01v8 L=0.15U W=0.42U AS=0.0693P
+ AD=0.1176P PS=0.75U PD=1.4U
* device instance $2335 r0 *1 68.09,38.815 sky130_fd_pr__pfet_01v8
M$2335 162 636 635 635 sky130_fd_pr__pfet_01v8 L=0.15U W=1U AS=0.26P
+ AD=0.15835P PS=2.52U PD=1.395U
* device instance $2336 r0 *1 2.77,42.935 sky130_fd_pr__pfet_01v8
M$2336 162 939 678 678 sky130_fd_pr__pfet_01v8 L=0.15U W=0.64U AS=0.1664P
+ AD=0.0864P PS=1.8U PD=0.91U
* device instance $2337 r0 *1 3.19,42.935 sky130_fd_pr__pfet_01v8
M$2337 679 678 162 162 sky130_fd_pr__pfet_01v8 L=0.15U W=0.64U AS=0.0864P
+ AD=0.1664P PS=0.91U PD=1.8U
* device instance $2338 r0 *1 4.13,42.965 sky130_fd_pr__pfet_01v8
M$2338 740 623 680 680 sky130_fd_pr__pfet_01v8 L=0.15U W=0.64U AS=0.1664P
+ AD=0.0672P PS=1.8U PD=0.85U
* device instance $2339 r0 *1 4.49,42.965 sky130_fd_pr__pfet_01v8
M$2339 162 681 740 740 sky130_fd_pr__pfet_01v8 L=0.15U W=0.64U AS=0.0672P
+ AD=0.1664P PS=0.85U PD=1.8U
* device instance $2340 r0 *1 5.43,42.965 sky130_fd_pr__pfet_01v8
M$2340 162 88 681 681 sky130_fd_pr__pfet_01v8 L=0.15U W=0.64U AS=0.1664P
+ AD=0.0928P PS=1.8U PD=0.93U
* device instance $2341 r0 *1 5.87,42.965 sky130_fd_pr__pfet_01v8
M$2341 741 88 162 162 sky130_fd_pr__pfet_01v8 L=0.15U W=0.64U AS=0.0928P
+ AD=0.1152P PS=0.93U PD=1U
* device instance $2342 r0 *1 6.38,42.965 sky130_fd_pr__pfet_01v8
M$2342 680 705 741 741 sky130_fd_pr__pfet_01v8 L=0.15U W=0.64U AS=0.1152P
+ AD=0.15985P PS=1U PD=1.265U
* device instance $2343 r0 *1 7.155,43.075 sky130_fd_pr__pfet_01v8
M$2343 682 679 680 680 sky130_fd_pr__pfet_01v8 L=0.15U W=0.42U AS=0.15985P
+ AD=0.06405P PS=1.265U PD=0.725U
* device instance $2344 r0 *1 7.61,43.075 sky130_fd_pr__pfet_01v8
M$2344 742 678 682 682 sky130_fd_pr__pfet_01v8 L=0.15U W=0.42U AS=0.06405P
+ AD=0.07665P PS=0.725U PD=0.785U
* device instance $2345 r0 *1 8.125,43.075 sky130_fd_pr__pfet_01v8
M$2345 742 683 162 162 sky130_fd_pr__pfet_01v8 L=0.15U W=0.42U AS=0.178875P
+ AD=0.07665P PS=1.26U PD=0.785U
* device instance $2346 r0 *1 8.785,42.91 sky130_fd_pr__pfet_01v8
M$2346 683 682 162 162 sky130_fd_pr__pfet_01v8 L=0.15U W=0.75U AS=0.178875P
+ AD=0.195P PS=1.26U PD=2.02U
* device instance $2347 r0 *1 12.225,42.965 sky130_fd_pr__pfet_01v8
M$2347 705 684 162 162 sky130_fd_pr__pfet_01v8 L=0.15U W=0.64U AS=0.154P
+ AD=0.1728P PS=1.335U PD=1.82U
* device instance $2348 r0 *1 12.71,42.785 sky130_fd_pr__pfet_01v8
M$2348 574 684 162 162 sky130_fd_pr__pfet_01v8 L=0.15U W=1U AS=0.154P AD=0.28P
+ PS=1.335U PD=2.56U
* device instance $2349 r0 *1 13.81,42.785 sky130_fd_pr__pfet_01v8
M$2349 162 574 706 706 sky130_fd_pr__pfet_01v8 L=0.15U W=1U AS=0.26P AD=0.135P
+ PS=2.52U PD=1.27U
* device instance $2350 r0 *1 14.23,42.785 sky130_fd_pr__pfet_01v8
M$2350 606 706 162 162 sky130_fd_pr__pfet_01v8 L=0.15U W=4U AS=0.54P AD=0.665P
+ PS=5.08U PD=6.33U
* device instance $2354 r0 *1 17.03,42.785 sky130_fd_pr__pfet_01v8
M$2354 162 589 707 707 sky130_fd_pr__pfet_01v8 L=0.15U W=1U AS=0.26P AD=0.135P
+ PS=2.52U PD=1.27U
* device instance $2355 r0 *1 17.45,42.785 sky130_fd_pr__pfet_01v8
M$2355 625 707 162 162 sky130_fd_pr__pfet_01v8 L=0.15U W=4U AS=0.54P
+ AD=0.742525P PS=5.08U PD=5.66U
* device instance $2359 r0 *1 19.71,43.075 sky130_fd_pr__pfet_01v8
M$2359 685 732 162 162 sky130_fd_pr__pfet_01v8 L=0.15U W=0.42U AS=0.337525P
+ AD=0.0609P PS=1.85U PD=0.71U
* device instance $2360 r0 *1 20.15,43.075 sky130_fd_pr__pfet_01v8
M$2360 685 108 162 162 sky130_fd_pr__pfet_01v8 L=0.15U W=0.42U AS=0.1841P
+ AD=0.0609P PS=1.26U PD=0.71U
* device instance $2361 r0 *1 20.92,42.965 sky130_fd_pr__pfet_01v8
M$2361 657 685 162 162 sky130_fd_pr__pfet_01v8 L=0.15U W=0.64U AS=0.1841P
+ AD=0.1696P PS=1.26U PD=1.81U
* device instance $2362 r0 *1 26.23,42.935 sky130_fd_pr__pfet_01v8
M$2362 162 939 686 686 sky130_fd_pr__pfet_01v8 L=0.15U W=0.64U AS=0.1664P
+ AD=0.0864P PS=1.8U PD=0.91U
* device instance $2363 r0 *1 26.65,42.935 sky130_fd_pr__pfet_01v8
M$2363 687 686 162 162 sky130_fd_pr__pfet_01v8 L=0.15U W=0.64U AS=0.0864P
+ AD=0.1664P PS=0.91U PD=1.8U
* device instance $2364 r0 *1 27.59,42.965 sky130_fd_pr__pfet_01v8
M$2364 746 708 688 688 sky130_fd_pr__pfet_01v8 L=0.15U W=0.64U AS=0.1664P
+ AD=0.0672P PS=1.8U PD=0.85U
* device instance $2365 r0 *1 27.95,42.965 sky130_fd_pr__pfet_01v8
M$2365 162 689 746 746 sky130_fd_pr__pfet_01v8 L=0.15U W=0.64U AS=0.0672P
+ AD=0.1664P PS=0.85U PD=1.8U
* device instance $2366 r0 *1 28.89,42.965 sky130_fd_pr__pfet_01v8
M$2366 162 88 689 689 sky130_fd_pr__pfet_01v8 L=0.15U W=0.64U AS=0.1664P
+ AD=0.0928P PS=1.8U PD=0.93U
* device instance $2367 r0 *1 29.33,42.965 sky130_fd_pr__pfet_01v8
M$2367 747 88 162 162 sky130_fd_pr__pfet_01v8 L=0.15U W=0.64U AS=0.0928P
+ AD=0.1152P PS=0.93U PD=1U
* device instance $2368 r0 *1 29.84,42.965 sky130_fd_pr__pfet_01v8
M$2368 688 709 747 747 sky130_fd_pr__pfet_01v8 L=0.15U W=0.64U AS=0.1152P
+ AD=0.15985P PS=1U PD=1.265U
* device instance $2369 r0 *1 30.615,43.075 sky130_fd_pr__pfet_01v8
M$2369 690 687 688 688 sky130_fd_pr__pfet_01v8 L=0.15U W=0.42U AS=0.15985P
+ AD=0.06405P PS=1.265U PD=0.725U
* device instance $2370 r0 *1 31.07,43.075 sky130_fd_pr__pfet_01v8
M$2370 749 686 690 690 sky130_fd_pr__pfet_01v8 L=0.15U W=0.42U AS=0.06405P
+ AD=0.07665P PS=0.725U PD=0.785U
* device instance $2371 r0 *1 31.585,43.075 sky130_fd_pr__pfet_01v8
M$2371 749 691 162 162 sky130_fd_pr__pfet_01v8 L=0.15U W=0.42U AS=0.178875P
+ AD=0.07665P PS=1.26U PD=0.785U
* device instance $2372 r0 *1 32.245,42.91 sky130_fd_pr__pfet_01v8
M$2372 691 690 162 162 sky130_fd_pr__pfet_01v8 L=0.15U W=0.75U AS=0.178875P
+ AD=0.195P PS=1.26U PD=2.02U
* device instance $2373 r0 *1 35.685,42.965 sky130_fd_pr__pfet_01v8
M$2373 709 692 162 162 sky130_fd_pr__pfet_01v8 L=0.15U W=0.64U AS=0.154P
+ AD=0.1728P PS=1.335U PD=1.82U
* device instance $2374 r0 *1 36.17,42.785 sky130_fd_pr__pfet_01v8
M$2374 593 692 162 162 sky130_fd_pr__pfet_01v8 L=0.15U W=1U AS=0.154P AD=0.28P
+ PS=1.335U PD=2.56U
* device instance $2375 r0 *1 44.63,42.785 sky130_fd_pr__pfet_01v8
M$2375 753 593 693 693 sky130_fd_pr__pfet_01v8 L=0.15U W=1U AS=0.26P AD=0.13P
+ PS=2.52U PD=1.26U
* device instance $2376 r0 *1 45.04,42.785 sky130_fd_pr__pfet_01v8
M$2376 754 407 753 753 sky130_fd_pr__pfet_01v8 L=0.15U W=1U AS=0.13P AD=0.19P
+ PS=1.26U PD=1.38U
* device instance $2377 r0 *1 45.57,42.785 sky130_fd_pr__pfet_01v8
M$2377 755 710 754 754 sky130_fd_pr__pfet_01v8 L=0.15U W=1U AS=0.19P AD=0.135P
+ PS=1.38U PD=1.27U
* device instance $2378 r0 *1 45.99,42.785 sky130_fd_pr__pfet_01v8
M$2378 162 694 755 755 sky130_fd_pr__pfet_01v8 L=0.15U W=1U AS=0.135P AD=0.26P
+ PS=1.27U PD=2.52U
* device instance $2379 r0 *1 49.23,42.785 sky130_fd_pr__pfet_01v8
M$2379 876 693 162 162 sky130_fd_pr__pfet_01v8 L=0.15U W=1U AS=0.26P AD=0.135P
+ PS=2.52U PD=1.27U
* device instance $2380 r0 *1 49.65,42.785 sky130_fd_pr__pfet_01v8
M$2380 162 695 876 876 sky130_fd_pr__pfet_01v8 L=0.15U W=1U AS=0.135P AD=0.165P
+ PS=1.27U PD=1.33U
* device instance $2381 r0 *1 50.13,42.785 sky130_fd_pr__pfet_01v8
M$2381 876 384 162 162 sky130_fd_pr__pfet_01v8 L=0.15U W=1U AS=0.165P AD=0.26P
+ PS=1.33U PD=2.52U
* device instance $2382 r0 *1 57.55,42.785 sky130_fd_pr__pfet_01v8
M$2382 696 711 162 162 sky130_fd_pr__pfet_01v8 L=0.15U W=1U AS=0.3P AD=0.135P
+ PS=2.6U PD=1.27U
* device instance $2383 r0 *1 57.97,42.785 sky130_fd_pr__pfet_01v8
M$2383 162 633 696 696 sky130_fd_pr__pfet_01v8 L=0.15U W=1U AS=0.135P AD=0.365P
+ PS=1.27U PD=1.73U
* device instance $2384 r0 *1 58.85,42.785 sky130_fd_pr__pfet_01v8
M$2384 758 633 162 162 sky130_fd_pr__pfet_01v8 L=0.15U W=1U AS=0.365P AD=0.105P
+ PS=1.73U PD=1.21U
* device instance $2385 r0 *1 59.21,42.785 sky130_fd_pr__pfet_01v8
M$2385 733 711 758 758 sky130_fd_pr__pfet_01v8 L=0.15U W=1U AS=0.105P AD=0.165P
+ PS=1.21U PD=1.33U
* device instance $2386 r0 *1 59.69,42.785 sky130_fd_pr__pfet_01v8
M$2386 162 696 733 733 sky130_fd_pr__pfet_01v8 L=0.15U W=1U AS=0.165P AD=0.36P
+ PS=1.33U PD=2.72U
* device instance $2387 r0 *1 60.73,42.935 sky130_fd_pr__pfet_01v8
M$2387 162 856 698 698 sky130_fd_pr__pfet_01v8 L=0.15U W=0.64U AS=0.1664P
+ AD=0.0864P PS=1.8U PD=0.91U
* device instance $2388 r0 *1 61.15,42.935 sky130_fd_pr__pfet_01v8
M$2388 699 698 162 162 sky130_fd_pr__pfet_01v8 L=0.15U W=0.64U AS=0.0864P
+ AD=0.1664P PS=0.91U PD=1.8U
* device instance $2389 r0 *1 62.09,42.965 sky130_fd_pr__pfet_01v8
M$2389 757 577 700 700 sky130_fd_pr__pfet_01v8 L=0.15U W=0.64U AS=0.1664P
+ AD=0.0672P PS=1.8U PD=0.85U
* device instance $2390 r0 *1 62.45,42.965 sky130_fd_pr__pfet_01v8
M$2390 162 701 757 757 sky130_fd_pr__pfet_01v8 L=0.15U W=0.64U AS=0.0672P
+ AD=0.1664P PS=0.85U PD=1.8U
* device instance $2391 r0 *1 63.39,42.965 sky130_fd_pr__pfet_01v8
M$2391 162 311 701 701 sky130_fd_pr__pfet_01v8 L=0.15U W=0.64U AS=0.1664P
+ AD=0.0928P PS=1.8U PD=0.93U
* device instance $2392 r0 *1 63.83,42.965 sky130_fd_pr__pfet_01v8
M$2392 756 311 162 162 sky130_fd_pr__pfet_01v8 L=0.15U W=0.64U AS=0.0928P
+ AD=0.1152P PS=0.93U PD=1U
* device instance $2393 r0 *1 64.34,42.965 sky130_fd_pr__pfet_01v8
M$2393 700 712 756 756 sky130_fd_pr__pfet_01v8 L=0.15U W=0.64U AS=0.1152P
+ AD=0.15985P PS=1U PD=1.265U
* device instance $2394 r0 *1 65.115,43.075 sky130_fd_pr__pfet_01v8
M$2394 702 699 700 700 sky130_fd_pr__pfet_01v8 L=0.15U W=0.42U AS=0.15985P
+ AD=0.06405P PS=1.265U PD=0.725U
* device instance $2395 r0 *1 65.57,43.075 sky130_fd_pr__pfet_01v8
M$2395 752 698 702 702 sky130_fd_pr__pfet_01v8 L=0.15U W=0.42U AS=0.06405P
+ AD=0.07665P PS=0.725U PD=0.785U
* device instance $2396 r0 *1 66.085,43.075 sky130_fd_pr__pfet_01v8
M$2396 752 703 162 162 sky130_fd_pr__pfet_01v8 L=0.15U W=0.42U AS=0.178875P
+ AD=0.07665P PS=1.26U PD=0.785U
* device instance $2397 r0 *1 66.745,42.91 sky130_fd_pr__pfet_01v8
M$2397 703 702 162 162 sky130_fd_pr__pfet_01v8 L=0.15U W=0.75U AS=0.178875P
+ AD=0.195P PS=1.26U PD=2.02U
* device instance $2398 r0 *1 70.185,42.965 sky130_fd_pr__pfet_01v8
M$2398 712 704 162 162 sky130_fd_pr__pfet_01v8 L=0.15U W=0.64U AS=0.154P
+ AD=0.1728P PS=1.335U PD=1.82U
* device instance $2399 r0 *1 70.67,42.785 sky130_fd_pr__pfet_01v8
M$2399 645 704 162 162 sky130_fd_pr__pfet_01v8 L=0.15U W=1U AS=0.154P AD=0.28P
+ PS=1.335U PD=2.56U
* device instance $2400 r0 *1 9.725,43.075 sky130_fd_pr__pfet_01v8
M$2400 743 683 162 162 sky130_fd_pr__pfet_01v8 L=0.15U W=0.42U AS=0.1092P
+ AD=0.06405P PS=1.36U PD=0.725U
* device instance $2401 r0 *1 10.18,43.075 sky130_fd_pr__pfet_01v8
M$2401 684 678 743 743 sky130_fd_pr__pfet_01v8 L=0.15U W=0.42U AS=0.06405P
+ AD=0.0567P PS=0.725U PD=0.69U
* device instance $2402 r0 *1 10.6,43.075 sky130_fd_pr__pfet_01v8
M$2402 744 679 684 684 sky130_fd_pr__pfet_01v8 L=0.15U W=0.42U AS=0.0567P
+ AD=0.0882P PS=0.69U PD=0.84U
* device instance $2403 r0 *1 11.17,43.075 sky130_fd_pr__pfet_01v8
M$2403 162 705 744 744 sky130_fd_pr__pfet_01v8 L=0.15U W=0.42U AS=0.0882P
+ AD=0.1113P PS=0.84U PD=1.37U
* device instance $2404 r0 *1 10.57,44.075 sky130_fd_pr__pfet_01v8
M$2404 784 587 763 763 sky130_fd_pr__pfet_01v8 L=0.15U W=0.64U AS=0.1664P
+ AD=0.0672P PS=1.8U PD=0.85U
* device instance $2405 r0 *1 10.93,44.075 sky130_fd_pr__pfet_01v8
M$2405 162 734 784 784 sky130_fd_pr__pfet_01v8 L=0.15U W=0.64U AS=0.0672P
+ AD=0.1664P PS=0.85U PD=1.8U
* device instance $2406 r0 *1 13.595,43.965 sky130_fd_pr__pfet_01v8
M$2406 764 762 763 763 sky130_fd_pr__pfet_01v8 L=0.15U W=0.42U AS=0.15985P
+ AD=0.06405P PS=1.265U PD=0.725U
* device instance $2407 r0 *1 14.05,43.965 sky130_fd_pr__pfet_01v8
M$2407 788 761 764 764 sky130_fd_pr__pfet_01v8 L=0.15U W=0.42U AS=0.06405P
+ AD=0.07665P PS=0.725U PD=0.785U
* device instance $2408 r0 *1 14.565,43.965 sky130_fd_pr__pfet_01v8
M$2408 162 765 788 788 sky130_fd_pr__pfet_01v8 L=0.15U W=0.42U AS=0.07665P
+ AD=0.178875P PS=0.785U PD=1.26U
* device instance $2409 r0 *1 11.87,44.075 sky130_fd_pr__pfet_01v8
M$2409 162 311 734 734 sky130_fd_pr__pfet_01v8 L=0.15U W=0.64U AS=0.1664P
+ AD=0.0928P PS=1.8U PD=0.93U
* device instance $2410 r0 *1 12.31,44.075 sky130_fd_pr__pfet_01v8
M$2410 786 311 162 162 sky130_fd_pr__pfet_01v8 L=0.15U W=0.64U AS=0.0928P
+ AD=0.1152P PS=0.93U PD=1U
* device instance $2411 r0 *1 12.82,44.075 sky130_fd_pr__pfet_01v8
M$2411 763 735 786 786 sky130_fd_pr__pfet_01v8 L=0.15U W=0.64U AS=0.1152P
+ AD=0.15985P PS=1U PD=1.265U
* device instance $2412 r0 *1 15.225,44.13 sky130_fd_pr__pfet_01v8
M$2412 765 764 162 162 sky130_fd_pr__pfet_01v8 L=0.15U W=0.75U AS=0.178875P
+ AD=0.195P PS=1.26U PD=2.02U
* device instance $2413 r0 *1 16.165,43.965 sky130_fd_pr__pfet_01v8
M$2413 789 765 162 162 sky130_fd_pr__pfet_01v8 L=0.15U W=0.42U AS=0.1092P
+ AD=0.06405P PS=1.36U PD=0.725U
* device instance $2414 r0 *1 16.62,43.965 sky130_fd_pr__pfet_01v8
M$2414 766 761 789 789 sky130_fd_pr__pfet_01v8 L=0.15U W=0.42U AS=0.06405P
+ AD=0.0567P PS=0.725U PD=0.69U
* device instance $2415 r0 *1 17.04,43.965 sky130_fd_pr__pfet_01v8
M$2415 791 762 766 766 sky130_fd_pr__pfet_01v8 L=0.15U W=0.42U AS=0.0567P
+ AD=0.0882P PS=0.69U PD=0.84U
* device instance $2416 r0 *1 17.61,43.965 sky130_fd_pr__pfet_01v8
M$2416 162 735 791 791 sky130_fd_pr__pfet_01v8 L=0.15U W=0.42U AS=0.0882P
+ AD=0.1113P PS=0.84U PD=1.37U
* device instance $2417 r0 *1 18.665,44.075 sky130_fd_pr__pfet_01v8
M$2417 162 766 735 735 sky130_fd_pr__pfet_01v8 L=0.15U W=0.64U AS=0.1728P
+ AD=0.154P PS=1.82U PD=1.335U
* device instance $2418 r0 *1 19.15,44.255 sky130_fd_pr__pfet_01v8
M$2418 590 766 162 162 sky130_fd_pr__pfet_01v8 L=0.15U W=1U AS=0.154P AD=0.28P
+ PS=1.335U PD=2.56U
* device instance $2419 r0 *1 26.775,44.16 sky130_fd_pr__pfet_01v8
M$2419 794 55 162 162 sky130_fd_pr__pfet_01v8 L=0.15U W=0.42U AS=0.15835P
+ AD=0.07665P PS=1.395U PD=0.785U
* device instance $2420 r0 *1 27.29,44.16 sky130_fd_pr__pfet_01v8
M$2420 759 592 794 794 sky130_fd_pr__pfet_01v8 L=0.15U W=0.42U AS=0.07665P
+ AD=0.1932P PS=0.785U PD=1.34U
* device instance $2421 r0 *1 28.36,44.16 sky130_fd_pr__pfet_01v8
M$2421 795 767 759 759 sky130_fd_pr__pfet_01v8 L=0.15U W=0.42U AS=0.1932P
+ AD=0.0441P PS=1.34U PD=0.63U
* device instance $2422 r0 *1 28.72,44.16 sky130_fd_pr__pfet_01v8
M$2422 162 808 795 795 sky130_fd_pr__pfet_01v8 L=0.15U W=0.42U AS=0.0441P
+ AD=0.0693P PS=0.63U PD=0.75U
* device instance $2423 r0 *1 29.2,44.16 sky130_fd_pr__pfet_01v8
M$2423 808 55 162 162 sky130_fd_pr__pfet_01v8 L=0.15U W=0.42U AS=0.0693P
+ AD=0.1176P PS=0.75U PD=1.4U
* device instance $2424 r0 *1 26.23,44.255 sky130_fd_pr__pfet_01v8
M$2424 162 759 708 708 sky130_fd_pr__pfet_01v8 L=0.15U W=1U AS=0.26P
+ AD=0.15835P PS=2.52U PD=1.395U
* device instance $2425 r0 *1 33.185,43.075 sky130_fd_pr__pfet_01v8
M$2425 750 691 162 162 sky130_fd_pr__pfet_01v8 L=0.15U W=0.42U AS=0.1092P
+ AD=0.06405P PS=1.36U PD=0.725U
* device instance $2426 r0 *1 33.64,43.075 sky130_fd_pr__pfet_01v8
M$2426 692 686 750 750 sky130_fd_pr__pfet_01v8 L=0.15U W=0.42U AS=0.06405P
+ AD=0.0567P PS=0.725U PD=0.69U
* device instance $2427 r0 *1 34.06,43.075 sky130_fd_pr__pfet_01v8
M$2427 751 687 692 692 sky130_fd_pr__pfet_01v8 L=0.15U W=0.42U AS=0.0567P
+ AD=0.0882P PS=0.69U PD=0.84U
* device instance $2428 r0 *1 34.63,43.075 sky130_fd_pr__pfet_01v8
M$2428 162 709 751 751 sky130_fd_pr__pfet_01v8 L=0.15U W=0.42U AS=0.0882P
+ AD=0.1113P PS=0.84U PD=1.37U
* device instance $2429 r0 *1 34.95,44.075 sky130_fd_pr__pfet_01v8
M$2429 796 801 770 770 sky130_fd_pr__pfet_01v8 L=0.15U W=0.64U AS=0.1664P
+ AD=0.0672P PS=1.8U PD=0.85U
* device instance $2430 r0 *1 35.31,44.075 sky130_fd_pr__pfet_01v8
M$2430 162 736 796 796 sky130_fd_pr__pfet_01v8 L=0.15U W=0.64U AS=0.0672P
+ AD=0.1664P PS=0.85U PD=1.8U
* device instance $2431 r0 *1 37.975,43.965 sky130_fd_pr__pfet_01v8
M$2431 771 769 770 770 sky130_fd_pr__pfet_01v8 L=0.15U W=0.42U AS=0.15985P
+ AD=0.06405P PS=1.265U PD=0.725U
* device instance $2432 r0 *1 38.43,43.965 sky130_fd_pr__pfet_01v8
M$2432 798 768 771 771 sky130_fd_pr__pfet_01v8 L=0.15U W=0.42U AS=0.06405P
+ AD=0.07665P PS=0.725U PD=0.785U
* device instance $2433 r0 *1 38.945,43.965 sky130_fd_pr__pfet_01v8
M$2433 162 772 798 798 sky130_fd_pr__pfet_01v8 L=0.15U W=0.42U AS=0.07665P
+ AD=0.178875P PS=0.785U PD=1.26U
* device instance $2434 r0 *1 36.25,44.075 sky130_fd_pr__pfet_01v8
M$2434 162 88 736 736 sky130_fd_pr__pfet_01v8 L=0.15U W=0.64U AS=0.1664P
+ AD=0.0928P PS=1.8U PD=0.93U
* device instance $2435 r0 *1 36.69,44.075 sky130_fd_pr__pfet_01v8
M$2435 797 88 162 162 sky130_fd_pr__pfet_01v8 L=0.15U W=0.64U AS=0.0928P
+ AD=0.1152P PS=0.93U PD=1U
* device instance $2436 r0 *1 37.2,44.075 sky130_fd_pr__pfet_01v8
M$2436 770 737 797 797 sky130_fd_pr__pfet_01v8 L=0.15U W=0.64U AS=0.1152P
+ AD=0.15985P PS=1U PD=1.265U
* device instance $2437 r0 *1 39.605,44.13 sky130_fd_pr__pfet_01v8
M$2437 772 771 162 162 sky130_fd_pr__pfet_01v8 L=0.15U W=0.75U AS=0.178875P
+ AD=0.195P PS=1.26U PD=2.02U
* device instance $2438 r0 *1 40.545,43.965 sky130_fd_pr__pfet_01v8
M$2438 799 772 162 162 sky130_fd_pr__pfet_01v8 L=0.15U W=0.42U AS=0.1092P
+ AD=0.06405P PS=1.36U PD=0.725U
* device instance $2439 r0 *1 41,43.965 sky130_fd_pr__pfet_01v8
M$2439 773 768 799 799 sky130_fd_pr__pfet_01v8 L=0.15U W=0.42U AS=0.06405P
+ AD=0.0567P PS=0.725U PD=0.69U
* device instance $2440 r0 *1 41.42,43.965 sky130_fd_pr__pfet_01v8
M$2440 800 769 773 773 sky130_fd_pr__pfet_01v8 L=0.15U W=0.42U AS=0.0567P
+ AD=0.0882P PS=0.69U PD=0.84U
* device instance $2441 r0 *1 41.99,43.965 sky130_fd_pr__pfet_01v8
M$2441 162 737 800 800 sky130_fd_pr__pfet_01v8 L=0.15U W=0.42U AS=0.0882P
+ AD=0.1113P PS=0.84U PD=1.37U
* device instance $2442 r0 *1 43.045,44.075 sky130_fd_pr__pfet_01v8
M$2442 162 773 737 737 sky130_fd_pr__pfet_01v8 L=0.15U W=0.64U AS=0.1728P
+ AD=0.154P PS=1.82U PD=1.335U
* device instance $2443 r0 *1 43.53,44.255 sky130_fd_pr__pfet_01v8
M$2443 710 773 162 162 sky130_fd_pr__pfet_01v8 L=0.15U W=1U AS=0.154P AD=0.28P
+ PS=1.335U PD=2.56U
* device instance $2444 r0 *1 44.63,44.255 sky130_fd_pr__pfet_01v8
M$2444 760 809 774 774 sky130_fd_pr__pfet_01v8 L=0.15U W=1U AS=0.26P AD=0.135P
+ PS=2.52U PD=1.27U
* device instance $2445 r0 *1 45.05,44.255 sky130_fd_pr__pfet_01v8
M$2445 775 710 760 760 sky130_fd_pr__pfet_01v8 L=0.15U W=1U AS=0.135P AD=0.135P
+ PS=1.27U PD=1.27U
* device instance $2446 r0 *1 45.47,44.255 sky130_fd_pr__pfet_01v8
M$2446 760 129 775 775 sky130_fd_pr__pfet_01v8 L=0.15U W=1U AS=0.135P AD=0.26P
+ PS=1.27U PD=2.52U
* device instance $2447 r0 *1 46.41,44.255 sky130_fd_pr__pfet_01v8
M$2447 775 136 162 162 sky130_fd_pr__pfet_01v8 L=0.15U W=1U AS=0.26P AD=0.165P
+ PS=2.52U PD=1.33U
* device instance $2448 r0 *1 46.89,44.255 sky130_fd_pr__pfet_01v8
M$2448 162 733 775 775 sky130_fd_pr__pfet_01v8 L=0.15U W=1U AS=0.165P
+ AD=0.1575P PS=1.33U PD=1.315U
* device instance $2449 r0 *1 47.355,44.255 sky130_fd_pr__pfet_01v8
M$2449 810 774 162 162 sky130_fd_pr__pfet_01v8 L=0.15U W=1U AS=0.1575P AD=0.26P
+ PS=1.315U PD=2.52U
* device instance $2450 r0 *1 48.33,44.175 sky130_fd_pr__pfet_01v8
M$2450 811 802 162 162 sky130_fd_pr__pfet_01v8 L=0.15U W=1.68U AS=0.3486P
+ AD=0.3318P PS=3.35U PD=3.31U
* device instance $2452 r0 *1 49.69,44.255 sky130_fd_pr__pfet_01v8
M$2452 807 811 776 776 sky130_fd_pr__pfet_01v8 L=0.15U W=1U AS=0.26P AD=0.105P
+ PS=2.52U PD=1.21U
* device instance $2453 r0 *1 50.05,44.255 sky130_fd_pr__pfet_01v8
M$2453 162 710 807 807 sky130_fd_pr__pfet_01v8 L=0.15U W=1U AS=0.105P AD=0.26P
+ PS=1.21U PD=2.52U
* device instance $2454 r0 *1 51.31,44.545 sky130_fd_pr__pfet_01v8
M$2454 777 710 162 162 sky130_fd_pr__pfet_01v8 L=0.15U W=0.42U AS=0.1573P
+ AD=0.1092P PS=1.39U PD=1.36U
* device instance $2455 r0 *1 51.85,44.255 sky130_fd_pr__pfet_01v8
M$2455 806 802 162 162 sky130_fd_pr__pfet_01v8 L=0.15U W=1U AS=0.1573P
+ AD=0.105P PS=1.39U PD=1.21U
* device instance $2456 r0 *1 52.21,44.255 sky130_fd_pr__pfet_01v8
M$2456 803 777 806 806 sky130_fd_pr__pfet_01v8 L=0.15U W=1U AS=0.105P AD=0.26P
+ PS=1.21U PD=2.52U
* device instance $2457 r0 *1 56.67,44.255 sky130_fd_pr__pfet_01v8
M$2457 805 776 162 162 sky130_fd_pr__pfet_01v8 L=0.15U W=1U AS=0.26P AD=0.105P
+ PS=2.52U PD=1.21U
* device instance $2458 r0 *1 57.03,44.255 sky130_fd_pr__pfet_01v8
M$2458 711 803 805 805 sky130_fd_pr__pfet_01v8 L=0.15U W=1U AS=0.105P AD=0.26P
+ PS=1.21U PD=2.52U
* device instance $2459 r0 *1 61.27,44.255 sky130_fd_pr__pfet_01v8
M$2459 804 989 162 162 sky130_fd_pr__pfet_01v8 L=0.15U W=1U AS=0.26P AD=0.105P
+ PS=2.52U PD=1.21U
* device instance $2460 r0 *1 61.63,44.255 sky130_fd_pr__pfet_01v8
M$2460 695 553 804 804 sky130_fd_pr__pfet_01v8 L=0.15U W=1U AS=0.105P AD=0.26P
+ PS=1.21U PD=2.52U
* device instance $2461 r0 *1 66.23,44.075 sky130_fd_pr__pfet_01v8
M$2461 793 635 780 780 sky130_fd_pr__pfet_01v8 L=0.15U W=0.64U AS=0.1664P
+ AD=0.0672P PS=1.8U PD=0.85U
* device instance $2462 r0 *1 66.59,44.075 sky130_fd_pr__pfet_01v8
M$2462 162 738 793 793 sky130_fd_pr__pfet_01v8 L=0.15U W=0.64U AS=0.0672P
+ AD=0.1664P PS=0.85U PD=1.8U
* device instance $2463 r0 *1 69.255,43.965 sky130_fd_pr__pfet_01v8
M$2463 781 779 780 780 sky130_fd_pr__pfet_01v8 L=0.15U W=0.42U AS=0.15985P
+ AD=0.06405P PS=1.265U PD=0.725U
* device instance $2464 r0 *1 69.71,43.965 sky130_fd_pr__pfet_01v8
M$2464 790 778 781 781 sky130_fd_pr__pfet_01v8 L=0.15U W=0.42U AS=0.06405P
+ AD=0.07665P PS=0.725U PD=0.785U
* device instance $2465 r0 *1 70.225,43.965 sky130_fd_pr__pfet_01v8
M$2465 162 782 790 790 sky130_fd_pr__pfet_01v8 L=0.15U W=0.42U AS=0.07665P
+ AD=0.178875P PS=0.785U PD=1.26U
* device instance $2466 r0 *1 67.53,44.075 sky130_fd_pr__pfet_01v8
M$2466 162 1134 738 738 sky130_fd_pr__pfet_01v8 L=0.15U W=0.64U AS=0.1664P
+ AD=0.0928P PS=1.8U PD=0.93U
* device instance $2467 r0 *1 67.97,44.075 sky130_fd_pr__pfet_01v8
M$2467 792 1134 162 162 sky130_fd_pr__pfet_01v8 L=0.15U W=0.64U AS=0.0928P
+ AD=0.1152P PS=0.93U PD=1U
* device instance $2468 r0 *1 68.48,44.075 sky130_fd_pr__pfet_01v8
M$2468 780 739 792 792 sky130_fd_pr__pfet_01v8 L=0.15U W=0.64U AS=0.1152P
+ AD=0.15985P PS=1U PD=1.265U
* device instance $2469 r0 *1 70.885,44.13 sky130_fd_pr__pfet_01v8
M$2469 782 781 162 162 sky130_fd_pr__pfet_01v8 L=0.15U W=0.75U AS=0.178875P
+ AD=0.195P PS=1.26U PD=2.02U
* device instance $2470 r0 *1 67.685,43.075 sky130_fd_pr__pfet_01v8
M$2470 748 703 162 162 sky130_fd_pr__pfet_01v8 L=0.15U W=0.42U AS=0.1092P
+ AD=0.06405P PS=1.36U PD=0.725U
* device instance $2471 r0 *1 68.14,43.075 sky130_fd_pr__pfet_01v8
M$2471 704 698 748 748 sky130_fd_pr__pfet_01v8 L=0.15U W=0.42U AS=0.06405P
+ AD=0.0567P PS=0.725U PD=0.69U
* device instance $2472 r0 *1 68.56,43.075 sky130_fd_pr__pfet_01v8
M$2472 745 699 704 704 sky130_fd_pr__pfet_01v8 L=0.15U W=0.42U AS=0.0567P
+ AD=0.0882P PS=0.69U PD=0.84U
* device instance $2473 r0 *1 69.13,43.075 sky130_fd_pr__pfet_01v8
M$2473 162 712 745 745 sky130_fd_pr__pfet_01v8 L=0.15U W=0.42U AS=0.0882P
+ AD=0.1113P PS=0.84U PD=1.37U
* device instance $2474 r0 *1 71.825,43.965 sky130_fd_pr__pfet_01v8
M$2474 787 782 162 162 sky130_fd_pr__pfet_01v8 L=0.15U W=0.42U AS=0.1092P
+ AD=0.06405P PS=1.36U PD=0.725U
* device instance $2475 r0 *1 72.28,43.965 sky130_fd_pr__pfet_01v8
M$2475 783 778 787 787 sky130_fd_pr__pfet_01v8 L=0.15U W=0.42U AS=0.06405P
+ AD=0.0567P PS=0.725U PD=0.69U
* device instance $2476 r0 *1 72.7,43.965 sky130_fd_pr__pfet_01v8
M$2476 785 779 783 783 sky130_fd_pr__pfet_01v8 L=0.15U W=0.42U AS=0.0567P
+ AD=0.0882P PS=0.69U PD=0.84U
* device instance $2477 r0 *1 73.27,43.965 sky130_fd_pr__pfet_01v8
M$2477 162 739 785 785 sky130_fd_pr__pfet_01v8 L=0.15U W=0.42U AS=0.0882P
+ AD=0.1113P PS=0.84U PD=1.37U
* device instance $2478 r0 *1 74.325,44.075 sky130_fd_pr__pfet_01v8
M$2478 162 783 739 739 sky130_fd_pr__pfet_01v8 L=0.15U W=0.64U AS=0.1728P
+ AD=0.154P PS=1.82U PD=1.335U
* device instance $2479 r0 *1 74.81,44.255 sky130_fd_pr__pfet_01v8
M$2479 553 783 162 162 sky130_fd_pr__pfet_01v8 L=0.15U W=1U AS=0.154P AD=0.28P
+ PS=1.335U PD=2.56U
* device instance $2480 r0 *1 7.83,48.225 sky130_fd_pr__pfet_01v8
M$2480 871 851 831 831 sky130_fd_pr__pfet_01v8 L=0.15U W=1U AS=0.26P AD=0.135P
+ PS=2.52U PD=1.27U
* device instance $2481 r0 *1 8.25,48.225 sky130_fd_pr__pfet_01v8
M$2481 872 852 871 871 sky130_fd_pr__pfet_01v8 L=0.15U W=1U AS=0.135P AD=0.135P
+ PS=1.27U PD=1.27U
* device instance $2482 r0 *1 8.67,48.225 sky130_fd_pr__pfet_01v8
M$2482 871 129 872 872 sky130_fd_pr__pfet_01v8 L=0.15U W=1U AS=0.135P AD=0.26P
+ PS=1.27U PD=2.52U
* device instance $2483 r0 *1 9.21,44.105 sky130_fd_pr__pfet_01v8
M$2483 162 939 761 761 sky130_fd_pr__pfet_01v8 L=0.15U W=0.64U AS=0.1664P
+ AD=0.0864P PS=1.8U PD=0.91U
* device instance $2484 r0 *1 9.63,44.105 sky130_fd_pr__pfet_01v8
M$2484 762 761 162 162 sky130_fd_pr__pfet_01v8 L=0.15U W=0.64U AS=0.0864P
+ AD=0.1664P PS=0.91U PD=1.8U
* device instance $2485 r0 *1 9.61,48.225 sky130_fd_pr__pfet_01v8
M$2485 872 130 162 162 sky130_fd_pr__pfet_01v8 L=0.15U W=1U AS=0.26P AD=0.165P
+ PS=2.52U PD=1.33U
* device instance $2486 r0 *1 10.09,48.225 sky130_fd_pr__pfet_01v8
M$2486 162 853 872 872 sky130_fd_pr__pfet_01v8 L=0.15U W=1U AS=0.165P
+ AD=0.1575P PS=1.33U PD=1.315U
* device instance $2487 r0 *1 10.555,48.225 sky130_fd_pr__pfet_01v8
M$2487 873 831 162 162 sky130_fd_pr__pfet_01v8 L=0.15U W=1U AS=0.1575P AD=0.26P
+ PS=1.315U PD=2.52U
* device instance $2488 r0 *1 11.735,48.225 sky130_fd_pr__pfet_01v8
M$2488 589 854 162 162 sky130_fd_pr__pfet_01v8 L=0.15U W=4U AS=0.795P
+ AD=0.5475P PS=6.59U PD=5.095U
* device instance $2492 r0 *1 13.43,48.225 sky130_fd_pr__pfet_01v8
M$2492 589 833 162 162 sky130_fd_pr__pfet_01v8 L=0.15U W=4U AS=0.5475P
+ AD=0.665P PS=5.095U PD=6.33U
* device instance $2496 r0 *1 15.63,48.225 sky130_fd_pr__pfet_01v8
M$2496 833 937 162 162 sky130_fd_pr__pfet_01v8 L=0.15U W=1U AS=0.26P AD=0.26P
+ PS=2.52U PD=2.52U
* device instance $2497 r0 *1 25.77,48.375 sky130_fd_pr__pfet_01v8
M$2497 162 939 834 834 sky130_fd_pr__pfet_01v8 L=0.15U W=0.64U AS=0.1664P
+ AD=0.0864P PS=1.8U PD=0.91U
* device instance $2498 r0 *1 26.19,48.375 sky130_fd_pr__pfet_01v8
M$2498 835 834 162 162 sky130_fd_pr__pfet_01v8 L=0.15U W=0.64U AS=0.0864P
+ AD=0.1664P PS=0.91U PD=1.8U
* device instance $2499 r0 *1 27.13,48.405 sky130_fd_pr__pfet_01v8
M$2499 879 642 836 836 sky130_fd_pr__pfet_01v8 L=0.15U W=0.64U AS=0.1664P
+ AD=0.0672P PS=1.8U PD=0.85U
* device instance $2500 r0 *1 27.49,48.405 sky130_fd_pr__pfet_01v8
M$2500 162 837 879 879 sky130_fd_pr__pfet_01v8 L=0.15U W=0.64U AS=0.0672P
+ AD=0.1664P PS=0.85U PD=1.8U
* device instance $2501 r0 *1 28.43,48.405 sky130_fd_pr__pfet_01v8
M$2501 162 311 837 837 sky130_fd_pr__pfet_01v8 L=0.15U W=0.64U AS=0.1664P
+ AD=0.0928P PS=1.8U PD=0.93U
* device instance $2502 r0 *1 28.87,48.405 sky130_fd_pr__pfet_01v8
M$2502 880 311 162 162 sky130_fd_pr__pfet_01v8 L=0.15U W=0.64U AS=0.0928P
+ AD=0.1152P PS=0.93U PD=1U
* device instance $2503 r0 *1 29.38,48.405 sky130_fd_pr__pfet_01v8
M$2503 836 855 880 880 sky130_fd_pr__pfet_01v8 L=0.15U W=0.64U AS=0.1152P
+ AD=0.15985P PS=1U PD=1.265U
* device instance $2504 r0 *1 30.155,48.515 sky130_fd_pr__pfet_01v8
M$2504 838 835 836 836 sky130_fd_pr__pfet_01v8 L=0.15U W=0.42U AS=0.15985P
+ AD=0.06405P PS=1.265U PD=0.725U
* device instance $2505 r0 *1 30.61,48.515 sky130_fd_pr__pfet_01v8
M$2505 881 834 838 838 sky130_fd_pr__pfet_01v8 L=0.15U W=0.42U AS=0.06405P
+ AD=0.07665P PS=0.725U PD=0.785U
* device instance $2506 r0 *1 31.125,48.515 sky130_fd_pr__pfet_01v8
M$2506 881 839 162 162 sky130_fd_pr__pfet_01v8 L=0.15U W=0.42U AS=0.178875P
+ AD=0.07665P PS=1.26U PD=0.785U
* device instance $2507 r0 *1 31.785,48.35 sky130_fd_pr__pfet_01v8
M$2507 839 838 162 162 sky130_fd_pr__pfet_01v8 L=0.15U W=0.75U AS=0.178875P
+ AD=0.195P PS=1.26U PD=2.02U
* device instance $2508 r0 *1 32.725,48.515 sky130_fd_pr__pfet_01v8
M$2508 882 839 162 162 sky130_fd_pr__pfet_01v8 L=0.15U W=0.42U AS=0.1092P
+ AD=0.06405P PS=1.36U PD=0.725U
* device instance $2509 r0 *1 33.18,48.515 sky130_fd_pr__pfet_01v8
M$2509 840 834 882 882 sky130_fd_pr__pfet_01v8 L=0.15U W=0.42U AS=0.06405P
+ AD=0.0567P PS=0.725U PD=0.69U
* device instance $2510 r0 *1 33.6,48.515 sky130_fd_pr__pfet_01v8
M$2510 883 835 840 840 sky130_fd_pr__pfet_01v8 L=0.15U W=0.42U AS=0.0567P
+ AD=0.0882P PS=0.69U PD=0.84U
* device instance $2511 r0 *1 34.17,48.515 sky130_fd_pr__pfet_01v8
M$2511 162 855 883 883 sky130_fd_pr__pfet_01v8 L=0.15U W=0.42U AS=0.0882P
+ AD=0.1113P PS=0.84U PD=1.37U
* device instance $2512 r0 *1 33.59,44.105 sky130_fd_pr__pfet_01v8
M$2512 162 939 768 768 sky130_fd_pr__pfet_01v8 L=0.15U W=0.64U AS=0.1664P
+ AD=0.0864P PS=1.8U PD=0.91U
* device instance $2513 r0 *1 34.01,44.105 sky130_fd_pr__pfet_01v8
M$2513 769 768 162 162 sky130_fd_pr__pfet_01v8 L=0.15U W=0.64U AS=0.0864P
+ AD=0.1664P PS=0.91U PD=1.8U
* device instance $2514 r0 *1 35.225,48.405 sky130_fd_pr__pfet_01v8
M$2514 855 840 162 162 sky130_fd_pr__pfet_01v8 L=0.15U W=0.64U AS=0.154P
+ AD=0.1728P PS=1.335U PD=1.82U
* device instance $2515 r0 *1 35.71,48.225 sky130_fd_pr__pfet_01v8
M$2515 592 840 162 162 sky130_fd_pr__pfet_01v8 L=0.15U W=1U AS=0.154P AD=0.28P
+ PS=1.335U PD=2.56U
* device instance $2516 r0 *1 40.975,48.405 sky130_fd_pr__pfet_01v8
M$2516 801 870 162 162 sky130_fd_pr__pfet_01v8 L=0.15U W=0.64U AS=0.1824P
+ AD=0.0896P PS=1.85U PD=0.92U
* device instance $2517 r0 *1 41.405,48.405 sky130_fd_pr__pfet_01v8
M$2517 884 55 801 801 sky130_fd_pr__pfet_01v8 L=0.15U W=0.64U AS=0.0896P
+ AD=0.0768P PS=0.92U PD=0.88U
* device instance $2518 r0 *1 41.795,48.405 sky130_fd_pr__pfet_01v8
M$2518 162 811 884 884 sky130_fd_pr__pfet_01v8 L=0.15U W=0.64U AS=0.0768P
+ AD=0.1696P PS=0.88U PD=1.81U
* device instance $2519 r0 *1 44.63,48.375 sky130_fd_pr__pfet_01v8
M$2519 162 856 842 842 sky130_fd_pr__pfet_01v8 L=0.15U W=0.64U AS=0.1664P
+ AD=0.0864P PS=1.8U PD=0.91U
* device instance $2520 r0 *1 45.05,48.375 sky130_fd_pr__pfet_01v8
M$2520 843 842 162 162 sky130_fd_pr__pfet_01v8 L=0.15U W=0.64U AS=0.0864P
+ AD=0.1664P PS=0.91U PD=1.8U
* device instance $2521 r0 *1 45.99,48.405 sky130_fd_pr__pfet_01v8
M$2521 887 810 844 844 sky130_fd_pr__pfet_01v8 L=0.15U W=0.64U AS=0.1664P
+ AD=0.0672P PS=1.8U PD=0.85U
* device instance $2522 r0 *1 46.35,48.405 sky130_fd_pr__pfet_01v8
M$2522 162 845 887 887 sky130_fd_pr__pfet_01v8 L=0.15U W=0.64U AS=0.0672P
+ AD=0.1664P PS=0.85U PD=1.8U
* device instance $2523 r0 *1 47.29,48.405 sky130_fd_pr__pfet_01v8
M$2523 162 311 845 845 sky130_fd_pr__pfet_01v8 L=0.15U W=0.64U AS=0.1664P
+ AD=0.0928P PS=1.8U PD=0.93U
* device instance $2524 r0 *1 47.73,48.405 sky130_fd_pr__pfet_01v8
M$2524 888 311 162 162 sky130_fd_pr__pfet_01v8 L=0.15U W=0.64U AS=0.0928P
+ AD=0.1152P PS=0.93U PD=1U
* device instance $2525 r0 *1 48.24,48.405 sky130_fd_pr__pfet_01v8
M$2525 844 857 888 888 sky130_fd_pr__pfet_01v8 L=0.15U W=0.64U AS=0.1152P
+ AD=0.15985P PS=1U PD=1.265U
* device instance $2526 r0 *1 49.015,48.515 sky130_fd_pr__pfet_01v8
M$2526 846 843 844 844 sky130_fd_pr__pfet_01v8 L=0.15U W=0.42U AS=0.15985P
+ AD=0.06405P PS=1.265U PD=0.725U
* device instance $2527 r0 *1 49.47,48.515 sky130_fd_pr__pfet_01v8
M$2527 889 842 846 846 sky130_fd_pr__pfet_01v8 L=0.15U W=0.42U AS=0.06405P
+ AD=0.07665P PS=0.725U PD=0.785U
* device instance $2528 r0 *1 49.985,48.515 sky130_fd_pr__pfet_01v8
M$2528 889 847 162 162 sky130_fd_pr__pfet_01v8 L=0.15U W=0.42U AS=0.178875P
+ AD=0.07665P PS=1.26U PD=0.785U
* device instance $2529 r0 *1 50.645,48.35 sky130_fd_pr__pfet_01v8
M$2529 847 846 162 162 sky130_fd_pr__pfet_01v8 L=0.15U W=0.75U AS=0.178875P
+ AD=0.195P PS=1.26U PD=2.02U
* device instance $2530 r0 *1 51.585,48.515 sky130_fd_pr__pfet_01v8
M$2530 886 847 162 162 sky130_fd_pr__pfet_01v8 L=0.15U W=0.42U AS=0.1092P
+ AD=0.06405P PS=1.36U PD=0.725U
* device instance $2531 r0 *1 52.04,48.515 sky130_fd_pr__pfet_01v8
M$2531 848 842 886 886 sky130_fd_pr__pfet_01v8 L=0.15U W=0.42U AS=0.06405P
+ AD=0.0567P PS=0.725U PD=0.69U
* device instance $2532 r0 *1 52.46,48.515 sky130_fd_pr__pfet_01v8
M$2532 885 843 848 848 sky130_fd_pr__pfet_01v8 L=0.15U W=0.42U AS=0.0567P
+ AD=0.0882P PS=0.69U PD=0.84U
* device instance $2533 r0 *1 53.03,48.515 sky130_fd_pr__pfet_01v8
M$2533 162 857 885 885 sky130_fd_pr__pfet_01v8 L=0.15U W=0.42U AS=0.0882P
+ AD=0.1113P PS=0.84U PD=1.37U
* device instance $2534 r0 *1 54.085,48.405 sky130_fd_pr__pfet_01v8
M$2534 857 848 162 162 sky130_fd_pr__pfet_01v8 L=0.15U W=0.64U AS=0.154P
+ AD=0.1728P PS=1.335U PD=1.82U
* device instance $2535 r0 *1 54.57,48.225 sky130_fd_pr__pfet_01v8
M$2535 802 848 162 162 sky130_fd_pr__pfet_01v8 L=0.15U W=1U AS=0.154P AD=0.28P
+ PS=1.335U PD=2.56U
* device instance $2536 r0 *1 61.65,48.225 sky130_fd_pr__pfet_01v8
M$2536 162 643 849 849 sky130_fd_pr__pfet_01v8 L=0.15U W=1U AS=0.26P AD=0.135P
+ PS=2.52U PD=1.27U
* device instance $2537 r0 *1 62.07,48.225 sky130_fd_pr__pfet_01v8
M$2537 850 849 162 162 sky130_fd_pr__pfet_01v8 L=0.15U W=4U AS=0.54P AD=0.665P
+ PS=5.08U PD=6.33U
* device instance $2541 r0 *1 64.87,44.105 sky130_fd_pr__pfet_01v8
M$2541 162 856 778 778 sky130_fd_pr__pfet_01v8 L=0.15U W=0.64U AS=0.1664P
+ AD=0.0864P PS=1.8U PD=0.91U
* device instance $2542 r0 *1 65.29,44.105 sky130_fd_pr__pfet_01v8
M$2542 779 778 162 162 sky130_fd_pr__pfet_01v8 L=0.15U W=0.64U AS=0.0864P
+ AD=0.1664P PS=0.91U PD=1.8U
* device instance $2543 r0 *1 4.68,49.405 sky130_fd_pr__pfet_01v8
M$2543 890 907 162 162 sky130_fd_pr__pfet_01v8 L=0.15U W=0.42U AS=0.1113P
+ AD=0.0609P PS=1.37U PD=0.71U
* device instance $2544 r0 *1 5.12,49.405 sky130_fd_pr__pfet_01v8
M$2544 162 108 890 890 sky130_fd_pr__pfet_01v8 L=0.15U W=0.42U AS=0.0609P
+ AD=0.1841P PS=0.71U PD=1.26U
* device instance $2545 r0 *1 5.89,49.515 sky130_fd_pr__pfet_01v8
M$2545 851 890 162 162 sky130_fd_pr__pfet_01v8 L=0.15U W=0.64U AS=0.1841P
+ AD=0.1696P PS=1.26U PD=1.81U
* device instance $2546 r0 *1 7.455,49.6 sky130_fd_pr__pfet_01v8
M$2546 912 55 162 162 sky130_fd_pr__pfet_01v8 L=0.15U W=0.42U AS=0.15835P
+ AD=0.07665P PS=1.395U PD=0.785U
* device instance $2547 r0 *1 7.97,49.6 sky130_fd_pr__pfet_01v8
M$2547 874 908 912 912 sky130_fd_pr__pfet_01v8 L=0.15U W=0.42U AS=0.07665P
+ AD=0.1932P PS=0.785U PD=1.34U
* device instance $2548 r0 *1 9.04,49.6 sky130_fd_pr__pfet_01v8
M$2548 913 917 874 874 sky130_fd_pr__pfet_01v8 L=0.15U W=0.42U AS=0.1932P
+ AD=0.0441P PS=1.34U PD=0.63U
* device instance $2549 r0 *1 9.4,49.6 sky130_fd_pr__pfet_01v8
M$2549 162 918 913 913 sky130_fd_pr__pfet_01v8 L=0.15U W=0.42U AS=0.0441P
+ AD=0.0693P PS=0.63U PD=0.75U
* device instance $2550 r0 *1 9.88,49.6 sky130_fd_pr__pfet_01v8
M$2550 918 55 162 162 sky130_fd_pr__pfet_01v8 L=0.15U W=0.42U AS=0.0693P
+ AD=0.1176P PS=0.75U PD=1.4U
* device instance $2551 r0 *1 6.91,49.695 sky130_fd_pr__pfet_01v8
M$2551 162 874 891 891 sky130_fd_pr__pfet_01v8 L=0.15U W=1U AS=0.26P
+ AD=0.15835P PS=2.52U PD=1.395U
* device instance $2552 r0 *1 11.09,49.695 sky130_fd_pr__pfet_01v8
M$2552 892 875 853 853 sky130_fd_pr__pfet_01v8 L=0.15U W=1U AS=0.3P AD=0.26P
+ PS=2.6U PD=2.52U
* device instance $2553 r0 *1 12.03,49.695 sky130_fd_pr__pfet_01v8
M$2553 892 852 162 162 sky130_fd_pr__pfet_01v8 L=0.15U W=1U AS=0.26P AD=0.135P
+ PS=2.52U PD=1.27U
* device instance $2554 r0 *1 12.45,49.695 sky130_fd_pr__pfet_01v8
M$2554 162 908 892 892 sky130_fd_pr__pfet_01v8 L=0.15U W=1U AS=0.135P AD=0.135P
+ PS=1.27U PD=1.27U
* device instance $2555 r0 *1 12.87,49.695 sky130_fd_pr__pfet_01v8
M$2555 915 908 162 162 sky130_fd_pr__pfet_01v8 L=0.15U W=1U AS=0.135P AD=0.135P
+ PS=1.27U PD=1.27U
* device instance $2556 r0 *1 13.29,49.695 sky130_fd_pr__pfet_01v8
M$2556 875 852 915 915 sky130_fd_pr__pfet_01v8 L=0.15U W=1U AS=0.135P AD=0.26P
+ PS=1.27U PD=2.52U
* device instance $2557 r0 *1 12.225,53.845 sky130_fd_pr__pfet_01v8
M$2557 932 935 162 162 sky130_fd_pr__pfet_01v8 L=0.15U W=0.64U AS=0.154P
+ AD=0.1728P PS=1.335U PD=1.82U
* device instance $2558 r0 *1 12.71,53.665 sky130_fd_pr__pfet_01v8
M$2558 854 935 162 162 sky130_fd_pr__pfet_01v8 L=0.15U W=1U AS=0.154P AD=0.28P
+ PS=1.335U PD=2.56U
* device instance $2559 r0 *1 13.95,53.665 sky130_fd_pr__pfet_01v8
M$2559 908 936 162 162 sky130_fd_pr__pfet_01v8 L=0.15U W=4U AS=0.665P AD=0.54P
+ PS=6.33U PD=5.08U
* device instance $2563 r0 *1 15.63,53.665 sky130_fd_pr__pfet_01v8
M$2563 936 937 162 162 sky130_fd_pr__pfet_01v8 L=0.15U W=1U AS=0.135P AD=0.26P
+ PS=1.27U PD=2.52U
* device instance $2564 r0 *1 17.03,53.665 sky130_fd_pr__pfet_01v8
M$2564 162 854 947 947 sky130_fd_pr__pfet_01v8 L=0.15U W=1U AS=0.26P AD=0.135P
+ PS=2.52U PD=1.27U
* device instance $2565 r0 *1 17.45,53.665 sky130_fd_pr__pfet_01v8
M$2565 852 947 162 162 sky130_fd_pr__pfet_01v8 L=0.15U W=4U AS=0.54P AD=0.795P
+ PS=5.08U PD=5.59U
* device instance $2569 r0 *1 19.64,53.665 sky130_fd_pr__pfet_01v8
M$2569 939 938 162 162 sky130_fd_pr__pfet_01v8 L=0.15U W=16U AS=2.4875P
+ AD=2.2375P PS=20.975U PD=20.475U
* device instance $2585 r0 *1 26.515,53.665 sky130_fd_pr__pfet_01v8
M$2585 938 310 162 162 sky130_fd_pr__pfet_01v8 L=0.15U W=4U AS=0.56P AD=0.685P
+ PS=5.12U PD=6.37U
* device instance $2589 r0 *1 21.21,49.695 sky130_fd_pr__pfet_01v8
M$2589 894 406 893 893 sky130_fd_pr__pfet_01v8 L=0.15U W=4U AS=0.665P AD=0.54P
+ PS=6.33U PD=5.08U
* device instance $2593 r0 *1 22.89,49.695 sky130_fd_pr__pfet_01v8
M$2593 895 876 893 893 sky130_fd_pr__pfet_01v8 L=0.15U W=4U AS=0.54P AD=0.665P
+ PS=5.08U PD=6.33U
* device instance $2597 r0 *1 25.09,49.695 sky130_fd_pr__pfet_01v8
M$2597 895 909 896 896 sky130_fd_pr__pfet_01v8 L=0.15U W=4U AS=0.665P AD=0.54P
+ PS=6.33U PD=5.08U
* device instance $2601 r0 *1 26.77,49.695 sky130_fd_pr__pfet_01v8
M$2601 162 852 896 896 sky130_fd_pr__pfet_01v8 L=0.15U W=4U AS=0.54P AD=0.685P
+ PS=5.08U PD=6.37U
* device instance $2605 r0 *1 43.32,49.405 sky130_fd_pr__pfet_01v8
M$2605 897 910 162 162 sky130_fd_pr__pfet_01v8 L=0.15U W=0.42U AS=0.1113P
+ AD=0.0609P PS=1.37U PD=0.71U
* device instance $2606 r0 *1 43.76,49.405 sky130_fd_pr__pfet_01v8
M$2606 162 108 897 897 sky130_fd_pr__pfet_01v8 L=0.15U W=0.42U AS=0.0609P
+ AD=0.1841P PS=0.71U PD=1.26U
* device instance $2607 r0 *1 44.53,49.515 sky130_fd_pr__pfet_01v8
M$2607 809 897 162 162 sky130_fd_pr__pfet_01v8 L=0.15U W=0.64U AS=0.1841P
+ AD=0.1696P PS=1.26U PD=1.81U
* device instance $2608 r0 *1 56.13,53.665 sky130_fd_pr__pfet_01v8
M$2608 964 948 940 940 sky130_fd_pr__pfet_01v8 L=0.15U W=1U AS=0.26P AD=0.135P
+ PS=2.52U PD=1.27U
* device instance $2609 r0 *1 56.55,53.665 sky130_fd_pr__pfet_01v8
M$2609 965 803 964 964 sky130_fd_pr__pfet_01v8 L=0.15U W=1U AS=0.135P AD=0.135P
+ PS=1.27U PD=1.27U
* device instance $2610 r0 *1 56.97,53.665 sky130_fd_pr__pfet_01v8
M$2610 162 982 965 965 sky130_fd_pr__pfet_01v8 L=0.15U W=1U AS=0.135P AD=0.4P
+ PS=1.27U PD=1.8U
* device instance $2611 r0 *1 57.92,53.665 sky130_fd_pr__pfet_01v8
M$2611 941 940 162 162 sky130_fd_pr__pfet_01v8 L=0.15U W=4U AS=0.805P AD=0.87P
+ PS=5.61U PD=5.74U
* device instance $2615 r0 *1 60.26,53.665 sky130_fd_pr__pfet_01v8
M$2615 948 942 162 162 sky130_fd_pr__pfet_01v8 L=0.15U W=4U AS=0.87P AD=0.54P
+ PS=5.74U PD=5.08U
* device instance $2619 r0 *1 61.94,53.665 sky130_fd_pr__pfet_01v8
M$2619 942 850 162 162 sky130_fd_pr__pfet_01v8 L=0.15U W=1U AS=0.135P AD=0.26P
+ PS=1.27U PD=2.52U
* device instance $2620 r0 *1 64.87,49.545 sky130_fd_pr__pfet_01v8
M$2620 162 856 898 898 sky130_fd_pr__pfet_01v8 L=0.15U W=0.64U AS=0.1664P
+ AD=0.0864P PS=1.8U PD=0.91U
* device instance $2621 r0 *1 65.29,49.545 sky130_fd_pr__pfet_01v8
M$2621 899 898 162 162 sky130_fd_pr__pfet_01v8 L=0.15U W=0.64U AS=0.0864P
+ AD=0.1664P PS=0.91U PD=1.8U
* device instance $2622 r0 *1 66.23,49.515 sky130_fd_pr__pfet_01v8
M$2622 916 911 900 900 sky130_fd_pr__pfet_01v8 L=0.15U W=0.64U AS=0.1664P
+ AD=0.0672P PS=1.8U PD=0.85U
* device instance $2623 r0 *1 66.59,49.515 sky130_fd_pr__pfet_01v8
M$2623 162 877 916 916 sky130_fd_pr__pfet_01v8 L=0.15U W=0.64U AS=0.0672P
+ AD=0.1664P PS=0.85U PD=1.8U
* device instance $2624 r0 *1 69.255,49.405 sky130_fd_pr__pfet_01v8
M$2624 901 899 900 900 sky130_fd_pr__pfet_01v8 L=0.15U W=0.42U AS=0.15985P
+ AD=0.06405P PS=1.265U PD=0.725U
* device instance $2625 r0 *1 69.71,49.405 sky130_fd_pr__pfet_01v8
M$2625 906 898 901 901 sky130_fd_pr__pfet_01v8 L=0.15U W=0.42U AS=0.06405P
+ AD=0.07665P PS=0.725U PD=0.785U
* device instance $2626 r0 *1 70.225,49.405 sky130_fd_pr__pfet_01v8
M$2626 162 902 906 906 sky130_fd_pr__pfet_01v8 L=0.15U W=0.42U AS=0.07665P
+ AD=0.178875P PS=0.785U PD=1.26U
* device instance $2627 r0 *1 67.53,49.515 sky130_fd_pr__pfet_01v8
M$2627 162 1134 877 877 sky130_fd_pr__pfet_01v8 L=0.15U W=0.64U AS=0.1664P
+ AD=0.0928P PS=1.8U PD=0.93U
* device instance $2628 r0 *1 67.97,49.515 sky130_fd_pr__pfet_01v8
M$2628 914 1134 162 162 sky130_fd_pr__pfet_01v8 L=0.15U W=0.64U AS=0.0928P
+ AD=0.1152P PS=0.93U PD=1U
* device instance $2629 r0 *1 68.48,49.515 sky130_fd_pr__pfet_01v8
M$2629 900 878 914 914 sky130_fd_pr__pfet_01v8 L=0.15U W=0.64U AS=0.1152P
+ AD=0.15985P PS=1U PD=1.265U
* device instance $2630 r0 *1 70.885,49.57 sky130_fd_pr__pfet_01v8
M$2630 902 901 162 162 sky130_fd_pr__pfet_01v8 L=0.15U W=0.75U AS=0.178875P
+ AD=0.195P PS=1.26U PD=2.02U
* device instance $2631 r0 *1 68.175,53.76 sky130_fd_pr__pfet_01v8
M$2631 961 55 162 162 sky130_fd_pr__pfet_01v8 L=0.15U W=0.42U AS=0.15835P
+ AD=0.07665P PS=1.395U PD=0.785U
* device instance $2632 r0 *1 68.69,53.76 sky130_fd_pr__pfet_01v8
M$2632 943 949 961 961 sky130_fd_pr__pfet_01v8 L=0.15U W=0.42U AS=0.07665P
+ AD=0.1932P PS=0.785U PD=1.34U
* device instance $2633 r0 *1 69.76,53.76 sky130_fd_pr__pfet_01v8
M$2633 958 944 943 943 sky130_fd_pr__pfet_01v8 L=0.15U W=0.42U AS=0.1932P
+ AD=0.0441P PS=1.34U PD=0.63U
* device instance $2634 r0 *1 70.12,53.76 sky130_fd_pr__pfet_01v8
M$2634 162 945 958 958 sky130_fd_pr__pfet_01v8 L=0.15U W=0.42U AS=0.0441P
+ AD=0.0693P PS=0.63U PD=0.75U
* device instance $2635 r0 *1 70.6,53.76 sky130_fd_pr__pfet_01v8
M$2635 945 55 162 162 sky130_fd_pr__pfet_01v8 L=0.15U W=0.42U AS=0.0693P
+ AD=0.1176P PS=0.75U PD=1.4U
* device instance $2636 r0 *1 67.63,53.665 sky130_fd_pr__pfet_01v8
M$2636 162 943 911 911 sky130_fd_pr__pfet_01v8 L=0.15U W=1U AS=0.26P
+ AD=0.15835P PS=2.52U PD=1.395U
* device instance $2637 r0 *1 71.825,49.405 sky130_fd_pr__pfet_01v8
M$2637 905 902 162 162 sky130_fd_pr__pfet_01v8 L=0.15U W=0.42U AS=0.1092P
+ AD=0.06405P PS=1.36U PD=0.725U
* device instance $2638 r0 *1 72.28,49.405 sky130_fd_pr__pfet_01v8
M$2638 903 898 905 905 sky130_fd_pr__pfet_01v8 L=0.15U W=0.42U AS=0.06405P
+ AD=0.0567P PS=0.725U PD=0.69U
* device instance $2639 r0 *1 72.7,49.405 sky130_fd_pr__pfet_01v8
M$2639 904 899 903 903 sky130_fd_pr__pfet_01v8 L=0.15U W=0.42U AS=0.0567P
+ AD=0.0882P PS=0.69U PD=0.84U
* device instance $2640 r0 *1 73.27,49.405 sky130_fd_pr__pfet_01v8
M$2640 162 878 904 904 sky130_fd_pr__pfet_01v8 L=0.15U W=0.42U AS=0.0882P
+ AD=0.1113P PS=0.84U PD=1.37U
* device instance $2641 r0 *1 74.325,49.515 sky130_fd_pr__pfet_01v8
M$2641 162 903 878 878 sky130_fd_pr__pfet_01v8 L=0.15U W=0.64U AS=0.1728P
+ AD=0.154P PS=1.82U PD=1.335U
* device instance $2642 r0 *1 74.81,49.695 sky130_fd_pr__pfet_01v8
M$2642 989 903 162 162 sky130_fd_pr__pfet_01v8 L=0.15U W=1U AS=0.154P AD=0.28P
+ PS=1.335U PD=2.56U
* device instance $2643 r0 *1 2.77,53.815 sky130_fd_pr__pfet_01v8
M$2643 162 939 929 929 sky130_fd_pr__pfet_01v8 L=0.15U W=0.64U AS=0.1664P
+ AD=0.0864P PS=1.8U PD=0.91U
* device instance $2644 r0 *1 3.19,53.815 sky130_fd_pr__pfet_01v8
M$2644 930 929 162 162 sky130_fd_pr__pfet_01v8 L=0.15U W=0.64U AS=0.0864P
+ AD=0.1664P PS=0.91U PD=1.8U
* device instance $2645 r0 *1 4.13,53.845 sky130_fd_pr__pfet_01v8
M$2645 957 891 931 931 sky130_fd_pr__pfet_01v8 L=0.15U W=0.64U AS=0.1664P
+ AD=0.0672P PS=1.8U PD=0.85U
* device instance $2646 r0 *1 4.49,53.845 sky130_fd_pr__pfet_01v8
M$2646 162 946 957 957 sky130_fd_pr__pfet_01v8 L=0.15U W=0.64U AS=0.0672P
+ AD=0.1664P PS=0.85U PD=1.8U
* device instance $2647 r0 *1 5.43,53.845 sky130_fd_pr__pfet_01v8
M$2647 162 88 946 946 sky130_fd_pr__pfet_01v8 L=0.15U W=0.64U AS=0.1664P
+ AD=0.0928P PS=1.8U PD=0.93U
* device instance $2648 r0 *1 5.87,53.845 sky130_fd_pr__pfet_01v8
M$2648 959 88 162 162 sky130_fd_pr__pfet_01v8 L=0.15U W=0.64U AS=0.0928P
+ AD=0.1152P PS=0.93U PD=1U
* device instance $2649 r0 *1 6.38,53.845 sky130_fd_pr__pfet_01v8
M$2649 931 932 959 959 sky130_fd_pr__pfet_01v8 L=0.15U W=0.64U AS=0.1152P
+ AD=0.15985P PS=1U PD=1.265U
* device instance $2650 r0 *1 7.155,53.955 sky130_fd_pr__pfet_01v8
M$2650 933 930 931 931 sky130_fd_pr__pfet_01v8 L=0.15U W=0.42U AS=0.15985P
+ AD=0.06405P PS=1.265U PD=0.725U
* device instance $2651 r0 *1 7.61,53.955 sky130_fd_pr__pfet_01v8
M$2651 960 929 933 933 sky130_fd_pr__pfet_01v8 L=0.15U W=0.42U AS=0.06405P
+ AD=0.07665P PS=0.725U PD=0.785U
* device instance $2652 r0 *1 8.125,53.955 sky130_fd_pr__pfet_01v8
M$2652 960 934 162 162 sky130_fd_pr__pfet_01v8 L=0.15U W=0.42U AS=0.178875P
+ AD=0.07665P PS=1.26U PD=0.785U
* device instance $2653 r0 *1 8.785,53.79 sky130_fd_pr__pfet_01v8
M$2653 934 933 162 162 sky130_fd_pr__pfet_01v8 L=0.15U W=0.75U AS=0.178875P
+ AD=0.195P PS=1.26U PD=2.02U
* device instance $2654 r0 *1 9.725,53.955 sky130_fd_pr__pfet_01v8
M$2654 962 934 162 162 sky130_fd_pr__pfet_01v8 L=0.15U W=0.42U AS=0.1092P
+ AD=0.06405P PS=1.36U PD=0.725U
* device instance $2655 r0 *1 10.18,53.955 sky130_fd_pr__pfet_01v8
M$2655 935 929 962 962 sky130_fd_pr__pfet_01v8 L=0.15U W=0.42U AS=0.06405P
+ AD=0.0567P PS=0.725U PD=0.69U
* device instance $2656 r0 *1 10.6,53.955 sky130_fd_pr__pfet_01v8
M$2656 963 930 935 935 sky130_fd_pr__pfet_01v8 L=0.15U W=0.42U AS=0.0567P
+ AD=0.0882P PS=0.69U PD=0.84U
* device instance $2657 r0 *1 11.17,53.955 sky130_fd_pr__pfet_01v8
M$2657 162 932 963 963 sky130_fd_pr__pfet_01v8 L=0.15U W=0.42U AS=0.0882P
+ AD=0.1113P PS=0.84U PD=1.37U
* device instance $2658 r0 *1 10.57,54.955 sky130_fd_pr__pfet_01v8
M$2658 991 873 968 968 sky130_fd_pr__pfet_01v8 L=0.15U W=0.64U AS=0.1664P
+ AD=0.0672P PS=1.8U PD=0.85U
* device instance $2659 r0 *1 10.93,54.955 sky130_fd_pr__pfet_01v8
M$2659 162 969 991 991 sky130_fd_pr__pfet_01v8 L=0.15U W=0.64U AS=0.0672P
+ AD=0.1664P PS=0.85U PD=1.8U
* device instance $2660 r0 *1 13.595,54.845 sky130_fd_pr__pfet_01v8
M$2660 970 967 968 968 sky130_fd_pr__pfet_01v8 L=0.15U W=0.42U AS=0.15985P
+ AD=0.06405P PS=1.265U PD=0.725U
* device instance $2661 r0 *1 14.05,54.845 sky130_fd_pr__pfet_01v8
M$2661 994 966 970 970 sky130_fd_pr__pfet_01v8 L=0.15U W=0.42U AS=0.06405P
+ AD=0.07665P PS=0.725U PD=0.785U
* device instance $2662 r0 *1 14.565,54.845 sky130_fd_pr__pfet_01v8
M$2662 162 971 994 994 sky130_fd_pr__pfet_01v8 L=0.15U W=0.42U AS=0.07665P
+ AD=0.178875P PS=0.785U PD=1.26U
* device instance $2663 r0 *1 11.87,54.955 sky130_fd_pr__pfet_01v8
M$2663 162 311 969 969 sky130_fd_pr__pfet_01v8 L=0.15U W=0.64U AS=0.1664P
+ AD=0.0928P PS=1.8U PD=0.93U
* device instance $2664 r0 *1 12.31,54.955 sky130_fd_pr__pfet_01v8
M$2664 992 311 162 162 sky130_fd_pr__pfet_01v8 L=0.15U W=0.64U AS=0.0928P
+ AD=0.1152P PS=0.93U PD=1U
* device instance $2665 r0 *1 12.82,54.955 sky130_fd_pr__pfet_01v8
M$2665 968 973 992 992 sky130_fd_pr__pfet_01v8 L=0.15U W=0.64U AS=0.1152P
+ AD=0.15985P PS=1U PD=1.265U
* device instance $2666 r0 *1 15.225,55.01 sky130_fd_pr__pfet_01v8
M$2666 971 970 162 162 sky130_fd_pr__pfet_01v8 L=0.15U W=0.75U AS=0.178875P
+ AD=0.195P PS=1.26U PD=2.02U
* device instance $2667 r0 *1 16.165,54.845 sky130_fd_pr__pfet_01v8
M$2667 995 971 162 162 sky130_fd_pr__pfet_01v8 L=0.15U W=0.42U AS=0.1092P
+ AD=0.06405P PS=1.36U PD=0.725U
* device instance $2668 r0 *1 16.62,54.845 sky130_fd_pr__pfet_01v8
M$2668 972 966 995 995 sky130_fd_pr__pfet_01v8 L=0.15U W=0.42U AS=0.06405P
+ AD=0.0567P PS=0.725U PD=0.69U
* device instance $2669 r0 *1 17.04,54.845 sky130_fd_pr__pfet_01v8
M$2669 996 967 972 972 sky130_fd_pr__pfet_01v8 L=0.15U W=0.42U AS=0.0567P
+ AD=0.0882P PS=0.69U PD=0.84U
* device instance $2670 r0 *1 17.61,54.845 sky130_fd_pr__pfet_01v8
M$2670 162 973 996 996 sky130_fd_pr__pfet_01v8 L=0.15U W=0.42U AS=0.0882P
+ AD=0.1113P PS=0.84U PD=1.37U
* device instance $2671 r0 *1 18.665,54.955 sky130_fd_pr__pfet_01v8
M$2671 162 972 973 973 sky130_fd_pr__pfet_01v8 L=0.15U W=0.64U AS=0.1728P
+ AD=0.154P PS=1.82U PD=1.335U
* device instance $2672 r0 *1 19.15,55.135 sky130_fd_pr__pfet_01v8
M$2672 937 972 162 162 sky130_fd_pr__pfet_01v8 L=0.15U W=1U AS=0.154P AD=0.28P
+ PS=1.335U PD=2.56U
* device instance $2673 r0 *1 28.29,55.135 sky130_fd_pr__pfet_01v8
M$2673 997 986 977 977 sky130_fd_pr__pfet_01v8 L=0.15U W=1U AS=0.26P AD=0.105P
+ PS=2.52U PD=1.21U
* device instance $2674 r0 *1 28.65,55.135 sky130_fd_pr__pfet_01v8
M$2674 162 974 997 997 sky130_fd_pr__pfet_01v8 L=0.15U W=1U AS=0.105P
+ AD=0.1573P PS=1.21U PD=1.39U
* device instance $2675 r0 *1 29.19,55.425 sky130_fd_pr__pfet_01v8
M$2675 986 909 162 162 sky130_fd_pr__pfet_01v8 L=0.15U W=0.42U AS=0.1573P
+ AD=0.1092P PS=1.39U PD=1.36U
* device instance $2676 r0 *1 31.23,55.135 sky130_fd_pr__pfet_01v8
M$2676 976 108 975 975 sky130_fd_pr__pfet_01v8 L=0.15U W=4U AS=0.665P AD=0.54P
+ PS=6.33U PD=5.08U
* device instance $2677 r0 *1 31.65,55.135 sky130_fd_pr__pfet_01v8
M$2677 987 977 976 976 sky130_fd_pr__pfet_01v8 L=0.15U W=4U AS=0.54P AD=0.54P
+ PS=5.08U PD=5.08U
* device instance $2684 r0 *1 34.59,55.135 sky130_fd_pr__pfet_01v8
M$2684 162 978 975 975 sky130_fd_pr__pfet_01v8 L=0.15U W=4U AS=0.54P AD=0.685P
+ PS=5.08U PD=6.37U
* device instance $2688 r0 *1 42.815,55.135 sky130_fd_pr__pfet_01v8
M$2688 162 856 979 979 sky130_fd_pr__pfet_01v8 L=0.15U W=3U AS=0.545P AD=0.545P
+ PS=5.09U PD=5.09U
* device instance $2691 r0 *1 44.635,55.135 sky130_fd_pr__pfet_01v8
M$2691 980 310 162 162 sky130_fd_pr__pfet_01v8 L=0.15U W=4U AS=0.685P AD=0.56P
+ PS=6.37U PD=5.12U
* device instance $2695 r0 *1 46.355,55.135 sky130_fd_pr__pfet_01v8
M$2695 856 980 162 162 sky130_fd_pr__pfet_01v8 L=0.15U W=16U AS=2.2375P
+ AD=2.3625P PS=20.475U PD=21.725U
* device instance $2711 r0 *1 59.405,54.955 sky130_fd_pr__pfet_01v8
M$2711 998 803 162 162 sky130_fd_pr__pfet_01v8 L=0.15U W=0.64U AS=0.1696P
+ AD=0.0768P PS=1.81U PD=0.88U
* device instance $2712 r0 *1 59.795,54.955 sky130_fd_pr__pfet_01v8
M$2712 981 948 998 998 sky130_fd_pr__pfet_01v8 L=0.15U W=0.64U AS=0.0768P
+ AD=0.0896P PS=0.88U PD=0.92U
* device instance $2713 r0 *1 60.225,54.955 sky130_fd_pr__pfet_01v8
M$2713 162 982 981 981 sky130_fd_pr__pfet_01v8 L=0.15U W=0.64U AS=0.0896P
+ AD=0.1824P PS=0.92U PD=1.85U
* device instance $2714 r0 *1 62.115,55.135 sky130_fd_pr__pfet_01v8
M$2714 983 941 162 162 sky130_fd_pr__pfet_01v8 L=0.15U W=1U AS=0.265P AD=0.14P
+ PS=2.53U PD=1.28U
* device instance $2715 r0 *1 62.545,55.135 sky130_fd_pr__pfet_01v8
M$2715 162 981 983 983 sky130_fd_pr__pfet_01v8 L=0.15U W=1U AS=0.14P AD=0.1775P
+ PS=1.28U PD=1.355U
* device instance $2716 r0 *1 63.05,55.135 sky130_fd_pr__pfet_01v8
M$2716 984 983 162 162 sky130_fd_pr__pfet_01v8 L=0.15U W=4U AS=0.5975P
+ AD=0.705P PS=5.195U PD=6.41U
* device instance $2720 r0 *1 65.35,55.055 sky130_fd_pr__pfet_01v8
M$2720 982 985 162 162 sky130_fd_pr__pfet_01v8 L=0.15U W=1.68U AS=0.3486P
+ AD=0.3318P PS=3.35U PD=3.31U
* device instance $2722 r0 *1 67.165,55.135 sky130_fd_pr__pfet_01v8
M$2722 1000 988 162 162 sky130_fd_pr__pfet_01v8 L=0.15U W=1U AS=0.265P
+ AD=0.135P PS=2.53U PD=1.27U
* device instance $2723 r0 *1 67.585,55.135 sky130_fd_pr__pfet_01v8
M$2723 162 949 1000 1000 sky130_fd_pr__pfet_01v8 L=0.15U W=1U AS=0.135P
+ AD=0.14575P PS=1.27U PD=1.335U
* device instance $2724 r0 *1 68.07,55.425 sky130_fd_pr__pfet_01v8
M$2724 988 989 162 162 sky130_fd_pr__pfet_01v8 L=0.15U W=0.42U AS=0.14575P
+ AD=0.1092P PS=1.335U PD=1.36U
* device instance $2725 r0 *1 69.11,55.135 sky130_fd_pr__pfet_01v8
M$2725 985 990 162 162 sky130_fd_pr__pfet_01v8 L=0.15U W=1U AS=0.36P AD=0.165P
+ PS=2.72U PD=1.33U
* device instance $2726 r0 *1 69.59,55.135 sky130_fd_pr__pfet_01v8
M$2726 993 949 985 985 sky130_fd_pr__pfet_01v8 L=0.15U W=1U AS=0.165P AD=0.105P
+ PS=1.33U PD=1.21U
* device instance $2727 r0 *1 69.95,55.135 sky130_fd_pr__pfet_01v8
M$2727 162 989 993 993 sky130_fd_pr__pfet_01v8 L=0.15U W=1U AS=0.105P AD=0.365P
+ PS=1.21U PD=1.73U
* device instance $2728 r0 *1 70.83,55.135 sky130_fd_pr__pfet_01v8
M$2728 990 989 162 162 sky130_fd_pr__pfet_01v8 L=0.15U W=1U AS=0.365P AD=0.135P
+ PS=1.73U PD=1.27U
* device instance $2729 r0 *1 71.25,55.135 sky130_fd_pr__pfet_01v8
M$2729 162 949 990 990 sky130_fd_pr__pfet_01v8 L=0.15U W=1U AS=0.135P AD=0.3P
+ PS=1.27U PD=2.6U
* device instance $2730 r0 *1 9.21,54.985 sky130_fd_pr__pfet_01v8
M$2730 162 939 966 966 sky130_fd_pr__pfet_01v8 L=0.15U W=0.64U AS=0.1664P
+ AD=0.0864P PS=1.8U PD=0.91U
* device instance $2731 r0 *1 9.63,54.985 sky130_fd_pr__pfet_01v8
M$2731 967 966 162 162 sky130_fd_pr__pfet_01v8 L=0.15U W=0.64U AS=0.0864P
+ AD=0.1664P PS=0.91U PD=1.8U
* device instance $2732 r0 *1 11.03,60.285 sky130_fd_pr__pfet_01v8
M$2732 1042 1081 162 162 sky130_fd_pr__pfet_01v8 L=0.15U W=0.42U AS=0.1092P
+ AD=0.0672P PS=1.36U PD=0.74U
* device instance $2733 r0 *1 11.5,60.285 sky130_fd_pr__pfet_01v8
M$2733 1044 1043 1042 1042 sky130_fd_pr__pfet_01v8 L=0.15U W=0.42U AS=0.0672P
+ AD=0.06615P PS=0.74U PD=0.735U
* device instance $2734 r0 *1 11.965,60.285 sky130_fd_pr__pfet_01v8
M$2734 1072 1041 1044 1044 sky130_fd_pr__pfet_01v8 L=0.15U W=0.42U AS=0.06615P
+ AD=0.0693P PS=0.735U PD=0.75U
* device instance $2735 r0 *1 12.445,60.285 sky130_fd_pr__pfet_01v8
M$2735 162 1045 1072 1072 sky130_fd_pr__pfet_01v8 L=0.15U W=0.42U AS=0.0693P
+ AD=0.178875P PS=0.75U PD=1.26U
* device instance $2736 r0 *1 13.58,60.285 sky130_fd_pr__pfet_01v8
M$2736 1061 1041 1045 1045 sky130_fd_pr__pfet_01v8 L=0.15U W=0.42U AS=0.1095P
+ AD=0.0567P PS=1.075U PD=0.69U
* device instance $2737 r0 *1 14,60.285 sky130_fd_pr__pfet_01v8
M$2737 1073 1043 1061 1061 sky130_fd_pr__pfet_01v8 L=0.15U W=0.42U AS=0.0567P
+ AD=0.09135P PS=0.69U PD=0.855U
* device instance $2738 r0 *1 14.585,60.285 sky130_fd_pr__pfet_01v8
M$2738 162 1046 1073 1073 sky130_fd_pr__pfet_01v8 L=0.15U W=0.42U AS=0.09135P
+ AD=0.1218P PS=0.855U PD=1.42U
* device instance $2739 r0 *1 13.105,60.45 sky130_fd_pr__pfet_01v8
M$2739 1045 1044 162 162 sky130_fd_pr__pfet_01v8 L=0.15U W=0.75U AS=0.178875P
+ AD=0.1095P PS=1.26U PD=1.075U
* device instance $2740 r0 *1 15.665,60.575 sky130_fd_pr__pfet_01v8
M$2740 162 1061 1046 1046 sky130_fd_pr__pfet_01v8 L=0.15U W=1U AS=0.28P
+ AD=0.1625P PS=2.56U PD=1.325U
* device instance $2741 r0 *1 16.14,60.575 sky130_fd_pr__pfet_01v8
M$2741 55 1046 162 162 sky130_fd_pr__pfet_01v8 L=0.15U W=4U AS=0.575P
+ AD=0.6925P PS=5.15U PD=6.385U
* device instance $2745 r0 *1 20.73,60.575 sky130_fd_pr__pfet_01v8
M$2745 162 1102 1047 1047 sky130_fd_pr__pfet_01v8 L=0.15U W=4U AS=0.685P
+ AD=0.54P PS=6.37U PD=5.08U
* device instance $2749 r0 *1 22.41,60.575 sky130_fd_pr__pfet_01v8
M$2749 1062 1010 1047 1047 sky130_fd_pr__pfet_01v8 L=0.15U W=4U AS=0.54P
+ AD=0.675P PS=5.08U PD=6.35U
* device instance $2753 r0 *1 24.84,60.575 sky130_fd_pr__pfet_01v8
M$2753 88 1048 162 162 sky130_fd_pr__pfet_01v8 L=0.15U W=8U AS=1.205P AD=1.08P
+ PS=11.41U PD=10.16U
* device instance $2761 r0 *1 28.2,60.575 sky130_fd_pr__pfet_01v8
M$2761 1048 1062 162 162 sky130_fd_pr__pfet_01v8 L=0.15U W=3U AS=0.405P
+ AD=0.53P PS=3.81U PD=5.06U
* device instance $2764 r0 *1 24.87,59.105 sky130_fd_pr__pfet_01v8
M$2764 162 55 1024 1024 sky130_fd_pr__pfet_01v8 L=0.15U W=2U AS=0.415P AD=0.27P
+ PS=3.83U PD=2.54U
* device instance $2766 r0 *1 25.71,59.105 sky130_fd_pr__pfet_01v8
M$2766 1034 977 1024 1024 sky130_fd_pr__pfet_01v8 L=0.15U W=2U AS=0.27P
+ AD=0.415P PS=2.54U PD=3.83U
* device instance $2768 r0 *1 27.09,59.105 sky130_fd_pr__pfet_01v8
M$2768 1010 1025 1034 1034 sky130_fd_pr__pfet_01v8 L=0.15U W=2U AS=0.395P
+ AD=0.395P PS=3.79U PD=3.79U
* device instance $2770 r0 *1 28.73,59.105 sky130_fd_pr__pfet_01v8
M$2770 162 977 1026 1026 sky130_fd_pr__pfet_01v8 L=0.15U W=2U AS=0.415P
+ AD=0.27P PS=3.83U PD=2.54U
* device instance $2772 r0 *1 29.57,59.105 sky130_fd_pr__pfet_01v8
M$2772 1012 1025 1026 1026 sky130_fd_pr__pfet_01v8 L=0.15U W=2U AS=0.27P
+ AD=0.395P PS=2.54U PD=3.79U
* device instance $2774 r0 *1 30.93,59.105 sky130_fd_pr__pfet_01v8
M$2774 1012 1013 162 162 sky130_fd_pr__pfet_01v8 L=0.15U W=2U AS=0.395P
+ AD=0.27P PS=3.79U PD=2.54U
* device instance $2776 r0 *1 31.77,59.105 sky130_fd_pr__pfet_01v8
M$2776 129 1012 162 162 sky130_fd_pr__pfet_01v8 L=0.15U W=4U AS=0.54P AD=0.54P
+ PS=5.08U PD=5.08U
* device instance $2780 r0 *1 33.45,59.105 sky130_fd_pr__pfet_01v8
M$2780 1013 108 162 162 sky130_fd_pr__pfet_01v8 L=0.15U W=1U AS=0.135P AD=0.38P
+ PS=1.27U PD=2.76U
* device instance $2781 r0 *1 32.21,60.575 sky130_fd_pr__pfet_01v8
M$2781 1077 977 1049 1049 sky130_fd_pr__pfet_01v8 L=0.15U W=1U AS=0.26P
+ AD=0.105P PS=2.52U PD=1.21U
* device instance $2782 r0 *1 32.57,60.575 sky130_fd_pr__pfet_01v8
M$2782 162 1063 1077 1077 sky130_fd_pr__pfet_01v8 L=0.15U W=1U AS=0.105P
+ AD=0.26P PS=1.21U PD=2.52U
* device instance $2783 r0 *1 33.83,60.865 sky130_fd_pr__pfet_01v8
M$2783 1064 974 162 162 sky130_fd_pr__pfet_01v8 L=0.15U W=0.42U AS=0.1573P
+ AD=0.1092P PS=1.39U PD=1.36U
* device instance $2784 r0 *1 34.37,60.575 sky130_fd_pr__pfet_01v8
M$2784 1079 909 162 162 sky130_fd_pr__pfet_01v8 L=0.15U W=1U AS=0.1573P
+ AD=0.105P PS=1.39U PD=1.21U
* device instance $2785 r0 *1 34.73,60.575 sky130_fd_pr__pfet_01v8
M$2785 1063 1064 1079 1079 sky130_fd_pr__pfet_01v8 L=0.15U W=1U AS=0.105P
+ AD=0.26P PS=1.21U PD=2.52U
* device instance $2786 r0 *1 34.97,59.105 sky130_fd_pr__pfet_01v8
M$2786 162 978 1014 1014 sky130_fd_pr__pfet_01v8 L=0.15U W=1U AS=0.26P
+ AD=0.135P PS=2.52U PD=1.27U
* device instance $2787 r0 *1 35.39,59.105 sky130_fd_pr__pfet_01v8
M$2787 1025 1014 162 162 sky130_fd_pr__pfet_01v8 L=0.15U W=4U AS=0.54P AD=0.71P
+ PS=5.08U PD=5.42U
* device instance $2791 r0 *1 37.41,59.105 sky130_fd_pr__pfet_01v8
M$2791 1015 987 162 162 sky130_fd_pr__pfet_01v8 L=0.15U W=2U AS=0.44P AD=0.27P
+ PS=2.88U PD=2.54U
* device instance $2793 r0 *1 38.25,59.105 sky130_fd_pr__pfet_01v8
M$2793 130 1015 162 162 sky130_fd_pr__pfet_01v8 L=0.15U W=6U AS=0.81P AD=0.935P
+ PS=7.62U PD=8.87U
* device instance $2799 r0 *1 40.03,60.575 sky130_fd_pr__pfet_01v8
M$2799 1066 1065 1050 1050 sky130_fd_pr__pfet_01v8 L=0.15U W=2U AS=0.395P
+ AD=0.395P PS=3.79U PD=2.79U
* device instance $2801 r0 *1 41.12,60.575 sky130_fd_pr__pfet_01v8
M$2801 1067 1063 1050 1050 sky130_fd_pr__pfet_01v8 L=0.15U W=2U AS=0.395P
+ AD=0.395P PS=2.79U PD=3.79U
* device instance $2803 r0 *1 42.41,59.105 sky130_fd_pr__pfet_01v8
M$2803 1040 1027 162 162 sky130_fd_pr__pfet_01v8 L=0.15U W=1U AS=0.26P
+ AD=0.105P PS=2.52U PD=1.21U
* device instance $2804 r0 *1 42.77,59.105 sky130_fd_pr__pfet_01v8
M$2804 1016 1017 1040 1040 sky130_fd_pr__pfet_01v8 L=0.15U W=1U AS=0.105P
+ AD=0.26P PS=1.21U PD=2.52U
* device instance $2805 r0 *1 42.48,60.575 sky130_fd_pr__pfet_01v8
M$2805 1067 1083 162 162 sky130_fd_pr__pfet_01v8 L=0.15U W=2U AS=0.395P
+ AD=0.28P PS=3.79U PD=2.56U
* device instance $2807 r0 *1 43.34,60.575 sky130_fd_pr__pfet_01v8
M$2807 1067 1033 162 162 sky130_fd_pr__pfet_01v8 L=0.15U W=2U AS=0.285P
+ AD=0.275P PS=2.57U PD=2.55U
* device instance $2809 r0 *1 44.19,60.575 sky130_fd_pr__pfet_01v8
M$2809 1067 1069 162 162 sky130_fd_pr__pfet_01v8 L=0.15U W=2U AS=0.27P
+ AD=0.395P PS=2.54U PD=3.79U
* device instance $2811 r0 *1 45.57,60.575 sky130_fd_pr__pfet_01v8
M$2811 1051 1083 1027 1027 sky130_fd_pr__pfet_01v8 L=0.15U W=1U AS=0.265P
+ AD=0.14P PS=2.53U PD=1.28U
* device instance $2812 r0 *1 46,60.575 sky130_fd_pr__pfet_01v8
M$2812 162 1069 1051 1051 sky130_fd_pr__pfet_01v8 L=0.15U W=1U AS=0.14P
+ AD=0.1475P PS=1.28U PD=1.295U
* device instance $2813 r0 *1 46.445,60.575 sky130_fd_pr__pfet_01v8
M$2813 1051 1070 162 162 sky130_fd_pr__pfet_01v8 L=0.15U W=1U AS=0.1475P
+ AD=0.265P PS=1.295U PD=2.53U
* device instance $2814 r0 *1 46.01,59.105 sky130_fd_pr__pfet_01v8
M$2814 162 987 1018 1018 sky130_fd_pr__pfet_01v8 L=0.15U W=1U AS=0.26P
+ AD=0.135P PS=2.52U PD=1.27U
* device instance $2815 r0 *1 46.43,59.105 sky130_fd_pr__pfet_01v8
M$2815 1019 1018 162 162 sky130_fd_pr__pfet_01v8 L=0.15U W=4U AS=0.54P
+ AD=0.665P PS=5.08U PD=6.33U
* device instance $2819 r0 *1 47.865,60.85 sky130_fd_pr__pfet_01v8
M$2819 1068 1070 162 162 sky130_fd_pr__pfet_01v8 L=0.15U W=0.42U AS=0.142225P
+ AD=0.06615P PS=1.335U PD=0.735U
* device instance $2820 r0 *1 48.33,60.85 sky130_fd_pr__pfet_01v8
M$2820 162 1069 1068 1068 sky130_fd_pr__pfet_01v8 L=0.15U W=0.42U AS=0.06615P
+ AD=0.0567P PS=0.735U PD=0.69U
* device instance $2821 r0 *1 48.75,60.85 sky130_fd_pr__pfet_01v8
M$2821 1068 1083 162 162 sky130_fd_pr__pfet_01v8 L=0.15U W=0.42U AS=0.0567P
+ AD=0.1092P PS=0.69U PD=1.36U
* device instance $2822 r0 *1 47.39,60.575 sky130_fd_pr__pfet_01v8
M$2822 162 1068 1017 1017 sky130_fd_pr__pfet_01v8 L=0.15U W=1U AS=0.26P
+ AD=0.142225P PS=2.52U PD=1.335U
* device instance $2823 r0 *1 48.7,59.105 sky130_fd_pr__pfet_01v8
M$2823 162 850 1032 1032 sky130_fd_pr__pfet_01v8 L=0.15U W=4U AS=0.685P
+ AD=0.54P PS=6.37U PD=5.08U
* device instance $2827 r0 *1 50.38,59.105 sky130_fd_pr__pfet_01v8
M$2827 1035 803 1032 1032 sky130_fd_pr__pfet_01v8 L=0.15U W=4U AS=0.54P
+ AD=0.665P PS=5.08U PD=6.33U
* device instance $2831 r0 *1 49.69,60.575 sky130_fd_pr__pfet_01v8
M$2831 1071 1065 1052 1052 sky130_fd_pr__pfet_01v8 L=0.15U W=2U AS=0.435P
+ AD=0.355P PS=3.87U PD=2.71U
* device instance $2833 r0 *1 50.7,60.575 sky130_fd_pr__pfet_01v8
M$2833 162 1083 1052 1052 sky130_fd_pr__pfet_01v8 L=0.15U W=2U AS=0.59P
+ AD=0.545P PS=3.18U PD=3.09U
* device instance $2835 r0 *1 52.09,60.575 sky130_fd_pr__pfet_01v8
M$2835 162 1070 1052 1052 sky130_fd_pr__pfet_01v8 L=0.15U W=2U AS=0.27P
+ AD=0.27P PS=2.54U PD=2.54U
* device instance $2837 r0 *1 52.93,60.575 sky130_fd_pr__pfet_01v8
M$2837 162 1069 1052 1052 sky130_fd_pr__pfet_01v8 L=0.15U W=2U AS=0.27P
+ AD=0.395P PS=2.54U PD=3.79U
* device instance $2839 r0 *1 52.58,59.105 sky130_fd_pr__pfet_01v8
M$2839 1035 982 1033 1033 sky130_fd_pr__pfet_01v8 L=0.15U W=4U AS=0.665P
+ AD=0.55P PS=6.33U PD=5.1U
* device instance $2843 r0 *1 54.28,59.105 sky130_fd_pr__pfet_01v8
M$2843 162 1000 1033 1033 sky130_fd_pr__pfet_01v8 L=0.15U W=4U AS=0.55P
+ AD=0.54P PS=5.1U PD=5.08U
* device instance $2847 r0 *1 55.96,59.105 sky130_fd_pr__pfet_01v8
M$2847 162 1022 1033 1033 sky130_fd_pr__pfet_01v8 L=0.15U W=4U AS=0.54P
+ AD=0.665P PS=5.08U PD=6.33U
* device instance $2851 r0 *1 60.27,59.105 sky130_fd_pr__pfet_01v8
M$2851 1036 1028 1023 1023 sky130_fd_pr__pfet_01v8 L=0.15U W=1U AS=0.26P
+ AD=0.135P PS=2.52U PD=1.27U
* device instance $2852 r0 *1 60.69,59.105 sky130_fd_pr__pfet_01v8
M$2852 1037 989 1036 1036 sky130_fd_pr__pfet_01v8 L=0.15U W=1U AS=0.135P
+ AD=0.135P PS=1.27U PD=1.27U
* device instance $2853 r0 *1 61.11,59.105 sky130_fd_pr__pfet_01v8
M$2853 1036 129 1037 1037 sky130_fd_pr__pfet_01v8 L=0.15U W=1U AS=0.135P
+ AD=0.26P PS=1.27U PD=2.52U
* device instance $2854 r0 *1 62.05,59.105 sky130_fd_pr__pfet_01v8
M$2854 1037 1019 162 162 sky130_fd_pr__pfet_01v8 L=0.15U W=1U AS=0.26P
+ AD=0.165P PS=2.52U PD=1.33U
* device instance $2855 r0 *1 62.53,59.105 sky130_fd_pr__pfet_01v8
M$2855 162 984 1037 1037 sky130_fd_pr__pfet_01v8 L=0.15U W=1U AS=0.165P
+ AD=0.1575P PS=1.33U PD=1.315U
* device instance $2856 r0 *1 62.995,59.105 sky130_fd_pr__pfet_01v8
M$2856 1038 1023 162 162 sky130_fd_pr__pfet_01v8 L=0.15U W=1U AS=0.1575P
+ AD=0.26P PS=1.315U PD=2.52U
* device instance $2857 r0 *1 63.97,59.105 sky130_fd_pr__pfet_01v8
M$2857 1039 941 162 162 sky130_fd_pr__pfet_01v8 L=0.15U W=1U AS=0.26P AD=0.135P
+ PS=2.52U PD=1.27U
* device instance $2858 r0 *1 64.39,59.105 sky130_fd_pr__pfet_01v8
M$2858 162 1000 1039 1039 sky130_fd_pr__pfet_01v8 L=0.15U W=1U AS=0.135P
+ AD=0.26P PS=1.27U PD=2.52U
* device instance $2859 r0 *1 64.85,60.395 sky130_fd_pr__pfet_01v8
M$2859 1080 1038 1055 1055 sky130_fd_pr__pfet_01v8 L=0.15U W=0.64U AS=0.1664P
+ AD=0.0672P PS=1.8U PD=0.85U
* device instance $2860 r0 *1 65.21,60.395 sky130_fd_pr__pfet_01v8
M$2860 162 1056 1080 1080 sky130_fd_pr__pfet_01v8 L=0.15U W=0.64U AS=0.0672P
+ AD=0.1664P PS=0.85U PD=1.8U
* device instance $2861 r0 *1 67.875,60.285 sky130_fd_pr__pfet_01v8
M$2861 1057 1054 1055 1055 sky130_fd_pr__pfet_01v8 L=0.15U W=0.42U AS=0.15985P
+ AD=0.06405P PS=1.265U PD=0.725U
* device instance $2862 r0 *1 68.33,60.285 sky130_fd_pr__pfet_01v8
M$2862 1076 1053 1057 1057 sky130_fd_pr__pfet_01v8 L=0.15U W=0.42U AS=0.06405P
+ AD=0.07665P PS=0.725U PD=0.785U
* device instance $2863 r0 *1 68.845,60.285 sky130_fd_pr__pfet_01v8
M$2863 162 1058 1076 1076 sky130_fd_pr__pfet_01v8 L=0.15U W=0.42U AS=0.07665P
+ AD=0.178875P PS=0.785U PD=1.26U
* device instance $2864 r0 *1 66.15,60.395 sky130_fd_pr__pfet_01v8
M$2864 162 311 1056 1056 sky130_fd_pr__pfet_01v8 L=0.15U W=0.64U AS=0.1664P
+ AD=0.0928P PS=1.8U PD=0.93U
* device instance $2865 r0 *1 66.59,60.395 sky130_fd_pr__pfet_01v8
M$2865 1078 311 162 162 sky130_fd_pr__pfet_01v8 L=0.15U W=0.64U AS=0.0928P
+ AD=0.1152P PS=0.93U PD=1U
* device instance $2866 r0 *1 67.1,60.395 sky130_fd_pr__pfet_01v8
M$2866 1055 1060 1078 1078 sky130_fd_pr__pfet_01v8 L=0.15U W=0.64U AS=0.1152P
+ AD=0.15985P PS=1U PD=1.265U
* device instance $2867 r0 *1 69.505,60.45 sky130_fd_pr__pfet_01v8
M$2867 1058 1057 162 162 sky130_fd_pr__pfet_01v8 L=0.15U W=0.75U AS=0.178875P
+ AD=0.195P PS=1.26U PD=2.02U
* device instance $2868 r0 *1 70.445,60.285 sky130_fd_pr__pfet_01v8
M$2868 1075 1058 162 162 sky130_fd_pr__pfet_01v8 L=0.15U W=0.42U AS=0.1092P
+ AD=0.06405P PS=1.36U PD=0.725U
* device instance $2869 r0 *1 70.9,60.285 sky130_fd_pr__pfet_01v8
M$2869 1059 1053 1075 1075 sky130_fd_pr__pfet_01v8 L=0.15U W=0.42U AS=0.06405P
+ AD=0.0567P PS=0.725U PD=0.69U
* device instance $2870 r0 *1 71.32,60.285 sky130_fd_pr__pfet_01v8
M$2870 1074 1054 1059 1059 sky130_fd_pr__pfet_01v8 L=0.15U W=0.42U AS=0.0567P
+ AD=0.0882P PS=0.69U PD=0.84U
* device instance $2871 r0 *1 71.89,60.285 sky130_fd_pr__pfet_01v8
M$2871 162 1060 1074 1074 sky130_fd_pr__pfet_01v8 L=0.15U W=0.42U AS=0.0882P
+ AD=0.1113P PS=0.84U PD=1.37U
* device instance $2872 r0 *1 72.945,60.395 sky130_fd_pr__pfet_01v8
M$2872 162 1059 1060 1060 sky130_fd_pr__pfet_01v8 L=0.15U W=0.64U AS=0.1728P
+ AD=0.154P PS=1.82U PD=1.335U
* device instance $2873 r0 *1 73.43,60.575 sky130_fd_pr__pfet_01v8
M$2873 949 1059 162 162 sky130_fd_pr__pfet_01v8 L=0.15U W=1U AS=0.154P AD=0.28P
+ PS=1.335U PD=2.56U
* device instance $2874 r0 *1 7.83,64.625 sky130_fd_pr__pfet_01v8
M$2874 1097 1118 162 162 sky130_fd_pr__pfet_01v8 L=0.15U W=1.68U AS=0.3318P
+ AD=0.3486P PS=3.31U PD=3.35U
* device instance $2876 r0 *1 9.21,64.545 sky130_fd_pr__pfet_01v8
M$2876 1136 1135 162 162 sky130_fd_pr__pfet_01v8 L=0.15U W=1U AS=0.26P
+ AD=0.1125P PS=2.52U PD=1.225U
* device instance $2877 r0 *1 9.585,64.545 sky130_fd_pr__pfet_01v8
M$2877 1099 1118 1136 1136 sky130_fd_pr__pfet_01v8 L=0.15U W=1U AS=0.1125P
+ AD=0.2325P PS=1.225U PD=1.465U
* device instance $2878 r0 *1 10.2,64.545 sky130_fd_pr__pfet_01v8
M$2878 1137 1100 1099 1099 sky130_fd_pr__pfet_01v8 L=0.15U W=1U AS=0.2325P
+ AD=0.105P PS=1.465U PD=1.21U
* device instance $2879 r0 *1 10.56,64.545 sky130_fd_pr__pfet_01v8
M$2879 162 894 1137 1137 sky130_fd_pr__pfet_01v8 L=0.15U W=1U AS=0.105P
+ AD=0.27P PS=1.21U PD=2.54U
* device instance $2880 r0 *1 9.67,60.425 sky130_fd_pr__pfet_01v8
M$2880 162 939 1041 1041 sky130_fd_pr__pfet_01v8 L=0.15U W=0.64U AS=0.1664P
+ AD=0.0864P PS=1.8U PD=0.91U
* device instance $2881 r0 *1 10.09,60.425 sky130_fd_pr__pfet_01v8
M$2881 1043 1041 162 162 sky130_fd_pr__pfet_01v8 L=0.15U W=0.64U AS=0.0864P
+ AD=0.1664P PS=0.91U PD=1.8U
* device instance $2882 r0 *1 11.53,64.545 sky130_fd_pr__pfet_01v8
M$2882 108 1119 162 162 sky130_fd_pr__pfet_01v8 L=0.15U W=1U AS=0.26P AD=0.135P
+ PS=2.52U PD=1.27U
* device instance $2883 r0 *1 11.95,64.545 sky130_fd_pr__pfet_01v8
M$2883 162 1101 108 108 sky130_fd_pr__pfet_01v8 L=0.15U W=1U AS=0.135P AD=0.26P
+ PS=1.27U PD=2.52U
* device instance $2884 r0 *1 12.91,64.625 sky130_fd_pr__pfet_01v8
M$2884 1101 55 162 162 sky130_fd_pr__pfet_01v8 L=0.15U W=1.68U AS=0.3486P
+ AD=0.3318P PS=3.35U PD=3.31U
* device instance $2886 r0 *1 17.05,64.545 sky130_fd_pr__pfet_01v8
M$2886 162 1119 1133 1133 sky130_fd_pr__pfet_01v8 L=0.15U W=4U AS=0.685P
+ AD=0.54P PS=6.37U PD=5.08U
* device instance $2890 r0 *1 18.73,64.545 sky130_fd_pr__pfet_01v8
M$2890 1102 55 1133 1133 sky130_fd_pr__pfet_01v8 L=0.15U W=4U AS=0.54P
+ AD=0.675P PS=5.08U PD=6.35U
* device instance $2894 r0 *1 22.255,64.545 sky130_fd_pr__pfet_01v8
M$2894 311 1102 162 162 sky130_fd_pr__pfet_01v8 L=0.15U W=8U AS=1.205P AD=1.42P
+ PS=11.41U PD=10.84U
* device instance $2902 r0 *1 26.295,64.545 sky130_fd_pr__pfet_01v8
M$2902 1103 1062 162 162 sky130_fd_pr__pfet_01v8 L=0.15U W=2U AS=0.61P AD=0.27P
+ PS=3.22U PD=2.54U
* device instance $2904 r0 *1 27.135,64.545 sky130_fd_pr__pfet_01v8
M$2904 1134 1103 162 162 sky130_fd_pr__pfet_01v8 L=0.15U W=6U AS=0.81P
+ AD=0.935P PS=7.62U PD=8.87U
* device instance $2910 r0 *1 30.37,64.695 sky130_fd_pr__pfet_01v8
M$2910 162 939 1104 1104 sky130_fd_pr__pfet_01v8 L=0.15U W=0.64U AS=0.1664P
+ AD=0.0864P PS=1.8U PD=0.91U
* device instance $2911 r0 *1 30.79,64.695 sky130_fd_pr__pfet_01v8
M$2911 1105 1104 162 162 sky130_fd_pr__pfet_01v8 L=0.15U W=0.64U AS=0.0864P
+ AD=0.1664P PS=0.91U PD=1.8U
* device instance $2912 r0 *1 31.73,64.725 sky130_fd_pr__pfet_01v8
M$2912 1138 1120 1106 1106 sky130_fd_pr__pfet_01v8 L=0.15U W=0.64U AS=0.1664P
+ AD=0.0672P PS=1.8U PD=0.85U
* device instance $2913 r0 *1 32.09,64.725 sky130_fd_pr__pfet_01v8
M$2913 162 1107 1138 1138 sky130_fd_pr__pfet_01v8 L=0.15U W=0.64U AS=0.0672P
+ AD=0.1664P PS=0.85U PD=1.8U
* device instance $2914 r0 *1 33.03,64.725 sky130_fd_pr__pfet_01v8
M$2914 162 311 1107 1107 sky130_fd_pr__pfet_01v8 L=0.15U W=0.64U AS=0.1664P
+ AD=0.0928P PS=1.8U PD=0.93U
* device instance $2915 r0 *1 33.47,64.725 sky130_fd_pr__pfet_01v8
M$2915 1139 311 162 162 sky130_fd_pr__pfet_01v8 L=0.15U W=0.64U AS=0.0928P
+ AD=0.1152P PS=0.93U PD=1U
* device instance $2916 r0 *1 33.98,64.725 sky130_fd_pr__pfet_01v8
M$2916 1106 1121 1139 1139 sky130_fd_pr__pfet_01v8 L=0.15U W=0.64U AS=0.1152P
+ AD=0.15985P PS=1U PD=1.265U
* device instance $2917 r0 *1 34.755,64.835 sky130_fd_pr__pfet_01v8
M$2917 1108 1105 1106 1106 sky130_fd_pr__pfet_01v8 L=0.15U W=0.42U AS=0.15985P
+ AD=0.06405P PS=1.265U PD=0.725U
* device instance $2918 r0 *1 35.21,64.835 sky130_fd_pr__pfet_01v8
M$2918 1140 1104 1108 1108 sky130_fd_pr__pfet_01v8 L=0.15U W=0.42U AS=0.06405P
+ AD=0.07665P PS=0.725U PD=0.785U
* device instance $2919 r0 *1 35.725,64.835 sky130_fd_pr__pfet_01v8
M$2919 1140 1109 162 162 sky130_fd_pr__pfet_01v8 L=0.15U W=0.42U AS=0.178875P
+ AD=0.07665P PS=1.26U PD=0.785U
* device instance $2920 r0 *1 36.385,64.67 sky130_fd_pr__pfet_01v8
M$2920 1109 1108 162 162 sky130_fd_pr__pfet_01v8 L=0.15U W=0.75U AS=0.178875P
+ AD=0.195P PS=1.26U PD=2.02U
* device instance $2921 r0 *1 39.825,64.725 sky130_fd_pr__pfet_01v8
M$2921 1121 1110 162 162 sky130_fd_pr__pfet_01v8 L=0.15U W=0.64U AS=0.154P
+ AD=0.1728P PS=1.335U PD=1.82U
* device instance $2922 r0 *1 40.31,64.545 sky130_fd_pr__pfet_01v8
M$2922 974 1110 162 162 sky130_fd_pr__pfet_01v8 L=0.15U W=1U AS=0.154P AD=0.28P
+ PS=1.335U PD=2.56U
* device instance $2923 r0 *1 41.41,64.545 sky130_fd_pr__pfet_01v8
M$2923 162 1066 1111 1111 sky130_fd_pr__pfet_01v8 L=0.15U W=1U AS=0.26P
+ AD=0.135P PS=2.52U PD=1.27U
* device instance $2924 r0 *1 41.83,64.545 sky130_fd_pr__pfet_01v8
M$2924 978 1111 162 162 sky130_fd_pr__pfet_01v8 L=0.15U W=4U AS=0.54P AD=0.665P
+ PS=5.08U PD=6.33U
* device instance $2928 r0 *1 45.65,64.545 sky130_fd_pr__pfet_01v8
M$2928 1083 1112 162 162 sky130_fd_pr__pfet_01v8 L=0.15U W=1U AS=0.36P
+ AD=0.165P PS=2.72U PD=1.33U
* device instance $2929 r0 *1 46.13,64.545 sky130_fd_pr__pfet_01v8
M$2929 1144 694 1083 1083 sky130_fd_pr__pfet_01v8 L=0.15U W=1U AS=0.165P
+ AD=0.105P PS=1.33U PD=1.21U
* device instance $2930 r0 *1 46.49,64.545 sky130_fd_pr__pfet_01v8
M$2930 162 1122 1144 1144 sky130_fd_pr__pfet_01v8 L=0.15U W=1U AS=0.105P
+ AD=0.365P PS=1.21U PD=1.73U
* device instance $2931 r0 *1 47.37,64.545 sky130_fd_pr__pfet_01v8
M$2931 1112 1122 162 162 sky130_fd_pr__pfet_01v8 L=0.15U W=1U AS=0.365P
+ AD=0.135P PS=1.73U PD=1.27U
* device instance $2932 r0 *1 47.79,64.545 sky130_fd_pr__pfet_01v8
M$2932 162 694 1112 1112 sky130_fd_pr__pfet_01v8 L=0.15U W=1U AS=0.135P
+ AD=0.41P PS=1.27U PD=1.82U
* device instance $2933 r0 *1 48.76,64.545 sky130_fd_pr__pfet_01v8
M$2933 1070 1114 162 162 sky130_fd_pr__pfet_01v8 L=0.15U W=4U AS=0.815P
+ AD=0.54P PS=5.63U PD=5.08U
* device instance $2937 r0 *1 50.44,64.545 sky130_fd_pr__pfet_01v8
M$2937 1114 1033 162 162 sky130_fd_pr__pfet_01v8 L=0.15U W=1U AS=0.135P
+ AD=0.26P PS=1.27U PD=2.52U
* device instance $2938 r0 *1 51.77,64.255 sky130_fd_pr__pfet_01v8
M$2938 162 1122 1115 1115 sky130_fd_pr__pfet_01v8 L=0.15U W=0.42U AS=0.1092P
+ AD=0.1573P PS=1.36U PD=1.39U
* device instance $2939 r0 *1 52.31,64.545 sky130_fd_pr__pfet_01v8
M$2939 1141 694 162 162 sky130_fd_pr__pfet_01v8 L=0.15U W=1U AS=0.1573P
+ AD=0.105P PS=1.39U PD=1.21U
* device instance $2940 r0 *1 52.67,64.545 sky130_fd_pr__pfet_01v8
M$2940 1065 1115 1141 1141 sky130_fd_pr__pfet_01v8 L=0.15U W=1U AS=0.105P
+ AD=0.26P PS=1.21U PD=2.52U
* device instance $2941 r0 *1 63.49,60.425 sky130_fd_pr__pfet_01v8
M$2941 162 856 1053 1053 sky130_fd_pr__pfet_01v8 L=0.15U W=0.64U AS=0.1664P
+ AD=0.0864P PS=1.8U PD=0.91U
* device instance $2942 r0 *1 63.91,60.425 sky130_fd_pr__pfet_01v8
M$2942 1054 1053 162 162 sky130_fd_pr__pfet_01v8 L=0.15U W=0.64U AS=0.0864P
+ AD=0.1664P PS=0.91U PD=1.8U
* device instance $2943 r0 *1 64.41,64.255 sky130_fd_pr__pfet_01v8
M$2943 162 1123 1116 1116 sky130_fd_pr__pfet_01v8 L=0.15U W=0.42U AS=0.1092P
+ AD=0.14575P PS=1.36U PD=1.335U
* device instance $2944 r0 *1 64.895,64.545 sky130_fd_pr__pfet_01v8
M$2944 1069 1124 162 162 sky130_fd_pr__pfet_01v8 L=0.15U W=1U AS=0.14575P
+ AD=0.135P PS=1.335U PD=1.27U
* device instance $2945 r0 *1 65.315,64.545 sky130_fd_pr__pfet_01v8
M$2945 162 1116 1069 1069 sky130_fd_pr__pfet_01v8 L=0.15U W=1U AS=0.135P
+ AD=0.595P PS=1.27U PD=2.19U
* device instance $2946 r0 *1 66.655,64.545 sky130_fd_pr__pfet_01v8
M$2946 366 1117 162 162 sky130_fd_pr__pfet_01v8 L=0.15U W=4U AS=1P AD=0.54P
+ PS=6U PD=5.08U
* device instance $2950 r0 *1 68.335,64.545 sky130_fd_pr__pfet_01v8
M$2950 1117 1124 162 162 sky130_fd_pr__pfet_01v8 L=0.15U W=1U AS=0.135P
+ AD=0.26P PS=1.27U PD=2.52U
* device instance $2951 r0 *1 5.09,66.015 sky130_fd_pr__pfet_01v8
M$2951 1135 1145 162 162 sky130_fd_pr__pfet_01v8 L=0.15U W=1U AS=0.26P
+ AD=0.135P PS=2.52U PD=1.27U
* device instance $2952 r0 *1 5.51,66.015 sky130_fd_pr__pfet_01v8
M$2952 162 55 1135 1135 sky130_fd_pr__pfet_01v8 L=0.15U W=1U AS=0.135P AD=0.26P
+ PS=1.27U PD=2.52U
* device instance $2953 r0 *1 8.775,65.835 sky130_fd_pr__pfet_01v8
M$2953 1081 1178 162 162 sky130_fd_pr__pfet_01v8 L=0.15U W=0.64U AS=0.1824P
+ AD=0.0896P PS=1.85U PD=0.92U
* device instance $2954 r0 *1 9.205,65.835 sky130_fd_pr__pfet_01v8
M$2954 1189 1145 1081 1081 sky130_fd_pr__pfet_01v8 L=0.15U W=0.64U AS=0.0896P
+ AD=0.0768P PS=0.92U PD=0.88U
* device instance $2955 r0 *1 9.595,65.835 sky130_fd_pr__pfet_01v8
M$2955 162 1101 1189 1189 sky130_fd_pr__pfet_01v8 L=0.15U W=0.64U AS=0.0768P
+ AD=0.1696P PS=0.88U PD=1.81U
* device instance $2956 r0 *1 10.61,66.015 sky130_fd_pr__pfet_01v8
M$2956 1100 1097 162 162 sky130_fd_pr__pfet_01v8 L=0.15U W=1U AS=0.26P
+ AD=0.135P PS=2.52U PD=1.27U
* device instance $2957 r0 *1 11.03,66.015 sky130_fd_pr__pfet_01v8
M$2957 162 1119 1100 1100 sky130_fd_pr__pfet_01v8 L=0.15U W=1U AS=0.135P
+ AD=0.26P PS=1.27U PD=2.52U
* device instance $2958 r0 *1 12.04,66.015 sky130_fd_pr__pfet_01v8
M$2958 162 1179 1146 1146 sky130_fd_pr__pfet_01v8 L=0.15U W=1U AS=0.33P
+ AD=0.2425P PS=2.66U PD=1.485U
* device instance $2959 r0 *1 12.675,66.015 sky130_fd_pr__pfet_01v8
M$2959 1147 894 162 162 sky130_fd_pr__pfet_01v8 L=0.15U W=1U AS=0.2425P
+ AD=0.165P PS=1.485U PD=1.33U
* device instance $2960 r0 *1 13.155,66.015 sky130_fd_pr__pfet_01v8
M$2960 162 1097 1147 1147 sky130_fd_pr__pfet_01v8 L=0.15U W=1U AS=0.165P
+ AD=0.225P PS=1.33U PD=1.45U
* device instance $2961 r0 *1 13.755,66.015 sky130_fd_pr__pfet_01v8
M$2961 1147 1119 162 162 sky130_fd_pr__pfet_01v8 L=0.15U W=1U AS=0.225P
+ AD=0.185P PS=1.45U PD=1.37U
* device instance $2962 r0 *1 14.275,66.015 sky130_fd_pr__pfet_01v8
M$2962 1179 1178 1147 1147 sky130_fd_pr__pfet_01v8 L=0.15U W=1U AS=0.185P
+ AD=0.14P PS=1.37U PD=1.28U
* device instance $2963 r0 *1 14.705,66.015 sky130_fd_pr__pfet_01v8
M$2963 1147 1148 1179 1179 sky130_fd_pr__pfet_01v8 L=0.15U W=1U AS=0.14P
+ AD=0.265P PS=1.28U PD=2.53U
* device instance $2964 r0 *1 25.24,65.725 sky130_fd_pr__pfet_01v8
M$2964 1151 108 162 162 sky130_fd_pr__pfet_01v8 L=0.15U W=0.42U AS=0.1841P
+ AD=0.0609P PS=1.26U PD=0.71U
* device instance $2965 r0 *1 25.68,65.725 sky130_fd_pr__pfet_01v8
M$2965 162 1152 1151 1151 sky130_fd_pr__pfet_01v8 L=0.15U W=0.42U AS=0.0609P
+ AD=0.1113P PS=0.71U PD=1.37U
* device instance $2966 r0 *1 24.47,65.835 sky130_fd_pr__pfet_01v8
M$2966 162 1151 1150 1150 sky130_fd_pr__pfet_01v8 L=0.15U W=0.64U AS=0.1696P
+ AD=0.1841P PS=1.81U PD=1.26U
* device instance $2967 r0 *1 26.69,66.015 sky130_fd_pr__pfet_01v8
M$2967 1154 1150 1153 1153 sky130_fd_pr__pfet_01v8 L=0.15U W=1U AS=0.26P
+ AD=0.135P PS=2.52U PD=1.27U
* device instance $2968 r0 *1 27.11,66.015 sky130_fd_pr__pfet_01v8
M$2968 1181 909 1154 1154 sky130_fd_pr__pfet_01v8 L=0.15U W=1U AS=0.135P
+ AD=0.135P PS=1.27U PD=1.27U
* device instance $2969 r0 *1 27.53,66.015 sky130_fd_pr__pfet_01v8
M$2969 1154 129 1181 1181 sky130_fd_pr__pfet_01v8 L=0.15U W=1U AS=0.135P
+ AD=0.26P PS=1.27U PD=2.52U
* device instance $2970 r0 *1 28.47,66.015 sky130_fd_pr__pfet_01v8
M$2970 1181 1182 162 162 sky130_fd_pr__pfet_01v8 L=0.15U W=1U AS=0.26P
+ AD=0.165P PS=2.52U PD=1.33U
* device instance $2971 r0 *1 28.95,66.015 sky130_fd_pr__pfet_01v8
M$2971 162 987 1181 1181 sky130_fd_pr__pfet_01v8 L=0.15U W=1U AS=0.165P
+ AD=0.1575P PS=1.33U PD=1.315U
* device instance $2972 r0 *1 29.415,66.015 sky130_fd_pr__pfet_01v8
M$2972 1120 1153 162 162 sky130_fd_pr__pfet_01v8 L=0.15U W=1U AS=0.1575P
+ AD=0.26P PS=1.315U PD=2.52U
* device instance $2973 r0 *1 32.31,66.015 sky130_fd_pr__pfet_01v8
M$2973 1182 1183 162 162 sky130_fd_pr__pfet_01v8 L=0.15U W=1U AS=0.36P
+ AD=0.165P PS=2.72U PD=1.33U
* device instance $2974 r0 *1 32.79,66.015 sky130_fd_pr__pfet_01v8
M$2974 1195 1071 1182 1182 sky130_fd_pr__pfet_01v8 L=0.15U W=1U AS=0.165P
+ AD=0.105P PS=1.33U PD=1.21U
* device instance $2975 r0 *1 33.15,66.015 sky130_fd_pr__pfet_01v8
M$2975 162 1049 1195 1195 sky130_fd_pr__pfet_01v8 L=0.15U W=1U AS=0.105P
+ AD=0.365P PS=1.21U PD=1.73U
* device instance $2976 r0 *1 34.03,66.015 sky130_fd_pr__pfet_01v8
M$2976 1183 1049 162 162 sky130_fd_pr__pfet_01v8 L=0.15U W=1U AS=0.365P
+ AD=0.135P PS=1.73U PD=1.27U
* device instance $2977 r0 *1 34.45,66.015 sky130_fd_pr__pfet_01v8
M$2977 162 1071 1183 1183 sky130_fd_pr__pfet_01v8 L=0.15U W=1U AS=0.135P
+ AD=0.3P PS=1.27U PD=2.6U
* device instance $2978 r0 *1 36.825,66.015 sky130_fd_pr__pfet_01v8
M$2978 162 1184 1155 1155 sky130_fd_pr__pfet_01v8 L=0.15U W=1U AS=0.26P
+ AD=0.1575P PS=2.52U PD=1.315U
* device instance $2979 r0 *1 37.29,66.015 sky130_fd_pr__pfet_01v8
M$2979 1156 1016 162 162 sky130_fd_pr__pfet_01v8 L=0.15U W=1U AS=0.1575P
+ AD=0.165P PS=1.315U PD=1.33U
* device instance $2980 r0 *1 37.77,66.015 sky130_fd_pr__pfet_01v8
M$2980 162 1287 1156 1156 sky130_fd_pr__pfet_01v8 L=0.15U W=1U AS=0.165P
+ AD=0.26P PS=1.33U PD=2.52U
* device instance $2981 r0 *1 37.325,64.835 sky130_fd_pr__pfet_01v8
M$2981 1142 1109 162 162 sky130_fd_pr__pfet_01v8 L=0.15U W=0.42U AS=0.1092P
+ AD=0.06405P PS=1.36U PD=0.725U
* device instance $2982 r0 *1 37.78,64.835 sky130_fd_pr__pfet_01v8
M$2982 1110 1104 1142 1142 sky130_fd_pr__pfet_01v8 L=0.15U W=0.42U AS=0.06405P
+ AD=0.0567P PS=0.725U PD=0.69U
* device instance $2983 r0 *1 38.2,64.835 sky130_fd_pr__pfet_01v8
M$2983 1143 1105 1110 1110 sky130_fd_pr__pfet_01v8 L=0.15U W=0.42U AS=0.0567P
+ AD=0.0882P PS=0.69U PD=0.84U
* device instance $2984 r0 *1 38.77,64.835 sky130_fd_pr__pfet_01v8
M$2984 162 1121 1143 1143 sky130_fd_pr__pfet_01v8 L=0.15U W=0.42U AS=0.0882P
+ AD=0.1113P PS=0.84U PD=1.37U
* device instance $2985 r0 *1 38.71,66.015 sky130_fd_pr__pfet_01v8
M$2985 1156 129 1157 1157 sky130_fd_pr__pfet_01v8 L=0.15U W=1U AS=0.26P
+ AD=0.135P PS=2.52U PD=1.27U
* device instance $2986 r0 *1 39.13,66.015 sky130_fd_pr__pfet_01v8
M$2986 1157 694 1156 1156 sky130_fd_pr__pfet_01v8 L=0.15U W=1U AS=0.135P
+ AD=0.135P PS=1.27U PD=1.27U
* device instance $2987 r0 *1 39.55,66.015 sky130_fd_pr__pfet_01v8
M$2987 1184 1158 1157 1157 sky130_fd_pr__pfet_01v8 L=0.15U W=1U AS=0.135P
+ AD=0.26P PS=1.27U PD=2.52U
* device instance $2988 r0 *1 41.135,65.835 sky130_fd_pr__pfet_01v8
M$2988 1160 1159 162 162 sky130_fd_pr__pfet_01v8 L=0.15U W=0.64U AS=0.154P
+ AD=0.1728P PS=1.335U PD=1.82U
* device instance $2989 r0 *1 40.65,66.015 sky130_fd_pr__pfet_01v8
M$2989 162 1159 694 694 sky130_fd_pr__pfet_01v8 L=0.15U W=1U AS=0.28P AD=0.154P
+ PS=2.56U PD=1.335U
* device instance $2990 r0 *1 42.19,65.725 sky130_fd_pr__pfet_01v8
M$2990 1197 1160 162 162 sky130_fd_pr__pfet_01v8 L=0.15U W=0.42U AS=0.1113P
+ AD=0.0882P PS=1.37U PD=0.84U
* device instance $2991 r0 *1 42.76,65.725 sky130_fd_pr__pfet_01v8
M$2991 1159 1185 1197 1197 sky130_fd_pr__pfet_01v8 L=0.15U W=0.42U AS=0.0882P
+ AD=0.0567P PS=0.84U PD=0.69U
* device instance $2992 r0 *1 43.18,65.725 sky130_fd_pr__pfet_01v8
M$2992 1198 1186 1159 1159 sky130_fd_pr__pfet_01v8 L=0.15U W=0.42U AS=0.0567P
+ AD=0.06405P PS=0.69U PD=0.725U
* device instance $2993 r0 *1 43.635,65.725 sky130_fd_pr__pfet_01v8
M$2993 162 1161 1198 1198 sky130_fd_pr__pfet_01v8 L=0.15U W=0.42U AS=0.06405P
+ AD=0.1092P PS=0.725U PD=1.36U
* device instance $2994 r0 *1 45.235,65.725 sky130_fd_pr__pfet_01v8
M$2994 1199 1161 162 162 sky130_fd_pr__pfet_01v8 L=0.15U W=0.42U AS=0.178875P
+ AD=0.07665P PS=1.26U PD=0.785U
* device instance $2995 r0 *1 45.75,65.725 sky130_fd_pr__pfet_01v8
M$2995 1162 1186 1199 1199 sky130_fd_pr__pfet_01v8 L=0.15U W=0.42U AS=0.07665P
+ AD=0.06405P PS=0.785U PD=0.725U
* device instance $2996 r0 *1 46.205,65.725 sky130_fd_pr__pfet_01v8
M$2996 1163 1185 1162 1162 sky130_fd_pr__pfet_01v8 L=0.15U W=0.42U AS=0.06405P
+ AD=0.15985P PS=0.725U PD=1.265U
* device instance $2997 r0 *1 46.98,65.835 sky130_fd_pr__pfet_01v8
M$2997 1200 1160 1163 1163 sky130_fd_pr__pfet_01v8 L=0.15U W=0.64U AS=0.15985P
+ AD=0.1152P PS=1.265U PD=1U
* device instance $2998 r0 *1 47.49,65.835 sky130_fd_pr__pfet_01v8
M$2998 162 1134 1200 1200 sky130_fd_pr__pfet_01v8 L=0.15U W=0.64U AS=0.1152P
+ AD=0.0928P PS=1U PD=0.93U
* device instance $2999 r0 *1 47.93,65.835 sky130_fd_pr__pfet_01v8
M$2999 1164 1134 162 162 sky130_fd_pr__pfet_01v8 L=0.15U W=0.64U AS=0.0928P
+ AD=0.1664P PS=0.93U PD=1.8U
* device instance $3000 r0 *1 44.575,65.89 sky130_fd_pr__pfet_01v8
M$3000 162 1162 1161 1161 sky130_fd_pr__pfet_01v8 L=0.15U W=0.75U AS=0.195P
+ AD=0.178875P PS=2.02U PD=1.26U
* device instance $3001 r0 *1 48.87,65.835 sky130_fd_pr__pfet_01v8
M$3001 1201 1164 162 162 sky130_fd_pr__pfet_01v8 L=0.15U W=0.64U AS=0.1664P
+ AD=0.0672P PS=1.8U PD=0.85U
* device instance $3002 r0 *1 49.23,65.835 sky130_fd_pr__pfet_01v8
M$3002 1163 1165 1201 1201 sky130_fd_pr__pfet_01v8 L=0.15U W=0.64U AS=0.0672P
+ AD=0.1664P PS=0.85U PD=1.8U
* device instance $3003 r0 *1 60.34,65.725 sky130_fd_pr__pfet_01v8
M$3003 1166 1022 162 162 sky130_fd_pr__pfet_01v8 L=0.15U W=0.42U AS=0.1113P
+ AD=0.0609P PS=1.37U PD=0.71U
* device instance $3004 r0 *1 60.78,65.725 sky130_fd_pr__pfet_01v8
M$3004 162 1069 1166 1166 sky130_fd_pr__pfet_01v8 L=0.15U W=0.42U AS=0.0609P
+ AD=0.1841P PS=0.71U PD=1.26U
* device instance $3005 r0 *1 61.55,65.835 sky130_fd_pr__pfet_01v8
M$3005 1167 1166 162 162 sky130_fd_pr__pfet_01v8 L=0.15U W=0.64U AS=0.1841P
+ AD=0.1696P PS=1.26U PD=1.81U
* device instance $3006 r0 *1 62.61,66.015 sky130_fd_pr__pfet_01v8
M$3006 1196 1039 1168 1168 sky130_fd_pr__pfet_01v8 L=0.15U W=1U AS=0.26P
+ AD=0.135P PS=2.52U PD=1.27U
* device instance $3007 r0 *1 63.03,66.015 sky130_fd_pr__pfet_01v8
M$3007 162 1167 1196 1196 sky130_fd_pr__pfet_01v8 L=0.15U W=1U AS=0.135P
+ AD=0.135P PS=1.27U PD=1.27U
* device instance $3008 r0 *1 63.45,66.015 sky130_fd_pr__pfet_01v8
M$3008 1169 1167 162 162 sky130_fd_pr__pfet_01v8 L=0.15U W=1U AS=0.135P
+ AD=0.135P PS=1.27U PD=1.27U
* device instance $3009 r0 *1 63.87,66.015 sky130_fd_pr__pfet_01v8
M$3009 162 1039 1169 1169 sky130_fd_pr__pfet_01v8 L=0.15U W=1U AS=0.135P
+ AD=0.26P PS=1.27U PD=2.52U
* device instance $3010 r0 *1 64.81,66.015 sky130_fd_pr__pfet_01v8
M$3010 1187 1168 1169 1169 sky130_fd_pr__pfet_01v8 L=0.15U W=1U AS=0.26P
+ AD=0.3P PS=2.52U PD=2.6U
* device instance $3011 r0 *1 67.15,65.835 sky130_fd_pr__pfet_01v8
M$3011 1194 1188 1172 1172 sky130_fd_pr__pfet_01v8 L=0.15U W=0.64U AS=0.1664P
+ AD=0.0672P PS=1.8U PD=0.85U
* device instance $3012 r0 *1 67.51,65.835 sky130_fd_pr__pfet_01v8
M$3012 162 1173 1194 1194 sky130_fd_pr__pfet_01v8 L=0.15U W=0.64U AS=0.0672P
+ AD=0.1664P PS=0.85U PD=1.8U
* device instance $3013 r0 *1 70.175,65.725 sky130_fd_pr__pfet_01v8
M$3013 1174 1171 1172 1172 sky130_fd_pr__pfet_01v8 L=0.15U W=0.42U AS=0.15985P
+ AD=0.06405P PS=1.265U PD=0.725U
* device instance $3014 r0 *1 70.63,65.725 sky130_fd_pr__pfet_01v8
M$3014 1192 1170 1174 1174 sky130_fd_pr__pfet_01v8 L=0.15U W=0.42U AS=0.06405P
+ AD=0.07665P PS=0.725U PD=0.785U
* device instance $3015 r0 *1 71.145,65.725 sky130_fd_pr__pfet_01v8
M$3015 162 1175 1192 1192 sky130_fd_pr__pfet_01v8 L=0.15U W=0.42U AS=0.07665P
+ AD=0.178875P PS=0.785U PD=1.26U
* device instance $3016 r0 *1 68.45,65.835 sky130_fd_pr__pfet_01v8
M$3016 162 1134 1173 1173 sky130_fd_pr__pfet_01v8 L=0.15U W=0.64U AS=0.1664P
+ AD=0.0928P PS=1.8U PD=0.93U
* device instance $3017 r0 *1 68.89,65.835 sky130_fd_pr__pfet_01v8
M$3017 1193 1134 162 162 sky130_fd_pr__pfet_01v8 L=0.15U W=0.64U AS=0.0928P
+ AD=0.1152P PS=0.93U PD=1U
* device instance $3018 r0 *1 69.4,65.835 sky130_fd_pr__pfet_01v8
M$3018 1172 1177 1193 1193 sky130_fd_pr__pfet_01v8 L=0.15U W=0.64U AS=0.1152P
+ AD=0.15985P PS=1U PD=1.265U
* device instance $3019 r0 *1 71.805,65.89 sky130_fd_pr__pfet_01v8
M$3019 1175 1174 162 162 sky130_fd_pr__pfet_01v8 L=0.15U W=0.75U AS=0.178875P
+ AD=0.195P PS=1.26U PD=2.02U
* device instance $3020 r0 *1 72.745,65.725 sky130_fd_pr__pfet_01v8
M$3020 1191 1175 162 162 sky130_fd_pr__pfet_01v8 L=0.15U W=0.42U AS=0.1092P
+ AD=0.06405P PS=1.36U PD=0.725U
* device instance $3021 r0 *1 73.2,65.725 sky130_fd_pr__pfet_01v8
M$3021 1176 1170 1191 1191 sky130_fd_pr__pfet_01v8 L=0.15U W=0.42U AS=0.06405P
+ AD=0.0567P PS=0.725U PD=0.69U
* device instance $3022 r0 *1 73.62,65.725 sky130_fd_pr__pfet_01v8
M$3022 1190 1171 1176 1176 sky130_fd_pr__pfet_01v8 L=0.15U W=0.42U AS=0.0567P
+ AD=0.0882P PS=0.69U PD=0.84U
* device instance $3023 r0 *1 74.19,65.725 sky130_fd_pr__pfet_01v8
M$3023 162 1177 1190 1190 sky130_fd_pr__pfet_01v8 L=0.15U W=0.42U AS=0.0882P
+ AD=0.1113P PS=0.84U PD=1.37U
* device instance $3024 r0 *1 75.245,65.835 sky130_fd_pr__pfet_01v8
M$3024 162 1176 1177 1177 sky130_fd_pr__pfet_01v8 L=0.15U W=0.64U AS=0.1728P
+ AD=0.154P PS=1.82U PD=1.335U
* device instance $3025 r0 *1 75.73,66.015 sky130_fd_pr__pfet_01v8
M$3025 1124 1176 162 162 sky130_fd_pr__pfet_01v8 L=0.15U W=1U AS=0.154P
+ AD=0.28P PS=1.335U PD=2.56U
* device instance $3026 r0 *1 5.55,69.985 sky130_fd_pr__pfet_01v8
M$3026 162 1202 1286 1286 sky130_fd_pr__pfet_01v8 L=0.15U W=2U AS=0.415P
+ AD=0.275P PS=3.83U PD=2.55U
* device instance $3027 r0 *1 5.98,69.985 sky130_fd_pr__pfet_01v8
M$3027 1286 1149 162 162 sky130_fd_pr__pfet_01v8 L=0.15U W=2U AS=0.28P
+ AD=0.275P PS=2.56U PD=2.55U
* device instance $3030 r0 *1 7.25,69.985 sky130_fd_pr__pfet_01v8
M$3030 1178 1118 1286 1286 sky130_fd_pr__pfet_01v8 L=0.15U W=2U AS=0.27P
+ AD=0.495P PS=2.54U PD=3.99U
* device instance $3032 r0 *1 8.75,70.135 sky130_fd_pr__pfet_01v8
M$3032 162 939 1229 1229 sky130_fd_pr__pfet_01v8 L=0.15U W=0.64U AS=0.1664P
+ AD=0.0864P PS=1.8U PD=0.91U
* device instance $3033 r0 *1 9.17,70.135 sky130_fd_pr__pfet_01v8
M$3033 1230 1229 162 162 sky130_fd_pr__pfet_01v8 L=0.15U W=0.64U AS=0.0864P
+ AD=0.1664P PS=0.91U PD=1.8U
* device instance $3034 r0 *1 10.11,70.275 sky130_fd_pr__pfet_01v8
M$3034 1231 1146 162 162 sky130_fd_pr__pfet_01v8 L=0.15U W=0.42U AS=0.1092P
+ AD=0.05775P PS=1.36U PD=0.695U
* device instance $3035 r0 *1 10.535,70.275 sky130_fd_pr__pfet_01v8
M$3035 1232 1230 1231 1231 sky130_fd_pr__pfet_01v8 L=0.15U W=0.42U AS=0.05775P
+ AD=0.06825P PS=0.695U PD=0.745U
* device instance $3036 r0 *1 11.01,70.275 sky130_fd_pr__pfet_01v8
M$3036 1295 1229 1232 1232 sky130_fd_pr__pfet_01v8 L=0.15U W=0.42U AS=0.06825P
+ AD=0.07665P PS=0.745U PD=0.785U
* device instance $3037 r0 *1 11.525,70.275 sky130_fd_pr__pfet_01v8
M$3037 1295 1233 162 162 sky130_fd_pr__pfet_01v8 L=0.15U W=0.42U AS=0.178875P
+ AD=0.07665P PS=1.26U PD=0.785U
* device instance $3038 r0 *1 12.185,70.11 sky130_fd_pr__pfet_01v8
M$3038 1233 1232 162 162 sky130_fd_pr__pfet_01v8 L=0.15U W=0.75U AS=0.178875P
+ AD=0.1095P PS=1.26U PD=1.075U
* device instance $3039 r0 *1 12.66,70.275 sky130_fd_pr__pfet_01v8
M$3039 1234 1229 1233 1233 sky130_fd_pr__pfet_01v8 L=0.15U W=0.42U AS=0.1095P
+ AD=0.0567P PS=1.075U PD=0.69U
* device instance $3040 r0 *1 13.08,70.275 sky130_fd_pr__pfet_01v8
M$3040 1296 1230 1234 1234 sky130_fd_pr__pfet_01v8 L=0.15U W=0.42U AS=0.0567P
+ AD=0.0882P PS=0.69U PD=0.84U
* device instance $3041 r0 *1 13.65,70.275 sky130_fd_pr__pfet_01v8
M$3041 162 1235 1296 1296 sky130_fd_pr__pfet_01v8 L=0.15U W=0.42U AS=0.0882P
+ AD=0.1113P PS=0.84U PD=1.37U
* device instance $3042 r0 *1 14.7,69.985 sky130_fd_pr__pfet_01v8
M$3042 162 1234 1235 1235 sky130_fd_pr__pfet_01v8 L=0.15U W=1U AS=0.27P
+ AD=0.135P PS=2.54U PD=1.27U
* device instance $3043 r0 *1 15.12,69.985 sky130_fd_pr__pfet_01v8
M$3043 1148 1235 162 162 sky130_fd_pr__pfet_01v8 L=0.15U W=1U AS=0.135P
+ AD=0.26P PS=1.27U PD=2.52U
* device instance $3044 r0 *1 15.83,65.935 sky130_fd_pr__pfet_01v8
M$3044 1180 1148 162 162 sky130_fd_pr__pfet_01v8 L=0.15U W=0.42U AS=0.1176P
+ AD=0.0567P PS=1.4U PD=0.69U
* device instance $3045 r0 *1 16.25,65.935 sky130_fd_pr__pfet_01v8
M$3045 1180 1102 162 162 sky130_fd_pr__pfet_01v8 L=0.15U W=0.42U AS=0.16655P
+ AD=0.0567P PS=1.39U PD=0.69U
* device instance $3046 r0 *1 16.79,66.015 sky130_fd_pr__pfet_01v8
M$3046 1149 1180 162 162 sky130_fd_pr__pfet_01v8 L=0.15U W=1U AS=0.16655P
+ AD=0.475P PS=1.39U PD=2.95U
* device instance $3047 r0 *1 22.09,70.135 sky130_fd_pr__pfet_01v8
M$3047 162 939 1236 1236 sky130_fd_pr__pfet_01v8 L=0.15U W=0.64U AS=0.1664P
+ AD=0.0864P PS=1.8U PD=0.91U
* device instance $3048 r0 *1 22.51,70.135 sky130_fd_pr__pfet_01v8
M$3048 1237 1236 162 162 sky130_fd_pr__pfet_01v8 L=0.15U W=0.64U AS=0.0864P
+ AD=0.1664P PS=0.91U PD=1.8U
* device instance $3049 r0 *1 23.45,70.165 sky130_fd_pr__pfet_01v8
M$3049 1297 1255 1238 1238 sky130_fd_pr__pfet_01v8 L=0.15U W=0.64U AS=0.1664P
+ AD=0.0672P PS=1.8U PD=0.85U
* device instance $3050 r0 *1 23.81,70.165 sky130_fd_pr__pfet_01v8
M$3050 162 1239 1297 1297 sky130_fd_pr__pfet_01v8 L=0.15U W=0.64U AS=0.0672P
+ AD=0.1664P PS=0.85U PD=1.8U
* device instance $3051 r0 *1 24.75,70.165 sky130_fd_pr__pfet_01v8
M$3051 162 1134 1239 1239 sky130_fd_pr__pfet_01v8 L=0.15U W=0.64U AS=0.1664P
+ AD=0.0928P PS=1.8U PD=0.93U
* device instance $3052 r0 *1 25.19,70.165 sky130_fd_pr__pfet_01v8
M$3052 1298 1134 162 162 sky130_fd_pr__pfet_01v8 L=0.15U W=0.64U AS=0.0928P
+ AD=0.1152P PS=0.93U PD=1U
* device instance $3053 r0 *1 25.7,70.165 sky130_fd_pr__pfet_01v8
M$3053 1238 1256 1298 1298 sky130_fd_pr__pfet_01v8 L=0.15U W=0.64U AS=0.1152P
+ AD=0.15985P PS=1U PD=1.265U
* device instance $3054 r0 *1 26.475,70.275 sky130_fd_pr__pfet_01v8
M$3054 1240 1237 1238 1238 sky130_fd_pr__pfet_01v8 L=0.15U W=0.42U AS=0.15985P
+ AD=0.06405P PS=1.265U PD=0.725U
* device instance $3055 r0 *1 26.93,70.275 sky130_fd_pr__pfet_01v8
M$3055 1299 1236 1240 1240 sky130_fd_pr__pfet_01v8 L=0.15U W=0.42U AS=0.06405P
+ AD=0.07665P PS=0.725U PD=0.785U
* device instance $3056 r0 *1 27.445,70.275 sky130_fd_pr__pfet_01v8
M$3056 1299 1241 162 162 sky130_fd_pr__pfet_01v8 L=0.15U W=0.42U AS=0.178875P
+ AD=0.07665P PS=1.26U PD=0.785U
* device instance $3057 r0 *1 28.105,70.11 sky130_fd_pr__pfet_01v8
M$3057 1241 1240 162 162 sky130_fd_pr__pfet_01v8 L=0.15U W=0.75U AS=0.178875P
+ AD=0.195P PS=1.26U PD=2.02U
* device instance $3058 r0 *1 29.045,70.275 sky130_fd_pr__pfet_01v8
M$3058 1300 1241 162 162 sky130_fd_pr__pfet_01v8 L=0.15U W=0.42U AS=0.1092P
+ AD=0.06405P PS=1.36U PD=0.725U
* device instance $3059 r0 *1 29.5,70.275 sky130_fd_pr__pfet_01v8
M$3059 1242 1236 1300 1300 sky130_fd_pr__pfet_01v8 L=0.15U W=0.42U AS=0.06405P
+ AD=0.0567P PS=0.725U PD=0.69U
* device instance $3060 r0 *1 29.92,70.275 sky130_fd_pr__pfet_01v8
M$3060 1301 1237 1242 1242 sky130_fd_pr__pfet_01v8 L=0.15U W=0.42U AS=0.0567P
+ AD=0.0882P PS=0.69U PD=0.84U
* device instance $3061 r0 *1 30.49,70.275 sky130_fd_pr__pfet_01v8
M$3061 162 1256 1301 1301 sky130_fd_pr__pfet_01v8 L=0.15U W=0.42U AS=0.0882P
+ AD=0.1113P PS=0.84U PD=1.37U
* device instance $3062 r0 *1 31.545,70.165 sky130_fd_pr__pfet_01v8
M$3062 1256 1242 162 162 sky130_fd_pr__pfet_01v8 L=0.15U W=0.64U AS=0.154P
+ AD=0.1728P PS=1.335U PD=1.82U
* device instance $3063 r0 *1 32.03,69.985 sky130_fd_pr__pfet_01v8
M$3063 909 1242 162 162 sky130_fd_pr__pfet_01v8 L=0.15U W=1U AS=0.154P AD=0.28P
+ PS=1.335U PD=2.56U
* device instance $3064 r0 *1 33.13,69.985 sky130_fd_pr__pfet_01v8
M$3064 162 987 1257 1257 sky130_fd_pr__pfet_01v8 L=0.15U W=1U AS=0.26P
+ AD=0.135P PS=2.52U PD=1.27U
* device instance $3065 r0 *1 33.55,69.985 sky130_fd_pr__pfet_01v8
M$3065 1287 1257 162 162 sky130_fd_pr__pfet_01v8 L=0.15U W=4U AS=0.54P
+ AD=0.665P PS=5.08U PD=6.33U
* device instance $3069 r0 *1 35.91,69.985 sky130_fd_pr__pfet_01v8
M$3069 870 1258 162 162 sky130_fd_pr__pfet_01v8 L=0.15U W=1U AS=0.26P AD=0.135P
+ PS=2.52U PD=1.27U
* device instance $3070 r0 *1 36.33,69.985 sky130_fd_pr__pfet_01v8
M$3070 162 55 870 870 sky130_fd_pr__pfet_01v8 L=0.15U W=1U AS=0.135P AD=0.26P
+ PS=1.27U PD=2.52U
* device instance $3071 r0 *1 41.95,70.165 sky130_fd_pr__pfet_01v8
M$3071 162 1259 1158 1158 sky130_fd_pr__pfet_01v8 L=0.15U W=0.64U AS=0.1696P
+ AD=0.1841P PS=1.81U PD=1.26U
* device instance $3072 r0 *1 42.72,70.275 sky130_fd_pr__pfet_01v8
M$3072 1259 108 162 162 sky130_fd_pr__pfet_01v8 L=0.15U W=0.42U AS=0.1841P
+ AD=0.0609P PS=1.26U PD=0.71U
* device instance $3073 r0 *1 43.16,70.275 sky130_fd_pr__pfet_01v8
M$3073 162 1288 1259 1259 sky130_fd_pr__pfet_01v8 L=0.15U W=0.42U AS=0.0609P
+ AD=0.1113P PS=0.71U PD=1.37U
* device instance $3074 r0 *1 44.63,70.135 sky130_fd_pr__pfet_01v8
M$3074 162 856 1243 1243 sky130_fd_pr__pfet_01v8 L=0.15U W=0.64U AS=0.1664P
+ AD=0.0864P PS=1.8U PD=0.91U
* device instance $3075 r0 *1 45.05,70.135 sky130_fd_pr__pfet_01v8
M$3075 1244 1243 162 162 sky130_fd_pr__pfet_01v8 L=0.15U W=0.64U AS=0.0864P
+ AD=0.1664P PS=0.91U PD=1.8U
* device instance $3076 r0 *1 45.99,70.165 sky130_fd_pr__pfet_01v8
M$3076 1305 1155 1245 1245 sky130_fd_pr__pfet_01v8 L=0.15U W=0.64U AS=0.1664P
+ AD=0.0672P PS=1.8U PD=0.85U
* device instance $3077 r0 *1 46.35,70.165 sky130_fd_pr__pfet_01v8
M$3077 162 1246 1305 1305 sky130_fd_pr__pfet_01v8 L=0.15U W=0.64U AS=0.0672P
+ AD=0.1664P PS=0.85U PD=1.8U
* device instance $3078 r0 *1 47.29,70.165 sky130_fd_pr__pfet_01v8
M$3078 162 311 1246 1246 sky130_fd_pr__pfet_01v8 L=0.15U W=0.64U AS=0.1664P
+ AD=0.0928P PS=1.8U PD=0.93U
* device instance $3079 r0 *1 47.73,70.165 sky130_fd_pr__pfet_01v8
M$3079 1306 311 162 162 sky130_fd_pr__pfet_01v8 L=0.15U W=0.64U AS=0.0928P
+ AD=0.1152P PS=0.93U PD=1U
* device instance $3080 r0 *1 48.24,70.165 sky130_fd_pr__pfet_01v8
M$3080 1245 1260 1306 1306 sky130_fd_pr__pfet_01v8 L=0.15U W=0.64U AS=0.1152P
+ AD=0.15985P PS=1U PD=1.265U
* device instance $3081 r0 *1 49.015,70.275 sky130_fd_pr__pfet_01v8
M$3081 1247 1244 1245 1245 sky130_fd_pr__pfet_01v8 L=0.15U W=0.42U AS=0.15985P
+ AD=0.06405P PS=1.265U PD=0.725U
* device instance $3082 r0 *1 49.47,70.275 sky130_fd_pr__pfet_01v8
M$3082 1304 1243 1247 1247 sky130_fd_pr__pfet_01v8 L=0.15U W=0.42U AS=0.06405P
+ AD=0.07665P PS=0.725U PD=0.785U
* device instance $3083 r0 *1 49.985,70.275 sky130_fd_pr__pfet_01v8
M$3083 1304 1248 162 162 sky130_fd_pr__pfet_01v8 L=0.15U W=0.42U AS=0.178875P
+ AD=0.07665P PS=1.26U PD=0.785U
* device instance $3084 r0 *1 50.645,70.11 sky130_fd_pr__pfet_01v8
M$3084 1248 1247 162 162 sky130_fd_pr__pfet_01v8 L=0.15U W=0.75U AS=0.178875P
+ AD=0.195P PS=1.26U PD=2.02U
* device instance $3085 r0 *1 50.17,65.865 sky130_fd_pr__pfet_01v8
M$3085 162 1186 1185 1185 sky130_fd_pr__pfet_01v8 L=0.15U W=0.64U AS=0.1664P
+ AD=0.0864P PS=1.8U PD=0.91U
* device instance $3086 r0 *1 50.59,65.865 sky130_fd_pr__pfet_01v8
M$3086 1186 856 162 162 sky130_fd_pr__pfet_01v8 L=0.15U W=0.64U AS=0.0864P
+ AD=0.1664P PS=0.91U PD=1.8U
* device instance $3087 r0 *1 51.585,70.275 sky130_fd_pr__pfet_01v8
M$3087 1303 1248 162 162 sky130_fd_pr__pfet_01v8 L=0.15U W=0.42U AS=0.1092P
+ AD=0.06405P PS=1.36U PD=0.725U
* device instance $3088 r0 *1 52.04,70.275 sky130_fd_pr__pfet_01v8
M$3088 1249 1243 1303 1303 sky130_fd_pr__pfet_01v8 L=0.15U W=0.42U AS=0.06405P
+ AD=0.0567P PS=0.725U PD=0.69U
* device instance $3089 r0 *1 52.46,70.275 sky130_fd_pr__pfet_01v8
M$3089 1302 1244 1249 1249 sky130_fd_pr__pfet_01v8 L=0.15U W=0.42U AS=0.0567P
+ AD=0.0882P PS=0.69U PD=0.84U
* device instance $3090 r0 *1 53.03,70.275 sky130_fd_pr__pfet_01v8
M$3090 162 1260 1302 1302 sky130_fd_pr__pfet_01v8 L=0.15U W=0.42U AS=0.0882P
+ AD=0.1113P PS=0.84U PD=1.37U
* device instance $3091 r0 *1 54.085,70.165 sky130_fd_pr__pfet_01v8
M$3091 1260 1249 162 162 sky130_fd_pr__pfet_01v8 L=0.15U W=0.64U AS=0.154P
+ AD=0.1728P PS=1.335U PD=1.82U
* device instance $3092 r0 *1 54.57,69.985 sky130_fd_pr__pfet_01v8
M$3092 1122 1249 162 162 sky130_fd_pr__pfet_01v8 L=0.15U W=1U AS=0.154P
+ AD=0.28P PS=1.335U PD=2.56U
* device instance $3093 r0 *1 57.12,70.275 sky130_fd_pr__pfet_01v8
M$3093 1250 1289 162 162 sky130_fd_pr__pfet_01v8 L=0.15U W=0.42U AS=0.1113P
+ AD=0.0609P PS=1.37U PD=0.71U
* device instance $3094 r0 *1 57.56,70.275 sky130_fd_pr__pfet_01v8
M$3094 1250 108 162 162 sky130_fd_pr__pfet_01v8 L=0.15U W=0.42U AS=0.1841P
+ AD=0.0609P PS=1.26U PD=0.71U
* device instance $3095 r0 *1 58.33,70.165 sky130_fd_pr__pfet_01v8
M$3095 1028 1250 162 162 sky130_fd_pr__pfet_01v8 L=0.15U W=0.64U AS=0.1841P
+ AD=0.1696P PS=1.26U PD=1.81U
* device instance $3096 r0 *1 60.27,69.985 sky130_fd_pr__pfet_01v8
M$3096 1290 1261 1251 1251 sky130_fd_pr__pfet_01v8 L=0.15U W=1U AS=0.26P
+ AD=0.135P PS=2.52U PD=1.27U
* device instance $3097 r0 *1 60.69,69.985 sky130_fd_pr__pfet_01v8
M$3097 1291 1262 1290 1290 sky130_fd_pr__pfet_01v8 L=0.15U W=1U AS=0.135P
+ AD=0.135P PS=1.27U PD=1.27U
* device instance $3098 r0 *1 61.11,69.985 sky130_fd_pr__pfet_01v8
M$3098 1290 129 1291 1291 sky130_fd_pr__pfet_01v8 L=0.15U W=1U AS=0.135P
+ AD=0.26P PS=1.27U PD=2.52U
* device instance $3099 r0 *1 62.05,69.985 sky130_fd_pr__pfet_01v8
M$3099 1291 1019 162 162 sky130_fd_pr__pfet_01v8 L=0.15U W=1U AS=0.26P
+ AD=0.165P PS=2.52U PD=1.33U
* device instance $3100 r0 *1 62.53,69.985 sky130_fd_pr__pfet_01v8
M$3100 162 1187 1291 1291 sky130_fd_pr__pfet_01v8 L=0.15U W=1U AS=0.165P
+ AD=0.1575P PS=1.33U PD=1.315U
* device instance $3101 r0 *1 62.995,69.985 sky130_fd_pr__pfet_01v8
M$3101 1252 1251 162 162 sky130_fd_pr__pfet_01v8 L=0.15U W=1U AS=0.1575P
+ AD=0.26P PS=1.315U PD=2.52U
* device instance $3102 r0 *1 65.31,69.695 sky130_fd_pr__pfet_01v8
M$3102 1263 1124 162 162 sky130_fd_pr__pfet_01v8 L=0.15U W=0.42U AS=0.14575P
+ AD=0.1092P PS=1.335U PD=1.36U
* device instance $3103 r0 *1 64.405,69.985 sky130_fd_pr__pfet_01v8
M$3103 1022 1263 162 162 sky130_fd_pr__pfet_01v8 L=0.15U W=1U AS=0.265P
+ AD=0.135P PS=2.53U PD=1.27U
* device instance $3104 r0 *1 64.825,69.985 sky130_fd_pr__pfet_01v8
M$3104 162 1123 1022 1022 sky130_fd_pr__pfet_01v8 L=0.15U W=1U AS=0.135P
+ AD=0.14575P PS=1.27U PD=1.335U
* device instance $3105 r0 *1 65.79,65.865 sky130_fd_pr__pfet_01v8
M$3105 162 856 1170 1170 sky130_fd_pr__pfet_01v8 L=0.15U W=0.64U AS=0.1664P
+ AD=0.0864P PS=1.8U PD=0.91U
* device instance $3106 r0 *1 66.21,65.865 sky130_fd_pr__pfet_01v8
M$3106 1171 1170 162 162 sky130_fd_pr__pfet_01v8 L=0.15U W=0.64U AS=0.0864P
+ AD=0.1664P PS=0.91U PD=1.8U
* device instance $3107 r0 *1 68.175,70.08 sky130_fd_pr__pfet_01v8
M$3107 1294 55 162 162 sky130_fd_pr__pfet_01v8 L=0.15U W=0.42U AS=0.15835P
+ AD=0.07665P PS=1.395U PD=0.785U
* device instance $3108 r0 *1 68.69,70.08 sky130_fd_pr__pfet_01v8
M$3108 1253 1123 1294 1294 sky130_fd_pr__pfet_01v8 L=0.15U W=0.42U AS=0.07665P
+ AD=0.1932P PS=0.785U PD=1.34U
* device instance $3109 r0 *1 69.76,70.08 sky130_fd_pr__pfet_01v8
M$3109 1293 1292 1253 1253 sky130_fd_pr__pfet_01v8 L=0.15U W=0.42U AS=0.1932P
+ AD=0.0441P PS=1.34U PD=0.63U
* device instance $3110 r0 *1 70.12,70.08 sky130_fd_pr__pfet_01v8
M$3110 162 1254 1293 1293 sky130_fd_pr__pfet_01v8 L=0.15U W=0.42U AS=0.0441P
+ AD=0.0693P PS=0.63U PD=0.75U
* device instance $3111 r0 *1 70.6,70.08 sky130_fd_pr__pfet_01v8
M$3111 1254 55 162 162 sky130_fd_pr__pfet_01v8 L=0.15U W=0.42U AS=0.0693P
+ AD=0.1176P PS=0.75U PD=1.4U
* device instance $3112 r0 *1 67.63,69.985 sky130_fd_pr__pfet_01v8
M$3112 162 1253 1188 1188 sky130_fd_pr__pfet_01v8 L=0.15U W=1U AS=0.26P
+ AD=0.15835P PS=2.52U PD=1.395U
* device instance $3113 r0 *1 8.29,71.305 sky130_fd_pr__pfet_01v8
M$3113 162 939 1307 1307 sky130_fd_pr__pfet_01v8 L=0.15U W=0.64U AS=0.1664P
+ AD=0.0864P PS=1.8U PD=0.91U
* device instance $3114 r0 *1 8.71,71.305 sky130_fd_pr__pfet_01v8
M$3114 1308 1307 162 162 sky130_fd_pr__pfet_01v8 L=0.15U W=0.64U AS=0.0864P
+ AD=0.1664P PS=0.91U PD=1.8U
* device instance $3115 r0 *1 9.65,71.165 sky130_fd_pr__pfet_01v8
M$3115 1309 1099 162 162 sky130_fd_pr__pfet_01v8 L=0.15U W=0.42U AS=0.1092P
+ AD=0.05775P PS=1.36U PD=0.695U
* device instance $3116 r0 *1 10.075,71.165 sky130_fd_pr__pfet_01v8
M$3116 1310 1308 1309 1309 sky130_fd_pr__pfet_01v8 L=0.15U W=0.42U AS=0.05775P
+ AD=0.06825P PS=0.695U PD=0.745U
* device instance $3117 r0 *1 10.55,71.165 sky130_fd_pr__pfet_01v8
M$3117 1327 1307 1310 1310 sky130_fd_pr__pfet_01v8 L=0.15U W=0.42U AS=0.06825P
+ AD=0.07665P PS=0.745U PD=0.785U
* device instance $3118 r0 *1 11.065,71.165 sky130_fd_pr__pfet_01v8
M$3118 162 1311 1327 1327 sky130_fd_pr__pfet_01v8 L=0.15U W=0.42U AS=0.07665P
+ AD=0.178875P PS=0.785U PD=1.26U
* device instance $3119 r0 *1 12.2,71.165 sky130_fd_pr__pfet_01v8
M$3119 1312 1307 1311 1311 sky130_fd_pr__pfet_01v8 L=0.15U W=0.42U AS=0.1095P
+ AD=0.0567P PS=1.075U PD=0.69U
* device instance $3120 r0 *1 12.62,71.165 sky130_fd_pr__pfet_01v8
M$3120 1329 1308 1312 1312 sky130_fd_pr__pfet_01v8 L=0.15U W=0.42U AS=0.0567P
+ AD=0.0882P PS=0.69U PD=0.84U
* device instance $3121 r0 *1 13.19,71.165 sky130_fd_pr__pfet_01v8
M$3121 162 1313 1329 1329 sky130_fd_pr__pfet_01v8 L=0.15U W=0.42U AS=0.0882P
+ AD=0.1113P PS=0.84U PD=1.37U
* device instance $3122 r0 *1 11.725,71.33 sky130_fd_pr__pfet_01v8
M$3122 1311 1310 162 162 sky130_fd_pr__pfet_01v8 L=0.15U W=0.75U AS=0.178875P
+ AD=0.1095P PS=1.26U PD=1.075U
* device instance $3123 r0 *1 14.24,71.455 sky130_fd_pr__pfet_01v8
M$3123 162 1312 1313 1313 sky130_fd_pr__pfet_01v8 L=0.15U W=1U AS=0.27P
+ AD=0.135P PS=2.54U PD=1.27U
* device instance $3124 r0 *1 14.66,71.455 sky130_fd_pr__pfet_01v8
M$3124 1119 1313 162 162 sky130_fd_pr__pfet_01v8 L=0.15U W=1U AS=0.135P
+ AD=0.26P PS=1.27U PD=2.52U
* device instance $3125 r0 *1 26.775,71.36 sky130_fd_pr__pfet_01v8
M$3125 1336 55 162 162 sky130_fd_pr__pfet_01v8 L=0.15U W=0.42U AS=0.15835P
+ AD=0.07665P PS=1.395U PD=0.785U
* device instance $3126 r0 *1 27.29,71.36 sky130_fd_pr__pfet_01v8
M$3126 1314 974 1336 1336 sky130_fd_pr__pfet_01v8 L=0.15U W=0.42U AS=0.07665P
+ AD=0.1932P PS=0.785U PD=1.34U
* device instance $3127 r0 *1 28.36,71.36 sky130_fd_pr__pfet_01v8
M$3127 1337 1332 1314 1314 sky130_fd_pr__pfet_01v8 L=0.15U W=0.42U AS=0.1932P
+ AD=0.0441P PS=1.34U PD=0.63U
* device instance $3128 r0 *1 28.72,71.36 sky130_fd_pr__pfet_01v8
M$3128 162 1340 1337 1337 sky130_fd_pr__pfet_01v8 L=0.15U W=0.42U AS=0.0441P
+ AD=0.0693P PS=0.63U PD=0.75U
* device instance $3129 r0 *1 29.2,71.36 sky130_fd_pr__pfet_01v8
M$3129 1340 55 162 162 sky130_fd_pr__pfet_01v8 L=0.15U W=0.42U AS=0.0693P
+ AD=0.1176P PS=0.75U PD=1.4U
* device instance $3130 r0 *1 26.23,71.455 sky130_fd_pr__pfet_01v8
M$3130 162 1314 1255 1255 sky130_fd_pr__pfet_01v8 L=0.15U W=1U AS=0.26P
+ AD=0.15835P PS=2.52U PD=1.395U
* device instance $3131 r0 *1 44.86,71.36 sky130_fd_pr__pfet_01v8
M$3131 162 55 1315 1315 sky130_fd_pr__pfet_01v8 L=0.15U W=0.42U AS=0.1176P
+ AD=0.0693P PS=1.4U PD=0.75U
* device instance $3132 r0 *1 45.34,71.36 sky130_fd_pr__pfet_01v8
M$3132 1338 1315 162 162 sky130_fd_pr__pfet_01v8 L=0.15U W=0.42U AS=0.0693P
+ AD=0.0441P PS=0.75U PD=0.63U
* device instance $3133 r0 *1 45.7,71.36 sky130_fd_pr__pfet_01v8
M$3133 1317 1316 1338 1338 sky130_fd_pr__pfet_01v8 L=0.15U W=0.42U AS=0.0441P
+ AD=0.1932P PS=0.63U PD=1.34U
* device instance $3134 r0 *1 46.77,71.36 sky130_fd_pr__pfet_01v8
M$3134 1339 1122 1317 1317 sky130_fd_pr__pfet_01v8 L=0.15U W=0.42U AS=0.1932P
+ AD=0.07665P PS=1.34U PD=0.785U
* device instance $3135 r0 *1 47.285,71.36 sky130_fd_pr__pfet_01v8
M$3135 1339 55 162 162 sky130_fd_pr__pfet_01v8 L=0.15U W=0.42U AS=0.15835P
+ AD=0.07665P PS=1.395U PD=0.785U
* device instance $3136 r0 *1 47.83,71.455 sky130_fd_pr__pfet_01v8
M$3136 1165 1317 162 162 sky130_fd_pr__pfet_01v8 L=0.15U W=1U AS=0.15835P
+ AD=0.26P PS=1.395U PD=2.52U
* device instance $3137 r0 *1 58.5,71.165 sky130_fd_pr__pfet_01v8
M$3137 1318 1333 162 162 sky130_fd_pr__pfet_01v8 L=0.15U W=0.42U AS=0.1113P
+ AD=0.0609P PS=1.37U PD=0.71U
* device instance $3138 r0 *1 58.94,71.165 sky130_fd_pr__pfet_01v8
M$3138 162 108 1318 1318 sky130_fd_pr__pfet_01v8 L=0.15U W=0.42U AS=0.0609P
+ AD=0.1841P PS=0.71U PD=1.26U
* device instance $3139 r0 *1 59.71,71.275 sky130_fd_pr__pfet_01v8
M$3139 1261 1318 162 162 sky130_fd_pr__pfet_01v8 L=0.15U W=0.64U AS=0.1841P
+ AD=0.1696P PS=1.26U PD=1.81U
* device instance $3140 r0 *1 60.73,71.305 sky130_fd_pr__pfet_01v8
M$3140 162 856 1319 1319 sky130_fd_pr__pfet_01v8 L=0.15U W=0.64U AS=0.1664P
+ AD=0.0864P PS=1.8U PD=0.91U
* device instance $3141 r0 *1 61.15,71.305 sky130_fd_pr__pfet_01v8
M$3141 1320 1319 162 162 sky130_fd_pr__pfet_01v8 L=0.15U W=0.64U AS=0.0864P
+ AD=0.1664P PS=0.91U PD=1.8U
* device instance $3142 r0 *1 62.09,71.275 sky130_fd_pr__pfet_01v8
M$3142 1335 1252 1322 1322 sky130_fd_pr__pfet_01v8 L=0.15U W=0.64U AS=0.1664P
+ AD=0.0672P PS=1.8U PD=0.85U
* device instance $3143 r0 *1 62.45,71.275 sky130_fd_pr__pfet_01v8
M$3143 162 1321 1335 1335 sky130_fd_pr__pfet_01v8 L=0.15U W=0.64U AS=0.0672P
+ AD=0.1664P PS=0.85U PD=1.8U
* device instance $3144 r0 *1 65.115,71.165 sky130_fd_pr__pfet_01v8
M$3144 1323 1320 1322 1322 sky130_fd_pr__pfet_01v8 L=0.15U W=0.42U AS=0.15985P
+ AD=0.06405P PS=1.265U PD=0.725U
* device instance $3145 r0 *1 65.57,71.165 sky130_fd_pr__pfet_01v8
M$3145 1331 1319 1323 1323 sky130_fd_pr__pfet_01v8 L=0.15U W=0.42U AS=0.06405P
+ AD=0.07665P PS=0.725U PD=0.785U
* device instance $3146 r0 *1 66.085,71.165 sky130_fd_pr__pfet_01v8
M$3146 162 1324 1331 1331 sky130_fd_pr__pfet_01v8 L=0.15U W=0.42U AS=0.07665P
+ AD=0.178875P PS=0.785U PD=1.26U
* device instance $3147 r0 *1 63.39,71.275 sky130_fd_pr__pfet_01v8
M$3147 162 311 1321 1321 sky130_fd_pr__pfet_01v8 L=0.15U W=0.64U AS=0.1664P
+ AD=0.0928P PS=1.8U PD=0.93U
* device instance $3148 r0 *1 63.83,71.275 sky130_fd_pr__pfet_01v8
M$3148 1334 311 162 162 sky130_fd_pr__pfet_01v8 L=0.15U W=0.64U AS=0.0928P
+ AD=0.1152P PS=0.93U PD=1U
* device instance $3149 r0 *1 64.34,71.275 sky130_fd_pr__pfet_01v8
M$3149 1322 1326 1334 1334 sky130_fd_pr__pfet_01v8 L=0.15U W=0.64U AS=0.1152P
+ AD=0.15985P PS=1U PD=1.265U
* device instance $3150 r0 *1 66.745,71.33 sky130_fd_pr__pfet_01v8
M$3150 1324 1323 162 162 sky130_fd_pr__pfet_01v8 L=0.15U W=0.75U AS=0.178875P
+ AD=0.195P PS=1.26U PD=2.02U
* device instance $3151 r0 *1 65.93,75.425 sky130_fd_pr__pfet_01v8
M$3151 1262 1353 162 162 sky130_fd_pr__pfet_01v8 L=0.15U W=4U AS=0.665P
+ AD=0.54P PS=6.33U PD=5.08U
* device instance $3155 r0 *1 67.61,75.425 sky130_fd_pr__pfet_01v8
M$3155 1353 1124 162 162 sky130_fd_pr__pfet_01v8 L=0.15U W=1U AS=0.135P
+ AD=0.26P PS=1.27U PD=2.52U
* device instance $3156 r0 *1 67.685,71.165 sky130_fd_pr__pfet_01v8
M$3156 1330 1324 162 162 sky130_fd_pr__pfet_01v8 L=0.15U W=0.42U AS=0.1092P
+ AD=0.06405P PS=1.36U PD=0.725U
* device instance $3157 r0 *1 68.14,71.165 sky130_fd_pr__pfet_01v8
M$3157 1325 1319 1330 1330 sky130_fd_pr__pfet_01v8 L=0.15U W=0.42U AS=0.06405P
+ AD=0.0567P PS=0.725U PD=0.69U
* device instance $3158 r0 *1 68.56,71.165 sky130_fd_pr__pfet_01v8
M$3158 1328 1320 1325 1325 sky130_fd_pr__pfet_01v8 L=0.15U W=0.42U AS=0.0567P
+ AD=0.0882P PS=0.69U PD=0.84U
* device instance $3159 r0 *1 69.13,71.165 sky130_fd_pr__pfet_01v8
M$3159 162 1326 1328 1328 sky130_fd_pr__pfet_01v8 L=0.15U W=0.42U AS=0.0882P
+ AD=0.1113P PS=0.84U PD=1.37U
* device instance $3160 r0 *1 70.185,71.275 sky130_fd_pr__pfet_01v8
M$3160 162 1325 1326 1326 sky130_fd_pr__pfet_01v8 L=0.15U W=0.64U AS=0.1728P
+ AD=0.154P PS=1.82U PD=1.335U
* device instance $3161 r0 *1 70.67,71.455 sky130_fd_pr__pfet_01v8
M$3161 1123 1325 162 162 sky130_fd_pr__pfet_01v8 L=0.15U W=1U AS=0.154P
+ AD=0.28P PS=1.335U PD=2.56U
.ENDS gcd
