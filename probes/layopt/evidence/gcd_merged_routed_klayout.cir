* cell gcd
.SUBCKT gcd
* net 1 resp_msg[8]
* net 12 dpath.a_lt_b$in1\[2\]
* net 14 dpath.a_mux$out\[8\]
* net 20 dpath.a_lt_b$in0\[8\]
* net 31 clknet_2_0__leaf_clk
* net 32 dpath.b_mux$out\[2\]
* net 50 dpath.a_lt_b$in0\[2\]
* net 53 _075_
* net 55 _069_
* net 57 resp_msg[7]
* net 65 dpath.a_mux$out\[2\]
* net 67 dpath.a_mux$out\[6\]
* net 69 _004_
* net 70 dpath.b_mux$out\[6\]
* net 71 req_rdy
* net 72 _048_
* net 73 dpath.b_mux$out\[8\]
* net 87 net2
* net 88 _089_
* net 89 resp_msg[6]
* net 90 net1
* net 91 _080_
* net 93 req_msg[6]
* net 94 VSS
* net 109 _076_
* net 110 _093_
* net 118 _090_
* net 120 dpath.b_mux$out\[7\]
* net 124 _087_
* net 127 req_msg[8]
* net 129 resp_msg[2]
* net 134 dpath.a_lt_b$in0\[7\]
* net 135 req_msg[7]
* net 136 dpath.a_lt_b$in1\[8\]
* net 137 net6
* net 156 req_msg[18]
* net 157 req_msg[22]
* net 158 req_msg[21]
* net 159 req_msg[23]
* net 160 req_msg[24]
* net 163 dpath.a_lt_b$in1\[6\]
* net 164 _088_
* net 167 VDD
* net 189 dpath.a_lt_b$in0\[6\]
* net 191 _047_
* net 194 dpath.a_mux$out\[7\]
* net 207 _022_
* net 208 req_msg[2]
* net 209 _040_
* net 211 net32
* net 212 _023_
* net 230 net9
* net 231 dpath.a_lt_b$in1\[7\]
* net 256 _036_
* net 257 _041_
* net 262 _030_
* net 266 _049_
* net 267 _024_
* net 271 _050_
* net 272 _051_
* net 275 _070_
* net 276 _027_
* net 277 net11
* net 278 _046_
* net 279 _026_
* net 280 _025_
* net 292 _042_
* net 304 _052_
* net 310 clknet_0_clk
* net 311 _020_
* net 315 ctrl$a_reg_en\[0\]
* net 329 clknet_2_1__leaf_clk
* net 330 _068_
* net 333 _019_
* net 334 _039_
* net 336 _043_
* net 337 _034_
* net 338 _021_
* net 339 dpath.a_lt_b$in0\[9\]
* net 341 dpath.a_lt_b$in1\[9\]
* net 346 resp_msg[9]
* net 352 _092_
* net 355 dpath.a_lt_b$in1\[3\]
* net 367 dpath.a_lt_b$in1\[5\]
* net 369 net52
* net 382 req_msg[19]
* net 383 resp_msg[3]
* net 385 _073_
* net 387 dpath.b_mux$out\[5\]
* net 388 _086_
* net 390 dpath.b_mux$out\[9\]
* net 405 dpath.a_mux$out\[3\]
* net 406 _103_
* net 407 _100_
* net 408 dpath.a_mux$out\[9\]
* net 433 _035_
* net 436 _071_
* net 437 _045_
* net 439 resp_msg[5]
* net 445 req_msg[9]
* net 447 dpath.b_mux$out\[3\]
* net 449 dpath.a_lt_b$in0\[3\]
* net 461 req_msg[3]
* net 462 req_msg[25]
* net 484 _029_
* net 495 _033_
* net 496 _031_
* net 497 dpath.a_lt_b$in0\[5\]
* net 499 req_msg[5]
* net 536 _028_
* net 543 _072_
* net 544 _044_
* net 547 dpath.a_mux$out\[5\]
* net 552 dpath.a_lt_b$in1\[1\]
* net 553 resp_msg[4]
* net 570 _085_
* net 571 dpath.a_lt_b$in1\[10\]
* net 572 resp_msg[10]
* net 575 net8
* net 576 _005_
* net 586 dpath.a_mux$out\[1\]
* net 588 _037_
* net 589 dpath.a_lt_b$in0\[1\]
* net 592 _053_
* net 596 _017_
* net 597 _094_
* net 598 net16
* net 599 resp_msg[1]
* net 600 _032_
* net 601 dpath.a_lt_b$in0\[4\]
* net 613 req_msg[26]
* net 619 req_msg[1]
* net 623 net12
* net 628 dpath.a_lt_b$in1\[4\]
* net 632 _054_
* net 634 dpath.b_mux$out\[10\]
* net 636 req_msg[17]
* net 637 _038_
* net 639 dpath.a_mux$out\[4\]
* net 640 _018_
* net 642 _055_
* net 643 dpath.a_lt_b$in0\[10\]
* net 644 req_msg[10]
* net 651 _091_
* net 653 clk
* net 654 _015_
* net 662 dpath.b_mux$out\[1\]
* net 693 _101_
* net 694 dpath.a_lt_b$in1\[14\]
* net 695 _099_
* net 708 dpath.b_mux$out\[4\]
* net 710 dpath.a_lt_b$in1\[11\]
* net 711 _067_
* net 712 dpath.a_mux$out\[10\]
* net 733 req_msg[20]
* net 734 resp_msg[11]
* net 768 req_msg[4]
* net 777 _003_
* net 802 dpath.b_mux$out\[11\]
* net 803 _084_
* net 804 dpath.a_lt_b$in0\[11\]
* net 805 _016_
* net 811 dpath.a_mux$out\[11\]
* net 834 dpath.a_lt_b$in1\[0\]
* net 844 clknet_2_3__leaf_clk
* net 862 _095_
* net 863 net13
* net 864 resp_msg[0]
* net 865 dpath.a_lt_b$in0\[0\]
* net 870 net3
* net 873 dpath.a_mux$out\[0\]
* net 875 dpath.a_lt_b$in1\[15\]
* net 876 _102_
* net 891 dpath.b_mux$out\[0\]
* net 907 req_msg[16]
* net 908 net7
* net 909 req_msg[27]
* net 910 dpath.b_mux$out\[12\]
* net 916 req_msg[0]
* net 918 _104_
* net 919 dpath.a_lt_b$in1\[12\]
* net 937 clknet_2_2__leaf_clk
* net 939 _056_
* net 942 req_msg[12]
* net 948 net30
* net 949 dpath.a_lt_b$in0\[12\]
* net 978 _066_
* net 979 _014_
* net 981 resp_msg[12]
* net 982 _013_
* net 985 net4
* net 995 _062_
* net 996 dpath.a_lt_b$in0\[15\]
* net 997 _079_
* net 1008 _078_
* net 1014 resp_msg[14]
* net 1015 _064_
* net 1017 net15
* net 1020 _012_
* net 1021 _010_
* net 1023 _057_
* net 1024 net10
* net 1025 _059_
* net 1026 _083_
* net 1035 _058_
* net 1038 dpath.a_mux$out\[12\]
* net 1048 _063_
* net 1062 ctrl$b_reg_en\[0\]
* net 1063 _061_
* net 1065 _077_
* net 1066 _008_
* net 1068 _011_
* net 1069 net28
* net 1070 _060_
* net 1080 _000_
* net 1081 _009_
* net 1097 _002_
* net 1098 _105_
* net 1099 _006_
* net 1100 _096_
* net 1102 net5
* net 1117 reset
* net 1118 _106_
* net 1119 ctrl.state.out\[2\]
* net 1121 dpath.a_lt_b$in0\[14\]
* net 1122 dpath.a_lt_b$in0\[13\]
* net 1123 dpath.a_lt_b$in1\[13\]
* net 1133 dpath.a_mux$out\[15\]
* net 1143 req_val
* net 1144 _097_
* net 1145 _001_
* net 1147 ctrl.state.out\[1\]
* net 1148 resp_val
* net 1150 _098_
* net 1156 dpath.a_mux$out\[14\]
* net 1166 _065_
* net 1179 req_msg[31]
* net 1181 resp_msg[15]
* net 1183 dpath.b_mux$out\[14\]
* net 1184 resp_msg[13]
* net 1198 resp_rdy
* net 1199 _007_
* net 1200 _081_
* net 1201 dpath.b_mux$out\[13\]
* net 1242 _074_
* net 1255 dpath.b_mux$out\[15\]
* net 1258 req_msg[11]
* net 1260 _082_
* net 1261 net53
* net 1286 net14
* net 1287 req_msg[30]
* net 1288 req_msg[28]
* net 1290 dpath.a_mux$out\[13\]
* net 1291 req_msg[13]
* net 1330 req_msg[15]
* net 1331 req_msg[14]
* net 1332 req_msg[29]
* device instance $1 r0 *1 5.07,3.165 sky130_fd_pr__nfet_01v8
M$1 94 31 6 6 sky130_fd_pr__nfet_01v8 L=0.15U W=0.42U AS=0.1092P AD=0.0567P
+ PS=1.36U PD=0.69U
* device instance $2 r0 *1 5.49,3.165 sky130_fd_pr__nfet_01v8
M$2 7 6 94 94 sky130_fd_pr__nfet_01v8 L=0.15U W=0.42U AS=0.0567P AD=0.1092P
+ PS=0.69U PD=1.36U
* device instance $3 r0 *1 6.43,3.165 sky130_fd_pr__nfet_01v8
M$3 21 32 8 8 sky130_fd_pr__nfet_01v8 L=0.15U W=0.42U AS=0.1092P AD=0.0441P
+ PS=1.36U PD=0.63U
* device instance $4 r0 *1 6.79,3.165 sky130_fd_pr__nfet_01v8
M$4 94 90 21 21 sky130_fd_pr__nfet_01v8 L=0.15U W=0.42U AS=0.0441P AD=0.1092P
+ PS=0.63U PD=1.36U
* device instance $5 r0 *1 9.59,3.135 sky130_fd_pr__nfet_01v8
M$5 2 6 8 8 sky130_fd_pr__nfet_01v8 L=0.15U W=0.36U AS=0.1446P AD=0.0522P
+ PS=1.18U PD=0.65U
* device instance $6 r0 *1 10.03,3.135 sky130_fd_pr__nfet_01v8
M$6 26 7 2 2 sky130_fd_pr__nfet_01v8 L=0.15U W=0.36U AS=0.0522P AD=0.0759P
+ PS=0.65U PD=0.8U
* device instance $7 r0 *1 7.73,3.165 sky130_fd_pr__nfet_01v8
M$7 94 90 9 9 sky130_fd_pr__nfet_01v8 L=0.15U W=0.42U AS=0.1092P AD=0.0609P
+ PS=1.36U PD=0.71U
* device instance $8 r0 *1 8.17,3.165 sky130_fd_pr__nfet_01v8
M$8 24 9 94 94 sky130_fd_pr__nfet_01v8 L=0.15U W=0.42U AS=0.0609P AD=0.0756P
+ PS=0.71U PD=0.78U
* device instance $9 r0 *1 8.68,3.165 sky130_fd_pr__nfet_01v8
M$9 8 10 24 24 sky130_fd_pr__nfet_01v8 L=0.15U W=0.42U AS=0.0756P AD=0.1446P
+ PS=0.78U PD=1.18U
* device instance $10 r0 *1 10.56,3.165 sky130_fd_pr__nfet_01v8
M$10 94 3 26 26 sky130_fd_pr__nfet_01v8 L=0.15U W=0.42U AS=0.0759P AD=0.12095P
+ PS=0.8U PD=1.085U
* device instance $11 r0 *1 11.155,3.275 sky130_fd_pr__nfet_01v8
M$11 3 2 94 94 sky130_fd_pr__nfet_01v8 L=0.15U W=0.64U AS=0.12095P AD=0.1664P
+ PS=1.085U PD=1.8U
* device instance $12 r0 *1 12.58,3.135 sky130_fd_pr__nfet_01v8
M$12 11 7 28 28 sky130_fd_pr__nfet_01v8 L=0.15U W=0.36U AS=0.0678P AD=0.0684P
+ PS=0.755U PD=0.74U
* device instance $13 r0 *1 13.11,3.135 sky130_fd_pr__nfet_01v8
M$13 30 6 11 11 sky130_fd_pr__nfet_01v8 L=0.15U W=0.36U AS=0.0684P AD=0.066P
+ PS=0.74U PD=0.745U
* device instance $14 r0 *1 12.095,3.165 sky130_fd_pr__nfet_01v8
M$14 28 3 94 94 sky130_fd_pr__nfet_01v8 L=0.15U W=0.42U AS=0.1092P AD=0.0678P
+ PS=1.36U PD=0.755U
* device instance $15 r0 *1 13.585,3.165 sky130_fd_pr__nfet_01v8
M$15 94 10 30 30 sky130_fd_pr__nfet_01v8 L=0.15U W=0.42U AS=0.066P AD=0.1092P
+ PS=0.745U PD=1.36U
* device instance $16 r0 *1 14.525,3.165 sky130_fd_pr__nfet_01v8
M$16 94 11 10 10 sky130_fd_pr__nfet_01v8 L=0.15U W=0.42U AS=0.1092P AD=0.10025P
+ PS=1.36U PD=0.985U
* device instance $17 r0 *1 15.01,3.28 sky130_fd_pr__nfet_01v8
M$17 12 11 94 94 sky130_fd_pr__nfet_01v8 L=0.15U W=0.65U AS=0.10025P AD=0.182P
+ PS=0.985U PD=1.86U
* device instance $18 r0 *1 60.73,3.165 sky130_fd_pr__nfet_01v8
M$18 94 329 13 13 sky130_fd_pr__nfet_01v8 L=0.15U W=0.42U AS=0.1092P AD=0.0567P
+ PS=1.36U PD=0.69U
* device instance $19 r0 *1 61.15,3.165 sky130_fd_pr__nfet_01v8
M$19 15 13 94 94 sky130_fd_pr__nfet_01v8 L=0.15U W=0.42U AS=0.0567P AD=0.1092P
+ PS=0.69U PD=1.36U
* device instance $20 r0 *1 62.09,3.165 sky130_fd_pr__nfet_01v8
M$20 29 14 16 16 sky130_fd_pr__nfet_01v8 L=0.15U W=0.42U AS=0.1092P AD=0.0441P
+ PS=1.36U PD=0.63U
* device instance $21 r0 *1 62.45,3.165 sky130_fd_pr__nfet_01v8
M$21 94 315 29 29 sky130_fd_pr__nfet_01v8 L=0.15U W=0.42U AS=0.0441P AD=0.1092P
+ PS=0.63U PD=1.36U
* device instance $22 r0 *1 65.25,3.135 sky130_fd_pr__nfet_01v8
M$22 4 13 16 16 sky130_fd_pr__nfet_01v8 L=0.15U W=0.36U AS=0.1446P AD=0.0522P
+ PS=1.18U PD=0.65U
* device instance $23 r0 *1 65.69,3.135 sky130_fd_pr__nfet_01v8
M$23 25 15 4 4 sky130_fd_pr__nfet_01v8 L=0.15U W=0.36U AS=0.0522P AD=0.0759P
+ PS=0.65U PD=0.8U
* device instance $24 r0 *1 63.39,3.165 sky130_fd_pr__nfet_01v8
M$24 94 315 17 17 sky130_fd_pr__nfet_01v8 L=0.15U W=0.42U AS=0.1092P AD=0.0609P
+ PS=1.36U PD=0.71U
* device instance $25 r0 *1 63.83,3.165 sky130_fd_pr__nfet_01v8
M$25 27 17 94 94 sky130_fd_pr__nfet_01v8 L=0.15U W=0.42U AS=0.0609P AD=0.0756P
+ PS=0.71U PD=0.78U
* device instance $26 r0 *1 64.34,3.165 sky130_fd_pr__nfet_01v8
M$26 16 18 27 27 sky130_fd_pr__nfet_01v8 L=0.15U W=0.42U AS=0.0756P AD=0.1446P
+ PS=0.78U PD=1.18U
* device instance $27 r0 *1 66.22,3.165 sky130_fd_pr__nfet_01v8
M$27 94 5 25 25 sky130_fd_pr__nfet_01v8 L=0.15U W=0.42U AS=0.0759P AD=0.12095P
+ PS=0.8U PD=1.085U
* device instance $28 r0 *1 66.815,3.275 sky130_fd_pr__nfet_01v8
M$28 5 4 94 94 sky130_fd_pr__nfet_01v8 L=0.15U W=0.64U AS=0.12095P AD=0.1664P
+ PS=1.085U PD=1.8U
* device instance $29 r0 *1 68.24,3.135 sky130_fd_pr__nfet_01v8
M$29 19 15 23 23 sky130_fd_pr__nfet_01v8 L=0.15U W=0.36U AS=0.0678P AD=0.0684P
+ PS=0.755U PD=0.74U
* device instance $30 r0 *1 68.77,3.135 sky130_fd_pr__nfet_01v8
M$30 22 13 19 19 sky130_fd_pr__nfet_01v8 L=0.15U W=0.36U AS=0.0684P AD=0.066P
+ PS=0.74U PD=0.745U
* device instance $31 r0 *1 67.755,3.165 sky130_fd_pr__nfet_01v8
M$31 23 5 94 94 sky130_fd_pr__nfet_01v8 L=0.15U W=0.42U AS=0.1092P AD=0.0678P
+ PS=1.36U PD=0.755U
* device instance $32 r0 *1 69.245,3.165 sky130_fd_pr__nfet_01v8
M$32 94 18 22 22 sky130_fd_pr__nfet_01v8 L=0.15U W=0.42U AS=0.066P AD=0.1092P
+ PS=0.745U PD=1.36U
* device instance $33 r0 *1 70.185,3.165 sky130_fd_pr__nfet_01v8
M$33 94 19 18 18 sky130_fd_pr__nfet_01v8 L=0.15U W=0.42U AS=0.1092P AD=0.10025P
+ PS=1.36U PD=0.985U
* device instance $34 r0 *1 70.67,3.28 sky130_fd_pr__nfet_01v8
M$34 20 19 94 94 sky130_fd_pr__nfet_01v8 L=0.15U W=0.65U AS=0.10025P AD=0.182P
+ PS=0.985U PD=1.86U
* device instance $35 r0 *1 5.53,7.715 sky130_fd_pr__nfet_01v8
M$35 94 31 43 43 sky130_fd_pr__nfet_01v8 L=0.15U W=0.42U AS=0.1092P AD=0.0567P
+ PS=1.36U PD=0.69U
* device instance $36 r0 *1 5.95,7.715 sky130_fd_pr__nfet_01v8
M$36 44 43 94 94 sky130_fd_pr__nfet_01v8 L=0.15U W=0.42U AS=0.0567P AD=0.1092P
+ PS=0.69U PD=1.36U
* device instance $37 r0 *1 6.89,7.715 sky130_fd_pr__nfet_01v8
M$37 95 65 45 45 sky130_fd_pr__nfet_01v8 L=0.15U W=0.42U AS=0.1092P AD=0.0441P
+ PS=1.36U PD=0.63U
* device instance $38 r0 *1 7.25,7.715 sky130_fd_pr__nfet_01v8
M$38 94 315 95 95 sky130_fd_pr__nfet_01v8 L=0.15U W=0.42U AS=0.0441P AD=0.1092P
+ PS=0.63U PD=1.36U
* device instance $39 r0 *1 8.19,7.715 sky130_fd_pr__nfet_01v8
M$39 94 315 46 46 sky130_fd_pr__nfet_01v8 L=0.15U W=0.42U AS=0.1092P AD=0.0609P
+ PS=1.36U PD=0.71U
* device instance $40 r0 *1 8.63,7.715 sky130_fd_pr__nfet_01v8
M$40 97 46 94 94 sky130_fd_pr__nfet_01v8 L=0.15U W=0.42U AS=0.0609P AD=0.0756P
+ PS=0.71U PD=0.78U
* device instance $41 r0 *1 9.14,7.715 sky130_fd_pr__nfet_01v8
M$41 45 49 97 97 sky130_fd_pr__nfet_01v8 L=0.15U W=0.42U AS=0.0756P AD=0.1446P
+ PS=0.78U PD=1.18U
* device instance $42 r0 *1 10.05,7.745 sky130_fd_pr__nfet_01v8
M$42 47 43 45 45 sky130_fd_pr__nfet_01v8 L=0.15U W=0.36U AS=0.1446P AD=0.0522P
+ PS=1.18U PD=0.65U
* device instance $43 r0 *1 10.49,7.745 sky130_fd_pr__nfet_01v8
M$43 47 44 99 99 sky130_fd_pr__nfet_01v8 L=0.15U W=0.36U AS=0.0759P AD=0.0522P
+ PS=0.8U PD=0.65U
* device instance $44 r0 *1 11.02,7.715 sky130_fd_pr__nfet_01v8
M$44 99 48 94 94 sky130_fd_pr__nfet_01v8 L=0.15U W=0.42U AS=0.12095P AD=0.0759P
+ PS=1.085U PD=0.8U
* device instance $45 r0 *1 11.615,7.605 sky130_fd_pr__nfet_01v8
M$45 48 47 94 94 sky130_fd_pr__nfet_01v8 L=0.15U W=0.64U AS=0.12095P AD=0.1664P
+ PS=1.085U PD=1.8U
* device instance $46 r0 *1 12.555,7.715 sky130_fd_pr__nfet_01v8
M$46 101 48 94 94 sky130_fd_pr__nfet_01v8 L=0.15U W=0.42U AS=0.1092P AD=0.0678P
+ PS=1.36U PD=0.755U
* device instance $47 r0 *1 13.04,7.745 sky130_fd_pr__nfet_01v8
M$47 66 44 101 101 sky130_fd_pr__nfet_01v8 L=0.15U W=0.36U AS=0.0678P
+ AD=0.0684P PS=0.755U PD=0.74U
* device instance $48 r0 *1 13.57,7.745 sky130_fd_pr__nfet_01v8
M$48 66 43 102 102 sky130_fd_pr__nfet_01v8 L=0.15U W=0.36U AS=0.066P AD=0.0684P
+ PS=0.745U PD=0.74U
* device instance $49 r0 *1 14.045,7.715 sky130_fd_pr__nfet_01v8
M$49 94 49 102 102 sky130_fd_pr__nfet_01v8 L=0.15U W=0.42U AS=0.066P AD=0.1092P
+ PS=0.745U PD=1.36U
* device instance $50 r0 *1 14.985,7.715 sky130_fd_pr__nfet_01v8
M$50 49 66 94 94 sky130_fd_pr__nfet_01v8 L=0.15U W=0.42U AS=0.10025P AD=0.1092P
+ PS=0.985U PD=1.36U
* device instance $51 r0 *1 15.47,7.6 sky130_fd_pr__nfet_01v8
M$51 50 66 94 94 sky130_fd_pr__nfet_01v8 L=0.15U W=0.65U AS=0.10025P AD=0.182P
+ PS=0.985U PD=1.86U
* device instance $52 r0 *1 23.47,7.6 sky130_fd_pr__nfet_01v8
M$52 94 88 51 51 sky130_fd_pr__nfet_01v8 L=0.15U W=0.65U AS=0.169P AD=0.10725P
+ PS=1.82U PD=0.98U
* device instance $53 r0 *1 23.95,7.6 sky130_fd_pr__nfet_01v8
M$53 105 163 94 94 sky130_fd_pr__nfet_01v8 L=0.15U W=0.65U AS=0.10725P
+ AD=0.06825P PS=0.98U PD=0.86U
* device instance $54 r0 *1 24.31,7.6 sky130_fd_pr__nfet_01v8
M$54 51 91 105 105 sky130_fd_pr__nfet_01v8 L=0.15U W=0.65U AS=0.06825P
+ AD=0.169P PS=0.86U PD=1.82U
* device instance $55 r0 *1 25.25,7.6 sky130_fd_pr__nfet_01v8
M$55 106 87 51 51 sky130_fd_pr__nfet_01v8 L=0.15U W=0.65U AS=0.169P AD=0.10725P
+ PS=1.82U PD=0.98U
* device instance $56 r0 *1 25.73,7.6 sky130_fd_pr__nfet_01v8
M$56 94 89 106 106 sky130_fd_pr__nfet_01v8 L=0.15U W=0.65U AS=0.10725P
+ AD=0.102375P PS=0.98U PD=0.965U
* device instance $57 r0 *1 26.195,7.6 sky130_fd_pr__nfet_01v8
M$57 67 51 94 94 sky130_fd_pr__nfet_01v8 L=0.15U W=0.65U AS=0.102375P AD=0.169P
+ PS=0.965U PD=1.82U
* device instance $58 r0 *1 27.64,7.715 sky130_fd_pr__nfet_01v8
M$58 94 69 92 92 sky130_fd_pr__nfet_01v8 L=0.15U W=0.42U AS=0.1113P AD=0.0588P
+ PS=1.37U PD=0.7U
* device instance $59 r0 *1 28.07,7.715 sky130_fd_pr__nfet_01v8
M$59 92 71 94 94 sky130_fd_pr__nfet_01v8 L=0.15U W=0.42U AS=0.0588P AD=0.0588P
+ PS=0.7U PD=0.7U
* device instance $60 r0 *1 28.5,7.715 sky130_fd_pr__nfet_01v8
M$60 70 53 92 92 sky130_fd_pr__nfet_01v8 L=0.15U W=0.42U AS=0.0588P AD=0.1113P
+ PS=0.7U PD=1.37U
* device instance $61 r0 *1 44.67,7.6 sky130_fd_pr__nfet_01v8
M$61 54 72 94 94 sky130_fd_pr__nfet_01v8 L=0.15U W=0.65U AS=0.169P AD=0.08775P
+ PS=1.82U PD=0.92U
* device instance $62 r0 *1 45.09,7.6 sky130_fd_pr__nfet_01v8
M$62 94 55 54 54 sky130_fd_pr__nfet_01v8 L=0.15U W=0.65U AS=0.08775P
+ AD=0.08775P PS=0.92U PD=0.92U
* device instance $63 r0 *1 45.51,7.6 sky130_fd_pr__nfet_01v8
M$63 107 55 94 94 sky130_fd_pr__nfet_01v8 L=0.15U W=0.65U AS=0.08775P
+ AD=0.08775P PS=0.92U PD=0.92U
* device instance $64 r0 *1 45.93,7.6 sky130_fd_pr__nfet_01v8
M$64 57 72 107 107 sky130_fd_pr__nfet_01v8 L=0.15U W=0.65U AS=0.08775P
+ AD=0.25025P PS=0.92U PD=1.42U
* device instance $65 r0 *1 46.85,7.6 sky130_fd_pr__nfet_01v8
M$65 94 54 57 57 sky130_fd_pr__nfet_01v8 L=0.15U W=0.65U AS=0.25025P AD=0.208P
+ PS=1.42U PD=1.94U
* device instance $66 r0 *1 64.87,7.715 sky130_fd_pr__nfet_01v8
M$66 94 329 58 58 sky130_fd_pr__nfet_01v8 L=0.15U W=0.42U AS=0.1092P AD=0.0567P
+ PS=1.36U PD=0.69U
* device instance $67 r0 *1 65.29,7.715 sky130_fd_pr__nfet_01v8
M$67 59 58 94 94 sky130_fd_pr__nfet_01v8 L=0.15U W=0.42U AS=0.0567P AD=0.1092P
+ PS=0.69U PD=1.36U
* device instance $68 r0 *1 66.23,7.715 sky130_fd_pr__nfet_01v8
M$68 104 73 60 60 sky130_fd_pr__nfet_01v8 L=0.15U W=0.42U AS=0.1092P AD=0.0441P
+ PS=1.36U PD=0.63U
* device instance $69 r0 *1 66.59,7.715 sky130_fd_pr__nfet_01v8
M$69 94 90 104 104 sky130_fd_pr__nfet_01v8 L=0.15U W=0.42U AS=0.0441P
+ AD=0.1092P PS=0.63U PD=1.36U
* device instance $70 r0 *1 67.53,7.715 sky130_fd_pr__nfet_01v8
M$70 94 90 61 61 sky130_fd_pr__nfet_01v8 L=0.15U W=0.42U AS=0.1092P AD=0.0609P
+ PS=1.36U PD=0.71U
* device instance $71 r0 *1 67.97,7.715 sky130_fd_pr__nfet_01v8
M$71 103 61 94 94 sky130_fd_pr__nfet_01v8 L=0.15U W=0.42U AS=0.0609P AD=0.0756P
+ PS=0.71U PD=0.78U
* device instance $72 r0 *1 68.48,7.715 sky130_fd_pr__nfet_01v8
M$72 60 64 103 103 sky130_fd_pr__nfet_01v8 L=0.15U W=0.42U AS=0.0756P
+ AD=0.1446P PS=0.78U PD=1.18U
* device instance $73 r0 *1 69.39,7.745 sky130_fd_pr__nfet_01v8
M$73 62 58 60 60 sky130_fd_pr__nfet_01v8 L=0.15U W=0.36U AS=0.1446P AD=0.0522P
+ PS=1.18U PD=0.65U
* device instance $74 r0 *1 69.83,7.745 sky130_fd_pr__nfet_01v8
M$74 62 59 100 100 sky130_fd_pr__nfet_01v8 L=0.15U W=0.36U AS=0.0759P
+ AD=0.0522P PS=0.8U PD=0.65U
* device instance $75 r0 *1 70.36,7.715 sky130_fd_pr__nfet_01v8
M$75 100 63 94 94 sky130_fd_pr__nfet_01v8 L=0.15U W=0.42U AS=0.12095P
+ AD=0.0759P PS=1.085U PD=0.8U
* device instance $76 r0 *1 70.955,7.605 sky130_fd_pr__nfet_01v8
M$76 63 62 94 94 sky130_fd_pr__nfet_01v8 L=0.15U W=0.64U AS=0.12095P AD=0.1664P
+ PS=1.085U PD=1.8U
* device instance $77 r0 *1 71.895,7.715 sky130_fd_pr__nfet_01v8
M$77 98 63 94 94 sky130_fd_pr__nfet_01v8 L=0.15U W=0.42U AS=0.1092P AD=0.0678P
+ PS=1.36U PD=0.755U
* device instance $78 r0 *1 72.38,7.745 sky130_fd_pr__nfet_01v8
M$78 74 59 98 98 sky130_fd_pr__nfet_01v8 L=0.15U W=0.36U AS=0.0678P AD=0.0684P
+ PS=0.755U PD=0.74U
* device instance $79 r0 *1 72.91,7.745 sky130_fd_pr__nfet_01v8
M$79 74 58 96 96 sky130_fd_pr__nfet_01v8 L=0.15U W=0.36U AS=0.066P AD=0.0684P
+ PS=0.745U PD=0.74U
* device instance $80 r0 *1 73.385,7.715 sky130_fd_pr__nfet_01v8
M$80 94 64 96 96 sky130_fd_pr__nfet_01v8 L=0.15U W=0.42U AS=0.066P AD=0.1092P
+ PS=0.745U PD=1.36U
* device instance $81 r0 *1 74.325,7.715 sky130_fd_pr__nfet_01v8
M$81 64 74 94 94 sky130_fd_pr__nfet_01v8 L=0.15U W=0.42U AS=0.10025P AD=0.1092P
+ PS=0.985U PD=1.36U
* device instance $82 r0 *1 74.81,7.6 sky130_fd_pr__nfet_01v8
M$82 136 74 94 94 sky130_fd_pr__nfet_01v8 L=0.15U W=0.65U AS=0.10025P AD=0.182P
+ PS=0.985U PD=1.86U
* device instance $83 r0 *1 6.98,8.605 sky130_fd_pr__nfet_01v8
M$83 138 156 108 108 sky130_fd_pr__nfet_01v8 L=0.15U W=0.42U AS=0.1113P
+ AD=0.0441P PS=1.37U PD=0.63U
* device instance $84 r0 *1 7.34,8.605 sky130_fd_pr__nfet_01v8
M$84 94 109 138 138 sky130_fd_pr__nfet_01v8 L=0.15U W=0.42U AS=0.0441P
+ AD=0.0966P PS=0.63U PD=0.88U
* device instance $85 r0 *1 7.95,8.605 sky130_fd_pr__nfet_01v8
M$85 110 108 94 94 sky130_fd_pr__nfet_01v8 L=0.15U W=0.42U AS=0.0966P
+ AD=0.1113P PS=0.88U PD=1.37U
* device instance $86 r0 *1 9.21,8.72 sky130_fd_pr__nfet_01v8
M$86 94 110 111 111 sky130_fd_pr__nfet_01v8 L=0.15U W=0.65U AS=0.169P
+ AD=0.10725P PS=1.82U PD=0.98U
* device instance $87 r0 *1 9.69,8.72 sky130_fd_pr__nfet_01v8
M$87 141 12 94 94 sky130_fd_pr__nfet_01v8 L=0.15U W=0.65U AS=0.10725P
+ AD=0.06825P PS=0.98U PD=0.86U
* device instance $88 r0 *1 10.05,8.72 sky130_fd_pr__nfet_01v8
M$88 111 91 141 141 sky130_fd_pr__nfet_01v8 L=0.15U W=0.65U AS=0.06825P
+ AD=0.169P PS=0.86U PD=1.82U
* device instance $89 r0 *1 10.99,8.72 sky130_fd_pr__nfet_01v8
M$89 142 87 111 111 sky130_fd_pr__nfet_01v8 L=0.15U W=0.65U AS=0.169P
+ AD=0.10725P PS=1.82U PD=0.98U
* device instance $90 r0 *1 11.47,8.72 sky130_fd_pr__nfet_01v8
M$90 94 129 142 142 sky130_fd_pr__nfet_01v8 L=0.15U W=0.65U AS=0.10725P
+ AD=0.102375P PS=0.98U PD=0.965U
* device instance $91 r0 *1 11.935,8.72 sky130_fd_pr__nfet_01v8
M$91 65 111 94 94 sky130_fd_pr__nfet_01v8 L=0.15U W=0.65U AS=0.102375P
+ AD=0.169P PS=0.965U PD=1.82U
* device instance $92 r0 *1 23.08,8.605 sky130_fd_pr__nfet_01v8
M$92 144 157 112 112 sky130_fd_pr__nfet_01v8 L=0.15U W=0.42U AS=0.1113P
+ AD=0.0441P PS=1.37U PD=0.63U
* device instance $93 r0 *1 23.44,8.605 sky130_fd_pr__nfet_01v8
M$93 94 109 144 144 sky130_fd_pr__nfet_01v8 L=0.15U W=0.42U AS=0.0441P
+ AD=0.0966P PS=0.63U PD=0.88U
* device instance $94 r0 *1 24.05,8.605 sky130_fd_pr__nfet_01v8
M$94 88 112 94 94 sky130_fd_pr__nfet_01v8 L=0.15U W=0.42U AS=0.0966P AD=0.1113P
+ PS=0.88U PD=1.37U
* device instance $95 r0 *1 25.31,8.605 sky130_fd_pr__nfet_01v8
M$95 94 31 130 130 sky130_fd_pr__nfet_01v8 L=0.15U W=0.42U AS=0.1092P
+ AD=0.0567P PS=1.36U PD=0.69U
* device instance $96 r0 *1 25.73,8.605 sky130_fd_pr__nfet_01v8
M$96 131 130 94 94 sky130_fd_pr__nfet_01v8 L=0.15U W=0.42U AS=0.0567P
+ AD=0.1092P PS=0.69U PD=1.36U
* device instance $97 r0 *1 26.67,8.605 sky130_fd_pr__nfet_01v8
M$97 147 70 113 113 sky130_fd_pr__nfet_01v8 L=0.15U W=0.42U AS=0.1092P
+ AD=0.0441P PS=1.36U PD=0.63U
* device instance $98 r0 *1 27.03,8.605 sky130_fd_pr__nfet_01v8
M$98 94 90 147 147 sky130_fd_pr__nfet_01v8 L=0.15U W=0.42U AS=0.0441P
+ AD=0.1092P PS=0.63U PD=1.36U
* device instance $99 r0 *1 29.83,8.575 sky130_fd_pr__nfet_01v8
M$99 114 130 113 113 sky130_fd_pr__nfet_01v8 L=0.15U W=0.36U AS=0.1446P
+ AD=0.0522P PS=1.18U PD=0.65U
* device instance $100 r0 *1 30.27,8.575 sky130_fd_pr__nfet_01v8
M$100 149 131 114 114 sky130_fd_pr__nfet_01v8 L=0.15U W=0.36U AS=0.0522P
+ AD=0.0759P PS=0.65U PD=0.8U
* device instance $101 r0 *1 27.97,8.605 sky130_fd_pr__nfet_01v8
M$101 94 90 132 132 sky130_fd_pr__nfet_01v8 L=0.15U W=0.42U AS=0.1092P
+ AD=0.0609P PS=1.36U PD=0.71U
* device instance $102 r0 *1 28.41,8.605 sky130_fd_pr__nfet_01v8
M$102 148 132 94 94 sky130_fd_pr__nfet_01v8 L=0.15U W=0.42U AS=0.0609P
+ AD=0.0756P PS=0.71U PD=0.78U
* device instance $103 r0 *1 28.92,8.605 sky130_fd_pr__nfet_01v8
M$103 113 133 148 148 sky130_fd_pr__nfet_01v8 L=0.15U W=0.42U AS=0.0756P
+ AD=0.1446P PS=0.78U PD=1.18U
* device instance $104 r0 *1 30.8,8.605 sky130_fd_pr__nfet_01v8
M$104 94 115 149 149 sky130_fd_pr__nfet_01v8 L=0.15U W=0.42U AS=0.0759P
+ AD=0.12095P PS=0.8U PD=1.085U
* device instance $105 r0 *1 31.395,8.715 sky130_fd_pr__nfet_01v8
M$105 115 114 94 94 sky130_fd_pr__nfet_01v8 L=0.15U W=0.64U AS=0.12095P
+ AD=0.1664P PS=1.085U PD=1.8U
* device instance $106 r0 *1 32.82,8.575 sky130_fd_pr__nfet_01v8
M$106 116 131 151 151 sky130_fd_pr__nfet_01v8 L=0.15U W=0.36U AS=0.0678P
+ AD=0.0684P PS=0.755U PD=0.74U
* device instance $107 r0 *1 33.35,8.575 sky130_fd_pr__nfet_01v8
M$107 153 130 116 116 sky130_fd_pr__nfet_01v8 L=0.15U W=0.36U AS=0.0684P
+ AD=0.066P PS=0.74U PD=0.745U
* device instance $108 r0 *1 32.335,8.605 sky130_fd_pr__nfet_01v8
M$108 151 115 94 94 sky130_fd_pr__nfet_01v8 L=0.15U W=0.42U AS=0.1092P
+ AD=0.0678P PS=1.36U PD=0.755U
* device instance $109 r0 *1 33.825,8.605 sky130_fd_pr__nfet_01v8
M$109 94 133 153 153 sky130_fd_pr__nfet_01v8 L=0.15U W=0.42U AS=0.066P
+ AD=0.1092P PS=0.745U PD=1.36U
* device instance $110 r0 *1 34.765,8.605 sky130_fd_pr__nfet_01v8
M$110 94 116 133 133 sky130_fd_pr__nfet_01v8 L=0.15U W=0.42U AS=0.1092P
+ AD=0.10025P PS=1.36U PD=0.985U
* device instance $111 r0 *1 35.25,8.72 sky130_fd_pr__nfet_01v8
M$111 163 116 94 94 sky130_fd_pr__nfet_01v8 L=0.15U W=0.65U AS=0.10025P
+ AD=0.182P PS=0.985U PD=1.86U
* device instance $112 r0 *1 37.34,8.605 sky130_fd_pr__nfet_01v8
M$112 154 158 117 117 sky130_fd_pr__nfet_01v8 L=0.15U W=0.42U AS=0.1113P
+ AD=0.0441P PS=1.37U PD=0.63U
* device instance $113 r0 *1 37.7,8.605 sky130_fd_pr__nfet_01v8
M$113 94 109 154 154 sky130_fd_pr__nfet_01v8 L=0.15U W=0.42U AS=0.0441P
+ AD=0.0966P PS=0.63U PD=0.88U
* device instance $114 r0 *1 38.31,8.605 sky130_fd_pr__nfet_01v8
M$114 118 117 94 94 sky130_fd_pr__nfet_01v8 L=0.15U W=0.42U AS=0.0966P
+ AD=0.1113P PS=0.88U PD=1.37U
* device instance $115 r0 *1 44.7,8.605 sky130_fd_pr__nfet_01v8
M$115 155 159 119 119 sky130_fd_pr__nfet_01v8 L=0.15U W=0.42U AS=0.1113P
+ AD=0.0441P PS=1.37U PD=0.63U
* device instance $116 r0 *1 45.06,8.605 sky130_fd_pr__nfet_01v8
M$116 94 109 155 155 sky130_fd_pr__nfet_01v8 L=0.15U W=0.42U AS=0.0441P
+ AD=0.0966P PS=0.63U PD=0.88U
* device instance $117 r0 *1 45.67,8.605 sky130_fd_pr__nfet_01v8
M$117 164 119 94 94 sky130_fd_pr__nfet_01v8 L=0.15U W=0.42U AS=0.0966P
+ AD=0.1113P PS=0.88U PD=1.37U
* device instance $118 r0 *1 47.475,8.605 sky130_fd_pr__nfet_01v8
M$118 152 71 94 94 sky130_fd_pr__nfet_01v8 L=0.15U W=0.42U AS=0.11285P
+ AD=0.0693P PS=1.045U PD=0.75U
* device instance $119 r0 *1 47.955,8.605 sky130_fd_pr__nfet_01v8
M$119 121 135 152 152 sky130_fd_pr__nfet_01v8 L=0.15U W=0.42U AS=0.0693P
+ AD=0.09975P PS=0.75U PD=0.895U
* device instance $120 r0 *1 48.58,8.605 sky130_fd_pr__nfet_01v8
M$120 150 134 121 121 sky130_fd_pr__nfet_01v8 L=0.15U W=0.42U AS=0.09975P
+ AD=0.0693P PS=0.895U PD=0.75U
* device instance $121 r0 *1 49.06,8.605 sky130_fd_pr__nfet_01v8
M$121 94 122 150 150 sky130_fd_pr__nfet_01v8 L=0.15U W=0.42U AS=0.0693P
+ AD=0.1449P PS=0.75U PD=1.11U
* device instance $122 r0 *1 49.9,8.605 sky130_fd_pr__nfet_01v8
M$122 122 71 94 94 sky130_fd_pr__nfet_01v8 L=0.15U W=0.42U AS=0.1449P
+ AD=0.1092P PS=1.11U PD=1.36U
* device instance $123 r0 *1 46.93,8.72 sky130_fd_pr__nfet_01v8
M$123 94 121 120 120 sky130_fd_pr__nfet_01v8 L=0.15U W=0.65U AS=0.169P
+ AD=0.11285P PS=1.82U PD=1.045U
* device instance $124 r0 *1 57.58,8.605 sky130_fd_pr__nfet_01v8
M$124 146 160 123 123 sky130_fd_pr__nfet_01v8 L=0.15U W=0.42U AS=0.1113P
+ AD=0.0441P PS=1.37U PD=0.63U
* device instance $125 r0 *1 57.94,8.605 sky130_fd_pr__nfet_01v8
M$125 94 109 146 146 sky130_fd_pr__nfet_01v8 L=0.15U W=0.42U AS=0.0441P
+ AD=0.0966P PS=0.63U PD=0.88U
* device instance $126 r0 *1 58.55,8.605 sky130_fd_pr__nfet_01v8
M$126 124 123 94 94 sky130_fd_pr__nfet_01v8 L=0.15U W=0.42U AS=0.0966P
+ AD=0.1113P PS=0.88U PD=1.37U
* device instance $127 r0 *1 59.81,8.72 sky130_fd_pr__nfet_01v8
M$127 94 124 125 125 sky130_fd_pr__nfet_01v8 L=0.15U W=0.65U AS=0.169P
+ AD=0.10725P PS=1.82U PD=0.98U
* device instance $128 r0 *1 60.29,8.72 sky130_fd_pr__nfet_01v8
M$128 145 136 94 94 sky130_fd_pr__nfet_01v8 L=0.15U W=0.65U AS=0.10725P
+ AD=0.06825P PS=0.98U PD=0.86U
* device instance $129 r0 *1 60.65,8.72 sky130_fd_pr__nfet_01v8
M$129 125 91 145 145 sky130_fd_pr__nfet_01v8 L=0.15U W=0.65U AS=0.06825P
+ AD=0.169P PS=0.86U PD=1.82U
* device instance $130 r0 *1 61.59,8.72 sky130_fd_pr__nfet_01v8
M$130 143 137 125 125 sky130_fd_pr__nfet_01v8 L=0.15U W=0.65U AS=0.169P
+ AD=0.10725P PS=1.82U PD=0.98U
* device instance $131 r0 *1 62.07,8.72 sky130_fd_pr__nfet_01v8
M$131 94 1 143 143 sky130_fd_pr__nfet_01v8 L=0.15U W=0.65U AS=0.10725P
+ AD=0.102375P PS=0.98U PD=0.965U
* device instance $132 r0 *1 62.535,8.72 sky130_fd_pr__nfet_01v8
M$132 14 125 94 94 sky130_fd_pr__nfet_01v8 L=0.15U W=0.65U AS=0.102375P
+ AD=0.169P PS=0.965U PD=1.82U
* device instance $133 r0 *1 68.175,8.605 sky130_fd_pr__nfet_01v8
M$133 140 71 94 94 sky130_fd_pr__nfet_01v8 L=0.15U W=0.42U AS=0.11285P
+ AD=0.0693P PS=1.045U PD=0.75U
* device instance $134 r0 *1 68.655,8.605 sky130_fd_pr__nfet_01v8
M$134 126 127 140 140 sky130_fd_pr__nfet_01v8 L=0.15U W=0.42U AS=0.0693P
+ AD=0.09975P PS=0.75U PD=0.895U
* device instance $135 r0 *1 69.28,8.605 sky130_fd_pr__nfet_01v8
M$135 139 20 126 126 sky130_fd_pr__nfet_01v8 L=0.15U W=0.42U AS=0.09975P
+ AD=0.0693P PS=0.895U PD=0.75U
* device instance $136 r0 *1 69.76,8.605 sky130_fd_pr__nfet_01v8
M$136 94 128 139 139 sky130_fd_pr__nfet_01v8 L=0.15U W=0.42U AS=0.0693P
+ AD=0.1449P PS=0.75U PD=1.11U
* device instance $137 r0 *1 70.6,8.605 sky130_fd_pr__nfet_01v8
M$137 128 71 94 94 sky130_fd_pr__nfet_01v8 L=0.15U W=0.42U AS=0.1449P
+ AD=0.1092P PS=1.11U PD=1.36U
* device instance $138 r0 *1 67.63,8.72 sky130_fd_pr__nfet_01v8
M$138 94 126 73 73 sky130_fd_pr__nfet_01v8 L=0.15U W=0.65U AS=0.169P
+ AD=0.11285P PS=1.82U PD=1.045U
* device instance $139 r0 *1 7.83,13.04 sky130_fd_pr__nfet_01v8
M$139 94 177 32 32 sky130_fd_pr__nfet_01v8 L=0.15U W=0.65U AS=0.169P
+ AD=0.11285P PS=1.82U PD=1.045U
* device instance $140 r0 *1 8.375,13.155 sky130_fd_pr__nfet_01v8
M$140 235 71 94 94 sky130_fd_pr__nfet_01v8 L=0.15U W=0.42U AS=0.11285P
+ AD=0.0693P PS=1.045U PD=0.75U
* device instance $141 r0 *1 8.855,13.155 sky130_fd_pr__nfet_01v8
M$141 177 208 235 235 sky130_fd_pr__nfet_01v8 L=0.15U W=0.42U AS=0.0693P
+ AD=0.09975P PS=0.75U PD=0.895U
* device instance $142 r0 *1 9.48,13.155 sky130_fd_pr__nfet_01v8
M$142 236 50 177 177 sky130_fd_pr__nfet_01v8 L=0.15U W=0.42U AS=0.09975P
+ AD=0.0693P PS=0.895U PD=0.75U
* device instance $143 r0 *1 9.96,13.155 sky130_fd_pr__nfet_01v8
M$143 94 232 236 236 sky130_fd_pr__nfet_01v8 L=0.15U W=0.42U AS=0.0693P
+ AD=0.1449P PS=0.75U PD=1.11U
* device instance $144 r0 *1 10.8,13.155 sky130_fd_pr__nfet_01v8
M$144 232 71 94 94 sky130_fd_pr__nfet_01v8 L=0.15U W=0.42U AS=0.1449P
+ AD=0.1092P PS=1.11U PD=1.36U
* device instance $145 r0 *1 12.53,13.04 sky130_fd_pr__nfet_01v8
M$145 238 209 178 178 sky130_fd_pr__nfet_01v8 L=0.15U W=0.65U AS=0.169P
+ AD=0.06825P PS=1.82U PD=0.86U
* device instance $146 r0 *1 12.89,13.04 sky130_fd_pr__nfet_01v8
M$146 94 230 238 238 sky130_fd_pr__nfet_01v8 L=0.15U W=0.65U AS=0.06825P
+ AD=0.08775P PS=0.86U PD=0.92U
* device instance $147 r0 *1 13.31,13.04 sky130_fd_pr__nfet_01v8
M$147 233 230 94 94 sky130_fd_pr__nfet_01v8 L=0.15U W=0.65U AS=0.08775P
+ AD=0.169P PS=0.92U PD=1.82U
* device instance $148 r0 *1 14.25,13.04 sky130_fd_pr__nfet_01v8
M$148 233 209 94 94 sky130_fd_pr__nfet_01v8 L=0.15U W=0.65U AS=0.169P
+ AD=0.08775P PS=1.82U PD=0.92U
* device instance $149 r0 *1 14.67,13.04 sky130_fd_pr__nfet_01v8
M$149 129 178 233 233 sky130_fd_pr__nfet_01v8 L=0.15U W=0.65U AS=0.08775P
+ AD=0.195P PS=0.92U PD=1.9U
* device instance $150 r0 *1 15.69,13.04 sky130_fd_pr__nfet_01v8
M$150 179 50 94 94 sky130_fd_pr__nfet_01v8 L=0.15U W=0.65U AS=0.169P
+ AD=0.08775P PS=1.82U PD=0.92U
* device instance $151 r0 *1 16.11,13.04 sky130_fd_pr__nfet_01v8
M$151 94 12 179 179 sky130_fd_pr__nfet_01v8 L=0.15U W=0.65U AS=0.08775P
+ AD=0.08775P PS=0.92U PD=0.92U
* device instance $152 r0 *1 16.53,13.04 sky130_fd_pr__nfet_01v8
M$152 241 12 94 94 sky130_fd_pr__nfet_01v8 L=0.15U W=0.65U AS=0.08775P
+ AD=0.08775P PS=0.92U PD=0.92U
* device instance $153 r0 *1 16.95,13.04 sky130_fd_pr__nfet_01v8
M$153 209 50 241 241 sky130_fd_pr__nfet_01v8 L=0.15U W=0.65U AS=0.08775P
+ AD=0.25025P PS=0.92U PD=1.42U
* device instance $154 r0 *1 17.87,13.04 sky130_fd_pr__nfet_01v8
M$154 94 179 209 209 sky130_fd_pr__nfet_01v8 L=0.15U W=0.65U AS=0.25025P
+ AD=0.208P PS=1.42U PD=1.94U
* device instance $155 r0 *1 19.33,13.155 sky130_fd_pr__nfet_01v8
M$155 94 31 181 181 sky130_fd_pr__nfet_01v8 L=0.15U W=0.42U AS=0.1092P
+ AD=0.0567P PS=1.36U PD=0.69U
* device instance $156 r0 *1 19.75,13.155 sky130_fd_pr__nfet_01v8
M$156 182 181 94 94 sky130_fd_pr__nfet_01v8 L=0.15U W=0.42U AS=0.0567P
+ AD=0.1092P PS=0.69U PD=1.36U
* device instance $157 r0 *1 20.69,13.155 sky130_fd_pr__nfet_01v8
M$157 242 67 184 184 sky130_fd_pr__nfet_01v8 L=0.15U W=0.42U AS=0.1092P
+ AD=0.0441P PS=1.36U PD=0.63U
* device instance $158 r0 *1 21.05,13.155 sky130_fd_pr__nfet_01v8
M$158 94 315 242 242 sky130_fd_pr__nfet_01v8 L=0.15U W=0.42U AS=0.0441P
+ AD=0.1092P PS=0.63U PD=1.36U
* device instance $159 r0 *1 21.99,13.155 sky130_fd_pr__nfet_01v8
M$159 94 315 183 183 sky130_fd_pr__nfet_01v8 L=0.15U W=0.42U AS=0.1092P
+ AD=0.0609P PS=1.36U PD=0.71U
* device instance $160 r0 *1 22.43,13.155 sky130_fd_pr__nfet_01v8
M$160 243 183 94 94 sky130_fd_pr__nfet_01v8 L=0.15U W=0.42U AS=0.0609P
+ AD=0.0756P PS=0.71U PD=0.78U
* device instance $161 r0 *1 22.94,13.155 sky130_fd_pr__nfet_01v8
M$161 184 188 243 243 sky130_fd_pr__nfet_01v8 L=0.15U W=0.42U AS=0.0756P
+ AD=0.1446P PS=0.78U PD=1.18U
* device instance $162 r0 *1 23.85,13.185 sky130_fd_pr__nfet_01v8
M$162 185 181 184 184 sky130_fd_pr__nfet_01v8 L=0.15U W=0.36U AS=0.1446P
+ AD=0.0522P PS=1.18U PD=0.65U
* device instance $163 r0 *1 24.29,13.185 sky130_fd_pr__nfet_01v8
M$163 185 182 245 245 sky130_fd_pr__nfet_01v8 L=0.15U W=0.36U AS=0.0759P
+ AD=0.0522P PS=0.8U PD=0.65U
* device instance $164 r0 *1 24.82,13.155 sky130_fd_pr__nfet_01v8
M$164 245 186 94 94 sky130_fd_pr__nfet_01v8 L=0.15U W=0.42U AS=0.12095P
+ AD=0.0759P PS=1.085U PD=0.8U
* device instance $165 r0 *1 25.415,13.045 sky130_fd_pr__nfet_01v8
M$165 186 185 94 94 sky130_fd_pr__nfet_01v8 L=0.15U W=0.64U AS=0.12095P
+ AD=0.1664P PS=1.085U PD=1.8U
* device instance $166 r0 *1 26.355,13.155 sky130_fd_pr__nfet_01v8
M$166 247 186 94 94 sky130_fd_pr__nfet_01v8 L=0.15U W=0.42U AS=0.1092P
+ AD=0.0678P PS=1.36U PD=0.755U
* device instance $167 r0 *1 26.84,13.185 sky130_fd_pr__nfet_01v8
M$167 187 182 247 247 sky130_fd_pr__nfet_01v8 L=0.15U W=0.36U AS=0.0678P
+ AD=0.0684P PS=0.755U PD=0.74U
* device instance $168 r0 *1 27.37,13.185 sky130_fd_pr__nfet_01v8
M$168 187 181 248 248 sky130_fd_pr__nfet_01v8 L=0.15U W=0.36U AS=0.066P
+ AD=0.0684P PS=0.745U PD=0.74U
* device instance $169 r0 *1 27.845,13.155 sky130_fd_pr__nfet_01v8
M$169 94 188 248 248 sky130_fd_pr__nfet_01v8 L=0.15U W=0.42U AS=0.066P
+ AD=0.1092P PS=0.745U PD=1.36U
* device instance $170 r0 *1 28.785,13.155 sky130_fd_pr__nfet_01v8
M$170 188 187 94 94 sky130_fd_pr__nfet_01v8 L=0.15U W=0.42U AS=0.10025P
+ AD=0.1092P PS=0.985U PD=1.36U
* device instance $171 r0 *1 29.27,13.04 sky130_fd_pr__nfet_01v8
M$171 189 187 94 94 sky130_fd_pr__nfet_01v8 L=0.15U W=0.65U AS=0.10025P
+ AD=0.182P PS=0.985U PD=1.86U
* device instance $172 r0 *1 30.85,13.04 sky130_fd_pr__nfet_01v8
M$172 251 93 94 94 sky130_fd_pr__nfet_01v8 L=0.15U W=0.65U AS=0.169P
+ AD=0.08775P PS=1.82U PD=0.92U
* device instance $173 r0 *1 31.27,13.04 sky130_fd_pr__nfet_01v8
M$173 53 71 251 251 sky130_fd_pr__nfet_01v8 L=0.15U W=0.65U AS=0.08775P
+ AD=0.169P PS=0.92U PD=1.82U
* device instance $174 r0 *1 32.625,13.155 sky130_fd_pr__nfet_01v8
M$174 94 189 69 69 sky130_fd_pr__nfet_01v8 L=0.15U W=0.42U AS=0.1092P
+ AD=0.1197P PS=1.36U PD=1.41U
* device instance $175 r0 *1 33.605,13.04 sky130_fd_pr__nfet_01v8
M$175 94 163 234 234 sky130_fd_pr__nfet_01v8 L=0.15U W=1.3U AS=0.299P AD=0.182P
+ PS=2.87U PD=1.86U
* device instance $176 r0 *1 34.035,13.04 sky130_fd_pr__nfet_01v8
M$176 234 69 94 94 sky130_fd_pr__nfet_01v8 L=0.15U W=1.3U AS=0.182P AD=0.21775P
+ PS=1.86U PD=1.97U
* device instance $179 r0 *1 35.435,13.04 sky130_fd_pr__nfet_01v8
M$179 72 191 234 234 sky130_fd_pr__nfet_01v8 L=0.15U W=1.3U AS=0.182P
+ AD=0.26325P PS=1.86U PD=2.76U
* device instance $181 r0 *1 40.95,13.04 sky130_fd_pr__nfet_01v8
M$181 94 164 192 192 sky130_fd_pr__nfet_01v8 L=0.15U W=0.65U AS=0.169P
+ AD=0.10725P PS=1.82U PD=0.98U
* device instance $182 r0 *1 41.43,13.04 sky130_fd_pr__nfet_01v8
M$182 254 231 94 94 sky130_fd_pr__nfet_01v8 L=0.15U W=0.65U AS=0.10725P
+ AD=0.06825P PS=0.98U PD=0.86U
* device instance $183 r0 *1 41.79,13.04 sky130_fd_pr__nfet_01v8
M$183 192 91 254 254 sky130_fd_pr__nfet_01v8 L=0.15U W=0.65U AS=0.06825P
+ AD=0.169P PS=0.86U PD=1.82U
* device instance $184 r0 *1 42.73,13.04 sky130_fd_pr__nfet_01v8
M$184 253 137 192 192 sky130_fd_pr__nfet_01v8 L=0.15U W=0.65U AS=0.169P
+ AD=0.10725P PS=1.82U PD=0.98U
* device instance $185 r0 *1 43.21,13.04 sky130_fd_pr__nfet_01v8
M$185 94 57 253 253 sky130_fd_pr__nfet_01v8 L=0.15U W=0.65U AS=0.10725P
+ AD=0.102375P PS=0.98U PD=0.965U
* device instance $186 r0 *1 43.675,13.04 sky130_fd_pr__nfet_01v8
M$186 194 192 94 94 sky130_fd_pr__nfet_01v8 L=0.15U W=0.65U AS=0.102375P
+ AD=0.169P PS=0.965U PD=1.82U
* device instance $187 r0 *1 46.93,13.155 sky130_fd_pr__nfet_01v8
M$187 94 329 195 195 sky130_fd_pr__nfet_01v8 L=0.15U W=0.42U AS=0.1092P
+ AD=0.0567P PS=1.36U PD=0.69U
* device instance $188 r0 *1 47.35,13.155 sky130_fd_pr__nfet_01v8
M$188 196 195 94 94 sky130_fd_pr__nfet_01v8 L=0.15U W=0.42U AS=0.0567P
+ AD=0.1092P PS=0.69U PD=1.36U
* device instance $189 r0 *1 48.29,13.155 sky130_fd_pr__nfet_01v8
M$189 252 120 198 198 sky130_fd_pr__nfet_01v8 L=0.15U W=0.42U AS=0.1092P
+ AD=0.0441P PS=1.36U PD=0.63U
* device instance $190 r0 *1 48.65,13.155 sky130_fd_pr__nfet_01v8
M$190 94 90 252 252 sky130_fd_pr__nfet_01v8 L=0.15U W=0.42U AS=0.0441P
+ AD=0.1092P PS=0.63U PD=1.36U
* device instance $191 r0 *1 49.59,13.155 sky130_fd_pr__nfet_01v8
M$191 94 90 197 197 sky130_fd_pr__nfet_01v8 L=0.15U W=0.42U AS=0.1092P
+ AD=0.0609P PS=1.36U PD=0.71U
* device instance $192 r0 *1 50.03,13.155 sky130_fd_pr__nfet_01v8
M$192 250 197 94 94 sky130_fd_pr__nfet_01v8 L=0.15U W=0.42U AS=0.0609P
+ AD=0.0756P PS=0.71U PD=0.78U
* device instance $193 r0 *1 50.54,13.155 sky130_fd_pr__nfet_01v8
M$193 198 202 250 250 sky130_fd_pr__nfet_01v8 L=0.15U W=0.42U AS=0.0756P
+ AD=0.1446P PS=0.78U PD=1.18U
* device instance $194 r0 *1 51.45,13.185 sky130_fd_pr__nfet_01v8
M$194 199 195 198 198 sky130_fd_pr__nfet_01v8 L=0.15U W=0.36U AS=0.1446P
+ AD=0.0522P PS=1.18U PD=0.65U
* device instance $195 r0 *1 51.89,13.185 sky130_fd_pr__nfet_01v8
M$195 199 196 249 249 sky130_fd_pr__nfet_01v8 L=0.15U W=0.36U AS=0.0759P
+ AD=0.0522P PS=0.8U PD=0.65U
* device instance $196 r0 *1 52.42,13.155 sky130_fd_pr__nfet_01v8
M$196 249 200 94 94 sky130_fd_pr__nfet_01v8 L=0.15U W=0.42U AS=0.12095P
+ AD=0.0759P PS=1.085U PD=0.8U
* device instance $197 r0 *1 53.015,13.045 sky130_fd_pr__nfet_01v8
M$197 200 199 94 94 sky130_fd_pr__nfet_01v8 L=0.15U W=0.64U AS=0.12095P
+ AD=0.1664P PS=1.085U PD=1.8U
* device instance $198 r0 *1 53.955,13.155 sky130_fd_pr__nfet_01v8
M$198 246 200 94 94 sky130_fd_pr__nfet_01v8 L=0.15U W=0.42U AS=0.1092P
+ AD=0.0678P PS=1.36U PD=0.755U
* device instance $199 r0 *1 54.44,13.185 sky130_fd_pr__nfet_01v8
M$199 201 196 246 246 sky130_fd_pr__nfet_01v8 L=0.15U W=0.36U AS=0.0678P
+ AD=0.0684P PS=0.755U PD=0.74U
* device instance $200 r0 *1 54.97,13.185 sky130_fd_pr__nfet_01v8
M$200 201 195 244 244 sky130_fd_pr__nfet_01v8 L=0.15U W=0.36U AS=0.066P
+ AD=0.0684P PS=0.745U PD=0.74U
* device instance $201 r0 *1 55.445,13.155 sky130_fd_pr__nfet_01v8
M$201 94 202 244 244 sky130_fd_pr__nfet_01v8 L=0.15U W=0.42U AS=0.066P
+ AD=0.1092P PS=0.745U PD=1.36U
* device instance $202 r0 *1 56.385,13.155 sky130_fd_pr__nfet_01v8
M$202 202 201 94 94 sky130_fd_pr__nfet_01v8 L=0.15U W=0.42U AS=0.10025P
+ AD=0.1092P PS=0.985U PD=1.36U
* device instance $203 r0 *1 56.87,13.04 sky130_fd_pr__nfet_01v8
M$203 231 201 94 94 sky130_fd_pr__nfet_01v8 L=0.15U W=0.65U AS=0.10025P
+ AD=0.182P PS=0.985U PD=1.86U
* device instance $204 r0 *1 61.69,13.04 sky130_fd_pr__nfet_01v8
M$204 203 211 94 94 sky130_fd_pr__nfet_01v8 L=0.15U W=0.65U AS=0.169P
+ AD=0.08775P PS=1.82U PD=0.92U
* device instance $205 r0 *1 62.11,13.04 sky130_fd_pr__nfet_01v8
M$205 94 212 203 203 sky130_fd_pr__nfet_01v8 L=0.15U W=0.65U AS=0.08775P
+ AD=0.08775P PS=0.92U PD=0.92U
* device instance $206 r0 *1 62.53,13.04 sky130_fd_pr__nfet_01v8
M$206 240 212 94 94 sky130_fd_pr__nfet_01v8 L=0.15U W=0.65U AS=0.08775P
+ AD=0.08775P PS=0.92U PD=0.92U
* device instance $207 r0 *1 62.95,13.04 sky130_fd_pr__nfet_01v8
M$207 1 211 240 240 sky130_fd_pr__nfet_01v8 L=0.15U W=0.65U AS=0.08775P
+ AD=0.25025P PS=0.92U PD=1.42U
* device instance $208 r0 *1 63.87,13.04 sky130_fd_pr__nfet_01v8
M$208 94 203 1 1 sky130_fd_pr__nfet_01v8 L=0.15U W=0.65U AS=0.25025P AD=0.208P
+ PS=1.42U PD=1.94U
* device instance $209 r0 *1 66.29,13.04 sky130_fd_pr__nfet_01v8
M$209 205 20 94 94 sky130_fd_pr__nfet_01v8 L=0.15U W=0.65U AS=0.169P
+ AD=0.08775P PS=1.82U PD=0.92U
* device instance $210 r0 *1 66.71,13.04 sky130_fd_pr__nfet_01v8
M$210 94 136 205 205 sky130_fd_pr__nfet_01v8 L=0.15U W=0.65U AS=0.08775P
+ AD=0.08775P PS=0.92U PD=0.92U
* device instance $211 r0 *1 67.13,13.04 sky130_fd_pr__nfet_01v8
M$211 239 136 94 94 sky130_fd_pr__nfet_01v8 L=0.15U W=0.65U AS=0.08775P
+ AD=0.08775P PS=0.92U PD=0.92U
* device instance $212 r0 *1 67.55,13.04 sky130_fd_pr__nfet_01v8
M$212 212 20 239 239 sky130_fd_pr__nfet_01v8 L=0.15U W=0.65U AS=0.08775P
+ AD=0.25025P PS=0.92U PD=1.42U
* device instance $213 r0 *1 68.47,13.04 sky130_fd_pr__nfet_01v8
M$213 94 205 212 212 sky130_fd_pr__nfet_01v8 L=0.15U W=0.65U AS=0.25025P
+ AD=0.208P PS=1.42U PD=1.94U
* device instance $214 r0 *1 69.47,12.925 sky130_fd_pr__nfet_01v8
M$214 94 136 213 213 sky130_fd_pr__nfet_01v8 L=0.15U W=0.42U AS=0.1092P
+ AD=0.10025P PS=1.36U PD=0.985U
* device instance $215 r0 *1 69.955,13.04 sky130_fd_pr__nfet_01v8
M$215 237 20 94 94 sky130_fd_pr__nfet_01v8 L=0.15U W=0.65U AS=0.10025P
+ AD=0.08775P PS=0.985U PD=0.92U
* device instance $216 r0 *1 70.375,13.04 sky130_fd_pr__nfet_01v8
M$216 207 213 237 237 sky130_fd_pr__nfet_01v8 L=0.15U W=0.65U AS=0.08775P
+ AD=0.169P PS=0.92U PD=1.82U
* device instance $217 r0 *1 12.665,14.045 sky130_fd_pr__nfet_01v8
M$217 94 50 255 255 sky130_fd_pr__nfet_01v8 L=0.15U W=0.42U AS=0.1092P
+ AD=0.10025P PS=1.36U PD=0.985U
* device instance $218 r0 *1 13.15,14.16 sky130_fd_pr__nfet_01v8
M$218 256 12 94 94 sky130_fd_pr__nfet_01v8 L=0.15U W=0.65U AS=0.10025P
+ AD=0.08775P PS=0.985U PD=0.92U
* device instance $219 r0 *1 13.57,14.16 sky130_fd_pr__nfet_01v8
M$219 94 255 256 256 sky130_fd_pr__nfet_01v8 L=0.15U W=0.65U AS=0.08775P
+ AD=0.169P PS=0.92U PD=1.82U
* device instance $220 r0 *1 13.82,18.48 sky130_fd_pr__nfet_01v8
M$220 94 293 292 292 sky130_fd_pr__nfet_01v8 L=0.15U W=0.65U AS=0.169P
+ AD=0.25675P PS=1.82U PD=1.44U
* device instance $221 r0 *1 14.76,18.48 sky130_fd_pr__nfet_01v8
M$221 293 256 94 94 sky130_fd_pr__nfet_01v8 L=0.15U W=0.65U AS=0.25675P
+ AD=0.089375P PS=1.44U PD=0.925U
* device instance $222 r0 *1 15.185,18.48 sky130_fd_pr__nfet_01v8
M$222 318 230 293 293 sky130_fd_pr__nfet_01v8 L=0.15U W=0.65U AS=0.089375P
+ AD=0.091P PS=0.925U PD=0.93U
* device instance $223 r0 *1 15.615,18.48 sky130_fd_pr__nfet_01v8
M$223 94 257 318 318 sky130_fd_pr__nfet_01v8 L=0.15U W=0.65U AS=0.091P
+ AD=0.17225P PS=0.93U PD=1.83U
* device instance $224 r0 *1 15.145,14.045 sky130_fd_pr__nfet_01v8
M$224 94 209 257 257 sky130_fd_pr__nfet_01v8 L=0.15U W=0.42U AS=0.1092P
+ AD=0.1197P PS=1.36U PD=1.41U
* device instance $225 r0 *1 28.63,14.16 sky130_fd_pr__nfet_01v8
M$225 281 189 258 258 sky130_fd_pr__nfet_01v8 L=0.15U W=0.65U AS=0.169P
+ AD=0.06825P PS=1.82U PD=0.86U
* device instance $226 r0 *1 28.99,14.16 sky130_fd_pr__nfet_01v8
M$226 94 163 281 281 sky130_fd_pr__nfet_01v8 L=0.15U W=0.65U AS=0.06825P
+ AD=0.08775P PS=0.86U PD=0.92U
* device instance $227 r0 *1 29.41,14.16 sky130_fd_pr__nfet_01v8
M$227 259 163 94 94 sky130_fd_pr__nfet_01v8 L=0.15U W=0.65U AS=0.08775P
+ AD=0.169P PS=0.92U PD=1.82U
* device instance $228 r0 *1 30.35,14.16 sky130_fd_pr__nfet_01v8
M$228 259 189 94 94 sky130_fd_pr__nfet_01v8 L=0.15U W=0.65U AS=0.169P
+ AD=0.08775P PS=1.82U PD=0.92U
* device instance $229 r0 *1 30.77,14.16 sky130_fd_pr__nfet_01v8
M$229 276 258 259 259 sky130_fd_pr__nfet_01v8 L=0.15U W=0.65U AS=0.08775P
+ AD=0.195P PS=0.92U PD=1.9U
* device instance $230 r0 *1 31.985,14.045 sky130_fd_pr__nfet_01v8
M$230 94 191 260 260 sky130_fd_pr__nfet_01v8 L=0.15U W=0.42U AS=0.1092P
+ AD=0.10025P PS=1.36U PD=0.985U
* device instance $231 r0 *1 32.47,14.16 sky130_fd_pr__nfet_01v8
M$231 89 275 94 94 sky130_fd_pr__nfet_01v8 L=0.15U W=0.65U AS=0.10025P
+ AD=0.08775P PS=0.985U PD=0.92U
* device instance $232 r0 *1 32.89,14.16 sky130_fd_pr__nfet_01v8
M$232 94 260 89 89 sky130_fd_pr__nfet_01v8 L=0.15U W=0.65U AS=0.08775P
+ AD=0.169P PS=0.92U PD=1.82U
* device instance $233 r0 *1 34.05,14.16 sky130_fd_pr__nfet_01v8
M$233 191 276 261 261 sky130_fd_pr__nfet_01v8 L=0.15U W=1.3U AS=0.25675P
+ AD=0.1755P PS=2.74U PD=1.84U
* device instance $235 r0 *1 34.89,14.16 sky130_fd_pr__nfet_01v8
M$235 263 262 261 261 sky130_fd_pr__nfet_01v8 L=0.15U W=1.3U AS=0.1755P
+ AD=0.25675P PS=1.84U PD=2.74U
* device instance $237 r0 *1 34.07,18.48 sky130_fd_pr__nfet_01v8
M$237 275 276 94 94 sky130_fd_pr__nfet_01v8 L=0.15U W=0.65U AS=0.17225P
+ AD=0.091P PS=1.83U PD=0.93U
* device instance $238 r0 *1 34.5,18.48 sky130_fd_pr__nfet_01v8
M$238 324 262 275 275 sky130_fd_pr__nfet_01v8 L=0.15U W=0.65U AS=0.091P
+ AD=0.095875P PS=0.93U PD=0.945U
* device instance $239 r0 *1 34.945,18.48 sky130_fd_pr__nfet_01v8
M$239 94 277 324 324 sky130_fd_pr__nfet_01v8 L=0.15U W=0.65U AS=0.095875P
+ AD=0.17225P PS=0.945U PD=1.83U
* device instance $240 r0 *1 35.89,18.48 sky130_fd_pr__nfet_01v8
M$240 279 69 94 94 sky130_fd_pr__nfet_01v8 L=0.15U W=0.65U AS=0.169P
+ AD=0.08775P PS=1.82U PD=0.92U
* device instance $241 r0 *1 36.31,18.48 sky130_fd_pr__nfet_01v8
M$241 94 163 279 279 sky130_fd_pr__nfet_01v8 L=0.15U W=0.65U AS=0.08775P
+ AD=0.169P PS=0.92U PD=1.82U
* device instance $242 r0 *1 36.25,14.16 sky130_fd_pr__nfet_01v8
M$242 263 277 94 94 sky130_fd_pr__nfet_01v8 L=0.15U W=1.3U AS=0.25675P
+ AD=0.28925P PS=2.74U PD=2.84U
* device instance $244 r0 *1 37.73,14.16 sky130_fd_pr__nfet_01v8
M$244 94 262 264 264 sky130_fd_pr__nfet_01v8 L=0.15U W=1.3U AS=0.25675P
+ AD=0.1755P PS=2.74U PD=1.84U
* device instance $246 r0 *1 38.57,14.16 sky130_fd_pr__nfet_01v8
M$246 265 278 264 264 sky130_fd_pr__nfet_01v8 L=0.15U W=1.3U AS=0.1755P
+ AD=0.25675P PS=1.84U PD=2.74U
* device instance $248 r0 *1 39.93,14.16 sky130_fd_pr__nfet_01v8
M$248 265 276 266 266 sky130_fd_pr__nfet_01v8 L=0.15U W=1.3U AS=0.25675P
+ AD=0.18525P PS=2.74U PD=1.87U
* device instance $250 r0 *1 40.8,14.16 sky130_fd_pr__nfet_01v8
M$250 94 279 266 266 sky130_fd_pr__nfet_01v8 L=0.15U W=1.3U AS=0.18525P
+ AD=0.25675P PS=1.87U PD=2.09U
* device instance $252 r0 *1 41.89,14.16 sky130_fd_pr__nfet_01v8
M$252 94 267 266 266 sky130_fd_pr__nfet_01v8 L=0.15U W=1.3U AS=0.25675P
+ AD=0.25675P PS=2.09U PD=2.74U
* device instance $254 r0 *1 45.325,14.045 sky130_fd_pr__nfet_01v8
M$254 94 134 268 268 sky130_fd_pr__nfet_01v8 L=0.15U W=0.42U AS=0.1092P
+ AD=0.10025P PS=1.36U PD=0.985U
* device instance $255 r0 *1 45.81,14.16 sky130_fd_pr__nfet_01v8
M$255 267 231 94 94 sky130_fd_pr__nfet_01v8 L=0.15U W=0.65U AS=0.10025P
+ AD=0.08775P PS=0.985U PD=0.92U
* device instance $256 r0 *1 46.23,14.16 sky130_fd_pr__nfet_01v8
M$256 94 268 267 267 sky130_fd_pr__nfet_01v8 L=0.15U W=0.65U AS=0.08775P
+ AD=0.169P PS=0.92U PD=1.82U
* device instance $257 r0 *1 47.39,14.16 sky130_fd_pr__nfet_01v8
M$257 55 280 94 94 sky130_fd_pr__nfet_01v8 L=0.15U W=0.65U AS=0.169P
+ AD=0.08775P PS=1.82U PD=0.92U
* device instance $258 r0 *1 47.81,14.16 sky130_fd_pr__nfet_01v8
M$258 94 267 55 55 sky130_fd_pr__nfet_01v8 L=0.15U W=0.65U AS=0.08775P
+ AD=0.169P PS=0.92U PD=1.82U
* device instance $259 r0 *1 50.385,14.045 sky130_fd_pr__nfet_01v8
M$259 94 231 269 269 sky130_fd_pr__nfet_01v8 L=0.15U W=0.42U AS=0.1092P
+ AD=0.10025P PS=1.36U PD=0.985U
* device instance $260 r0 *1 50.87,14.16 sky130_fd_pr__nfet_01v8
M$260 280 134 94 94 sky130_fd_pr__nfet_01v8 L=0.15U W=0.65U AS=0.10025P
+ AD=0.08775P PS=0.985U PD=0.92U
* device instance $261 r0 *1 51.29,14.16 sky130_fd_pr__nfet_01v8
M$261 94 269 280 280 sky130_fd_pr__nfet_01v8 L=0.15U W=0.65U AS=0.08775P
+ AD=0.169P PS=0.92U PD=1.82U
* device instance $262 r0 *1 53.625,18.595 sky130_fd_pr__nfet_01v8
M$262 303 302 94 94 sky130_fd_pr__nfet_01v8 L=0.15U W=0.42U AS=0.10025P
+ AD=0.1092P PS=0.985U PD=1.36U
* device instance $263 r0 *1 54.11,18.48 sky130_fd_pr__nfet_01v8
M$263 134 302 94 94 sky130_fd_pr__nfet_01v8 L=0.15U W=0.65U AS=0.10025P
+ AD=0.182P PS=0.985U PD=1.86U
* device instance $264 r0 *1 57.655,14.045 sky130_fd_pr__nfet_01v8
M$264 270 280 94 94 sky130_fd_pr__nfet_01v8 L=0.15U W=0.42U AS=0.1092P
+ AD=0.0567P PS=1.36U PD=0.69U
* device instance $265 r0 *1 58.075,14.045 sky130_fd_pr__nfet_01v8
M$265 94 266 270 270 sky130_fd_pr__nfet_01v8 L=0.15U W=0.42U AS=0.0567P
+ AD=0.10025P PS=0.69U PD=0.985U
* device instance $266 r0 *1 58.56,14.16 sky130_fd_pr__nfet_01v8
M$266 271 270 94 94 sky130_fd_pr__nfet_01v8 L=0.15U W=0.65U AS=0.10025P
+ AD=0.169P PS=0.985U PD=1.82U
* device instance $267 r0 *1 59.95,18.48 sky130_fd_pr__nfet_01v8
M$267 94 212 316 316 sky130_fd_pr__nfet_01v8 L=0.15U W=1.3U AS=0.25675P
+ AD=0.1755P PS=2.74U PD=1.84U
* device instance $269 r0 *1 60.79,18.48 sky130_fd_pr__nfet_01v8
M$269 94 266 316 316 sky130_fd_pr__nfet_01v8 L=0.15U W=1.3U AS=0.1755P
+ AD=0.1755P PS=1.84U PD=1.84U
* device instance $271 r0 *1 61.63,18.48 sky130_fd_pr__nfet_01v8
M$271 94 280 316 316 sky130_fd_pr__nfet_01v8 L=0.15U W=1.3U AS=0.3185P
+ AD=0.3185P PS=2.28U PD=2.28U
* device instance $273 r0 *1 62.91,18.48 sky130_fd_pr__nfet_01v8
M$273 317 207 316 316 sky130_fd_pr__nfet_01v8 L=0.15U W=1.3U AS=0.1755P
+ AD=0.26975P PS=1.84U PD=2.78U
* device instance $275 r0 *1 63.5,14.045 sky130_fd_pr__nfet_01v8
M$275 273 207 272 272 sky130_fd_pr__nfet_01v8 L=0.15U W=0.42U AS=0.1113P
+ AD=0.0588P PS=1.37U PD=0.7U
* device instance $276 r0 *1 63.93,14.045 sky130_fd_pr__nfet_01v8
M$276 94 271 273 273 sky130_fd_pr__nfet_01v8 L=0.15U W=0.42U AS=0.0588P
+ AD=0.0588P PS=0.7U PD=0.7U
* device instance $277 r0 *1 64.36,14.045 sky130_fd_pr__nfet_01v8
M$277 273 212 94 94 sky130_fd_pr__nfet_01v8 L=0.15U W=0.42U AS=0.0588P
+ AD=0.1113P PS=0.7U PD=1.37U
* device instance $278 r0 *1 64.31,18.48 sky130_fd_pr__nfet_01v8
M$278 317 311 304 304 sky130_fd_pr__nfet_01v8 L=0.15U W=1.3U AS=0.26975P
+ AD=0.25675P PS=2.78U PD=2.74U
* device instance $280 r0 *1 65.32,14.16 sky130_fd_pr__nfet_01v8
M$280 211 274 94 94 sky130_fd_pr__nfet_01v8 L=0.15U W=2.6U AS=0.43225P
+ AD=0.351P PS=4.58U PD=3.68U
* device instance $284 r0 *1 67,14.16 sky130_fd_pr__nfet_01v8
M$284 274 271 94 94 sky130_fd_pr__nfet_01v8 L=0.15U W=0.65U AS=0.08775P
+ AD=0.169P PS=0.92U PD=1.82U
* device instance $285 r0 *1 17.03,19.6 sky130_fd_pr__nfet_01v8
M$285 94 334 335 335 sky130_fd_pr__nfet_01v8 L=0.15U W=0.65U AS=0.169P
+ AD=0.08775P PS=1.82U PD=0.92U
* device instance $286 r0 *1 17.45,19.6 sky130_fd_pr__nfet_01v8
M$286 230 335 94 94 sky130_fd_pr__nfet_01v8 L=0.15U W=2.6U AS=0.351P AD=0.52P
+ PS=3.68U PD=4.2U
* device instance $290 r0 *1 19.65,19.6 sky130_fd_pr__nfet_01v8
M$290 325 334 94 94 sky130_fd_pr__nfet_01v8 L=0.15U W=2.6U AS=0.52P AD=0.351P
+ PS=4.2U PD=3.68U
* device instance $293 r0 *1 20.91,19.6 sky130_fd_pr__nfet_01v8
M$293 336 257 325 325 sky130_fd_pr__nfet_01v8 L=0.15U W=2.6U AS=0.351P
+ AD=0.351P PS=3.68U PD=3.68U
* device instance $298 r0 *1 23.01,19.6 sky130_fd_pr__nfet_01v8
M$298 336 337 94 94 sky130_fd_pr__nfet_01v8 L=0.15U W=2.6U AS=0.378625P
+ AD=0.47775P PS=3.765U PD=4.72U
* device instance $301 r0 *1 24.35,19.6 sky130_fd_pr__nfet_01v8
M$301 94 256 336 336 sky130_fd_pr__nfet_01v8 L=0.15U W=2.6U AS=0.352625P
+ AD=0.35425P PS=3.685U PD=3.69U
* device instance $306 r0 *1 27.155,19.485 sky130_fd_pr__nfet_01v8
M$306 326 310 94 94 sky130_fd_pr__nfet_01v8 L=0.15U W=1.68U AS=0.2877P
+ AD=0.2352P PS=3.47U PD=2.8U
* device instance $310 r0 *1 28.875,19.485 sky130_fd_pr__nfet_01v8
M$310 31 326 94 94 sky130_fd_pr__nfet_01v8 L=0.15U W=6.72U AS=0.93975P
+ AD=1.07465P PS=11.195U PD=11.925U
* device instance $326 r0 *1 36.25,19.6 sky130_fd_pr__nfet_01v8
M$326 277 327 94 94 sky130_fd_pr__nfet_01v8 L=0.15U W=2.6U AS=0.45695P
+ AD=0.351P PS=4.19U PD=3.68U
* device instance $330 r0 *1 37.93,19.6 sky130_fd_pr__nfet_01v8
M$330 327 278 94 94 sky130_fd_pr__nfet_01v8 L=0.15U W=0.65U AS=0.08775P
+ AD=0.169P PS=0.92U PD=1.82U
* device instance $331 r0 *1 44.17,18.595 sky130_fd_pr__nfet_01v8
M$331 94 329 296 296 sky130_fd_pr__nfet_01v8 L=0.15U W=0.42U AS=0.1092P
+ AD=0.0567P PS=1.36U PD=0.69U
* device instance $332 r0 *1 44.59,18.595 sky130_fd_pr__nfet_01v8
M$332 297 296 94 94 sky130_fd_pr__nfet_01v8 L=0.15U W=0.42U AS=0.0567P
+ AD=0.1092P PS=0.69U PD=1.36U
* device instance $333 r0 *1 45.53,18.595 sky130_fd_pr__nfet_01v8
M$333 323 194 298 298 sky130_fd_pr__nfet_01v8 L=0.15U W=0.42U AS=0.1092P
+ AD=0.0441P PS=1.36U PD=0.63U
* device instance $334 r0 *1 45.89,18.595 sky130_fd_pr__nfet_01v8
M$334 94 315 323 323 sky130_fd_pr__nfet_01v8 L=0.15U W=0.42U AS=0.0441P
+ AD=0.1092P PS=0.63U PD=1.36U
* device instance $335 r0 *1 46.475,19.485 sky130_fd_pr__nfet_01v8
M$335 328 310 94 94 sky130_fd_pr__nfet_01v8 L=0.15U W=1.68U AS=0.2877P
+ AD=0.2352P PS=3.47U PD=2.8U
* device instance $339 r0 *1 48.195,19.485 sky130_fd_pr__nfet_01v8
M$339 329 328 94 94 sky130_fd_pr__nfet_01v8 L=0.15U W=6.72U AS=0.93975P
+ AD=0.99225P PS=11.195U PD=11.865U
* device instance $355 r0 *1 46.83,18.595 sky130_fd_pr__nfet_01v8
M$355 94 315 299 299 sky130_fd_pr__nfet_01v8 L=0.15U W=0.42U AS=0.1092P
+ AD=0.0609P PS=1.36U PD=0.71U
* device instance $356 r0 *1 47.27,18.595 sky130_fd_pr__nfet_01v8
M$356 322 299 94 94 sky130_fd_pr__nfet_01v8 L=0.15U W=0.42U AS=0.0609P
+ AD=0.0756P PS=0.71U PD=0.78U
* device instance $357 r0 *1 47.78,18.595 sky130_fd_pr__nfet_01v8
M$357 298 303 322 322 sky130_fd_pr__nfet_01v8 L=0.15U W=0.42U AS=0.0756P
+ AD=0.1446P PS=0.78U PD=1.18U
* device instance $358 r0 *1 48.69,18.625 sky130_fd_pr__nfet_01v8
M$358 300 296 298 298 sky130_fd_pr__nfet_01v8 L=0.15U W=0.36U AS=0.1446P
+ AD=0.0522P PS=1.18U PD=0.65U
* device instance $359 r0 *1 49.13,18.625 sky130_fd_pr__nfet_01v8
M$359 300 297 321 321 sky130_fd_pr__nfet_01v8 L=0.15U W=0.36U AS=0.0759P
+ AD=0.0522P PS=0.8U PD=0.65U
* device instance $360 r0 *1 49.66,18.595 sky130_fd_pr__nfet_01v8
M$360 321 301 94 94 sky130_fd_pr__nfet_01v8 L=0.15U W=0.42U AS=0.12095P
+ AD=0.0759P PS=1.085U PD=0.8U
* device instance $361 r0 *1 50.255,18.485 sky130_fd_pr__nfet_01v8
M$361 301 300 94 94 sky130_fd_pr__nfet_01v8 L=0.15U W=0.64U AS=0.12095P
+ AD=0.1664P PS=1.085U PD=1.8U
* device instance $362 r0 *1 51.195,18.595 sky130_fd_pr__nfet_01v8
M$362 320 301 94 94 sky130_fd_pr__nfet_01v8 L=0.15U W=0.42U AS=0.1092P
+ AD=0.0678P PS=1.36U PD=0.755U
* device instance $363 r0 *1 51.68,18.625 sky130_fd_pr__nfet_01v8
M$363 302 297 320 320 sky130_fd_pr__nfet_01v8 L=0.15U W=0.36U AS=0.0678P
+ AD=0.0684P PS=0.755U PD=0.74U
* device instance $364 r0 *1 52.21,18.625 sky130_fd_pr__nfet_01v8
M$364 302 296 319 319 sky130_fd_pr__nfet_01v8 L=0.15U W=0.36U AS=0.066P
+ AD=0.0684P PS=0.745U PD=0.74U
* device instance $365 r0 *1 52.685,18.595 sky130_fd_pr__nfet_01v8
M$365 94 303 319 319 sky130_fd_pr__nfet_01v8 L=0.15U W=0.42U AS=0.066P
+ AD=0.1092P PS=0.745U PD=1.36U
* device instance $366 r0 *1 63.51,19.6 sky130_fd_pr__nfet_01v8
M$366 343 338 94 94 sky130_fd_pr__nfet_01v8 L=0.15U W=0.65U AS=0.169P
+ AD=0.08775P PS=1.82U PD=0.92U
* device instance $367 r0 *1 63.93,19.6 sky130_fd_pr__nfet_01v8
M$367 330 311 343 343 sky130_fd_pr__nfet_01v8 L=0.15U W=0.65U AS=0.08775P
+ AD=0.169P PS=0.92U PD=1.82U
* device instance $368 r0 *1 64.97,19.6 sky130_fd_pr__nfet_01v8
M$368 342 272 331 331 sky130_fd_pr__nfet_01v8 L=0.15U W=0.65U AS=0.169P
+ AD=0.06825P PS=1.82U PD=0.86U
* device instance $369 r0 *1 65.33,19.6 sky130_fd_pr__nfet_01v8
M$369 94 330 342 342 sky130_fd_pr__nfet_01v8 L=0.15U W=0.65U AS=0.06825P
+ AD=0.08775P PS=0.86U PD=0.92U
* device instance $370 r0 *1 65.75,19.6 sky130_fd_pr__nfet_01v8
M$370 332 330 94 94 sky130_fd_pr__nfet_01v8 L=0.15U W=0.65U AS=0.08775P
+ AD=0.169P PS=0.92U PD=1.82U
* device instance $371 r0 *1 66.69,19.6 sky130_fd_pr__nfet_01v8
M$371 332 272 94 94 sky130_fd_pr__nfet_01v8 L=0.15U W=0.65U AS=0.169P
+ AD=0.08775P PS=1.82U PD=0.92U
* device instance $372 r0 *1 67.11,19.6 sky130_fd_pr__nfet_01v8
M$372 346 331 332 332 sky130_fd_pr__nfet_01v8 L=0.15U W=0.65U AS=0.08775P
+ AD=0.195P PS=0.92U PD=1.9U
* device instance $373 r0 *1 68.325,19.485 sky130_fd_pr__nfet_01v8
M$373 94 339 340 340 sky130_fd_pr__nfet_01v8 L=0.15U W=0.42U AS=0.1092P
+ AD=0.10025P PS=1.36U PD=0.985U
* device instance $374 r0 *1 68.81,19.6 sky130_fd_pr__nfet_01v8
M$374 333 341 94 94 sky130_fd_pr__nfet_01v8 L=0.15U W=0.65U AS=0.10025P
+ AD=0.08775P PS=0.985U PD=0.92U
* device instance $375 r0 *1 69.23,19.6 sky130_fd_pr__nfet_01v8
M$375 94 340 333 333 sky130_fd_pr__nfet_01v8 L=0.15U W=0.65U AS=0.08775P
+ AD=0.169P PS=0.92U PD=1.82U
* device instance $376 r0 *1 6.98,24.035 sky130_fd_pr__nfet_01v8
M$376 409 382 351 351 sky130_fd_pr__nfet_01v8 L=0.15U W=0.42U AS=0.1113P
+ AD=0.0441P PS=1.37U PD=0.63U
* device instance $377 r0 *1 7.34,24.035 sky130_fd_pr__nfet_01v8
M$377 94 109 409 409 sky130_fd_pr__nfet_01v8 L=0.15U W=0.42U AS=0.0441P
+ AD=0.0966P PS=0.63U PD=0.88U
* device instance $378 r0 *1 7.95,24.035 sky130_fd_pr__nfet_01v8
M$378 352 351 94 94 sky130_fd_pr__nfet_01v8 L=0.15U W=0.42U AS=0.0966P
+ AD=0.1113P PS=0.88U PD=1.37U
* device instance $379 r0 *1 9.21,23.92 sky130_fd_pr__nfet_01v8
M$379 94 352 353 353 sky130_fd_pr__nfet_01v8 L=0.15U W=0.65U AS=0.169P
+ AD=0.10725P PS=1.82U PD=0.98U
* device instance $380 r0 *1 9.69,23.92 sky130_fd_pr__nfet_01v8
M$380 412 355 94 94 sky130_fd_pr__nfet_01v8 L=0.15U W=0.65U AS=0.10725P
+ AD=0.06825P PS=0.98U PD=0.86U
* device instance $381 r0 *1 10.05,23.92 sky130_fd_pr__nfet_01v8
M$381 353 91 412 412 sky130_fd_pr__nfet_01v8 L=0.15U W=0.65U AS=0.06825P
+ AD=0.169P PS=0.86U PD=1.82U
* device instance $382 r0 *1 10.99,23.92 sky130_fd_pr__nfet_01v8
M$382 414 87 353 353 sky130_fd_pr__nfet_01v8 L=0.15U W=0.65U AS=0.169P
+ AD=0.10725P PS=1.82U PD=0.98U
* device instance $383 r0 *1 11.47,23.92 sky130_fd_pr__nfet_01v8
M$383 94 383 414 414 sky130_fd_pr__nfet_01v8 L=0.15U W=0.65U AS=0.10725P
+ AD=0.102375P PS=0.98U PD=0.965U
* device instance $384 r0 *1 11.935,23.92 sky130_fd_pr__nfet_01v8
M$384 405 353 94 94 sky130_fd_pr__nfet_01v8 L=0.15U W=0.65U AS=0.102375P
+ AD=0.169P PS=0.965U PD=1.82U
* device instance $385 r0 *1 12.93,23.92 sky130_fd_pr__nfet_01v8
M$385 356 385 94 94 sky130_fd_pr__nfet_01v8 L=0.15U W=0.65U AS=0.169P
+ AD=0.08775P PS=1.82U PD=0.92U
* device instance $386 r0 *1 13.35,23.92 sky130_fd_pr__nfet_01v8
M$386 94 292 356 356 sky130_fd_pr__nfet_01v8 L=0.15U W=0.65U AS=0.08775P
+ AD=0.08775P PS=0.92U PD=0.92U
* device instance $387 r0 *1 13.77,23.92 sky130_fd_pr__nfet_01v8
M$387 416 292 94 94 sky130_fd_pr__nfet_01v8 L=0.15U W=0.65U AS=0.08775P
+ AD=0.08775P PS=0.92U PD=0.92U
* device instance $388 r0 *1 14.19,23.92 sky130_fd_pr__nfet_01v8
M$388 383 385 416 416 sky130_fd_pr__nfet_01v8 L=0.15U W=0.65U AS=0.08775P
+ AD=0.25025P PS=0.92U PD=1.42U
* device instance $389 r0 *1 15.11,23.92 sky130_fd_pr__nfet_01v8
M$389 94 356 383 383 sky130_fd_pr__nfet_01v8 L=0.15U W=0.65U AS=0.25025P
+ AD=0.208P PS=1.42U PD=1.94U
* device instance $390 r0 *1 17.49,24.005 sky130_fd_pr__nfet_01v8
M$390 386 598 94 94 sky130_fd_pr__nfet_01v8 L=0.15U W=0.42U AS=0.1092P
+ AD=0.0693P PS=1.36U PD=0.75U
* device instance $391 r0 *1 17.97,24.005 sky130_fd_pr__nfet_01v8
M$391 94 12 386 386 sky130_fd_pr__nfet_01v8 L=0.15U W=0.42U AS=0.0693P
+ AD=0.0567P PS=0.75U PD=0.69U
* device instance $392 r0 *1 18.39,24.005 sky130_fd_pr__nfet_01v8
M$392 386 355 94 94 sky130_fd_pr__nfet_01v8 L=0.15U W=0.42U AS=0.0567P
+ AD=0.0567P PS=0.69U PD=0.69U
* device instance $393 r0 *1 18.81,24.005 sky130_fd_pr__nfet_01v8
M$393 386 163 94 94 sky130_fd_pr__nfet_01v8 L=0.15U W=0.42U AS=0.101875P
+ AD=0.0567P PS=0.99U PD=0.69U
* device instance $394 r0 *1 19.3,23.92 sky130_fd_pr__nfet_01v8
M$394 406 386 94 94 sky130_fd_pr__nfet_01v8 L=0.15U W=0.65U AS=0.101875P
+ AD=0.1755P PS=0.99U PD=1.84U
* device instance $395 r0 *1 27.625,24.035 sky130_fd_pr__nfet_01v8
M$395 358 31 94 94 sky130_fd_pr__nfet_01v8 L=0.15U W=1.68U AS=0.315P AD=0.3423P
+ PS=3.6U PD=3.73U
* device instance $399 r0 *1 41.41,24.035 sky130_fd_pr__nfet_01v8
M$399 94 329 359 359 sky130_fd_pr__nfet_01v8 L=0.15U W=0.42U AS=0.1092P
+ AD=0.0567P PS=1.36U PD=0.69U
* device instance $400 r0 *1 41.83,24.035 sky130_fd_pr__nfet_01v8
M$400 360 359 94 94 sky130_fd_pr__nfet_01v8 L=0.15U W=0.42U AS=0.0567P
+ AD=0.1092P PS=0.69U PD=1.36U
* device instance $401 r0 *1 42.77,24.035 sky130_fd_pr__nfet_01v8
M$401 421 387 362 362 sky130_fd_pr__nfet_01v8 L=0.15U W=0.42U AS=0.1092P
+ AD=0.0441P PS=1.36U PD=0.63U
* device instance $402 r0 *1 43.13,24.035 sky130_fd_pr__nfet_01v8
M$402 94 90 421 421 sky130_fd_pr__nfet_01v8 L=0.15U W=0.42U AS=0.0441P
+ AD=0.1092P PS=0.63U PD=1.36U
* device instance $403 r0 *1 44.07,24.035 sky130_fd_pr__nfet_01v8
M$403 94 90 361 361 sky130_fd_pr__nfet_01v8 L=0.15U W=0.42U AS=0.1092P
+ AD=0.0609P PS=1.36U PD=0.71U
* device instance $404 r0 *1 44.51,24.035 sky130_fd_pr__nfet_01v8
M$404 423 361 94 94 sky130_fd_pr__nfet_01v8 L=0.15U W=0.42U AS=0.0609P
+ AD=0.0756P PS=0.71U PD=0.78U
* device instance $405 r0 *1 45.02,24.035 sky130_fd_pr__nfet_01v8
M$405 362 366 423 423 sky130_fd_pr__nfet_01v8 L=0.15U W=0.42U AS=0.0756P
+ AD=0.1446P PS=0.78U PD=1.18U
* device instance $406 r0 *1 45.93,24.065 sky130_fd_pr__nfet_01v8
M$406 363 359 362 362 sky130_fd_pr__nfet_01v8 L=0.15U W=0.36U AS=0.1446P
+ AD=0.0522P PS=1.18U PD=0.65U
* device instance $407 r0 *1 46.37,24.065 sky130_fd_pr__nfet_01v8
M$407 363 360 424 424 sky130_fd_pr__nfet_01v8 L=0.15U W=0.36U AS=0.0759P
+ AD=0.0522P PS=0.8U PD=0.65U
* device instance $408 r0 *1 46.9,24.035 sky130_fd_pr__nfet_01v8
M$408 424 364 94 94 sky130_fd_pr__nfet_01v8 L=0.15U W=0.42U AS=0.12095P
+ AD=0.0759P PS=1.085U PD=0.8U
* device instance $409 r0 *1 47.495,23.925 sky130_fd_pr__nfet_01v8
M$409 364 363 94 94 sky130_fd_pr__nfet_01v8 L=0.15U W=0.64U AS=0.12095P
+ AD=0.1664P PS=1.085U PD=1.8U
* device instance $410 r0 *1 48.435,24.035 sky130_fd_pr__nfet_01v8
M$410 422 364 94 94 sky130_fd_pr__nfet_01v8 L=0.15U W=0.42U AS=0.1092P
+ AD=0.0678P PS=1.36U PD=0.755U
* device instance $411 r0 *1 48.92,24.065 sky130_fd_pr__nfet_01v8
M$411 365 360 422 422 sky130_fd_pr__nfet_01v8 L=0.15U W=0.36U AS=0.0678P
+ AD=0.0684P PS=0.755U PD=0.74U
* device instance $412 r0 *1 49.45,24.065 sky130_fd_pr__nfet_01v8
M$412 365 359 420 420 sky130_fd_pr__nfet_01v8 L=0.15U W=0.36U AS=0.066P
+ AD=0.0684P PS=0.745U PD=0.74U
* device instance $413 r0 *1 49.925,24.035 sky130_fd_pr__nfet_01v8
M$413 94 366 420 420 sky130_fd_pr__nfet_01v8 L=0.15U W=0.42U AS=0.066P
+ AD=0.1092P PS=0.745U PD=1.36U
* device instance $414 r0 *1 50.865,24.035 sky130_fd_pr__nfet_01v8
M$414 366 365 94 94 sky130_fd_pr__nfet_01v8 L=0.15U W=0.42U AS=0.10025P
+ AD=0.1092P PS=0.985U PD=1.36U
* device instance $415 r0 *1 51.35,23.92 sky130_fd_pr__nfet_01v8
M$415 367 365 94 94 sky130_fd_pr__nfet_01v8 L=0.15U W=0.65U AS=0.10025P
+ AD=0.182P PS=0.985U PD=1.86U
* device instance $416 r0 *1 53.39,23.92 sky130_fd_pr__nfet_01v8
M$416 407 369 94 94 sky130_fd_pr__nfet_01v8 L=0.15U W=1.3U AS=0.26975P
+ AD=0.1755P PS=2.78U PD=1.84U
* device instance $418 r0 *1 54.23,23.92 sky130_fd_pr__nfet_01v8
M$418 407 341 94 94 sky130_fd_pr__nfet_01v8 L=0.15U W=1.3U AS=0.1755P
+ AD=0.26975P PS=1.84U PD=2.78U
* device instance $420 r0 *1 55.63,23.92 sky130_fd_pr__nfet_01v8
M$420 407 136 94 94 sky130_fd_pr__nfet_01v8 L=0.15U W=1.3U AS=0.26975P
+ AD=0.1755P PS=2.78U PD=1.84U
* device instance $422 r0 *1 56.47,23.92 sky130_fd_pr__nfet_01v8
M$422 407 231 94 94 sky130_fd_pr__nfet_01v8 L=0.15U W=1.3U AS=0.1755P
+ AD=0.25675P PS=1.84U PD=2.74U
* device instance $424 r0 *1 60.73,23.92 sky130_fd_pr__nfet_01v8
M$424 94 388 372 372 sky130_fd_pr__nfet_01v8 L=0.15U W=0.65U AS=0.169P
+ AD=0.10725P PS=1.82U PD=0.98U
* device instance $425 r0 *1 61.21,23.92 sky130_fd_pr__nfet_01v8
M$425 419 341 94 94 sky130_fd_pr__nfet_01v8 L=0.15U W=0.65U AS=0.10725P
+ AD=0.06825P PS=0.98U PD=0.86U
* device instance $426 r0 *1 61.57,23.92 sky130_fd_pr__nfet_01v8
M$426 372 91 419 419 sky130_fd_pr__nfet_01v8 L=0.15U W=0.65U AS=0.06825P
+ AD=0.169P PS=0.86U PD=1.82U
* device instance $427 r0 *1 62.51,23.92 sky130_fd_pr__nfet_01v8
M$427 418 137 372 372 sky130_fd_pr__nfet_01v8 L=0.15U W=0.65U AS=0.169P
+ AD=0.10725P PS=1.82U PD=0.98U
* device instance $428 r0 *1 62.99,23.92 sky130_fd_pr__nfet_01v8
M$428 94 346 418 418 sky130_fd_pr__nfet_01v8 L=0.15U W=0.65U AS=0.10725P
+ AD=0.102375P PS=0.98U PD=0.965U
* device instance $429 r0 *1 63.455,23.92 sky130_fd_pr__nfet_01v8
M$429 408 372 94 94 sky130_fd_pr__nfet_01v8 L=0.15U W=0.65U AS=0.102375P
+ AD=0.169P PS=0.965U PD=1.82U
* device instance $430 r0 *1 64.41,24.035 sky130_fd_pr__nfet_01v8
M$430 94 329 374 374 sky130_fd_pr__nfet_01v8 L=0.15U W=0.42U AS=0.1092P
+ AD=0.0567P PS=1.36U PD=0.69U
* device instance $431 r0 *1 64.83,24.035 sky130_fd_pr__nfet_01v8
M$431 375 374 94 94 sky130_fd_pr__nfet_01v8 L=0.15U W=0.42U AS=0.0567P
+ AD=0.1092P PS=0.69U PD=1.36U
* device instance $432 r0 *1 65.77,24.035 sky130_fd_pr__nfet_01v8
M$432 417 390 377 377 sky130_fd_pr__nfet_01v8 L=0.15U W=0.42U AS=0.1092P
+ AD=0.0441P PS=1.36U PD=0.63U
* device instance $433 r0 *1 66.13,24.035 sky130_fd_pr__nfet_01v8
M$433 94 1102 417 417 sky130_fd_pr__nfet_01v8 L=0.15U W=0.42U AS=0.0441P
+ AD=0.1092P PS=0.63U PD=1.36U
* device instance $434 r0 *1 67.07,24.035 sky130_fd_pr__nfet_01v8
M$434 94 1102 376 376 sky130_fd_pr__nfet_01v8 L=0.15U W=0.42U AS=0.1092P
+ AD=0.0609P PS=1.36U PD=0.71U
* device instance $435 r0 *1 67.51,24.035 sky130_fd_pr__nfet_01v8
M$435 415 376 94 94 sky130_fd_pr__nfet_01v8 L=0.15U W=0.42U AS=0.0609P
+ AD=0.0756P PS=0.71U PD=0.78U
* device instance $436 r0 *1 68.02,24.035 sky130_fd_pr__nfet_01v8
M$436 377 381 415 415 sky130_fd_pr__nfet_01v8 L=0.15U W=0.42U AS=0.0756P
+ AD=0.1446P PS=0.78U PD=1.18U
* device instance $437 r0 *1 68.93,24.065 sky130_fd_pr__nfet_01v8
M$437 378 374 377 377 sky130_fd_pr__nfet_01v8 L=0.15U W=0.36U AS=0.1446P
+ AD=0.0522P PS=1.18U PD=0.65U
* device instance $438 r0 *1 69.37,24.065 sky130_fd_pr__nfet_01v8
M$438 378 375 413 413 sky130_fd_pr__nfet_01v8 L=0.15U W=0.36U AS=0.0759P
+ AD=0.0522P PS=0.8U PD=0.65U
* device instance $439 r0 *1 69.9,24.035 sky130_fd_pr__nfet_01v8
M$439 413 379 94 94 sky130_fd_pr__nfet_01v8 L=0.15U W=0.42U AS=0.12095P
+ AD=0.0759P PS=1.085U PD=0.8U
* device instance $440 r0 *1 70.495,23.925 sky130_fd_pr__nfet_01v8
M$440 379 378 94 94 sky130_fd_pr__nfet_01v8 L=0.15U W=0.64U AS=0.12095P
+ AD=0.1664P PS=1.085U PD=1.8U
* device instance $441 r0 *1 71.435,24.035 sky130_fd_pr__nfet_01v8
M$441 411 379 94 94 sky130_fd_pr__nfet_01v8 L=0.15U W=0.42U AS=0.1092P
+ AD=0.0678P PS=1.36U PD=0.755U
* device instance $442 r0 *1 71.92,24.065 sky130_fd_pr__nfet_01v8
M$442 380 375 411 411 sky130_fd_pr__nfet_01v8 L=0.15U W=0.36U AS=0.0678P
+ AD=0.0684P PS=0.755U PD=0.74U
* device instance $443 r0 *1 72.45,24.065 sky130_fd_pr__nfet_01v8
M$443 380 374 410 410 sky130_fd_pr__nfet_01v8 L=0.15U W=0.36U AS=0.066P
+ AD=0.0684P PS=0.745U PD=0.74U
* device instance $444 r0 *1 72.925,24.035 sky130_fd_pr__nfet_01v8
M$444 94 381 410 410 sky130_fd_pr__nfet_01v8 L=0.15U W=0.42U AS=0.066P
+ AD=0.1092P PS=0.745U PD=1.36U
* device instance $445 r0 *1 73.865,24.035 sky130_fd_pr__nfet_01v8
M$445 381 380 94 94 sky130_fd_pr__nfet_01v8 L=0.15U W=0.42U AS=0.10025P
+ AD=0.1092P PS=0.985U PD=1.36U
* device instance $446 r0 *1 74.35,23.92 sky130_fd_pr__nfet_01v8
M$446 341 380 94 94 sky130_fd_pr__nfet_01v8 L=0.15U W=0.65U AS=0.10025P
+ AD=0.182P PS=0.985U PD=1.86U
* device instance $447 r0 *1 4.61,24.925 sky130_fd_pr__nfet_01v8
M$447 94 31 425 425 sky130_fd_pr__nfet_01v8 L=0.15U W=0.42U AS=0.1092P
+ AD=0.0567P PS=1.36U PD=0.69U
* device instance $448 r0 *1 5.03,24.925 sky130_fd_pr__nfet_01v8
M$448 426 425 94 94 sky130_fd_pr__nfet_01v8 L=0.15U W=0.42U AS=0.0567P
+ AD=0.1092P PS=0.69U PD=1.36U
* device instance $449 r0 *1 5.97,24.925 sky130_fd_pr__nfet_01v8
M$449 452 447 427 427 sky130_fd_pr__nfet_01v8 L=0.15U W=0.42U AS=0.1092P
+ AD=0.0441P PS=1.36U PD=0.63U
* device instance $450 r0 *1 6.33,24.925 sky130_fd_pr__nfet_01v8
M$450 94 90 452 452 sky130_fd_pr__nfet_01v8 L=0.15U W=0.42U AS=0.0441P
+ AD=0.1092P PS=0.63U PD=1.36U
* device instance $451 r0 *1 9.13,24.895 sky130_fd_pr__nfet_01v8
M$451 429 425 427 427 sky130_fd_pr__nfet_01v8 L=0.15U W=0.36U AS=0.1446P
+ AD=0.0522P PS=1.18U PD=0.65U
* device instance $452 r0 *1 9.57,24.895 sky130_fd_pr__nfet_01v8
M$452 456 426 429 429 sky130_fd_pr__nfet_01v8 L=0.15U W=0.36U AS=0.0522P
+ AD=0.0759P PS=0.65U PD=0.8U
* device instance $453 r0 *1 7.27,24.925 sky130_fd_pr__nfet_01v8
M$453 94 90 428 428 sky130_fd_pr__nfet_01v8 L=0.15U W=0.42U AS=0.1092P
+ AD=0.0609P PS=1.36U PD=0.71U
* device instance $454 r0 *1 7.71,24.925 sky130_fd_pr__nfet_01v8
M$454 454 428 94 94 sky130_fd_pr__nfet_01v8 L=0.15U W=0.42U AS=0.0609P
+ AD=0.0756P PS=0.71U PD=0.78U
* device instance $455 r0 *1 8.22,24.925 sky130_fd_pr__nfet_01v8
M$455 427 448 454 454 sky130_fd_pr__nfet_01v8 L=0.15U W=0.42U AS=0.0756P
+ AD=0.1446P PS=0.78U PD=1.18U
* device instance $456 r0 *1 10.1,24.925 sky130_fd_pr__nfet_01v8
M$456 94 430 456 456 sky130_fd_pr__nfet_01v8 L=0.15U W=0.42U AS=0.0759P
+ AD=0.12095P PS=0.8U PD=1.085U
* device instance $457 r0 *1 10.695,25.035 sky130_fd_pr__nfet_01v8
M$457 430 429 94 94 sky130_fd_pr__nfet_01v8 L=0.15U W=0.64U AS=0.12095P
+ AD=0.1664P PS=1.085U PD=1.8U
* device instance $458 r0 *1 12.12,24.895 sky130_fd_pr__nfet_01v8
M$458 431 426 457 457 sky130_fd_pr__nfet_01v8 L=0.15U W=0.36U AS=0.0678P
+ AD=0.0684P PS=0.755U PD=0.74U
* device instance $459 r0 *1 12.65,24.895 sky130_fd_pr__nfet_01v8
M$459 458 425 431 431 sky130_fd_pr__nfet_01v8 L=0.15U W=0.36U AS=0.0684P
+ AD=0.066P PS=0.74U PD=0.745U
* device instance $460 r0 *1 11.635,24.925 sky130_fd_pr__nfet_01v8
M$460 457 430 94 94 sky130_fd_pr__nfet_01v8 L=0.15U W=0.42U AS=0.1092P
+ AD=0.0678P PS=1.36U PD=0.755U
* device instance $461 r0 *1 13.125,24.925 sky130_fd_pr__nfet_01v8
M$461 94 448 458 458 sky130_fd_pr__nfet_01v8 L=0.15U W=0.42U AS=0.066P
+ AD=0.1092P PS=0.745U PD=1.36U
* device instance $462 r0 *1 14.065,24.925 sky130_fd_pr__nfet_01v8
M$462 94 431 448 448 sky130_fd_pr__nfet_01v8 L=0.15U W=0.42U AS=0.1092P
+ AD=0.10025P PS=1.36U PD=0.985U
* device instance $463 r0 *1 14.55,25.04 sky130_fd_pr__nfet_01v8
M$463 355 431 94 94 sky130_fd_pr__nfet_01v8 L=0.15U W=0.65U AS=0.10025P
+ AD=0.182P PS=0.985U PD=1.86U
* device instance $464 r0 *1 18.185,24.925 sky130_fd_pr__nfet_01v8
M$464 94 355 432 432 sky130_fd_pr__nfet_01v8 L=0.15U W=0.42U AS=0.1092P
+ AD=0.10025P PS=1.36U PD=0.985U
* device instance $465 r0 *1 18.67,25.04 sky130_fd_pr__nfet_01v8
M$465 433 449 94 94 sky130_fd_pr__nfet_01v8 L=0.15U W=0.65U AS=0.10025P
+ AD=0.08775P PS=0.985U PD=0.92U
* device instance $466 r0 *1 19.09,25.04 sky130_fd_pr__nfet_01v8
M$466 94 432 433 433 sky130_fd_pr__nfet_01v8 L=0.15U W=0.65U AS=0.08775P
+ AD=0.169P PS=0.92U PD=1.82U
* device instance $467 r0 *1 20.25,25.04 sky130_fd_pr__nfet_01v8
M$467 385 433 94 94 sky130_fd_pr__nfet_01v8 L=0.15U W=0.65U AS=0.169P
+ AD=0.08775P PS=1.82U PD=0.92U
* device instance $468 r0 *1 20.67,25.04 sky130_fd_pr__nfet_01v8
M$468 94 337 385 385 sky130_fd_pr__nfet_01v8 L=0.15U W=0.65U AS=0.08775P
+ AD=0.169P PS=0.92U PD=1.82U
* device instance $469 r0 *1 21.865,24.925 sky130_fd_pr__nfet_01v8
M$469 94 449 434 434 sky130_fd_pr__nfet_01v8 L=0.15U W=0.42U AS=0.1092P
+ AD=0.10025P PS=1.36U PD=0.985U
* device instance $470 r0 *1 22.35,25.04 sky130_fd_pr__nfet_01v8
M$470 337 355 94 94 sky130_fd_pr__nfet_01v8 L=0.15U W=0.65U AS=0.10025P
+ AD=0.08775P PS=0.985U PD=0.92U
* device instance $471 r0 *1 22.77,25.04 sky130_fd_pr__nfet_01v8
M$471 94 434 337 337 sky130_fd_pr__nfet_01v8 L=0.15U W=0.65U AS=0.08775P
+ AD=0.169P PS=0.92U PD=1.82U
* device instance $472 r0 *1 34.985,25.04 sky130_fd_pr__nfet_01v8
M$472 450 436 435 435 sky130_fd_pr__nfet_01v8 L=0.15U W=1.3U AS=0.2665P
+ AD=0.1755P PS=2.77U PD=1.84U
* device instance $474 r0 *1 35.825,25.04 sky130_fd_pr__nfet_01v8
M$474 94 437 435 435 sky130_fd_pr__nfet_01v8 L=0.15U W=1.3U AS=0.1755P
+ AD=0.26975P PS=1.84U PD=2.78U
* device instance $476 r0 *1 37.225,25.04 sky130_fd_pr__nfet_01v8
M$476 438 437 94 94 sky130_fd_pr__nfet_01v8 L=0.15U W=1.3U AS=0.26975P
+ AD=0.1755P PS=2.78U PD=1.84U
* device instance $478 r0 *1 38.065,25.04 sky130_fd_pr__nfet_01v8
M$478 438 436 94 94 sky130_fd_pr__nfet_01v8 L=0.15U W=1.3U AS=0.186875P
+ AD=0.268125P PS=1.875U PD=2.775U
* device instance $480 r0 *1 39.46,25.04 sky130_fd_pr__nfet_01v8
M$480 438 450 439 439 sky130_fd_pr__nfet_01v8 L=0.15U W=1.3U AS=0.25675P
+ AD=0.25675P PS=2.74U PD=2.74U
* device instance $482 r0 *1 46.47,25.04 sky130_fd_pr__nfet_01v8
M$482 94 329 440 440 sky130_fd_pr__nfet_01v8 L=0.15U W=1.95U AS=0.3445P
+ AD=0.26325P PS=3.66U PD=2.76U
* device instance $485 r0 *1 47.73,25.04 sky130_fd_pr__nfet_01v8
M$485 441 440 94 94 sky130_fd_pr__nfet_01v8 L=0.15U W=3.9U AS=0.5265P
+ AD=0.5265P PS=5.52U PD=5.52U
* device instance $491 r0 *1 50.25,25.04 sky130_fd_pr__nfet_01v8
M$491 442 441 94 94 sky130_fd_pr__nfet_01v8 L=0.15U W=10.4U AS=1.404P
+ AD=1.48525P PS=14.72U PD=15.62U
* device instance $507 r0 *1 61.26,24.925 sky130_fd_pr__nfet_01v8
M$507 460 462 443 443 sky130_fd_pr__nfet_01v8 L=0.15U W=0.42U AS=0.1113P
+ AD=0.0441P PS=1.37U PD=0.63U
* device instance $508 r0 *1 61.62,24.925 sky130_fd_pr__nfet_01v8
M$508 94 109 460 460 sky130_fd_pr__nfet_01v8 L=0.15U W=0.42U AS=0.0441P
+ AD=0.0966P PS=0.63U PD=0.88U
* device instance $509 r0 *1 62.23,24.925 sky130_fd_pr__nfet_01v8
M$509 388 443 94 94 sky130_fd_pr__nfet_01v8 L=0.15U W=0.42U AS=0.0966P
+ AD=0.1113P PS=0.88U PD=1.37U
* device instance $510 r0 *1 64.365,24.925 sky130_fd_pr__nfet_01v8
M$510 94 333 311 311 sky130_fd_pr__nfet_01v8 L=0.15U W=0.42U AS=0.1092P
+ AD=0.1197P PS=1.36U PD=1.41U
* device instance $511 r0 *1 65.33,25.155 sky130_fd_pr__nfet_01v8
M$511 451 339 94 94 sky130_fd_pr__nfet_01v8 L=0.15U W=0.42U AS=0.10025P
+ AD=0.1092P PS=0.985U PD=1.36U
* device instance $512 r0 *1 65.815,25.04 sky130_fd_pr__nfet_01v8
M$512 459 341 94 94 sky130_fd_pr__nfet_01v8 L=0.15U W=0.65U AS=0.10025P
+ AD=0.08775P PS=0.985U PD=0.92U
* device instance $513 r0 *1 66.235,25.04 sky130_fd_pr__nfet_01v8
M$513 338 451 459 459 sky130_fd_pr__nfet_01v8 L=0.15U W=0.65U AS=0.08775P
+ AD=0.169P PS=0.92U PD=1.82U
* device instance $514 r0 *1 68.175,24.925 sky130_fd_pr__nfet_01v8
M$514 455 71 94 94 sky130_fd_pr__nfet_01v8 L=0.15U W=0.42U AS=0.11285P
+ AD=0.0693P PS=1.045U PD=0.75U
* device instance $515 r0 *1 68.655,24.925 sky130_fd_pr__nfet_01v8
M$515 444 445 455 455 sky130_fd_pr__nfet_01v8 L=0.15U W=0.42U AS=0.0693P
+ AD=0.09975P PS=0.75U PD=0.895U
* device instance $516 r0 *1 69.28,24.925 sky130_fd_pr__nfet_01v8
M$516 453 339 444 444 sky130_fd_pr__nfet_01v8 L=0.15U W=0.42U AS=0.09975P
+ AD=0.0693P PS=0.895U PD=0.75U
* device instance $517 r0 *1 69.76,24.925 sky130_fd_pr__nfet_01v8
M$517 94 446 453 453 sky130_fd_pr__nfet_01v8 L=0.15U W=0.42U AS=0.0693P
+ AD=0.1449P PS=0.75U PD=1.11U
* device instance $518 r0 *1 70.6,24.925 sky130_fd_pr__nfet_01v8
M$518 446 71 94 94 sky130_fd_pr__nfet_01v8 L=0.15U W=0.42U AS=0.1449P
+ AD=0.1092P PS=1.11U PD=1.36U
* device instance $519 r0 *1 67.63,25.04 sky130_fd_pr__nfet_01v8
M$519 94 444 390 390 sky130_fd_pr__nfet_01v8 L=0.15U W=0.65U AS=0.169P
+ AD=0.11285P PS=1.82U PD=1.045U
* device instance $520 r0 *1 5.07,29.36 sky130_fd_pr__nfet_01v8
M$520 94 474 447 447 sky130_fd_pr__nfet_01v8 L=0.15U W=0.65U AS=0.169P
+ AD=0.11285P PS=1.82U PD=1.045U
* device instance $521 r0 *1 5.615,29.475 sky130_fd_pr__nfet_01v8
M$521 518 71 94 94 sky130_fd_pr__nfet_01v8 L=0.15U W=0.42U AS=0.11285P
+ AD=0.0693P PS=1.045U PD=0.75U
* device instance $522 r0 *1 6.095,29.475 sky130_fd_pr__nfet_01v8
M$522 474 461 518 518 sky130_fd_pr__nfet_01v8 L=0.15U W=0.42U AS=0.0693P
+ AD=0.09975P PS=0.75U PD=0.895U
* device instance $523 r0 *1 6.72,29.475 sky130_fd_pr__nfet_01v8
M$523 519 449 474 474 sky130_fd_pr__nfet_01v8 L=0.15U W=0.42U AS=0.09975P
+ AD=0.0693P PS=0.895U PD=0.75U
* device instance $524 r0 *1 7.2,29.475 sky130_fd_pr__nfet_01v8
M$524 94 514 519 519 sky130_fd_pr__nfet_01v8 L=0.15U W=0.42U AS=0.0693P
+ AD=0.1449P PS=0.75U PD=1.11U
* device instance $525 r0 *1 8.04,29.475 sky130_fd_pr__nfet_01v8
M$525 514 71 94 94 sky130_fd_pr__nfet_01v8 L=0.15U W=0.42U AS=0.1449P
+ AD=0.1092P PS=1.11U PD=1.36U
* device instance $526 r0 *1 9.21,29.475 sky130_fd_pr__nfet_01v8
M$526 94 31 475 475 sky130_fd_pr__nfet_01v8 L=0.15U W=0.42U AS=0.1092P
+ AD=0.0567P PS=1.36U PD=0.69U
* device instance $527 r0 *1 9.63,29.475 sky130_fd_pr__nfet_01v8
M$527 476 475 94 94 sky130_fd_pr__nfet_01v8 L=0.15U W=0.42U AS=0.0567P
+ AD=0.1092P PS=0.69U PD=1.36U
* device instance $528 r0 *1 10.57,29.475 sky130_fd_pr__nfet_01v8
M$528 521 405 478 478 sky130_fd_pr__nfet_01v8 L=0.15U W=0.42U AS=0.1092P
+ AD=0.0441P PS=1.36U PD=0.63U
* device instance $529 r0 *1 10.93,29.475 sky130_fd_pr__nfet_01v8
M$529 94 315 521 521 sky130_fd_pr__nfet_01v8 L=0.15U W=0.42U AS=0.0441P
+ AD=0.1092P PS=0.63U PD=1.36U
* device instance $530 r0 *1 11.87,29.475 sky130_fd_pr__nfet_01v8
M$530 94 315 477 477 sky130_fd_pr__nfet_01v8 L=0.15U W=0.42U AS=0.1092P
+ AD=0.0609P PS=1.36U PD=0.71U
* device instance $531 r0 *1 12.31,29.475 sky130_fd_pr__nfet_01v8
M$531 523 477 94 94 sky130_fd_pr__nfet_01v8 L=0.15U W=0.42U AS=0.0609P
+ AD=0.0756P PS=0.71U PD=0.78U
* device instance $532 r0 *1 12.82,29.475 sky130_fd_pr__nfet_01v8
M$532 478 482 523 523 sky130_fd_pr__nfet_01v8 L=0.15U W=0.42U AS=0.0756P
+ AD=0.1446P PS=0.78U PD=1.18U
* device instance $533 r0 *1 13.73,29.505 sky130_fd_pr__nfet_01v8
M$533 479 475 478 478 sky130_fd_pr__nfet_01v8 L=0.15U W=0.36U AS=0.1446P
+ AD=0.0522P PS=1.18U PD=0.65U
* device instance $534 r0 *1 14.17,29.505 sky130_fd_pr__nfet_01v8
M$534 479 476 524 524 sky130_fd_pr__nfet_01v8 L=0.15U W=0.36U AS=0.0759P
+ AD=0.0522P PS=0.8U PD=0.65U
* device instance $535 r0 *1 14.7,29.475 sky130_fd_pr__nfet_01v8
M$535 524 480 94 94 sky130_fd_pr__nfet_01v8 L=0.15U W=0.42U AS=0.12095P
+ AD=0.0759P PS=1.085U PD=0.8U
* device instance $536 r0 *1 15.295,29.365 sky130_fd_pr__nfet_01v8
M$536 480 479 94 94 sky130_fd_pr__nfet_01v8 L=0.15U W=0.64U AS=0.12095P
+ AD=0.1664P PS=1.085U PD=1.8U
* device instance $537 r0 *1 16.235,29.475 sky130_fd_pr__nfet_01v8
M$537 527 480 94 94 sky130_fd_pr__nfet_01v8 L=0.15U W=0.42U AS=0.1092P
+ AD=0.0678P PS=1.36U PD=0.755U
* device instance $538 r0 *1 16.72,29.505 sky130_fd_pr__nfet_01v8
M$538 481 476 527 527 sky130_fd_pr__nfet_01v8 L=0.15U W=0.36U AS=0.0678P
+ AD=0.0684P PS=0.755U PD=0.74U
* device instance $539 r0 *1 17.25,29.505 sky130_fd_pr__nfet_01v8
M$539 481 475 529 529 sky130_fd_pr__nfet_01v8 L=0.15U W=0.36U AS=0.066P
+ AD=0.0684P PS=0.745U PD=0.74U
* device instance $540 r0 *1 17.725,29.475 sky130_fd_pr__nfet_01v8
M$540 94 482 529 529 sky130_fd_pr__nfet_01v8 L=0.15U W=0.42U AS=0.066P
+ AD=0.1092P PS=0.745U PD=1.36U
* device instance $541 r0 *1 18.665,29.475 sky130_fd_pr__nfet_01v8
M$541 482 481 94 94 sky130_fd_pr__nfet_01v8 L=0.15U W=0.42U AS=0.10025P
+ AD=0.1092P PS=0.985U PD=1.36U
* device instance $542 r0 *1 19.15,29.36 sky130_fd_pr__nfet_01v8
M$542 449 481 94 94 sky130_fd_pr__nfet_01v8 L=0.15U W=0.65U AS=0.10025P
+ AD=0.182P PS=0.985U PD=1.86U
* device instance $543 r0 *1 26.26,30.365 sky130_fd_pr__nfet_01v8
M$543 94 433 533 533 sky130_fd_pr__nfet_01v8 L=0.15U W=0.42U AS=0.1113P
+ AD=0.0588P PS=1.37U PD=0.7U
* device instance $544 r0 *1 26.69,30.365 sky130_fd_pr__nfet_01v8
M$544 533 336 94 94 sky130_fd_pr__nfet_01v8 L=0.15U W=0.42U AS=0.0588P
+ AD=0.0588P PS=0.7U PD=0.7U
* device instance $545 r0 *1 27.12,30.365 sky130_fd_pr__nfet_01v8
M$545 543 495 533 533 sky130_fd_pr__nfet_01v8 L=0.15U W=0.42U AS=0.0588P
+ AD=0.1113P PS=0.7U PD=1.37U
* device instance $546 r0 *1 30.91,29.36 sky130_fd_pr__nfet_01v8
M$546 515 336 94 94 sky130_fd_pr__nfet_01v8 L=0.15U W=2.6U AS=0.44525P
+ AD=0.351P PS=4.62U PD=3.68U
* device instance $550 r0 *1 32.59,29.36 sky130_fd_pr__nfet_01v8
M$550 515 433 94 94 sky130_fd_pr__nfet_01v8 L=0.15U W=2.6U AS=0.351P AD=0.3575P
+ PS=3.68U PD=3.7U
* device instance $554 r0 *1 34.29,29.36 sky130_fd_pr__nfet_01v8
M$554 515 495 94 94 sky130_fd_pr__nfet_01v8 L=0.15U W=2.6U AS=0.3575P
+ AD=0.44525P PS=3.7U PD=4.62U
* device instance $558 r0 *1 31.77,30.48 sky130_fd_pr__nfet_01v8
M$558 539 544 94 94 sky130_fd_pr__nfet_01v8 L=0.15U W=0.65U AS=0.169P
+ AD=0.08775P PS=1.82U PD=0.92U
* device instance $559 r0 *1 32.19,30.48 sky130_fd_pr__nfet_01v8
M$559 437 496 539 539 sky130_fd_pr__nfet_01v8 L=0.15U W=0.65U AS=0.08775P
+ AD=0.169P PS=0.92U PD=1.82U
* device instance $560 r0 *1 35.91,30.48 sky130_fd_pr__nfet_01v8
M$560 540 262 94 94 sky130_fd_pr__nfet_01v8 L=0.15U W=0.65U AS=0.169P
+ AD=0.08775P PS=1.82U PD=0.92U
* device instance $561 r0 *1 36.33,30.48 sky130_fd_pr__nfet_01v8
M$561 436 484 540 540 sky130_fd_pr__nfet_01v8 L=0.15U W=0.65U AS=0.08775P
+ AD=0.169P PS=0.92U PD=1.82U
* device instance $562 r0 *1 36.53,29.36 sky130_fd_pr__nfet_01v8
M$562 515 496 517 517 sky130_fd_pr__nfet_01v8 L=0.15U W=2.6U AS=0.44525P
+ AD=0.351P PS=4.62U PD=3.68U
* device instance $566 r0 *1 38.21,29.36 sky130_fd_pr__nfet_01v8
M$566 278 484 517 517 sky130_fd_pr__nfet_01v8 L=0.15U W=2.6U AS=0.351P
+ AD=0.44525P PS=3.68U PD=4.62U
* device instance $570 r0 *1 38.19,30.48 sky130_fd_pr__nfet_01v8
M$570 94 118 535 535 sky130_fd_pr__nfet_01v8 L=0.15U W=0.65U AS=0.169P
+ AD=0.10725P PS=1.82U PD=0.98U
* device instance $571 r0 *1 38.67,30.48 sky130_fd_pr__nfet_01v8
M$571 541 367 94 94 sky130_fd_pr__nfet_01v8 L=0.15U W=0.65U AS=0.10725P
+ AD=0.06825P PS=0.98U PD=0.86U
* device instance $572 r0 *1 39.03,30.48 sky130_fd_pr__nfet_01v8
M$572 535 91 541 541 sky130_fd_pr__nfet_01v8 L=0.15U W=0.65U AS=0.06825P
+ AD=0.169P PS=0.86U PD=1.82U
* device instance $573 r0 *1 39.97,30.48 sky130_fd_pr__nfet_01v8
M$573 542 137 535 535 sky130_fd_pr__nfet_01v8 L=0.15U W=0.65U AS=0.169P
+ AD=0.10725P PS=1.82U PD=0.98U
* device instance $574 r0 *1 40.45,30.48 sky130_fd_pr__nfet_01v8
M$574 94 439 542 542 sky130_fd_pr__nfet_01v8 L=0.15U W=0.65U AS=0.10725P
+ AD=0.102375P PS=0.98U PD=0.965U
* device instance $575 r0 *1 40.915,30.48 sky130_fd_pr__nfet_01v8
M$575 547 535 94 94 sky130_fd_pr__nfet_01v8 L=0.15U W=0.65U AS=0.102375P
+ AD=0.169P PS=0.965U PD=1.82U
* device instance $576 r0 *1 41.87,29.245 sky130_fd_pr__nfet_01v8
M$576 94 497 498 498 sky130_fd_pr__nfet_01v8 L=0.15U W=0.42U AS=0.1092P
+ AD=0.10025P PS=1.36U PD=0.985U
* device instance $577 r0 *1 42.355,29.36 sky130_fd_pr__nfet_01v8
M$577 532 367 94 94 sky130_fd_pr__nfet_01v8 L=0.15U W=0.65U AS=0.10025P
+ AD=0.08775P PS=0.985U PD=0.92U
* device instance $578 r0 *1 42.775,29.36 sky130_fd_pr__nfet_01v8
M$578 262 498 532 532 sky130_fd_pr__nfet_01v8 L=0.15U W=0.65U AS=0.08775P
+ AD=0.169P PS=0.92U PD=1.82U
* device instance $579 r0 *1 42.285,30.365 sky130_fd_pr__nfet_01v8
M$579 94 536 484 484 sky130_fd_pr__nfet_01v8 L=0.15U W=0.42U AS=0.1092P
+ AD=0.1197P PS=1.36U PD=1.41U
* device instance $580 r0 *1 44.17,29.36 sky130_fd_pr__nfet_01v8
M$580 94 485 387 387 sky130_fd_pr__nfet_01v8 L=0.15U W=0.65U AS=0.169P
+ AD=0.11285P PS=1.82U PD=1.045U
* device instance $581 r0 *1 44.715,29.475 sky130_fd_pr__nfet_01v8
M$581 531 71 94 94 sky130_fd_pr__nfet_01v8 L=0.15U W=0.42U AS=0.11285P
+ AD=0.0693P PS=1.045U PD=0.75U
* device instance $582 r0 *1 45.195,29.475 sky130_fd_pr__nfet_01v8
M$582 485 499 531 531 sky130_fd_pr__nfet_01v8 L=0.15U W=0.42U AS=0.0693P
+ AD=0.09975P PS=0.75U PD=0.895U
* device instance $583 r0 *1 45.82,29.475 sky130_fd_pr__nfet_01v8
M$583 530 497 485 485 sky130_fd_pr__nfet_01v8 L=0.15U W=0.42U AS=0.09975P
+ AD=0.0693P PS=0.895U PD=0.75U
* device instance $584 r0 *1 46.3,29.475 sky130_fd_pr__nfet_01v8
M$584 94 516 530 530 sky130_fd_pr__nfet_01v8 L=0.15U W=0.42U AS=0.0693P
+ AD=0.1449P PS=0.75U PD=1.11U
* device instance $585 r0 *1 47.14,29.475 sky130_fd_pr__nfet_01v8
M$585 516 71 94 94 sky130_fd_pr__nfet_01v8 L=0.15U W=0.42U AS=0.1449P
+ AD=0.1092P PS=1.11U PD=1.36U
* device instance $586 r0 *1 44.865,30.365 sky130_fd_pr__nfet_01v8
M$586 94 497 537 537 sky130_fd_pr__nfet_01v8 L=0.15U W=0.42U AS=0.1092P
+ AD=0.10025P PS=1.36U PD=0.985U
* device instance $587 r0 *1 45.35,30.48 sky130_fd_pr__nfet_01v8
M$587 536 367 94 94 sky130_fd_pr__nfet_01v8 L=0.15U W=0.65U AS=0.10025P
+ AD=0.08775P PS=0.985U PD=0.92U
* device instance $588 r0 *1 45.77,30.48 sky130_fd_pr__nfet_01v8
M$588 94 537 536 536 sky130_fd_pr__nfet_01v8 L=0.15U W=0.65U AS=0.08775P
+ AD=0.349375P PS=0.92U PD=1.725U
* device instance $589 r0 *1 46.995,30.48 sky130_fd_pr__nfet_01v8
M$589 538 997 94 94 sky130_fd_pr__nfet_01v8 L=0.15U W=1.3U AS=0.437125P
+ AD=0.1755P PS=2.645U PD=1.84U
* device instance $591 r0 *1 47.835,30.48 sky130_fd_pr__nfet_01v8
M$591 137 538 94 94 sky130_fd_pr__nfet_01v8 L=0.15U W=3.9U AS=0.5265P
+ AD=0.60775P PS=5.52U PD=6.42U
* device instance $597 r0 *1 60.73,29.475 sky130_fd_pr__nfet_01v8
M$597 94 329 486 486 sky130_fd_pr__nfet_01v8 L=0.15U W=0.42U AS=0.1092P
+ AD=0.0567P PS=1.36U PD=0.69U
* device instance $598 r0 *1 61.15,29.475 sky130_fd_pr__nfet_01v8
M$598 487 486 94 94 sky130_fd_pr__nfet_01v8 L=0.15U W=0.42U AS=0.0567P
+ AD=0.1092P PS=0.69U PD=1.36U
* device instance $599 r0 *1 62.09,29.475 sky130_fd_pr__nfet_01v8
M$599 528 408 489 489 sky130_fd_pr__nfet_01v8 L=0.15U W=0.42U AS=0.1092P
+ AD=0.0441P PS=1.36U PD=0.63U
* device instance $600 r0 *1 62.45,29.475 sky130_fd_pr__nfet_01v8
M$600 94 315 528 528 sky130_fd_pr__nfet_01v8 L=0.15U W=0.42U AS=0.0441P
+ AD=0.1092P PS=0.63U PD=1.36U
* device instance $601 r0 *1 63.39,29.475 sky130_fd_pr__nfet_01v8
M$601 94 315 488 488 sky130_fd_pr__nfet_01v8 L=0.15U W=0.42U AS=0.1092P
+ AD=0.0609P PS=1.36U PD=0.71U
* device instance $602 r0 *1 63.83,29.475 sky130_fd_pr__nfet_01v8
M$602 526 488 94 94 sky130_fd_pr__nfet_01v8 L=0.15U W=0.42U AS=0.0609P
+ AD=0.0756P PS=0.71U PD=0.78U
* device instance $603 r0 *1 64.34,29.475 sky130_fd_pr__nfet_01v8
M$603 489 493 526 526 sky130_fd_pr__nfet_01v8 L=0.15U W=0.42U AS=0.0756P
+ AD=0.1446P PS=0.78U PD=1.18U
* device instance $604 r0 *1 65.25,29.505 sky130_fd_pr__nfet_01v8
M$604 490 486 489 489 sky130_fd_pr__nfet_01v8 L=0.15U W=0.36U AS=0.1446P
+ AD=0.0522P PS=1.18U PD=0.65U
* device instance $605 r0 *1 65.69,29.505 sky130_fd_pr__nfet_01v8
M$605 490 487 525 525 sky130_fd_pr__nfet_01v8 L=0.15U W=0.36U AS=0.0759P
+ AD=0.0522P PS=0.8U PD=0.65U
* device instance $606 r0 *1 66.22,29.475 sky130_fd_pr__nfet_01v8
M$606 525 491 94 94 sky130_fd_pr__nfet_01v8 L=0.15U W=0.42U AS=0.12095P
+ AD=0.0759P PS=1.085U PD=0.8U
* device instance $607 r0 *1 66.815,29.365 sky130_fd_pr__nfet_01v8
M$607 491 490 94 94 sky130_fd_pr__nfet_01v8 L=0.15U W=0.64U AS=0.12095P
+ AD=0.1664P PS=1.085U PD=1.8U
* device instance $608 r0 *1 67.755,29.475 sky130_fd_pr__nfet_01v8
M$608 522 491 94 94 sky130_fd_pr__nfet_01v8 L=0.15U W=0.42U AS=0.1092P
+ AD=0.0678P PS=1.36U PD=0.755U
* device instance $609 r0 *1 68.24,29.505 sky130_fd_pr__nfet_01v8
M$609 492 487 522 522 sky130_fd_pr__nfet_01v8 L=0.15U W=0.36U AS=0.0678P
+ AD=0.0684P PS=0.755U PD=0.74U
* device instance $610 r0 *1 68.77,29.505 sky130_fd_pr__nfet_01v8
M$610 492 486 520 520 sky130_fd_pr__nfet_01v8 L=0.15U W=0.36U AS=0.066P
+ AD=0.0684P PS=0.745U PD=0.74U
* device instance $611 r0 *1 69.245,29.475 sky130_fd_pr__nfet_01v8
M$611 94 493 520 520 sky130_fd_pr__nfet_01v8 L=0.15U W=0.42U AS=0.066P
+ AD=0.1092P PS=0.745U PD=1.36U
* device instance $612 r0 *1 70.185,29.475 sky130_fd_pr__nfet_01v8
M$612 493 492 94 94 sky130_fd_pr__nfet_01v8 L=0.15U W=0.42U AS=0.10025P
+ AD=0.1092P PS=0.985U PD=1.36U
* device instance $613 r0 *1 70.67,29.36 sky130_fd_pr__nfet_01v8
M$613 339 492 94 94 sky130_fd_pr__nfet_01v8 L=0.15U W=0.65U AS=0.10025P
+ AD=0.182P PS=0.985U PD=1.86U
* device instance $614 r0 *1 13.765,34.915 sky130_fd_pr__nfet_01v8
M$614 94 552 576 576 sky130_fd_pr__nfet_01v8 L=0.15U W=0.42U AS=0.1092P
+ AD=0.1197P PS=1.36U PD=1.41U
* device instance $615 r0 *1 27.155,34.8 sky130_fd_pr__nfet_01v8
M$615 579 544 554 554 sky130_fd_pr__nfet_01v8 L=0.15U W=0.65U AS=0.17225P
+ AD=0.06825P PS=1.83U PD=0.86U
* device instance $616 r0 *1 27.515,34.8 sky130_fd_pr__nfet_01v8
M$616 94 543 579 579 sky130_fd_pr__nfet_01v8 L=0.15U W=0.65U AS=0.06825P
+ AD=0.138125P PS=0.86U PD=1.075U
* device instance $617 r0 *1 28.09,34.8 sky130_fd_pr__nfet_01v8
M$617 553 554 94 94 sky130_fd_pr__nfet_01v8 L=0.15U W=2.6U AS=0.411125P
+ AD=0.45825P PS=3.865U PD=4.66U
* device instance $621 r0 *1 28.08,30.395 sky130_fd_pr__nfet_01v8
M$621 94 336 534 534 sky130_fd_pr__nfet_01v8 L=0.15U W=0.42U AS=0.1092P
+ AD=0.0567P PS=1.36U PD=0.69U
* device instance $622 r0 *1 28.5,30.395 sky130_fd_pr__nfet_01v8
M$622 534 433 94 94 sky130_fd_pr__nfet_01v8 L=0.15U W=0.42U AS=0.0567P
+ AD=0.0567P PS=0.69U PD=0.69U
* device instance $623 r0 *1 28.92,30.395 sky130_fd_pr__nfet_01v8
M$623 534 495 94 94 sky130_fd_pr__nfet_01v8 L=0.15U W=0.42U AS=0.101875P
+ AD=0.0567P PS=0.99U PD=0.69U
* device instance $624 r0 *1 29.41,30.48 sky130_fd_pr__nfet_01v8
M$624 544 534 94 94 sky130_fd_pr__nfet_01v8 L=0.15U W=0.65U AS=0.101875P
+ AD=0.182P PS=0.99U PD=1.86U
* device instance $625 r0 *1 40.49,34.915 sky130_fd_pr__nfet_01v8
M$625 94 329 555 555 sky130_fd_pr__nfet_01v8 L=0.15U W=0.42U AS=0.1092P
+ AD=0.0567P PS=1.36U PD=0.69U
* device instance $626 r0 *1 40.91,34.915 sky130_fd_pr__nfet_01v8
M$626 556 555 94 94 sky130_fd_pr__nfet_01v8 L=0.15U W=0.42U AS=0.0567P
+ AD=0.1092P PS=0.69U PD=1.36U
* device instance $627 r0 *1 41.85,34.915 sky130_fd_pr__nfet_01v8
M$627 583 547 557 557 sky130_fd_pr__nfet_01v8 L=0.15U W=0.42U AS=0.1092P
+ AD=0.0441P PS=1.36U PD=0.63U
* device instance $628 r0 *1 42.21,34.915 sky130_fd_pr__nfet_01v8
M$628 94 315 583 583 sky130_fd_pr__nfet_01v8 L=0.15U W=0.42U AS=0.0441P
+ AD=0.1092P PS=0.63U PD=1.36U
* device instance $629 r0 *1 43.15,34.915 sky130_fd_pr__nfet_01v8
M$629 94 315 558 558 sky130_fd_pr__nfet_01v8 L=0.15U W=0.42U AS=0.1092P
+ AD=0.0609P PS=1.36U PD=0.71U
* device instance $630 r0 *1 43.59,34.915 sky130_fd_pr__nfet_01v8
M$630 584 558 94 94 sky130_fd_pr__nfet_01v8 L=0.15U W=0.42U AS=0.0609P
+ AD=0.0756P PS=0.71U PD=0.78U
* device instance $631 r0 *1 44.1,34.915 sky130_fd_pr__nfet_01v8
M$631 557 562 584 584 sky130_fd_pr__nfet_01v8 L=0.15U W=0.42U AS=0.0756P
+ AD=0.1446P PS=0.78U PD=1.18U
* device instance $632 r0 *1 45.01,34.945 sky130_fd_pr__nfet_01v8
M$632 559 555 557 557 sky130_fd_pr__nfet_01v8 L=0.15U W=0.36U AS=0.1446P
+ AD=0.0522P PS=1.18U PD=0.65U
* device instance $633 r0 *1 45.45,34.945 sky130_fd_pr__nfet_01v8
M$633 559 556 582 582 sky130_fd_pr__nfet_01v8 L=0.15U W=0.36U AS=0.0759P
+ AD=0.0522P PS=0.8U PD=0.65U
* device instance $634 r0 *1 45.98,34.915 sky130_fd_pr__nfet_01v8
M$634 582 560 94 94 sky130_fd_pr__nfet_01v8 L=0.15U W=0.42U AS=0.12095P
+ AD=0.0759P PS=1.085U PD=0.8U
* device instance $635 r0 *1 46.575,34.805 sky130_fd_pr__nfet_01v8
M$635 560 559 94 94 sky130_fd_pr__nfet_01v8 L=0.15U W=0.64U AS=0.12095P
+ AD=0.1664P PS=1.085U PD=1.8U
* device instance $636 r0 *1 47.515,34.915 sky130_fd_pr__nfet_01v8
M$636 581 560 94 94 sky130_fd_pr__nfet_01v8 L=0.15U W=0.42U AS=0.1092P
+ AD=0.0678P PS=1.36U PD=0.755U
* device instance $637 r0 *1 48,34.945 sky130_fd_pr__nfet_01v8
M$637 561 556 581 581 sky130_fd_pr__nfet_01v8 L=0.15U W=0.36U AS=0.0678P
+ AD=0.0684P PS=0.755U PD=0.74U
* device instance $638 r0 *1 48.53,34.945 sky130_fd_pr__nfet_01v8
M$638 561 555 580 580 sky130_fd_pr__nfet_01v8 L=0.15U W=0.36U AS=0.066P
+ AD=0.0684P PS=0.745U PD=0.74U
* device instance $639 r0 *1 49.005,34.915 sky130_fd_pr__nfet_01v8
M$639 94 562 580 580 sky130_fd_pr__nfet_01v8 L=0.15U W=0.42U AS=0.066P
+ AD=0.1092P PS=0.745U PD=1.36U
* device instance $640 r0 *1 49.945,34.915 sky130_fd_pr__nfet_01v8
M$640 562 561 94 94 sky130_fd_pr__nfet_01v8 L=0.15U W=0.42U AS=0.10025P
+ AD=0.1092P PS=0.985U PD=1.36U
* device instance $641 r0 *1 50.43,34.8 sky130_fd_pr__nfet_01v8
M$641 497 561 94 94 sky130_fd_pr__nfet_01v8 L=0.15U W=0.65U AS=0.10025P
+ AD=0.182P PS=0.985U PD=1.86U
* device instance $642 r0 *1 59.81,34.8 sky130_fd_pr__nfet_01v8
M$642 94 304 563 563 sky130_fd_pr__nfet_01v8 L=0.15U W=0.65U AS=0.169P
+ AD=0.08775P PS=1.82U PD=0.92U
* device instance $643 r0 *1 60.23,34.8 sky130_fd_pr__nfet_01v8
M$643 575 563 94 94 sky130_fd_pr__nfet_01v8 L=0.15U W=2.6U AS=0.351P
+ AD=0.43225P PS=3.68U PD=4.58U
* device instance $647 r0 *1 62.57,34.8 sky130_fd_pr__nfet_01v8
M$647 94 570 564 564 sky130_fd_pr__nfet_01v8 L=0.15U W=0.65U AS=0.169P
+ AD=0.10725P PS=1.82U PD=0.98U
* device instance $648 r0 *1 63.05,34.8 sky130_fd_pr__nfet_01v8
M$648 578 571 94 94 sky130_fd_pr__nfet_01v8 L=0.15U W=0.65U AS=0.10725P
+ AD=0.06825P PS=0.98U PD=0.86U
* device instance $649 r0 *1 63.41,34.8 sky130_fd_pr__nfet_01v8
M$649 564 91 578 578 sky130_fd_pr__nfet_01v8 L=0.15U W=0.65U AS=0.06825P
+ AD=0.169P PS=0.86U PD=1.82U
* device instance $650 r0 *1 64.35,34.8 sky130_fd_pr__nfet_01v8
M$650 577 87 564 564 sky130_fd_pr__nfet_01v8 L=0.15U W=0.65U AS=0.169P
+ AD=0.10725P PS=1.82U PD=0.98U
* device instance $651 r0 *1 64.83,34.8 sky130_fd_pr__nfet_01v8
M$651 94 572 577 577 sky130_fd_pr__nfet_01v8 L=0.15U W=0.65U AS=0.10725P
+ AD=0.102375P PS=0.98U PD=0.965U
* device instance $652 r0 *1 65.295,34.8 sky130_fd_pr__nfet_01v8
M$652 712 564 94 94 sky130_fd_pr__nfet_01v8 L=0.15U W=0.65U AS=0.102375P
+ AD=0.169P PS=0.965U PD=1.82U
* device instance $653 r0 *1 8.75,35.92 sky130_fd_pr__nfet_01v8
M$653 94 597 585 585 sky130_fd_pr__nfet_01v8 L=0.15U W=0.65U AS=0.169P
+ AD=0.10725P PS=1.82U PD=0.98U
* device instance $654 r0 *1 9.23,35.92 sky130_fd_pr__nfet_01v8
M$654 602 598 94 94 sky130_fd_pr__nfet_01v8 L=0.15U W=0.65U AS=0.10725P
+ AD=0.06825P PS=0.98U PD=0.86U
* device instance $655 r0 *1 9.59,35.92 sky130_fd_pr__nfet_01v8
M$655 585 91 602 602 sky130_fd_pr__nfet_01v8 L=0.15U W=0.65U AS=0.06825P
+ AD=0.169P PS=0.86U PD=1.82U
* device instance $656 r0 *1 10.53,35.92 sky130_fd_pr__nfet_01v8
M$656 603 87 585 585 sky130_fd_pr__nfet_01v8 L=0.15U W=0.65U AS=0.169P
+ AD=0.10725P PS=1.82U PD=0.98U
* device instance $657 r0 *1 11.01,35.92 sky130_fd_pr__nfet_01v8
M$657 94 599 603 603 sky130_fd_pr__nfet_01v8 L=0.15U W=0.65U AS=0.10725P
+ AD=0.102375P PS=0.98U PD=0.965U
* device instance $658 r0 *1 11.475,35.92 sky130_fd_pr__nfet_01v8
M$658 586 585 94 94 sky130_fd_pr__nfet_01v8 L=0.15U W=0.65U AS=0.102375P
+ AD=0.169P PS=0.965U PD=1.82U
* device instance $659 r0 *1 12.53,35.805 sky130_fd_pr__nfet_01v8
M$659 606 576 587 587 sky130_fd_pr__nfet_01v8 L=0.15U W=0.42U AS=0.1092P
+ AD=0.0441P PS=1.36U PD=0.63U
* device instance $660 r0 *1 12.89,35.805 sky130_fd_pr__nfet_01v8
M$660 94 588 606 606 sky130_fd_pr__nfet_01v8 L=0.15U W=0.42U AS=0.0441P
+ AD=0.0567P PS=0.63U PD=0.69U
* device instance $661 r0 *1 13.31,35.805 sky130_fd_pr__nfet_01v8
M$661 607 588 94 94 sky130_fd_pr__nfet_01v8 L=0.15U W=0.42U AS=0.0567P
+ AD=0.0441P PS=0.69U PD=0.63U
* device instance $662 r0 *1 13.67,35.805 sky130_fd_pr__nfet_01v8
M$662 587 589 607 607 sky130_fd_pr__nfet_01v8 L=0.15U W=0.42U AS=0.0441P
+ AD=0.0567P PS=0.63U PD=0.69U
* device instance $663 r0 *1 14.09,35.805 sky130_fd_pr__nfet_01v8
M$663 610 589 587 587 sky130_fd_pr__nfet_01v8 L=0.15U W=0.42U AS=0.0567P
+ AD=0.0441P PS=0.69U PD=0.63U
* device instance $664 r0 *1 14.45,35.805 sky130_fd_pr__nfet_01v8
M$664 94 576 610 610 sky130_fd_pr__nfet_01v8 L=0.15U W=0.42U AS=0.0441P
+ AD=0.162225P PS=0.63U PD=1.25U
* device instance $665 r0 *1 15.2,35.92 sky130_fd_pr__nfet_01v8
M$665 334 587 94 94 sky130_fd_pr__nfet_01v8 L=0.15U W=1.3U AS=0.249975P
+ AD=0.26325P PS=2.17U PD=2.76U
* device instance $667 r0 *1 31.705,35.805 sky130_fd_pr__nfet_01v8
M$667 94 600 495 495 sky130_fd_pr__nfet_01v8 L=0.15U W=0.42U AS=0.1092P
+ AD=0.1197P PS=1.36U PD=1.41U
* device instance $668 r0 *1 34.05,36.035 sky130_fd_pr__nfet_01v8
M$668 590 628 94 94 sky130_fd_pr__nfet_01v8 L=0.15U W=0.42U AS=0.10025P
+ AD=0.1092P PS=0.985U PD=1.36U
* device instance $669 r0 *1 34.535,35.92 sky130_fd_pr__nfet_01v8
M$669 609 601 94 94 sky130_fd_pr__nfet_01v8 L=0.15U W=0.65U AS=0.10025P
+ AD=0.08775P PS=0.985U PD=0.92U
* device instance $670 r0 *1 34.955,35.92 sky130_fd_pr__nfet_01v8
M$670 496 590 609 609 sky130_fd_pr__nfet_01v8 L=0.15U W=0.65U AS=0.08775P
+ AD=0.169P PS=0.92U PD=1.82U
* device instance $671 r0 *1 59.42,35.805 sky130_fd_pr__nfet_01v8
M$671 608 613 591 591 sky130_fd_pr__nfet_01v8 L=0.15U W=0.42U AS=0.1113P
+ AD=0.0441P PS=1.37U PD=0.63U
* device instance $672 r0 *1 59.78,35.805 sky130_fd_pr__nfet_01v8
M$672 94 109 608 608 sky130_fd_pr__nfet_01v8 L=0.15U W=0.42U AS=0.0441P
+ AD=0.0966P PS=0.63U PD=0.88U
* device instance $673 r0 *1 60.39,35.805 sky130_fd_pr__nfet_01v8
M$673 570 591 94 94 sky130_fd_pr__nfet_01v8 L=0.15U W=0.42U AS=0.0966P
+ AD=0.1113P PS=0.88U PD=1.37U
* device instance $674 r0 *1 61.67,35.92 sky130_fd_pr__nfet_01v8
M$674 605 575 94 94 sky130_fd_pr__nfet_01v8 L=0.15U W=0.65U AS=0.169P
+ AD=0.08775P PS=1.82U PD=0.92U
* device instance $675 r0 *1 62.09,35.92 sky130_fd_pr__nfet_01v8
M$675 592 338 605 605 sky130_fd_pr__nfet_01v8 L=0.15U W=0.65U AS=0.08775P
+ AD=0.169P PS=0.92U PD=1.82U
* device instance $676 r0 *1 63.13,35.92 sky130_fd_pr__nfet_01v8
M$676 604 592 593 593 sky130_fd_pr__nfet_01v8 L=0.15U W=0.65U AS=0.169P
+ AD=0.06825P PS=1.82U PD=0.86U
* device instance $677 r0 *1 63.49,35.92 sky130_fd_pr__nfet_01v8
M$677 94 640 604 604 sky130_fd_pr__nfet_01v8 L=0.15U W=0.65U AS=0.06825P
+ AD=0.08775P PS=0.86U PD=0.92U
* device instance $678 r0 *1 63.91,35.92 sky130_fd_pr__nfet_01v8
M$678 594 640 94 94 sky130_fd_pr__nfet_01v8 L=0.15U W=0.65U AS=0.08775P
+ AD=0.169P PS=0.92U PD=1.82U
* device instance $679 r0 *1 64.85,35.92 sky130_fd_pr__nfet_01v8
M$679 594 592 94 94 sky130_fd_pr__nfet_01v8 L=0.15U W=0.65U AS=0.169P
+ AD=0.08775P PS=1.82U PD=0.92U
* device instance $680 r0 *1 65.27,35.92 sky130_fd_pr__nfet_01v8
M$680 572 593 594 594 sky130_fd_pr__nfet_01v8 L=0.15U W=0.65U AS=0.08775P
+ AD=0.195P PS=0.92U PD=1.9U
* device instance $681 r0 *1 66.485,35.805 sky130_fd_pr__nfet_01v8
M$681 94 643 595 595 sky130_fd_pr__nfet_01v8 L=0.15U W=0.42U AS=0.1092P
+ AD=0.10025P PS=1.36U PD=0.985U
* device instance $682 r0 *1 66.97,35.92 sky130_fd_pr__nfet_01v8
M$682 596 571 94 94 sky130_fd_pr__nfet_01v8 L=0.15U W=0.65U AS=0.10025P
+ AD=0.08775P PS=0.985U PD=0.92U
* device instance $683 r0 *1 67.39,35.92 sky130_fd_pr__nfet_01v8
M$683 94 595 596 596 sky130_fd_pr__nfet_01v8 L=0.15U W=0.65U AS=0.08775P
+ AD=0.169P PS=0.92U PD=1.82U
* device instance $684 r0 *1 6.91,40.24 sky130_fd_pr__nfet_01v8
M$684 94 621 662 662 sky130_fd_pr__nfet_01v8 L=0.15U W=0.65U AS=0.169P
+ AD=0.11285P PS=1.82U PD=1.045U
* device instance $685 r0 *1 7.455,40.355 sky130_fd_pr__nfet_01v8
M$685 664 71 94 94 sky130_fd_pr__nfet_01v8 L=0.15U W=0.42U AS=0.11285P
+ AD=0.0693P PS=1.045U PD=0.75U
* device instance $686 r0 *1 7.935,40.355 sky130_fd_pr__nfet_01v8
M$686 621 619 664 664 sky130_fd_pr__nfet_01v8 L=0.15U W=0.42U AS=0.0693P
+ AD=0.09975P PS=0.75U PD=0.895U
* device instance $687 r0 *1 8.56,40.355 sky130_fd_pr__nfet_01v8
M$687 665 589 621 621 sky130_fd_pr__nfet_01v8 L=0.15U W=0.42U AS=0.09975P
+ AD=0.0693P PS=0.895U PD=0.75U
* device instance $688 r0 *1 9.04,40.355 sky130_fd_pr__nfet_01v8
M$688 94 649 665 665 sky130_fd_pr__nfet_01v8 L=0.15U W=0.42U AS=0.0693P
+ AD=0.1449P PS=0.75U PD=1.11U
* device instance $689 r0 *1 9.88,40.355 sky130_fd_pr__nfet_01v8
M$689 649 71 94 94 sky130_fd_pr__nfet_01v8 L=0.15U W=0.42U AS=0.1449P
+ AD=0.1092P PS=1.11U PD=1.36U
* device instance $690 r0 *1 11.15,40.24 sky130_fd_pr__nfet_01v8
M$690 666 637 622 622 sky130_fd_pr__nfet_01v8 L=0.15U W=0.65U AS=0.169P
+ AD=0.06825P PS=1.82U PD=0.86U
* device instance $691 r0 *1 11.51,40.24 sky130_fd_pr__nfet_01v8
M$691 94 623 666 666 sky130_fd_pr__nfet_01v8 L=0.15U W=0.65U AS=0.06825P
+ AD=0.08775P PS=0.86U PD=0.92U
* device instance $692 r0 *1 11.93,40.24 sky130_fd_pr__nfet_01v8
M$692 650 623 94 94 sky130_fd_pr__nfet_01v8 L=0.15U W=0.65U AS=0.08775P
+ AD=0.169P PS=0.92U PD=1.82U
* device instance $693 r0 *1 12.87,40.24 sky130_fd_pr__nfet_01v8
M$693 650 637 94 94 sky130_fd_pr__nfet_01v8 L=0.15U W=0.65U AS=0.169P
+ AD=0.08775P PS=1.82U PD=0.92U
* device instance $694 r0 *1 13.29,40.24 sky130_fd_pr__nfet_01v8
M$694 599 622 650 650 sky130_fd_pr__nfet_01v8 L=0.15U W=0.65U AS=0.08775P
+ AD=0.195P PS=0.92U PD=1.9U
* device instance $695 r0 *1 14.31,40.24 sky130_fd_pr__nfet_01v8
M$695 624 589 94 94 sky130_fd_pr__nfet_01v8 L=0.15U W=0.65U AS=0.169P
+ AD=0.08775P PS=1.82U PD=0.92U
* device instance $696 r0 *1 14.73,40.24 sky130_fd_pr__nfet_01v8
M$696 94 598 624 624 sky130_fd_pr__nfet_01v8 L=0.15U W=0.65U AS=0.08775P
+ AD=0.08775P PS=0.92U PD=0.92U
* device instance $697 r0 *1 15.15,40.24 sky130_fd_pr__nfet_01v8
M$697 668 598 94 94 sky130_fd_pr__nfet_01v8 L=0.15U W=0.65U AS=0.08775P
+ AD=0.08775P PS=0.92U PD=0.92U
* device instance $698 r0 *1 15.57,40.24 sky130_fd_pr__nfet_01v8
M$698 637 589 668 668 sky130_fd_pr__nfet_01v8 L=0.15U W=0.65U AS=0.08775P
+ AD=0.25025P PS=0.92U PD=1.42U
* device instance $699 r0 *1 16.49,40.24 sky130_fd_pr__nfet_01v8
M$699 94 624 637 637 sky130_fd_pr__nfet_01v8 L=0.15U W=0.65U AS=0.25025P
+ AD=0.208P PS=1.42U PD=1.94U
* device instance $700 r0 *1 25.77,40.24 sky130_fd_pr__nfet_01v8
M$700 94 651 626 626 sky130_fd_pr__nfet_01v8 L=0.15U W=0.65U AS=0.169P
+ AD=0.10725P PS=1.82U PD=0.98U
* device instance $701 r0 *1 26.25,40.24 sky130_fd_pr__nfet_01v8
M$701 670 628 94 94 sky130_fd_pr__nfet_01v8 L=0.15U W=0.65U AS=0.10725P
+ AD=0.06825P PS=0.98U PD=0.86U
* device instance $702 r0 *1 26.61,40.24 sky130_fd_pr__nfet_01v8
M$702 626 91 670 670 sky130_fd_pr__nfet_01v8 L=0.15U W=0.65U AS=0.06825P
+ AD=0.169P PS=0.86U PD=1.82U
* device instance $703 r0 *1 27.55,40.24 sky130_fd_pr__nfet_01v8
M$703 671 137 626 626 sky130_fd_pr__nfet_01v8 L=0.15U W=0.65U AS=0.169P
+ AD=0.10725P PS=1.82U PD=0.98U
* device instance $704 r0 *1 28.03,40.24 sky130_fd_pr__nfet_01v8
M$704 94 553 671 671 sky130_fd_pr__nfet_01v8 L=0.15U W=0.65U AS=0.10725P
+ AD=0.102375P PS=0.98U PD=0.965U
* device instance $705 r0 *1 28.495,40.24 sky130_fd_pr__nfet_01v8
M$705 639 626 94 94 sky130_fd_pr__nfet_01v8 L=0.15U W=0.65U AS=0.102375P
+ AD=0.169P PS=0.965U PD=1.82U
* device instance $706 r0 *1 30.93,40.24 sky130_fd_pr__nfet_01v8
M$706 672 601 629 629 sky130_fd_pr__nfet_01v8 L=0.15U W=0.65U AS=0.169P
+ AD=0.06825P PS=1.82U PD=0.86U
* device instance $707 r0 *1 31.29,40.24 sky130_fd_pr__nfet_01v8
M$707 94 628 672 672 sky130_fd_pr__nfet_01v8 L=0.15U W=0.65U AS=0.06825P
+ AD=0.08775P PS=0.86U PD=0.92U
* device instance $708 r0 *1 31.71,40.24 sky130_fd_pr__nfet_01v8
M$708 652 628 94 94 sky130_fd_pr__nfet_01v8 L=0.15U W=0.65U AS=0.08775P
+ AD=0.169P PS=0.92U PD=1.82U
* device instance $709 r0 *1 32.65,40.24 sky130_fd_pr__nfet_01v8
M$709 652 601 94 94 sky130_fd_pr__nfet_01v8 L=0.15U W=0.65U AS=0.169P
+ AD=0.08775P PS=1.82U PD=0.92U
* device instance $710 r0 *1 33.07,40.24 sky130_fd_pr__nfet_01v8
M$710 600 629 652 652 sky130_fd_pr__nfet_01v8 L=0.15U W=0.65U AS=0.08775P
+ AD=0.195P PS=0.92U PD=1.9U
* device instance $711 r0 *1 55.67,40.24 sky130_fd_pr__nfet_01v8
M$711 674 575 94 94 sky130_fd_pr__nfet_01v8 L=0.15U W=0.65U AS=0.169P
+ AD=0.06825P PS=1.82U PD=0.86U
* device instance $712 r0 *1 56.03,40.24 sky130_fd_pr__nfet_01v8
M$712 673 338 674 674 sky130_fd_pr__nfet_01v8 L=0.15U W=0.65U AS=0.06825P
+ AD=0.118625P PS=0.86U PD=1.015U
* device instance $713 r0 *1 56.545,40.24 sky130_fd_pr__nfet_01v8
M$713 632 640 673 673 sky130_fd_pr__nfet_01v8 L=0.15U W=0.65U AS=0.118625P
+ AD=0.105625P PS=1.015U PD=0.975U
* device instance $714 r0 *1 57.02,40.24 sky130_fd_pr__nfet_01v8
M$714 94 596 632 632 sky130_fd_pr__nfet_01v8 L=0.15U W=0.65U AS=0.105625P
+ AD=0.1755P PS=0.975U PD=1.84U
* device instance $715 r0 *1 59.35,40.24 sky130_fd_pr__nfet_01v8
M$715 675 338 94 94 sky130_fd_pr__nfet_01v8 L=0.15U W=0.65U AS=0.169P
+ AD=0.089375P PS=1.82U PD=0.925U
* device instance $716 r0 *1 59.775,40.24 sky130_fd_pr__nfet_01v8
M$716 676 304 675 675 sky130_fd_pr__nfet_01v8 L=0.15U W=0.65U AS=0.089375P
+ AD=0.091P PS=0.925U PD=0.93U
* device instance $717 r0 *1 60.205,40.24 sky130_fd_pr__nfet_01v8
M$717 642 640 676 676 sky130_fd_pr__nfet_01v8 L=0.15U W=0.65U AS=0.091P
+ AD=0.115375P PS=0.93U PD=1.005U
* device instance $718 r0 *1 60.71,40.24 sky130_fd_pr__nfet_01v8
M$718 94 596 642 642 sky130_fd_pr__nfet_01v8 L=0.15U W=0.65U AS=0.115375P
+ AD=0.112125P PS=1.005U PD=0.995U
* device instance $719 r0 *1 61.205,40.24 sky130_fd_pr__nfet_01v8
M$719 642 654 94 94 sky130_fd_pr__nfet_01v8 L=0.15U W=0.65U AS=0.112125P
+ AD=0.169P PS=0.995U PD=1.82U
* device instance $720 r0 *1 64.51,40.24 sky130_fd_pr__nfet_01v8
M$720 677 643 633 633 sky130_fd_pr__nfet_01v8 L=0.15U W=0.65U AS=0.169P
+ AD=0.06825P PS=1.82U PD=0.86U
* device instance $721 r0 *1 64.87,40.24 sky130_fd_pr__nfet_01v8
M$721 94 571 677 677 sky130_fd_pr__nfet_01v8 L=0.15U W=0.65U AS=0.06825P
+ AD=0.08775P PS=0.86U PD=0.92U
* device instance $722 r0 *1 65.29,40.24 sky130_fd_pr__nfet_01v8
M$722 655 571 94 94 sky130_fd_pr__nfet_01v8 L=0.15U W=0.65U AS=0.08775P
+ AD=0.169P PS=0.92U PD=1.82U
* device instance $723 r0 *1 66.23,40.24 sky130_fd_pr__nfet_01v8
M$723 655 643 94 94 sky130_fd_pr__nfet_01v8 L=0.15U W=0.65U AS=0.169P
+ AD=0.08775P PS=1.82U PD=0.92U
* device instance $724 r0 *1 66.65,40.24 sky130_fd_pr__nfet_01v8
M$724 640 633 655 655 sky130_fd_pr__nfet_01v8 L=0.15U W=0.65U AS=0.08775P
+ AD=0.195P PS=0.92U PD=1.9U
* device instance $725 r0 *1 68.09,40.24 sky130_fd_pr__nfet_01v8
M$725 94 635 634 634 sky130_fd_pr__nfet_01v8 L=0.15U W=0.65U AS=0.169P
+ AD=0.11285P PS=1.82U PD=1.045U
* device instance $726 r0 *1 68.635,40.355 sky130_fd_pr__nfet_01v8
M$726 669 71 94 94 sky130_fd_pr__nfet_01v8 L=0.15U W=0.42U AS=0.11285P
+ AD=0.0693P PS=1.045U PD=0.75U
* device instance $727 r0 *1 69.115,40.355 sky130_fd_pr__nfet_01v8
M$727 635 644 669 669 sky130_fd_pr__nfet_01v8 L=0.15U W=0.42U AS=0.0693P
+ AD=0.09975P PS=0.75U PD=0.895U
* device instance $728 r0 *1 69.74,40.355 sky130_fd_pr__nfet_01v8
M$728 667 643 635 635 sky130_fd_pr__nfet_01v8 L=0.15U W=0.42U AS=0.09975P
+ AD=0.0693P PS=0.895U PD=0.75U
* device instance $729 r0 *1 70.22,40.355 sky130_fd_pr__nfet_01v8
M$729 94 656 667 667 sky130_fd_pr__nfet_01v8 L=0.15U W=0.42U AS=0.0693P
+ AD=0.1449P PS=0.75U PD=1.11U
* device instance $730 r0 *1 71.06,40.355 sky130_fd_pr__nfet_01v8
M$730 656 71 94 94 sky130_fd_pr__nfet_01v8 L=0.15U W=0.42U AS=0.1449P
+ AD=0.1092P PS=1.11U PD=1.36U
* device instance $731 r0 *1 2.77,41.245 sky130_fd_pr__nfet_01v8
M$731 94 937 678 678 sky130_fd_pr__nfet_01v8 L=0.15U W=0.42U AS=0.1092P
+ AD=0.0567P PS=1.36U PD=0.69U
* device instance $732 r0 *1 3.19,41.245 sky130_fd_pr__nfet_01v8
M$732 679 678 94 94 sky130_fd_pr__nfet_01v8 L=0.15U W=0.42U AS=0.0567P
+ AD=0.1092P PS=0.69U PD=1.36U
* device instance $733 r0 *1 4.13,41.245 sky130_fd_pr__nfet_01v8
M$733 714 662 680 680 sky130_fd_pr__nfet_01v8 L=0.15U W=0.42U AS=0.1092P
+ AD=0.0441P PS=1.36U PD=0.63U
* device instance $734 r0 *1 4.49,41.245 sky130_fd_pr__nfet_01v8
M$734 94 90 714 714 sky130_fd_pr__nfet_01v8 L=0.15U W=0.42U AS=0.0441P
+ AD=0.1092P PS=0.63U PD=1.36U
* device instance $735 r0 *1 4.68,40.355 sky130_fd_pr__nfet_01v8
M$735 663 636 620 620 sky130_fd_pr__nfet_01v8 L=0.15U W=0.42U AS=0.1113P
+ AD=0.0441P PS=1.37U PD=0.63U
* device instance $736 r0 *1 5.04,40.355 sky130_fd_pr__nfet_01v8
M$736 94 109 663 663 sky130_fd_pr__nfet_01v8 L=0.15U W=0.42U AS=0.0441P
+ AD=0.0966P PS=0.63U PD=0.88U
* device instance $737 r0 *1 5.65,40.355 sky130_fd_pr__nfet_01v8
M$737 597 620 94 94 sky130_fd_pr__nfet_01v8 L=0.15U W=0.42U AS=0.0966P
+ AD=0.1113P PS=0.88U PD=1.37U
* device instance $738 r0 *1 7.29,41.215 sky130_fd_pr__nfet_01v8
M$738 682 678 680 680 sky130_fd_pr__nfet_01v8 L=0.15U W=0.36U AS=0.1446P
+ AD=0.0522P PS=1.18U PD=0.65U
* device instance $739 r0 *1 7.73,41.215 sky130_fd_pr__nfet_01v8
M$739 716 679 682 682 sky130_fd_pr__nfet_01v8 L=0.15U W=0.36U AS=0.0522P
+ AD=0.0759P PS=0.65U PD=0.8U
* device instance $740 r0 *1 5.43,41.245 sky130_fd_pr__nfet_01v8
M$740 94 90 681 681 sky130_fd_pr__nfet_01v8 L=0.15U W=0.42U AS=0.1092P
+ AD=0.0609P PS=1.36U PD=0.71U
* device instance $741 r0 *1 5.87,41.245 sky130_fd_pr__nfet_01v8
M$741 715 681 94 94 sky130_fd_pr__nfet_01v8 L=0.15U W=0.42U AS=0.0609P
+ AD=0.0756P PS=0.71U PD=0.78U
* device instance $742 r0 *1 6.38,41.245 sky130_fd_pr__nfet_01v8
M$742 680 705 715 715 sky130_fd_pr__nfet_01v8 L=0.15U W=0.42U AS=0.0756P
+ AD=0.1446P PS=0.78U PD=1.18U
* device instance $743 r0 *1 8.26,41.245 sky130_fd_pr__nfet_01v8
M$743 94 683 716 716 sky130_fd_pr__nfet_01v8 L=0.15U W=0.42U AS=0.0759P
+ AD=0.12095P PS=0.8U PD=1.085U
* device instance $744 r0 *1 8.855,41.355 sky130_fd_pr__nfet_01v8
M$744 683 682 94 94 sky130_fd_pr__nfet_01v8 L=0.15U W=0.64U AS=0.12095P
+ AD=0.1664P PS=1.085U PD=1.8U
* device instance $745 r0 *1 10.28,41.215 sky130_fd_pr__nfet_01v8
M$745 684 679 719 719 sky130_fd_pr__nfet_01v8 L=0.15U W=0.36U AS=0.0678P
+ AD=0.0684P PS=0.755U PD=0.74U
* device instance $746 r0 *1 10.81,41.215 sky130_fd_pr__nfet_01v8
M$746 720 678 684 684 sky130_fd_pr__nfet_01v8 L=0.15U W=0.36U AS=0.0684P
+ AD=0.066P PS=0.74U PD=0.745U
* device instance $747 r0 *1 9.795,41.245 sky130_fd_pr__nfet_01v8
M$747 719 683 94 94 sky130_fd_pr__nfet_01v8 L=0.15U W=0.42U AS=0.1092P
+ AD=0.0678P PS=1.36U PD=0.755U
* device instance $748 r0 *1 11.285,41.245 sky130_fd_pr__nfet_01v8
M$748 94 705 720 720 sky130_fd_pr__nfet_01v8 L=0.15U W=0.42U AS=0.066P
+ AD=0.1092P PS=0.745U PD=1.36U
* device instance $749 r0 *1 12.225,41.245 sky130_fd_pr__nfet_01v8
M$749 94 684 705 705 sky130_fd_pr__nfet_01v8 L=0.15U W=0.42U AS=0.1092P
+ AD=0.10025P PS=1.36U PD=0.985U
* device instance $750 r0 *1 12.71,41.36 sky130_fd_pr__nfet_01v8
M$750 552 684 94 94 sky130_fd_pr__nfet_01v8 L=0.15U W=0.65U AS=0.10025P
+ AD=0.182P PS=0.985U PD=1.86U
* device instance $751 r0 *1 13.81,41.36 sky130_fd_pr__nfet_01v8
M$751 94 552 706 706 sky130_fd_pr__nfet_01v8 L=0.15U W=0.65U AS=0.169P
+ AD=0.08775P PS=1.82U PD=0.92U
* device instance $752 r0 *1 14.23,41.36 sky130_fd_pr__nfet_01v8
M$752 598 706 94 94 sky130_fd_pr__nfet_01v8 L=0.15U W=2.6U AS=0.351P
+ AD=0.43225P PS=3.68U PD=4.58U
* device instance $756 r0 *1 17.03,41.36 sky130_fd_pr__nfet_01v8
M$756 94 588 707 707 sky130_fd_pr__nfet_01v8 L=0.15U W=0.65U AS=0.169P
+ AD=0.08775P PS=1.82U PD=0.92U
* device instance $757 r0 *1 17.45,41.36 sky130_fd_pr__nfet_01v8
M$757 623 707 94 94 sky130_fd_pr__nfet_01v8 L=0.15U W=2.6U AS=0.351P
+ AD=0.43225P PS=3.68U PD=4.58U
* device instance $761 r0 *1 19.71,41.245 sky130_fd_pr__nfet_01v8
M$761 723 733 685 685 sky130_fd_pr__nfet_01v8 L=0.15U W=0.42U AS=0.1113P
+ AD=0.0441P PS=1.37U PD=0.63U
* device instance $762 r0 *1 20.07,41.245 sky130_fd_pr__nfet_01v8
M$762 94 109 723 723 sky130_fd_pr__nfet_01v8 L=0.15U W=0.42U AS=0.0441P
+ AD=0.0966P PS=0.63U PD=0.88U
* device instance $763 r0 *1 20.68,41.245 sky130_fd_pr__nfet_01v8
M$763 651 685 94 94 sky130_fd_pr__nfet_01v8 L=0.15U W=0.42U AS=0.0966P
+ AD=0.1113P PS=0.88U PD=1.37U
* device instance $764 r0 *1 26.23,41.245 sky130_fd_pr__nfet_01v8
M$764 94 937 686 686 sky130_fd_pr__nfet_01v8 L=0.15U W=0.42U AS=0.1092P
+ AD=0.0567P PS=1.36U PD=0.69U
* device instance $765 r0 *1 26.65,41.245 sky130_fd_pr__nfet_01v8
M$765 687 686 94 94 sky130_fd_pr__nfet_01v8 L=0.15U W=0.42U AS=0.0567P
+ AD=0.1092P PS=0.69U PD=1.36U
* device instance $766 r0 *1 27.59,41.245 sky130_fd_pr__nfet_01v8
M$766 724 708 688 688 sky130_fd_pr__nfet_01v8 L=0.15U W=0.42U AS=0.1092P
+ AD=0.0441P PS=1.36U PD=0.63U
* device instance $767 r0 *1 27.95,41.245 sky130_fd_pr__nfet_01v8
M$767 94 90 724 724 sky130_fd_pr__nfet_01v8 L=0.15U W=0.42U AS=0.0441P
+ AD=0.1092P PS=0.63U PD=1.36U
* device instance $768 r0 *1 30.75,41.215 sky130_fd_pr__nfet_01v8
M$768 690 686 688 688 sky130_fd_pr__nfet_01v8 L=0.15U W=0.36U AS=0.1446P
+ AD=0.0522P PS=1.18U PD=0.65U
* device instance $769 r0 *1 31.19,41.215 sky130_fd_pr__nfet_01v8
M$769 727 687 690 690 sky130_fd_pr__nfet_01v8 L=0.15U W=0.36U AS=0.0522P
+ AD=0.0759P PS=0.65U PD=0.8U
* device instance $770 r0 *1 28.89,41.245 sky130_fd_pr__nfet_01v8
M$770 94 90 689 689 sky130_fd_pr__nfet_01v8 L=0.15U W=0.42U AS=0.1092P
+ AD=0.0609P PS=1.36U PD=0.71U
* device instance $771 r0 *1 29.33,41.245 sky130_fd_pr__nfet_01v8
M$771 726 689 94 94 sky130_fd_pr__nfet_01v8 L=0.15U W=0.42U AS=0.0609P
+ AD=0.0756P PS=0.71U PD=0.78U
* device instance $772 r0 *1 29.84,41.245 sky130_fd_pr__nfet_01v8
M$772 688 709 726 726 sky130_fd_pr__nfet_01v8 L=0.15U W=0.42U AS=0.0756P
+ AD=0.1446P PS=0.78U PD=1.18U
* device instance $773 r0 *1 31.72,41.245 sky130_fd_pr__nfet_01v8
M$773 94 691 727 727 sky130_fd_pr__nfet_01v8 L=0.15U W=0.42U AS=0.0759P
+ AD=0.12095P PS=0.8U PD=1.085U
* device instance $774 r0 *1 32.315,41.355 sky130_fd_pr__nfet_01v8
M$774 691 690 94 94 sky130_fd_pr__nfet_01v8 L=0.15U W=0.64U AS=0.12095P
+ AD=0.1664P PS=1.085U PD=1.8U
* device instance $775 r0 *1 33.74,41.215 sky130_fd_pr__nfet_01v8
M$775 692 687 728 728 sky130_fd_pr__nfet_01v8 L=0.15U W=0.36U AS=0.0678P
+ AD=0.0684P PS=0.755U PD=0.74U
* device instance $776 r0 *1 34.27,41.215 sky130_fd_pr__nfet_01v8
M$776 729 686 692 692 sky130_fd_pr__nfet_01v8 L=0.15U W=0.36U AS=0.0684P
+ AD=0.066P PS=0.74U PD=0.745U
* device instance $777 r0 *1 33.255,41.245 sky130_fd_pr__nfet_01v8
M$777 728 691 94 94 sky130_fd_pr__nfet_01v8 L=0.15U W=0.42U AS=0.1092P
+ AD=0.0678P PS=1.36U PD=0.755U
* device instance $778 r0 *1 34.745,41.245 sky130_fd_pr__nfet_01v8
M$778 94 709 729 729 sky130_fd_pr__nfet_01v8 L=0.15U W=0.42U AS=0.066P
+ AD=0.1092P PS=0.745U PD=1.36U
* device instance $779 r0 *1 35.435,40.355 sky130_fd_pr__nfet_01v8
M$779 630 653 94 94 sky130_fd_pr__nfet_01v8 L=0.15U W=1.68U AS=0.2877P
+ AD=0.2352P PS=3.47U PD=2.8U
* device instance $783 r0 *1 37.155,40.355 sky130_fd_pr__nfet_01v8
M$783 310 630 94 94 sky130_fd_pr__nfet_01v8 L=0.15U W=6.72U AS=0.93975P
+ AD=0.99225P PS=11.195U PD=11.865U
* device instance $799 r0 *1 35.685,41.245 sky130_fd_pr__nfet_01v8
M$799 94 692 709 709 sky130_fd_pr__nfet_01v8 L=0.15U W=0.42U AS=0.1092P
+ AD=0.10025P PS=1.36U PD=0.985U
* device instance $800 r0 *1 36.17,41.36 sky130_fd_pr__nfet_01v8
M$800 628 692 94 94 sky130_fd_pr__nfet_01v8 L=0.15U W=0.65U AS=0.10025P
+ AD=0.182P PS=0.985U PD=1.86U
* device instance $801 r0 *1 44.63,41.36 sky130_fd_pr__nfet_01v8
M$801 693 628 94 94 sky130_fd_pr__nfet_01v8 L=0.15U W=0.65U AS=0.169P
+ AD=0.118625P PS=1.82U PD=1.015U
* device instance $802 r0 *1 45.145,41.36 sky130_fd_pr__nfet_01v8
M$802 94 367 693 693 sky130_fd_pr__nfet_01v8 L=0.15U W=0.65U AS=0.118625P
+ AD=0.089375P PS=1.015U PD=0.925U
* device instance $803 r0 *1 45.57,41.36 sky130_fd_pr__nfet_01v8
M$803 693 710 94 94 sky130_fd_pr__nfet_01v8 L=0.15U W=0.65U AS=0.089375P
+ AD=0.08775P PS=0.925U PD=0.92U
* device instance $804 r0 *1 45.99,41.36 sky130_fd_pr__nfet_01v8
M$804 94 694 693 693 sky130_fd_pr__nfet_01v8 L=0.15U W=0.65U AS=0.08775P
+ AD=0.169P PS=0.92U PD=1.82U
* device instance $805 r0 *1 49.23,41.36 sky130_fd_pr__nfet_01v8
M$805 731 693 94 94 sky130_fd_pr__nfet_01v8 L=0.15U W=0.65U AS=0.169P
+ AD=0.08775P PS=1.82U PD=0.92U
* device instance $806 r0 *1 49.65,41.36 sky130_fd_pr__nfet_01v8
M$806 732 695 731 731 sky130_fd_pr__nfet_01v8 L=0.15U W=0.65U AS=0.08775P
+ AD=0.10725P PS=0.92U PD=0.98U
* device instance $807 r0 *1 50.13,41.36 sky130_fd_pr__nfet_01v8
M$807 876 407 732 732 sky130_fd_pr__nfet_01v8 L=0.15U W=0.65U AS=0.10725P
+ AD=0.169P PS=0.98U PD=1.82U
* device instance $808 r0 *1 57.61,41.36 sky130_fd_pr__nfet_01v8
M$808 730 711 696 696 sky130_fd_pr__nfet_01v8 L=0.15U W=0.65U AS=0.169P
+ AD=0.06825P PS=1.82U PD=0.86U
* device instance $809 r0 *1 57.97,41.36 sky130_fd_pr__nfet_01v8
M$809 94 632 730 730 sky130_fd_pr__nfet_01v8 L=0.15U W=0.65U AS=0.06825P
+ AD=0.08775P PS=0.86U PD=0.92U
* device instance $810 r0 *1 58.39,41.36 sky130_fd_pr__nfet_01v8
M$810 697 632 94 94 sky130_fd_pr__nfet_01v8 L=0.15U W=0.65U AS=0.08775P
+ AD=0.169P PS=0.92U PD=1.82U
* device instance $811 r0 *1 59.33,41.36 sky130_fd_pr__nfet_01v8
M$811 697 711 94 94 sky130_fd_pr__nfet_01v8 L=0.15U W=0.65U AS=0.169P
+ AD=0.08775P PS=1.82U PD=0.92U
* device instance $812 r0 *1 59.75,41.36 sky130_fd_pr__nfet_01v8
M$812 734 696 697 697 sky130_fd_pr__nfet_01v8 L=0.15U W=0.65U AS=0.08775P
+ AD=0.195P PS=0.92U PD=1.9U
* device instance $813 r0 *1 60.73,41.245 sky130_fd_pr__nfet_01v8
M$813 94 844 698 698 sky130_fd_pr__nfet_01v8 L=0.15U W=0.42U AS=0.1092P
+ AD=0.0567P PS=1.36U PD=0.69U
* device instance $814 r0 *1 61.15,41.245 sky130_fd_pr__nfet_01v8
M$814 699 698 94 94 sky130_fd_pr__nfet_01v8 L=0.15U W=0.42U AS=0.0567P
+ AD=0.1092P PS=0.69U PD=1.36U
* device instance $815 r0 *1 62.09,41.245 sky130_fd_pr__nfet_01v8
M$815 725 712 700 700 sky130_fd_pr__nfet_01v8 L=0.15U W=0.42U AS=0.1092P
+ AD=0.0441P PS=1.36U PD=0.63U
* device instance $816 r0 *1 62.45,41.245 sky130_fd_pr__nfet_01v8
M$816 94 315 725 725 sky130_fd_pr__nfet_01v8 L=0.15U W=0.42U AS=0.0441P
+ AD=0.1092P PS=0.63U PD=1.36U
* device instance $817 r0 *1 65.25,41.215 sky130_fd_pr__nfet_01v8
M$817 702 698 700 700 sky130_fd_pr__nfet_01v8 L=0.15U W=0.36U AS=0.1446P
+ AD=0.0522P PS=1.18U PD=0.65U
* device instance $818 r0 *1 65.69,41.215 sky130_fd_pr__nfet_01v8
M$818 721 699 702 702 sky130_fd_pr__nfet_01v8 L=0.15U W=0.36U AS=0.0522P
+ AD=0.0759P PS=0.65U PD=0.8U
* device instance $819 r0 *1 63.39,41.245 sky130_fd_pr__nfet_01v8
M$819 94 315 701 701 sky130_fd_pr__nfet_01v8 L=0.15U W=0.42U AS=0.1092P
+ AD=0.0609P PS=1.36U PD=0.71U
* device instance $820 r0 *1 63.83,41.245 sky130_fd_pr__nfet_01v8
M$820 722 701 94 94 sky130_fd_pr__nfet_01v8 L=0.15U W=0.42U AS=0.0609P
+ AD=0.0756P PS=0.71U PD=0.78U
* device instance $821 r0 *1 64.34,41.245 sky130_fd_pr__nfet_01v8
M$821 700 713 722 722 sky130_fd_pr__nfet_01v8 L=0.15U W=0.42U AS=0.0756P
+ AD=0.1446P PS=0.78U PD=1.18U
* device instance $822 r0 *1 66.22,41.245 sky130_fd_pr__nfet_01v8
M$822 94 703 721 721 sky130_fd_pr__nfet_01v8 L=0.15U W=0.42U AS=0.0759P
+ AD=0.12095P PS=0.8U PD=1.085U
* device instance $823 r0 *1 66.815,41.355 sky130_fd_pr__nfet_01v8
M$823 703 702 94 94 sky130_fd_pr__nfet_01v8 L=0.15U W=0.64U AS=0.12095P
+ AD=0.1664P PS=1.085U PD=1.8U
* device instance $824 r0 *1 68.24,41.215 sky130_fd_pr__nfet_01v8
M$824 704 699 718 718 sky130_fd_pr__nfet_01v8 L=0.15U W=0.36U AS=0.0678P
+ AD=0.0684P PS=0.755U PD=0.74U
* device instance $825 r0 *1 68.77,41.215 sky130_fd_pr__nfet_01v8
M$825 717 698 704 704 sky130_fd_pr__nfet_01v8 L=0.15U W=0.36U AS=0.0684P
+ AD=0.066P PS=0.74U PD=0.745U
* device instance $826 r0 *1 67.755,41.245 sky130_fd_pr__nfet_01v8
M$826 718 703 94 94 sky130_fd_pr__nfet_01v8 L=0.15U W=0.42U AS=0.1092P
+ AD=0.0678P PS=1.36U PD=0.755U
* device instance $827 r0 *1 69.245,41.245 sky130_fd_pr__nfet_01v8
M$827 94 713 717 717 sky130_fd_pr__nfet_01v8 L=0.15U W=0.42U AS=0.066P
+ AD=0.1092P PS=0.745U PD=1.36U
* device instance $828 r0 *1 70.185,41.245 sky130_fd_pr__nfet_01v8
M$828 94 704 713 713 sky130_fd_pr__nfet_01v8 L=0.15U W=0.42U AS=0.1092P
+ AD=0.10025P PS=1.36U PD=0.985U
* device instance $829 r0 *1 70.67,41.36 sky130_fd_pr__nfet_01v8
M$829 643 704 94 94 sky130_fd_pr__nfet_01v8 L=0.15U W=0.65U AS=0.10025P
+ AD=0.182P PS=0.985U PD=1.86U
* device instance $830 r0 *1 7.83,46.8 sky130_fd_pr__nfet_01v8
M$830 94 862 831 831 sky130_fd_pr__nfet_01v8 L=0.15U W=0.65U AS=0.169P
+ AD=0.10725P PS=1.82U PD=0.98U
* device instance $831 r0 *1 8.31,46.8 sky130_fd_pr__nfet_01v8
M$831 868 863 94 94 sky130_fd_pr__nfet_01v8 L=0.15U W=0.65U AS=0.10725P
+ AD=0.06825P PS=0.98U PD=0.86U
* device instance $832 r0 *1 8.67,46.8 sky130_fd_pr__nfet_01v8
M$832 831 91 868 868 sky130_fd_pr__nfet_01v8 L=0.15U W=0.65U AS=0.06825P
+ AD=0.169P PS=0.86U PD=1.82U
* device instance $833 r0 *1 9.21,45.795 sky130_fd_pr__nfet_01v8
M$833 94 937 762 762 sky130_fd_pr__nfet_01v8 L=0.15U W=0.42U AS=0.1092P
+ AD=0.0567P PS=1.36U PD=0.69U
* device instance $834 r0 *1 9.63,45.795 sky130_fd_pr__nfet_01v8
M$834 763 762 94 94 sky130_fd_pr__nfet_01v8 L=0.15U W=0.42U AS=0.0567P
+ AD=0.1092P PS=0.69U PD=1.36U
* device instance $835 r0 *1 9.61,46.8 sky130_fd_pr__nfet_01v8
M$835 869 87 831 831 sky130_fd_pr__nfet_01v8 L=0.15U W=0.65U AS=0.169P
+ AD=0.10725P PS=1.82U PD=0.98U
* device instance $836 r0 *1 10.09,46.8 sky130_fd_pr__nfet_01v8
M$836 94 864 869 869 sky130_fd_pr__nfet_01v8 L=0.15U W=0.65U AS=0.10725P
+ AD=0.102375P PS=0.98U PD=0.965U
* device instance $837 r0 *1 10.555,46.8 sky130_fd_pr__nfet_01v8
M$837 873 831 94 94 sky130_fd_pr__nfet_01v8 L=0.15U W=0.65U AS=0.102375P
+ AD=0.169P PS=0.965U PD=1.82U
* device instance $838 r0 *1 10.57,45.795 sky130_fd_pr__nfet_01v8
M$838 813 586 764 764 sky130_fd_pr__nfet_01v8 L=0.15U W=0.42U AS=0.1092P
+ AD=0.0441P PS=1.36U PD=0.63U
* device instance $839 r0 *1 10.93,45.795 sky130_fd_pr__nfet_01v8
M$839 94 315 813 813 sky130_fd_pr__nfet_01v8 L=0.15U W=0.42U AS=0.0441P
+ AD=0.1092P PS=0.63U PD=1.36U
* device instance $840 r0 *1 11.51,46.8 sky130_fd_pr__nfet_01v8
M$840 94 865 832 832 sky130_fd_pr__nfet_01v8 L=0.15U W=0.65U AS=0.169P
+ AD=0.169P PS=1.82U PD=1.82U
* device instance $841 r0 *1 11.87,45.795 sky130_fd_pr__nfet_01v8
M$841 94 315 735 735 sky130_fd_pr__nfet_01v8 L=0.15U W=0.42U AS=0.1092P
+ AD=0.0609P PS=1.36U PD=0.71U
* device instance $842 r0 *1 12.31,45.795 sky130_fd_pr__nfet_01v8
M$842 815 735 94 94 sky130_fd_pr__nfet_01v8 L=0.15U W=0.42U AS=0.0609P
+ AD=0.0756P PS=0.71U PD=0.78U
* device instance $843 r0 *1 12.82,45.795 sky130_fd_pr__nfet_01v8
M$843 764 736 815 815 sky130_fd_pr__nfet_01v8 L=0.15U W=0.42U AS=0.0756P
+ AD=0.1446P PS=0.78U PD=1.18U
* device instance $844 r0 *1 13.73,45.825 sky130_fd_pr__nfet_01v8
M$844 765 762 764 764 sky130_fd_pr__nfet_01v8 L=0.15U W=0.36U AS=0.1446P
+ AD=0.0522P PS=1.18U PD=0.65U
* device instance $845 r0 *1 14.17,45.825 sky130_fd_pr__nfet_01v8
M$845 765 763 817 817 sky130_fd_pr__nfet_01v8 L=0.15U W=0.36U AS=0.0759P
+ AD=0.0522P PS=0.8U PD=0.65U
* device instance $846 r0 *1 14.7,45.795 sky130_fd_pr__nfet_01v8
M$846 817 766 94 94 sky130_fd_pr__nfet_01v8 L=0.15U W=0.42U AS=0.12095P
+ AD=0.0759P PS=1.085U PD=0.8U
* device instance $847 r0 *1 15.295,45.685 sky130_fd_pr__nfet_01v8
M$847 766 765 94 94 sky130_fd_pr__nfet_01v8 L=0.15U W=0.64U AS=0.12095P
+ AD=0.1664P PS=1.085U PD=1.8U
* device instance $848 r0 *1 12.45,46.8 sky130_fd_pr__nfet_01v8
M$848 588 832 833 833 sky130_fd_pr__nfet_01v8 L=0.15U W=2.6U AS=0.43225P
+ AD=0.355875P PS=4.58U PD=3.695U
* device instance $852 r0 *1 14.145,46.8 sky130_fd_pr__nfet_01v8
M$852 94 834 833 833 sky130_fd_pr__nfet_01v8 L=0.15U W=2.6U AS=0.355875P
+ AD=0.51675P PS=3.695U PD=4.84U
* device instance $856 r0 *1 16.235,45.795 sky130_fd_pr__nfet_01v8
M$856 820 766 94 94 sky130_fd_pr__nfet_01v8 L=0.15U W=0.42U AS=0.1092P
+ AD=0.0678P PS=1.36U PD=0.755U
* device instance $857 r0 *1 16.72,45.825 sky130_fd_pr__nfet_01v8
M$857 767 763 820 820 sky130_fd_pr__nfet_01v8 L=0.15U W=0.36U AS=0.0678P
+ AD=0.0684P PS=0.755U PD=0.74U
* device instance $858 r0 *1 17.25,45.825 sky130_fd_pr__nfet_01v8
M$858 767 762 819 819 sky130_fd_pr__nfet_01v8 L=0.15U W=0.36U AS=0.066P
+ AD=0.0684P PS=0.745U PD=0.74U
* device instance $859 r0 *1 17.725,45.795 sky130_fd_pr__nfet_01v8
M$859 94 736 819 819 sky130_fd_pr__nfet_01v8 L=0.15U W=0.42U AS=0.066P
+ AD=0.1092P PS=0.745U PD=1.36U
* device instance $860 r0 *1 18.665,45.795 sky130_fd_pr__nfet_01v8
M$860 736 767 94 94 sky130_fd_pr__nfet_01v8 L=0.15U W=0.42U AS=0.10025P
+ AD=0.1092P PS=0.985U PD=1.36U
* device instance $861 r0 *1 19.15,45.68 sky130_fd_pr__nfet_01v8
M$861 589 767 94 94 sky130_fd_pr__nfet_01v8 L=0.15U W=0.65U AS=0.10025P
+ AD=0.182P PS=0.985U PD=1.86U
* device instance $862 r0 *1 25.77,46.685 sky130_fd_pr__nfet_01v8
M$862 94 937 835 835 sky130_fd_pr__nfet_01v8 L=0.15U W=0.42U AS=0.1092P
+ AD=0.0567P PS=1.36U PD=0.69U
* device instance $863 r0 *1 26.19,46.685 sky130_fd_pr__nfet_01v8
M$863 836 835 94 94 sky130_fd_pr__nfet_01v8 L=0.15U W=0.42U AS=0.0567P
+ AD=0.1092P PS=0.69U PD=1.36U
* device instance $864 r0 *1 26.23,45.68 sky130_fd_pr__nfet_01v8
M$864 94 760 708 708 sky130_fd_pr__nfet_01v8 L=0.15U W=0.65U AS=0.169P
+ AD=0.11285P PS=1.82U PD=1.045U
* device instance $865 r0 *1 26.775,45.795 sky130_fd_pr__nfet_01v8
M$865 822 71 94 94 sky130_fd_pr__nfet_01v8 L=0.15U W=0.42U AS=0.11285P
+ AD=0.0693P PS=1.045U PD=0.75U
* device instance $866 r0 *1 27.255,45.795 sky130_fd_pr__nfet_01v8
M$866 760 768 822 822 sky130_fd_pr__nfet_01v8 L=0.15U W=0.42U AS=0.0693P
+ AD=0.09975P PS=0.75U PD=0.895U
* device instance $867 r0 *1 27.88,45.795 sky130_fd_pr__nfet_01v8
M$867 823 601 760 760 sky130_fd_pr__nfet_01v8 L=0.15U W=0.42U AS=0.09975P
+ AD=0.0693P PS=0.895U PD=0.75U
* device instance $868 r0 *1 28.36,45.795 sky130_fd_pr__nfet_01v8
M$868 94 810 823 823 sky130_fd_pr__nfet_01v8 L=0.15U W=0.42U AS=0.0693P
+ AD=0.1449P PS=0.75U PD=1.11U
* device instance $869 r0 *1 29.2,45.795 sky130_fd_pr__nfet_01v8
M$869 810 71 94 94 sky130_fd_pr__nfet_01v8 L=0.15U W=0.42U AS=0.1449P
+ AD=0.1092P PS=1.11U PD=1.36U
* device instance $870 r0 *1 27.13,46.685 sky130_fd_pr__nfet_01v8
M$870 852 639 837 837 sky130_fd_pr__nfet_01v8 L=0.15U W=0.42U AS=0.1092P
+ AD=0.0441P PS=1.36U PD=0.63U
* device instance $871 r0 *1 27.49,46.685 sky130_fd_pr__nfet_01v8
M$871 94 315 852 852 sky130_fd_pr__nfet_01v8 L=0.15U W=0.42U AS=0.0441P
+ AD=0.1092P PS=0.63U PD=1.36U
* device instance $872 r0 *1 30.29,46.655 sky130_fd_pr__nfet_01v8
M$872 839 835 837 837 sky130_fd_pr__nfet_01v8 L=0.15U W=0.36U AS=0.1446P
+ AD=0.0522P PS=1.18U PD=0.65U
* device instance $873 r0 *1 30.73,46.655 sky130_fd_pr__nfet_01v8
M$873 854 836 839 839 sky130_fd_pr__nfet_01v8 L=0.15U W=0.36U AS=0.0522P
+ AD=0.0759P PS=0.65U PD=0.8U
* device instance $874 r0 *1 28.43,46.685 sky130_fd_pr__nfet_01v8
M$874 94 315 838 838 sky130_fd_pr__nfet_01v8 L=0.15U W=0.42U AS=0.1092P
+ AD=0.0609P PS=1.36U PD=0.71U
* device instance $875 r0 *1 28.87,46.685 sky130_fd_pr__nfet_01v8
M$875 853 838 94 94 sky130_fd_pr__nfet_01v8 L=0.15U W=0.42U AS=0.0609P
+ AD=0.0756P PS=0.71U PD=0.78U
* device instance $876 r0 *1 29.38,46.685 sky130_fd_pr__nfet_01v8
M$876 837 866 853 853 sky130_fd_pr__nfet_01v8 L=0.15U W=0.42U AS=0.0756P
+ AD=0.1446P PS=0.78U PD=1.18U
* device instance $877 r0 *1 31.26,46.685 sky130_fd_pr__nfet_01v8
M$877 94 840 854 854 sky130_fd_pr__nfet_01v8 L=0.15U W=0.42U AS=0.0759P
+ AD=0.12095P PS=0.8U PD=1.085U
* device instance $878 r0 *1 31.855,46.795 sky130_fd_pr__nfet_01v8
M$878 840 839 94 94 sky130_fd_pr__nfet_01v8 L=0.15U W=0.64U AS=0.12095P
+ AD=0.1664P PS=1.085U PD=1.8U
* device instance $879 r0 *1 33.28,46.655 sky130_fd_pr__nfet_01v8
M$879 841 836 856 856 sky130_fd_pr__nfet_01v8 L=0.15U W=0.36U AS=0.0678P
+ AD=0.0684P PS=0.755U PD=0.74U
* device instance $880 r0 *1 33.81,46.655 sky130_fd_pr__nfet_01v8
M$880 857 835 841 841 sky130_fd_pr__nfet_01v8 L=0.15U W=0.36U AS=0.0684P
+ AD=0.066P PS=0.74U PD=0.745U
* device instance $881 r0 *1 32.795,46.685 sky130_fd_pr__nfet_01v8
M$881 856 840 94 94 sky130_fd_pr__nfet_01v8 L=0.15U W=0.42U AS=0.1092P
+ AD=0.0678P PS=1.36U PD=0.755U
* device instance $882 r0 *1 34.285,46.685 sky130_fd_pr__nfet_01v8
M$882 94 866 857 857 sky130_fd_pr__nfet_01v8 L=0.15U W=0.42U AS=0.066P
+ AD=0.1092P PS=0.745U PD=1.36U
* device instance $883 r0 *1 33.59,45.795 sky130_fd_pr__nfet_01v8
M$883 94 937 769 769 sky130_fd_pr__nfet_01v8 L=0.15U W=0.42U AS=0.1092P
+ AD=0.0567P PS=1.36U PD=0.69U
* device instance $884 r0 *1 34.01,45.795 sky130_fd_pr__nfet_01v8
M$884 770 769 94 94 sky130_fd_pr__nfet_01v8 L=0.15U W=0.42U AS=0.0567P
+ AD=0.1092P PS=0.69U PD=1.36U
* device instance $885 r0 *1 34.95,45.795 sky130_fd_pr__nfet_01v8
M$885 824 802 771 771 sky130_fd_pr__nfet_01v8 L=0.15U W=0.42U AS=0.1092P
+ AD=0.0441P PS=1.36U PD=0.63U
* device instance $886 r0 *1 35.31,45.795 sky130_fd_pr__nfet_01v8
M$886 94 90 824 824 sky130_fd_pr__nfet_01v8 L=0.15U W=0.42U AS=0.0441P
+ AD=0.1092P PS=0.63U PD=1.36U
* device instance $887 r0 *1 35.225,46.685 sky130_fd_pr__nfet_01v8
M$887 94 841 866 866 sky130_fd_pr__nfet_01v8 L=0.15U W=0.42U AS=0.1092P
+ AD=0.10025P PS=1.36U PD=0.985U
* device instance $888 r0 *1 35.71,46.8 sky130_fd_pr__nfet_01v8
M$888 601 841 94 94 sky130_fd_pr__nfet_01v8 L=0.15U W=0.65U AS=0.10025P
+ AD=0.182P PS=0.985U PD=1.86U
* device instance $889 r0 *1 36.25,45.795 sky130_fd_pr__nfet_01v8
M$889 94 90 737 737 sky130_fd_pr__nfet_01v8 L=0.15U W=0.42U AS=0.1092P
+ AD=0.0609P PS=1.36U PD=0.71U
* device instance $890 r0 *1 36.69,45.795 sky130_fd_pr__nfet_01v8
M$890 825 737 94 94 sky130_fd_pr__nfet_01v8 L=0.15U W=0.42U AS=0.0609P
+ AD=0.0756P PS=0.71U PD=0.78U
* device instance $891 r0 *1 37.2,45.795 sky130_fd_pr__nfet_01v8
M$891 771 738 825 825 sky130_fd_pr__nfet_01v8 L=0.15U W=0.42U AS=0.0756P
+ AD=0.1446P PS=0.78U PD=1.18U
* device instance $892 r0 *1 38.11,45.825 sky130_fd_pr__nfet_01v8
M$892 772 769 771 771 sky130_fd_pr__nfet_01v8 L=0.15U W=0.36U AS=0.1446P
+ AD=0.0522P PS=1.18U PD=0.65U
* device instance $893 r0 *1 38.55,45.825 sky130_fd_pr__nfet_01v8
M$893 772 770 826 826 sky130_fd_pr__nfet_01v8 L=0.15U W=0.36U AS=0.0759P
+ AD=0.0522P PS=0.8U PD=0.65U
* device instance $894 r0 *1 39.08,45.795 sky130_fd_pr__nfet_01v8
M$894 826 773 94 94 sky130_fd_pr__nfet_01v8 L=0.15U W=0.42U AS=0.12095P
+ AD=0.0759P PS=1.085U PD=0.8U
* device instance $895 r0 *1 39.675,45.685 sky130_fd_pr__nfet_01v8
M$895 773 772 94 94 sky130_fd_pr__nfet_01v8 L=0.15U W=0.64U AS=0.12095P
+ AD=0.1664P PS=1.085U PD=1.8U
* device instance $896 r0 *1 40.615,45.795 sky130_fd_pr__nfet_01v8
M$896 827 773 94 94 sky130_fd_pr__nfet_01v8 L=0.15U W=0.42U AS=0.1092P
+ AD=0.0678P PS=1.36U PD=0.755U
* device instance $897 r0 *1 41.1,45.825 sky130_fd_pr__nfet_01v8
M$897 774 770 827 827 sky130_fd_pr__nfet_01v8 L=0.15U W=0.36U AS=0.0678P
+ AD=0.0684P PS=0.755U PD=0.74U
* device instance $898 r0 *1 41.63,45.825 sky130_fd_pr__nfet_01v8
M$898 774 769 828 828 sky130_fd_pr__nfet_01v8 L=0.15U W=0.36U AS=0.066P
+ AD=0.0684P PS=0.745U PD=0.74U
* device instance $899 r0 *1 42.105,45.795 sky130_fd_pr__nfet_01v8
M$899 94 738 828 828 sky130_fd_pr__nfet_01v8 L=0.15U W=0.42U AS=0.066P
+ AD=0.1092P PS=0.745U PD=1.36U
* device instance $900 r0 *1 40.98,46.685 sky130_fd_pr__nfet_01v8
M$900 94 777 842 842 sky130_fd_pr__nfet_01v8 L=0.15U W=0.42U AS=0.1113P
+ AD=0.0588P PS=1.37U PD=0.7U
* device instance $901 r0 *1 41.41,46.685 sky130_fd_pr__nfet_01v8
M$901 842 71 94 94 sky130_fd_pr__nfet_01v8 L=0.15U W=0.42U AS=0.0588P
+ AD=0.0588P PS=0.7U PD=0.7U
* device instance $902 r0 *1 41.84,46.685 sky130_fd_pr__nfet_01v8
M$902 802 1242 842 842 sky130_fd_pr__nfet_01v8 L=0.15U W=0.42U AS=0.0588P
+ AD=0.1113P PS=0.7U PD=1.37U
* device instance $903 r0 *1 43.045,45.795 sky130_fd_pr__nfet_01v8
M$903 738 774 94 94 sky130_fd_pr__nfet_01v8 L=0.15U W=0.42U AS=0.10025P
+ AD=0.1092P PS=0.985U PD=1.36U
* device instance $904 r0 *1 43.53,45.68 sky130_fd_pr__nfet_01v8
M$904 710 774 94 94 sky130_fd_pr__nfet_01v8 L=0.15U W=0.65U AS=0.10025P
+ AD=0.182P PS=0.985U PD=1.86U
* device instance $905 r0 *1 44.63,45.68 sky130_fd_pr__nfet_01v8
M$905 94 803 775 775 sky130_fd_pr__nfet_01v8 L=0.15U W=0.65U AS=0.169P
+ AD=0.10725P PS=1.82U PD=0.98U
* device instance $906 r0 *1 45.11,45.68 sky130_fd_pr__nfet_01v8
M$906 830 710 94 94 sky130_fd_pr__nfet_01v8 L=0.15U W=0.65U AS=0.10725P
+ AD=0.06825P PS=0.98U PD=0.86U
* device instance $907 r0 *1 45.47,45.68 sky130_fd_pr__nfet_01v8
M$907 775 91 830 830 sky130_fd_pr__nfet_01v8 L=0.15U W=0.65U AS=0.06825P
+ AD=0.169P PS=0.86U PD=1.82U
* device instance $908 r0 *1 44.63,46.685 sky130_fd_pr__nfet_01v8
M$908 94 844 843 843 sky130_fd_pr__nfet_01v8 L=0.15U W=0.42U AS=0.1092P
+ AD=0.0567P PS=1.36U PD=0.69U
* device instance $909 r0 *1 45.05,46.685 sky130_fd_pr__nfet_01v8
M$909 845 843 94 94 sky130_fd_pr__nfet_01v8 L=0.15U W=0.42U AS=0.0567P
+ AD=0.1092P PS=0.69U PD=1.36U
* device instance $910 r0 *1 45.99,46.685 sky130_fd_pr__nfet_01v8
M$910 860 811 846 846 sky130_fd_pr__nfet_01v8 L=0.15U W=0.42U AS=0.1092P
+ AD=0.0441P PS=1.36U PD=0.63U
* device instance $911 r0 *1 46.35,46.685 sky130_fd_pr__nfet_01v8
M$911 94 315 860 860 sky130_fd_pr__nfet_01v8 L=0.15U W=0.42U AS=0.0441P
+ AD=0.1092P PS=0.63U PD=1.36U
* device instance $912 r0 *1 46.41,45.68 sky130_fd_pr__nfet_01v8
M$912 829 137 775 775 sky130_fd_pr__nfet_01v8 L=0.15U W=0.65U AS=0.169P
+ AD=0.10725P PS=1.82U PD=0.98U
* device instance $913 r0 *1 46.89,45.68 sky130_fd_pr__nfet_01v8
M$913 94 734 829 829 sky130_fd_pr__nfet_01v8 L=0.15U W=0.65U AS=0.10725P
+ AD=0.102375P PS=0.98U PD=0.965U
* device instance $914 r0 *1 47.355,45.68 sky130_fd_pr__nfet_01v8
M$914 811 775 94 94 sky130_fd_pr__nfet_01v8 L=0.15U W=0.65U AS=0.102375P
+ AD=0.169P PS=0.965U PD=1.82U
* device instance $915 r0 *1 49.15,46.655 sky130_fd_pr__nfet_01v8
M$915 848 843 846 846 sky130_fd_pr__nfet_01v8 L=0.15U W=0.36U AS=0.1446P
+ AD=0.0522P PS=1.18U PD=0.65U
* device instance $916 r0 *1 49.59,46.655 sky130_fd_pr__nfet_01v8
M$916 859 845 848 848 sky130_fd_pr__nfet_01v8 L=0.15U W=0.36U AS=0.0522P
+ AD=0.0759P PS=0.65U PD=0.8U
* device instance $917 r0 *1 47.29,46.685 sky130_fd_pr__nfet_01v8
M$917 94 315 847 847 sky130_fd_pr__nfet_01v8 L=0.15U W=0.42U AS=0.1092P
+ AD=0.0609P PS=1.36U PD=0.71U
* device instance $918 r0 *1 47.73,46.685 sky130_fd_pr__nfet_01v8
M$918 861 847 94 94 sky130_fd_pr__nfet_01v8 L=0.15U W=0.42U AS=0.0609P
+ AD=0.0756P PS=0.71U PD=0.78U
* device instance $919 r0 *1 48.24,46.685 sky130_fd_pr__nfet_01v8
M$919 846 867 861 861 sky130_fd_pr__nfet_01v8 L=0.15U W=0.42U AS=0.0756P
+ AD=0.1446P PS=0.78U PD=1.18U
* device instance $920 r0 *1 50.12,46.685 sky130_fd_pr__nfet_01v8
M$920 94 849 859 859 sky130_fd_pr__nfet_01v8 L=0.15U W=0.42U AS=0.0759P
+ AD=0.12095P PS=0.8U PD=1.085U
* device instance $921 r0 *1 50.715,46.795 sky130_fd_pr__nfet_01v8
M$921 849 848 94 94 sky130_fd_pr__nfet_01v8 L=0.15U W=0.64U AS=0.12095P
+ AD=0.1664P PS=1.085U PD=1.8U
* device instance $922 r0 *1 48.725,45.795 sky130_fd_pr__nfet_01v8
M$922 94 804 777 777 sky130_fd_pr__nfet_01v8 L=0.15U W=0.42U AS=0.1092P
+ AD=0.1197P PS=1.36U PD=1.41U
* device instance $923 r0 *1 49.69,45.68 sky130_fd_pr__nfet_01v8
M$923 654 777 94 94 sky130_fd_pr__nfet_01v8 L=0.15U W=0.65U AS=0.169P
+ AD=0.08775P PS=1.82U PD=0.92U
* device instance $924 r0 *1 50.11,45.68 sky130_fd_pr__nfet_01v8
M$924 94 710 654 654 sky130_fd_pr__nfet_01v8 L=0.15U W=0.65U AS=0.08775P
+ AD=0.169P PS=0.92U PD=1.82U
* device instance $925 r0 *1 51.305,45.795 sky130_fd_pr__nfet_01v8
M$925 778 710 94 94 sky130_fd_pr__nfet_01v8 L=0.15U W=0.42U AS=0.10025P
+ AD=0.1092P PS=0.985U PD=1.36U
* device instance $926 r0 *1 51.79,45.68 sky130_fd_pr__nfet_01v8
M$926 805 804 94 94 sky130_fd_pr__nfet_01v8 L=0.15U W=0.65U AS=0.10025P
+ AD=0.08775P PS=0.985U PD=0.92U
* device instance $927 r0 *1 52.21,45.68 sky130_fd_pr__nfet_01v8
M$927 94 778 805 805 sky130_fd_pr__nfet_01v8 L=0.15U W=0.65U AS=0.08775P
+ AD=0.169P PS=0.92U PD=1.82U
* device instance $928 r0 *1 52.14,46.655 sky130_fd_pr__nfet_01v8
M$928 850 845 858 858 sky130_fd_pr__nfet_01v8 L=0.15U W=0.36U AS=0.0678P
+ AD=0.0684P PS=0.755U PD=0.74U
* device instance $929 r0 *1 52.67,46.655 sky130_fd_pr__nfet_01v8
M$929 855 843 850 850 sky130_fd_pr__nfet_01v8 L=0.15U W=0.36U AS=0.0684P
+ AD=0.066P PS=0.74U PD=0.745U
* device instance $930 r0 *1 51.655,46.685 sky130_fd_pr__nfet_01v8
M$930 858 849 94 94 sky130_fd_pr__nfet_01v8 L=0.15U W=0.42U AS=0.1092P
+ AD=0.0678P PS=1.36U PD=0.755U
* device instance $931 r0 *1 53.145,46.685 sky130_fd_pr__nfet_01v8
M$931 94 867 855 855 sky130_fd_pr__nfet_01v8 L=0.15U W=0.42U AS=0.066P
+ AD=0.1092P PS=0.745U PD=1.36U
* device instance $932 r0 *1 54.085,46.685 sky130_fd_pr__nfet_01v8
M$932 94 850 867 867 sky130_fd_pr__nfet_01v8 L=0.15U W=0.42U AS=0.1092P
+ AD=0.10025P PS=1.36U PD=0.985U
* device instance $933 r0 *1 54.57,46.8 sky130_fd_pr__nfet_01v8
M$933 804 850 94 94 sky130_fd_pr__nfet_01v8 L=0.15U W=0.65U AS=0.10025P
+ AD=0.182P PS=0.985U PD=1.86U
* device instance $934 r0 *1 56.59,45.68 sky130_fd_pr__nfet_01v8
M$934 711 805 94 94 sky130_fd_pr__nfet_01v8 L=0.15U W=0.65U AS=0.169P
+ AD=0.08775P PS=1.82U PD=0.92U
* device instance $935 r0 *1 57.01,45.68 sky130_fd_pr__nfet_01v8
M$935 94 654 711 711 sky130_fd_pr__nfet_01v8 L=0.15U W=0.65U AS=0.08775P
+ AD=0.169P PS=0.92U PD=1.82U
* device instance $936 r0 *1 61.19,45.68 sky130_fd_pr__nfet_01v8
M$936 695 571 94 94 sky130_fd_pr__nfet_01v8 L=0.15U W=0.65U AS=0.169P
+ AD=0.08775P PS=1.82U PD=0.92U
* device instance $937 r0 *1 61.61,45.68 sky130_fd_pr__nfet_01v8
M$937 94 919 695 695 sky130_fd_pr__nfet_01v8 L=0.15U W=0.65U AS=0.08775P
+ AD=0.169P PS=0.92U PD=1.82U
* device instance $938 r0 *1 61.65,46.8 sky130_fd_pr__nfet_01v8
M$938 94 642 851 851 sky130_fd_pr__nfet_01v8 L=0.15U W=0.65U AS=0.169P
+ AD=0.08775P PS=1.82U PD=0.92U
* device instance $939 r0 *1 62.07,46.8 sky130_fd_pr__nfet_01v8
M$939 870 851 94 94 sky130_fd_pr__nfet_01v8 L=0.15U W=2.6U AS=0.351P
+ AD=0.43225P PS=3.68U PD=4.58U
* device instance $943 r0 *1 64.87,45.795 sky130_fd_pr__nfet_01v8
M$943 94 844 779 779 sky130_fd_pr__nfet_01v8 L=0.15U W=0.42U AS=0.1092P
+ AD=0.0567P PS=1.36U PD=0.69U
* device instance $944 r0 *1 65.29,45.795 sky130_fd_pr__nfet_01v8
M$944 780 779 94 94 sky130_fd_pr__nfet_01v8 L=0.15U W=0.42U AS=0.0567P
+ AD=0.1092P PS=0.69U PD=1.36U
* device instance $945 r0 *1 66.23,45.795 sky130_fd_pr__nfet_01v8
M$945 821 634 781 781 sky130_fd_pr__nfet_01v8 L=0.15U W=0.42U AS=0.1092P
+ AD=0.0441P PS=1.36U PD=0.63U
* device instance $946 r0 *1 66.59,45.795 sky130_fd_pr__nfet_01v8
M$946 94 1102 821 821 sky130_fd_pr__nfet_01v8 L=0.15U W=0.42U AS=0.0441P
+ AD=0.1092P PS=0.63U PD=1.36U
* device instance $947 r0 *1 67.53,45.795 sky130_fd_pr__nfet_01v8
M$947 94 1102 739 739 sky130_fd_pr__nfet_01v8 L=0.15U W=0.42U AS=0.1092P
+ AD=0.0609P PS=1.36U PD=0.71U
* device instance $948 r0 *1 67.97,45.795 sky130_fd_pr__nfet_01v8
M$948 818 739 94 94 sky130_fd_pr__nfet_01v8 L=0.15U W=0.42U AS=0.0609P
+ AD=0.0756P PS=0.71U PD=0.78U
* device instance $949 r0 *1 68.48,45.795 sky130_fd_pr__nfet_01v8
M$949 781 740 818 818 sky130_fd_pr__nfet_01v8 L=0.15U W=0.42U AS=0.0756P
+ AD=0.1446P PS=0.78U PD=1.18U
* device instance $950 r0 *1 69.39,45.825 sky130_fd_pr__nfet_01v8
M$950 782 779 781 781 sky130_fd_pr__nfet_01v8 L=0.15U W=0.36U AS=0.1446P
+ AD=0.0522P PS=1.18U PD=0.65U
* device instance $951 r0 *1 69.83,45.825 sky130_fd_pr__nfet_01v8
M$951 782 780 816 816 sky130_fd_pr__nfet_01v8 L=0.15U W=0.36U AS=0.0759P
+ AD=0.0522P PS=0.8U PD=0.65U
* device instance $952 r0 *1 70.36,45.795 sky130_fd_pr__nfet_01v8
M$952 816 783 94 94 sky130_fd_pr__nfet_01v8 L=0.15U W=0.42U AS=0.12095P
+ AD=0.0759P PS=1.085U PD=0.8U
* device instance $953 r0 *1 70.955,45.685 sky130_fd_pr__nfet_01v8
M$953 783 782 94 94 sky130_fd_pr__nfet_01v8 L=0.15U W=0.64U AS=0.12095P
+ AD=0.1664P PS=1.085U PD=1.8U
* device instance $954 r0 *1 71.895,45.795 sky130_fd_pr__nfet_01v8
M$954 814 783 94 94 sky130_fd_pr__nfet_01v8 L=0.15U W=0.42U AS=0.1092P
+ AD=0.0678P PS=1.36U PD=0.755U
* device instance $955 r0 *1 72.38,45.825 sky130_fd_pr__nfet_01v8
M$955 784 780 814 814 sky130_fd_pr__nfet_01v8 L=0.15U W=0.36U AS=0.0678P
+ AD=0.0684P PS=0.755U PD=0.74U
* device instance $956 r0 *1 72.91,45.825 sky130_fd_pr__nfet_01v8
M$956 784 779 812 812 sky130_fd_pr__nfet_01v8 L=0.15U W=0.36U AS=0.066P
+ AD=0.0684P PS=0.745U PD=0.74U
* device instance $957 r0 *1 73.385,45.795 sky130_fd_pr__nfet_01v8
M$957 94 740 812 812 sky130_fd_pr__nfet_01v8 L=0.15U W=0.42U AS=0.066P
+ AD=0.1092P PS=0.745U PD=1.36U
* device instance $958 r0 *1 74.325,45.795 sky130_fd_pr__nfet_01v8
M$958 740 784 94 94 sky130_fd_pr__nfet_01v8 L=0.15U W=0.42U AS=0.10025P
+ AD=0.1092P PS=0.985U PD=1.36U
* device instance $959 r0 *1 74.81,45.68 sky130_fd_pr__nfet_01v8
M$959 571 784 94 94 sky130_fd_pr__nfet_01v8 L=0.15U W=0.65U AS=0.10025P
+ AD=0.182P PS=0.985U PD=1.86U
* device instance $960 r0 *1 2.77,52.125 sky130_fd_pr__nfet_01v8
M$960 94 937 930 930 sky130_fd_pr__nfet_01v8 L=0.15U W=0.42U AS=0.1092P
+ AD=0.0567P PS=1.36U PD=0.69U
* device instance $961 r0 *1 3.19,52.125 sky130_fd_pr__nfet_01v8
M$961 931 930 94 94 sky130_fd_pr__nfet_01v8 L=0.15U W=0.42U AS=0.0567P
+ AD=0.1092P PS=0.69U PD=1.36U
* device instance $962 r0 *1 4.13,52.125 sky130_fd_pr__nfet_01v8
M$962 950 891 932 932 sky130_fd_pr__nfet_01v8 L=0.15U W=0.42U AS=0.1092P
+ AD=0.0441P PS=1.36U PD=0.63U
* device instance $963 r0 *1 4.49,52.125 sky130_fd_pr__nfet_01v8
M$963 94 90 950 950 sky130_fd_pr__nfet_01v8 L=0.15U W=0.42U AS=0.0441P
+ AD=0.1092P PS=0.63U PD=1.36U
* device instance $964 r0 *1 4.68,51.235 sky130_fd_pr__nfet_01v8
M$964 920 907 890 890 sky130_fd_pr__nfet_01v8 L=0.15U W=0.42U AS=0.1113P
+ AD=0.0441P PS=1.37U PD=0.63U
* device instance $965 r0 *1 5.04,51.235 sky130_fd_pr__nfet_01v8
M$965 94 109 920 920 sky130_fd_pr__nfet_01v8 L=0.15U W=0.42U AS=0.0441P
+ AD=0.0966P PS=0.63U PD=0.88U
* device instance $966 r0 *1 5.65,51.235 sky130_fd_pr__nfet_01v8
M$966 862 890 94 94 sky130_fd_pr__nfet_01v8 L=0.15U W=0.42U AS=0.0966P
+ AD=0.1113P PS=0.88U PD=1.37U
* device instance $967 r0 *1 7.29,52.095 sky130_fd_pr__nfet_01v8
M$967 933 930 932 932 sky130_fd_pr__nfet_01v8 L=0.15U W=0.36U AS=0.1446P
+ AD=0.0522P PS=1.18U PD=0.65U
* device instance $968 r0 *1 7.73,52.095 sky130_fd_pr__nfet_01v8
M$968 953 931 933 933 sky130_fd_pr__nfet_01v8 L=0.15U W=0.36U AS=0.0522P
+ AD=0.0759P PS=0.65U PD=0.8U
* device instance $969 r0 *1 5.43,52.125 sky130_fd_pr__nfet_01v8
M$969 94 90 944 944 sky130_fd_pr__nfet_01v8 L=0.15U W=0.42U AS=0.1092P
+ AD=0.0609P PS=1.36U PD=0.71U
* device instance $970 r0 *1 5.87,52.125 sky130_fd_pr__nfet_01v8
M$970 951 944 94 94 sky130_fd_pr__nfet_01v8 L=0.15U W=0.42U AS=0.0609P
+ AD=0.0756P PS=0.71U PD=0.78U
* device instance $971 r0 *1 6.38,52.125 sky130_fd_pr__nfet_01v8
M$971 932 945 951 951 sky130_fd_pr__nfet_01v8 L=0.15U W=0.42U AS=0.0756P
+ AD=0.1446P PS=0.78U PD=1.18U
* device instance $972 r0 *1 8.26,52.125 sky130_fd_pr__nfet_01v8
M$972 94 934 953 953 sky130_fd_pr__nfet_01v8 L=0.15U W=0.42U AS=0.0759P
+ AD=0.12095P PS=0.8U PD=1.085U
* device instance $973 r0 *1 8.855,52.235 sky130_fd_pr__nfet_01v8
M$973 934 933 94 94 sky130_fd_pr__nfet_01v8 L=0.15U W=0.64U AS=0.12095P
+ AD=0.1664P PS=1.085U PD=1.8U
* device instance $974 r0 *1 6.91,51.12 sky130_fd_pr__nfet_01v8
M$974 94 874 891 891 sky130_fd_pr__nfet_01v8 L=0.15U W=0.65U AS=0.169P
+ AD=0.11285P PS=1.82U PD=1.045U
* device instance $975 r0 *1 7.455,51.235 sky130_fd_pr__nfet_01v8
M$975 922 71 94 94 sky130_fd_pr__nfet_01v8 L=0.15U W=0.42U AS=0.11285P
+ AD=0.0693P PS=1.045U PD=0.75U
* device instance $976 r0 *1 7.935,51.235 sky130_fd_pr__nfet_01v8
M$976 874 916 922 922 sky130_fd_pr__nfet_01v8 L=0.15U W=0.42U AS=0.0693P
+ AD=0.09975P PS=0.75U PD=0.895U
* device instance $977 r0 *1 8.56,51.235 sky130_fd_pr__nfet_01v8
M$977 924 908 874 874 sky130_fd_pr__nfet_01v8 L=0.15U W=0.42U AS=0.09975P
+ AD=0.0693P PS=0.895U PD=0.75U
* device instance $978 r0 *1 9.04,51.235 sky130_fd_pr__nfet_01v8
M$978 94 917 924 924 sky130_fd_pr__nfet_01v8 L=0.15U W=0.42U AS=0.0693P
+ AD=0.1449P PS=0.75U PD=1.11U
* device instance $979 r0 *1 9.88,51.235 sky130_fd_pr__nfet_01v8
M$979 917 71 94 94 sky130_fd_pr__nfet_01v8 L=0.15U W=0.42U AS=0.1449P
+ AD=0.1092P PS=1.11U PD=1.36U
* device instance $980 r0 *1 10.28,52.095 sky130_fd_pr__nfet_01v8
M$980 935 931 954 954 sky130_fd_pr__nfet_01v8 L=0.15U W=0.36U AS=0.0678P
+ AD=0.0684P PS=0.755U PD=0.74U
* device instance $981 r0 *1 10.81,52.095 sky130_fd_pr__nfet_01v8
M$981 956 930 935 935 sky130_fd_pr__nfet_01v8 L=0.15U W=0.36U AS=0.0684P
+ AD=0.066P PS=0.74U PD=0.745U
* device instance $982 r0 *1 9.795,52.125 sky130_fd_pr__nfet_01v8
M$982 954 934 94 94 sky130_fd_pr__nfet_01v8 L=0.15U W=0.42U AS=0.1092P
+ AD=0.0678P PS=1.36U PD=0.755U
* device instance $983 r0 *1 11.285,52.125 sky130_fd_pr__nfet_01v8
M$983 94 945 956 956 sky130_fd_pr__nfet_01v8 L=0.15U W=0.42U AS=0.066P
+ AD=0.1092P PS=0.745U PD=1.36U
* device instance $984 r0 *1 11.09,51.12 sky130_fd_pr__nfet_01v8
M$984 892 863 94 94 sky130_fd_pr__nfet_01v8 L=0.15U W=0.65U AS=0.169P
+ AD=0.08775P PS=1.82U PD=0.92U
* device instance $985 r0 *1 11.51,51.12 sky130_fd_pr__nfet_01v8
M$985 94 908 892 892 sky130_fd_pr__nfet_01v8 L=0.15U W=0.65U AS=0.08775P
+ AD=0.08775P PS=0.92U PD=0.92U
* device instance $986 r0 *1 11.93,51.12 sky130_fd_pr__nfet_01v8
M$986 927 908 94 94 sky130_fd_pr__nfet_01v8 L=0.15U W=0.65U AS=0.08775P
+ AD=0.08775P PS=0.92U PD=0.92U
* device instance $987 r0 *1 12.35,51.12 sky130_fd_pr__nfet_01v8
M$987 864 863 927 927 sky130_fd_pr__nfet_01v8 L=0.15U W=0.65U AS=0.08775P
+ AD=0.25025P PS=0.92U PD=1.42U
* device instance $988 r0 *1 13.27,51.12 sky130_fd_pr__nfet_01v8
M$988 94 892 864 864 sky130_fd_pr__nfet_01v8 L=0.15U W=0.65U AS=0.25025P
+ AD=0.208P PS=1.42U PD=1.94U
* device instance $989 r0 *1 12.225,52.125 sky130_fd_pr__nfet_01v8
M$989 94 935 945 945 sky130_fd_pr__nfet_01v8 L=0.15U W=0.42U AS=0.1092P
+ AD=0.10025P PS=1.36U PD=0.985U
* device instance $990 r0 *1 12.71,52.24 sky130_fd_pr__nfet_01v8
M$990 834 935 94 94 sky130_fd_pr__nfet_01v8 L=0.15U W=0.65U AS=0.10025P
+ AD=0.182P PS=0.985U PD=1.86U
* device instance $991 r0 *1 13.81,52.24 sky130_fd_pr__nfet_01v8
M$991 94 865 946 946 sky130_fd_pr__nfet_01v8 L=0.15U W=0.65U AS=0.169P
+ AD=0.08775P PS=1.82U PD=0.92U
* device instance $992 r0 *1 14.23,52.24 sky130_fd_pr__nfet_01v8
M$992 908 946 94 94 sky130_fd_pr__nfet_01v8 L=0.15U W=2.6U AS=0.351P
+ AD=0.43225P PS=3.68U PD=4.58U
* device instance $996 r0 *1 19.64,52.125 sky130_fd_pr__nfet_01v8
M$996 937 936 94 94 sky130_fd_pr__nfet_01v8 L=0.15U W=6.72U AS=1.103975P
+ AD=0.93975P PS=11.925U PD=11.195U
* device instance $1012 r0 *1 26.515,52.125 sky130_fd_pr__nfet_01v8
M$1012 936 310 94 94 sky130_fd_pr__nfet_01v8 L=0.15U W=1.68U AS=0.2352P
+ AD=0.2877P PS=2.8U PD=3.47U
* device instance $1016 r0 *1 17.03,52.24 sky130_fd_pr__nfet_01v8
M$1016 94 834 947 947 sky130_fd_pr__nfet_01v8 L=0.15U W=0.65U AS=0.169P
+ AD=0.08775P PS=1.82U PD=0.92U
* device instance $1017 r0 *1 17.45,52.24 sky130_fd_pr__nfet_01v8
M$1017 863 947 94 94 sky130_fd_pr__nfet_01v8 L=0.15U W=2.6U AS=0.351P
+ AD=0.486275P PS=3.68U PD=4.19U
* device instance $1021 r0 *1 21.19,51.12 sky130_fd_pr__nfet_01v8
M$1021 918 863 94 94 sky130_fd_pr__nfet_01v8 L=0.15U W=2.6U AS=0.44525P
+ AD=0.351P PS=4.62U PD=3.68U
* device instance $1025 r0 *1 22.87,51.12 sky130_fd_pr__nfet_01v8
M$1025 918 875 94 94 sky130_fd_pr__nfet_01v8 L=0.15U W=2.6U AS=0.351P AD=0.52P
+ PS=3.68U PD=4.2U
* device instance $1029 r0 *1 25.07,51.12 sky130_fd_pr__nfet_01v8
M$1029 918 876 94 94 sky130_fd_pr__nfet_01v8 L=0.15U W=2.6U AS=0.52P AD=0.351P
+ PS=4.2U PD=3.68U
* device instance $1033 r0 *1 26.75,51.12 sky130_fd_pr__nfet_01v8
M$1033 918 406 94 94 sky130_fd_pr__nfet_01v8 L=0.15U W=2.6U AS=0.351P
+ AD=0.43225P PS=3.68U PD=4.58U
* device instance $1037 r0 *1 43.32,51.235 sky130_fd_pr__nfet_01v8
M$1037 929 909 897 897 sky130_fd_pr__nfet_01v8 L=0.15U W=0.42U AS=0.1113P
+ AD=0.0441P PS=1.37U PD=0.63U
* device instance $1038 r0 *1 43.68,51.235 sky130_fd_pr__nfet_01v8
M$1038 94 109 929 929 sky130_fd_pr__nfet_01v8 L=0.15U W=0.42U AS=0.0441P
+ AD=0.0966P PS=0.63U PD=0.88U
* device instance $1039 r0 *1 44.29,51.235 sky130_fd_pr__nfet_01v8
M$1039 803 897 94 94 sky130_fd_pr__nfet_01v8 L=0.15U W=0.42U AS=0.0966P
+ AD=0.1113P PS=0.88U PD=1.37U
* device instance $1040 r0 *1 56.13,52.24 sky130_fd_pr__nfet_01v8
M$1040 94 948 938 938 sky130_fd_pr__nfet_01v8 L=0.15U W=0.65U AS=0.169P
+ AD=0.08775P PS=1.82U PD=0.92U
* device instance $1041 r0 *1 56.55,52.24 sky130_fd_pr__nfet_01v8
M$1041 938 805 94 94 sky130_fd_pr__nfet_01v8 L=0.15U W=0.65U AS=0.08775P
+ AD=0.08775P PS=0.92U PD=0.92U
* device instance $1042 r0 *1 56.97,52.24 sky130_fd_pr__nfet_01v8
M$1042 94 979 938 938 sky130_fd_pr__nfet_01v8 L=0.15U W=0.65U AS=0.08775P
+ AD=0.26P PS=0.92U PD=1.45U
* device instance $1043 r0 *1 57.92,52.24 sky130_fd_pr__nfet_01v8
M$1043 939 938 94 94 sky130_fd_pr__nfet_01v8 L=0.15U W=2.6U AS=0.52325P
+ AD=0.5655P PS=4.21U PD=4.34U
* device instance $1047 r0 *1 60.26,52.24 sky130_fd_pr__nfet_01v8
M$1047 948 940 94 94 sky130_fd_pr__nfet_01v8 L=0.15U W=2.6U AS=0.5655P
+ AD=0.351P PS=4.34U PD=3.68U
* device instance $1051 r0 *1 61.94,52.24 sky130_fd_pr__nfet_01v8
M$1051 940 870 94 94 sky130_fd_pr__nfet_01v8 L=0.15U W=0.65U AS=0.08775P
+ AD=0.169P PS=0.92U PD=1.82U
* device instance $1052 r0 *1 64.87,51.235 sky130_fd_pr__nfet_01v8
M$1052 94 844 898 898 sky130_fd_pr__nfet_01v8 L=0.15U W=0.42U AS=0.1092P
+ AD=0.0567P PS=1.36U PD=0.69U
* device instance $1053 r0 *1 65.29,51.235 sky130_fd_pr__nfet_01v8
M$1053 899 898 94 94 sky130_fd_pr__nfet_01v8 L=0.15U W=0.42U AS=0.0567P
+ AD=0.1092P PS=0.69U PD=1.36U
* device instance $1054 r0 *1 66.23,51.235 sky130_fd_pr__nfet_01v8
M$1054 928 910 900 900 sky130_fd_pr__nfet_01v8 L=0.15U W=0.42U AS=0.1092P
+ AD=0.0441P PS=1.36U PD=0.63U
* device instance $1055 r0 *1 66.59,51.235 sky130_fd_pr__nfet_01v8
M$1055 94 1102 928 928 sky130_fd_pr__nfet_01v8 L=0.15U W=0.42U AS=0.0441P
+ AD=0.1092P PS=0.63U PD=1.36U
* device instance $1056 r0 *1 67.53,51.235 sky130_fd_pr__nfet_01v8
M$1056 94 1102 877 877 sky130_fd_pr__nfet_01v8 L=0.15U W=0.42U AS=0.1092P
+ AD=0.0609P PS=1.36U PD=0.71U
* device instance $1057 r0 *1 67.97,51.235 sky130_fd_pr__nfet_01v8
M$1057 926 877 94 94 sky130_fd_pr__nfet_01v8 L=0.15U W=0.42U AS=0.0609P
+ AD=0.0756P PS=0.71U PD=0.78U
* device instance $1058 r0 *1 68.48,51.235 sky130_fd_pr__nfet_01v8
M$1058 900 878 926 926 sky130_fd_pr__nfet_01v8 L=0.15U W=0.42U AS=0.0756P
+ AD=0.1446P PS=0.78U PD=1.18U
* device instance $1059 r0 *1 69.39,51.265 sky130_fd_pr__nfet_01v8
M$1059 901 898 900 900 sky130_fd_pr__nfet_01v8 L=0.15U W=0.36U AS=0.1446P
+ AD=0.0522P PS=1.18U PD=0.65U
* device instance $1060 r0 *1 69.83,51.265 sky130_fd_pr__nfet_01v8
M$1060 901 899 925 925 sky130_fd_pr__nfet_01v8 L=0.15U W=0.36U AS=0.0759P
+ AD=0.0522P PS=0.8U PD=0.65U
* device instance $1061 r0 *1 70.36,51.235 sky130_fd_pr__nfet_01v8
M$1061 925 902 94 94 sky130_fd_pr__nfet_01v8 L=0.15U W=0.42U AS=0.12095P
+ AD=0.0759P PS=1.085U PD=0.8U
* device instance $1062 r0 *1 70.955,51.125 sky130_fd_pr__nfet_01v8
M$1062 902 901 94 94 sky130_fd_pr__nfet_01v8 L=0.15U W=0.64U AS=0.12095P
+ AD=0.1664P PS=1.085U PD=1.8U
* device instance $1063 r0 *1 68.175,52.125 sky130_fd_pr__nfet_01v8
M$1063 955 71 94 94 sky130_fd_pr__nfet_01v8 L=0.15U W=0.42U AS=0.11285P
+ AD=0.0693P PS=1.045U PD=0.75U
* device instance $1064 r0 *1 68.655,52.125 sky130_fd_pr__nfet_01v8
M$1064 941 942 955 955 sky130_fd_pr__nfet_01v8 L=0.15U W=0.42U AS=0.0693P
+ AD=0.09975P PS=0.75U PD=0.895U
* device instance $1065 r0 *1 69.28,52.125 sky130_fd_pr__nfet_01v8
M$1065 952 949 941 941 sky130_fd_pr__nfet_01v8 L=0.15U W=0.42U AS=0.09975P
+ AD=0.0693P PS=0.895U PD=0.75U
* device instance $1066 r0 *1 69.76,52.125 sky130_fd_pr__nfet_01v8
M$1066 94 943 952 952 sky130_fd_pr__nfet_01v8 L=0.15U W=0.42U AS=0.0693P
+ AD=0.1449P PS=0.75U PD=1.11U
* device instance $1067 r0 *1 70.6,52.125 sky130_fd_pr__nfet_01v8
M$1067 943 71 94 94 sky130_fd_pr__nfet_01v8 L=0.15U W=0.42U AS=0.1449P
+ AD=0.1092P PS=1.11U PD=1.36U
* device instance $1068 r0 *1 67.63,52.24 sky130_fd_pr__nfet_01v8
M$1068 94 941 910 910 sky130_fd_pr__nfet_01v8 L=0.15U W=0.65U AS=0.169P
+ AD=0.11285P PS=1.82U PD=1.045U
* device instance $1069 r0 *1 71.895,51.235 sky130_fd_pr__nfet_01v8
M$1069 923 902 94 94 sky130_fd_pr__nfet_01v8 L=0.15U W=0.42U AS=0.1092P
+ AD=0.0678P PS=1.36U PD=0.755U
* device instance $1070 r0 *1 72.38,51.265 sky130_fd_pr__nfet_01v8
M$1070 903 899 923 923 sky130_fd_pr__nfet_01v8 L=0.15U W=0.36U AS=0.0678P
+ AD=0.0684P PS=0.755U PD=0.74U
* device instance $1071 r0 *1 72.91,51.265 sky130_fd_pr__nfet_01v8
M$1071 903 898 921 921 sky130_fd_pr__nfet_01v8 L=0.15U W=0.36U AS=0.066P
+ AD=0.0684P PS=0.745U PD=0.74U
* device instance $1072 r0 *1 73.385,51.235 sky130_fd_pr__nfet_01v8
M$1072 94 878 921 921 sky130_fd_pr__nfet_01v8 L=0.15U W=0.42U AS=0.066P
+ AD=0.1092P PS=0.745U PD=1.36U
* device instance $1073 r0 *1 74.325,51.235 sky130_fd_pr__nfet_01v8
M$1073 878 903 94 94 sky130_fd_pr__nfet_01v8 L=0.15U W=0.42U AS=0.10025P
+ AD=0.1092P PS=0.985U PD=1.36U
* device instance $1074 r0 *1 74.81,51.12 sky130_fd_pr__nfet_01v8
M$1074 919 903 94 94 sky130_fd_pr__nfet_01v8 L=0.15U W=0.65U AS=0.10025P
+ AD=0.182P PS=0.985U PD=1.86U
* device instance $1075 r0 *1 9.21,56.675 sky130_fd_pr__nfet_01v8
M$1075 94 937 966 966 sky130_fd_pr__nfet_01v8 L=0.15U W=0.42U AS=0.1092P
+ AD=0.0567P PS=1.36U PD=0.69U
* device instance $1076 r0 *1 9.63,56.675 sky130_fd_pr__nfet_01v8
M$1076 967 966 94 94 sky130_fd_pr__nfet_01v8 L=0.15U W=0.42U AS=0.0567P
+ AD=0.1092P PS=0.69U PD=1.36U
* device instance $1077 r0 *1 10.57,56.675 sky130_fd_pr__nfet_01v8
M$1077 1000 873 968 968 sky130_fd_pr__nfet_01v8 L=0.15U W=0.42U AS=0.1092P
+ AD=0.0441P PS=1.36U PD=0.63U
* device instance $1078 r0 *1 10.93,56.675 sky130_fd_pr__nfet_01v8
M$1078 94 315 1000 1000 sky130_fd_pr__nfet_01v8 L=0.15U W=0.42U AS=0.0441P
+ AD=0.1092P PS=0.63U PD=1.36U
* device instance $1079 r0 *1 11.87,56.675 sky130_fd_pr__nfet_01v8
M$1079 94 315 969 969 sky130_fd_pr__nfet_01v8 L=0.15U W=0.42U AS=0.1092P
+ AD=0.0609P PS=1.36U PD=0.71U
* device instance $1080 r0 *1 12.31,56.675 sky130_fd_pr__nfet_01v8
M$1080 1001 969 94 94 sky130_fd_pr__nfet_01v8 L=0.15U W=0.42U AS=0.0609P
+ AD=0.0756P PS=0.71U PD=0.78U
* device instance $1081 r0 *1 12.82,56.675 sky130_fd_pr__nfet_01v8
M$1081 968 973 1001 1001 sky130_fd_pr__nfet_01v8 L=0.15U W=0.42U AS=0.0756P
+ AD=0.1446P PS=0.78U PD=1.18U
* device instance $1082 r0 *1 13.73,56.705 sky130_fd_pr__nfet_01v8
M$1082 970 966 968 968 sky130_fd_pr__nfet_01v8 L=0.15U W=0.36U AS=0.1446P
+ AD=0.0522P PS=1.18U PD=0.65U
* device instance $1083 r0 *1 14.17,56.705 sky130_fd_pr__nfet_01v8
M$1083 970 967 1002 1002 sky130_fd_pr__nfet_01v8 L=0.15U W=0.36U AS=0.0759P
+ AD=0.0522P PS=0.8U PD=0.65U
* device instance $1084 r0 *1 14.7,56.675 sky130_fd_pr__nfet_01v8
M$1084 1002 971 94 94 sky130_fd_pr__nfet_01v8 L=0.15U W=0.42U AS=0.12095P
+ AD=0.0759P PS=1.085U PD=0.8U
* device instance $1085 r0 *1 15.295,56.565 sky130_fd_pr__nfet_01v8
M$1085 971 970 94 94 sky130_fd_pr__nfet_01v8 L=0.15U W=0.64U AS=0.12095P
+ AD=0.1664P PS=1.085U PD=1.8U
* device instance $1086 r0 *1 16.235,56.675 sky130_fd_pr__nfet_01v8
M$1086 1005 971 94 94 sky130_fd_pr__nfet_01v8 L=0.15U W=0.42U AS=0.1092P
+ AD=0.0678P PS=1.36U PD=0.755U
* device instance $1087 r0 *1 16.72,56.705 sky130_fd_pr__nfet_01v8
M$1087 972 967 1005 1005 sky130_fd_pr__nfet_01v8 L=0.15U W=0.36U AS=0.0678P
+ AD=0.0684P PS=0.755U PD=0.74U
* device instance $1088 r0 *1 17.25,56.705 sky130_fd_pr__nfet_01v8
M$1088 972 966 1006 1006 sky130_fd_pr__nfet_01v8 L=0.15U W=0.36U AS=0.066P
+ AD=0.0684P PS=0.745U PD=0.74U
* device instance $1089 r0 *1 17.725,56.675 sky130_fd_pr__nfet_01v8
M$1089 94 973 1006 1006 sky130_fd_pr__nfet_01v8 L=0.15U W=0.42U AS=0.066P
+ AD=0.1092P PS=0.745U PD=1.36U
* device instance $1090 r0 *1 18.665,56.675 sky130_fd_pr__nfet_01v8
M$1090 973 972 94 94 sky130_fd_pr__nfet_01v8 L=0.15U W=0.42U AS=0.10025P
+ AD=0.1092P PS=0.985U PD=1.36U
* device instance $1091 r0 *1 19.15,56.56 sky130_fd_pr__nfet_01v8
M$1091 865 972 94 94 sky130_fd_pr__nfet_01v8 L=0.15U W=0.65U AS=0.10025P
+ AD=0.182P PS=0.985U PD=1.86U
* device instance $1092 r0 *1 28.305,56.675 sky130_fd_pr__nfet_01v8
M$1092 984 875 94 94 sky130_fd_pr__nfet_01v8 L=0.15U W=0.42U AS=0.10025P
+ AD=0.1092P PS=0.985U PD=1.36U
* device instance $1093 r0 *1 28.79,56.56 sky130_fd_pr__nfet_01v8
M$1093 995 996 94 94 sky130_fd_pr__nfet_01v8 L=0.15U W=0.65U AS=0.10025P
+ AD=0.08775P PS=0.985U PD=0.92U
* device instance $1094 r0 *1 29.21,56.56 sky130_fd_pr__nfet_01v8
M$1094 94 984 995 995 sky130_fd_pr__nfet_01v8 L=0.15U W=0.65U AS=0.08775P
+ AD=0.169P PS=0.92U PD=1.82U
* device instance $1095 r0 *1 30.85,56.56 sky130_fd_pr__nfet_01v8
M$1095 997 985 94 94 sky130_fd_pr__nfet_01v8 L=0.15U W=2.6U AS=0.44525P
+ AD=0.351P PS=4.62U PD=3.68U
* device instance $1099 r0 *1 32.53,56.56 sky130_fd_pr__nfet_01v8
M$1099 997 109 94 94 sky130_fd_pr__nfet_01v8 L=0.15U W=2.6U AS=0.351P
+ AD=0.43225P PS=3.68U PD=4.58U
* device instance $1102 r0 *1 33.79,56.56 sky130_fd_pr__nfet_01v8
M$1102 94 995 997 997 sky130_fd_pr__nfet_01v8 L=0.15U W=2.6U AS=0.351P
+ AD=0.351P PS=3.68U PD=3.68U
* device instance $1107 r0 *1 43.26,56.675 sky130_fd_pr__nfet_01v8
M$1107 976 844 94 94 sky130_fd_pr__nfet_01v8 L=0.15U W=0.84U AS=0.1701P
+ AD=0.168P PS=2.07U PD=2.06U
* device instance $1109 r0 *1 44.635,56.675 sky130_fd_pr__nfet_01v8
M$1109 977 310 94 94 sky130_fd_pr__nfet_01v8 L=0.15U W=1.68U AS=0.2877P
+ AD=0.2352P PS=3.47U PD=2.8U
* device instance $1113 r0 *1 46.355,56.675 sky130_fd_pr__nfet_01v8
M$1113 844 977 94 94 sky130_fd_pr__nfet_01v8 L=0.15U W=6.72U AS=0.93975P
+ AD=0.99225P PS=11.195U PD=11.865U
* device instance $1129 r0 *1 59.38,56.675 sky130_fd_pr__nfet_01v8
M$1129 94 805 999 999 sky130_fd_pr__nfet_01v8 L=0.15U W=0.42U AS=0.1113P
+ AD=0.0588P PS=1.37U PD=0.7U
* device instance $1130 r0 *1 59.81,56.675 sky130_fd_pr__nfet_01v8
M$1130 999 948 94 94 sky130_fd_pr__nfet_01v8 L=0.15U W=0.42U AS=0.0588P
+ AD=0.0588P PS=0.7U PD=0.7U
* device instance $1131 r0 *1 60.24,56.675 sky130_fd_pr__nfet_01v8
M$1131 978 979 999 999 sky130_fd_pr__nfet_01v8 L=0.15U W=0.42U AS=0.0588P
+ AD=0.1113P PS=0.7U PD=1.37U
* device instance $1132 r0 *1 62.115,56.56 sky130_fd_pr__nfet_01v8
M$1132 1007 939 980 980 sky130_fd_pr__nfet_01v8 L=0.15U W=0.65U AS=0.17225P
+ AD=0.06825P PS=1.83U PD=0.86U
* device instance $1133 r0 *1 62.475,56.56 sky130_fd_pr__nfet_01v8
M$1133 94 978 1007 1007 sky130_fd_pr__nfet_01v8 L=0.15U W=0.65U AS=0.06825P
+ AD=0.138125P PS=0.86U PD=1.075U
* device instance $1134 r0 *1 63.05,56.56 sky130_fd_pr__nfet_01v8
M$1134 981 980 94 94 sky130_fd_pr__nfet_01v8 L=0.15U W=2.6U AS=0.411125P
+ AD=0.45825P PS=3.865U PD=4.66U
* device instance $1138 r0 *1 65.745,56.675 sky130_fd_pr__nfet_01v8
M$1138 94 982 979 979 sky130_fd_pr__nfet_01v8 L=0.15U W=0.42U AS=0.1092P
+ AD=0.1197P PS=1.36U PD=1.41U
* device instance $1139 r0 *1 66.71,56.445 sky130_fd_pr__nfet_01v8
M$1139 94 919 986 986 sky130_fd_pr__nfet_01v8 L=0.15U W=0.42U AS=0.1092P
+ AD=0.10025P PS=1.36U PD=0.985U
* device instance $1140 r0 *1 67.195,56.56 sky130_fd_pr__nfet_01v8
M$1140 1004 949 94 94 sky130_fd_pr__nfet_01v8 L=0.15U W=0.65U AS=0.10025P
+ AD=0.08775P PS=0.985U PD=0.92U
* device instance $1141 r0 *1 67.615,56.56 sky130_fd_pr__nfet_01v8
M$1141 1020 986 1004 1004 sky130_fd_pr__nfet_01v8 L=0.15U W=0.65U AS=0.08775P
+ AD=0.169P PS=0.92U PD=1.82U
* device instance $1142 r0 *1 69.11,56.56 sky130_fd_pr__nfet_01v8
M$1142 1003 949 983 983 sky130_fd_pr__nfet_01v8 L=0.15U W=0.65U AS=0.169P
+ AD=0.06825P PS=1.82U PD=0.86U
* device instance $1143 r0 *1 69.47,56.56 sky130_fd_pr__nfet_01v8
M$1143 94 919 1003 1003 sky130_fd_pr__nfet_01v8 L=0.15U W=0.65U AS=0.06825P
+ AD=0.08775P PS=0.86U PD=0.92U
* device instance $1144 r0 *1 69.89,56.56 sky130_fd_pr__nfet_01v8
M$1144 998 919 94 94 sky130_fd_pr__nfet_01v8 L=0.15U W=0.65U AS=0.08775P
+ AD=0.169P PS=0.92U PD=1.82U
* device instance $1145 r0 *1 70.83,56.56 sky130_fd_pr__nfet_01v8
M$1145 998 949 94 94 sky130_fd_pr__nfet_01v8 L=0.15U W=0.65U AS=0.169P
+ AD=0.08775P PS=1.82U PD=0.92U
* device instance $1146 r0 *1 71.25,56.56 sky130_fd_pr__nfet_01v8
M$1146 982 983 998 998 sky130_fd_pr__nfet_01v8 L=0.15U W=0.65U AS=0.08775P
+ AD=0.195P PS=0.92U PD=1.9U
* device instance $1147 r0 *1 15.665,62 sky130_fd_pr__nfet_01v8
M$1147 94 1061 1045 1045 sky130_fd_pr__nfet_01v8 L=0.15U W=0.65U AS=0.169P
+ AD=0.105625P PS=1.82U PD=0.975U
* device instance $1148 r0 *1 16.14,62 sky130_fd_pr__nfet_01v8
M$1148 71 1045 94 94 sky130_fd_pr__nfet_01v8 L=0.15U W=2.6U AS=0.37375P
+ AD=0.453375P PS=3.75U PD=4.645U
* device instance $1152 r0 *1 20.73,62 sky130_fd_pr__nfet_01v8
M$1152 1062 1100 94 94 sky130_fd_pr__nfet_01v8 L=0.15U W=2.6U AS=0.44525P
+ AD=0.351P PS=4.62U PD=3.68U
* device instance $1156 r0 *1 22.41,62 sky130_fd_pr__nfet_01v8
M$1156 1062 1008 94 94 sky130_fd_pr__nfet_01v8 L=0.15U W=2.6U AS=0.351P
+ AD=0.59475P PS=3.68U PD=4.43U
* device instance $1160 r0 *1 24.84,62 sky130_fd_pr__nfet_01v8
M$1160 90 1047 94 94 sky130_fd_pr__nfet_01v8 L=0.15U W=5.2U AS=0.94575P
+ AD=0.702P PS=8.11U PD=7.36U
* device instance $1168 r0 *1 28.2,62 sky130_fd_pr__nfet_01v8
M$1168 1047 1062 94 94 sky130_fd_pr__nfet_01v8 L=0.15U W=1.95U AS=0.26325P
+ AD=0.3445P PS=2.76U PD=3.66U
* device instance $1171 r0 *1 24.87,57.68 sky130_fd_pr__nfet_01v8
M$1171 1008 71 94 94 sky130_fd_pr__nfet_01v8 L=0.15U W=1.3U AS=0.2665P
+ AD=0.1755P PS=2.77U PD=1.84U
* device instance $1173 r0 *1 25.71,57.68 sky130_fd_pr__nfet_01v8
M$1173 1008 995 94 94 sky130_fd_pr__nfet_01v8 L=0.15U W=1.3U AS=0.1755P
+ AD=0.25675P PS=1.84U PD=2.74U
* device instance $1175 r0 *1 27.09,57.68 sky130_fd_pr__nfet_01v8
M$1175 1008 1024 94 94 sky130_fd_pr__nfet_01v8 L=0.15U W=1.3U AS=0.25675P
+ AD=0.25675P PS=2.74U PD=2.74U
* device instance $1177 r0 *1 28.65,57.68 sky130_fd_pr__nfet_01v8
M$1177 94 109 1009 1009 sky130_fd_pr__nfet_01v8 L=0.15U W=0.65U AS=0.19825P
+ AD=0.08775P PS=1.91U PD=0.92U
* device instance $1178 r0 *1 29.07,57.68 sky130_fd_pr__nfet_01v8
M$1178 91 1010 94 94 sky130_fd_pr__nfet_01v8 L=0.15U W=2.6U AS=0.351P
+ AD=0.43225P PS=3.68U PD=4.58U
* device instance $1182 r0 *1 31.27,57.68 sky130_fd_pr__nfet_01v8
M$1182 1010 1009 1011 1011 sky130_fd_pr__nfet_01v8 L=0.15U W=1.3U AS=0.25675P
+ AD=0.1755P PS=2.74U PD=1.84U
* device instance $1184 r0 *1 32.11,57.68 sky130_fd_pr__nfet_01v8
M$1184 94 1024 1011 1011 sky130_fd_pr__nfet_01v8 L=0.15U W=1.3U AS=0.1755P
+ AD=0.1755P PS=1.84U PD=1.84U
* device instance $1186 r0 *1 32.95,57.68 sky130_fd_pr__nfet_01v8
M$1186 94 995 1011 1011 sky130_fd_pr__nfet_01v8 L=0.15U W=1.3U AS=0.1755P
+ AD=0.26975P PS=1.84U PD=2.78U
* device instance $1188 r0 *1 32.21,62 sky130_fd_pr__nfet_01v8
M$1188 1048 995 94 94 sky130_fd_pr__nfet_01v8 L=0.15U W=0.65U AS=0.169P
+ AD=0.08775P PS=1.82U PD=0.92U
* device instance $1189 r0 *1 32.63,62 sky130_fd_pr__nfet_01v8
M$1189 94 1063 1048 1048 sky130_fd_pr__nfet_01v8 L=0.15U W=0.65U AS=0.08775P
+ AD=0.169P PS=0.92U PD=1.82U
* device instance $1190 r0 *1 33.825,62.115 sky130_fd_pr__nfet_01v8
M$1190 1064 996 94 94 sky130_fd_pr__nfet_01v8 L=0.15U W=0.42U AS=0.10025P
+ AD=0.1092P PS=0.985U PD=1.36U
* device instance $1191 r0 *1 34.31,62 sky130_fd_pr__nfet_01v8
M$1191 1063 875 94 94 sky130_fd_pr__nfet_01v8 L=0.15U W=0.65U AS=0.10025P
+ AD=0.08775P PS=0.985U PD=0.92U
* device instance $1192 r0 *1 34.73,62 sky130_fd_pr__nfet_01v8
M$1192 94 1064 1063 1063 sky130_fd_pr__nfet_01v8 L=0.15U W=0.65U AS=0.08775P
+ AD=0.169P PS=0.92U PD=1.82U
* device instance $1193 r0 *1 34.97,57.68 sky130_fd_pr__nfet_01v8
M$1193 94 985 1012 1012 sky130_fd_pr__nfet_01v8 L=0.15U W=0.65U AS=0.169P
+ AD=0.08775P PS=1.82U PD=0.92U
* device instance $1194 r0 *1 35.39,57.68 sky130_fd_pr__nfet_01v8
M$1194 1024 1012 94 94 sky130_fd_pr__nfet_01v8 L=0.15U W=2.6U AS=0.351P
+ AD=0.4615P PS=3.68U PD=4.02U
* device instance $1198 r0 *1 37.41,57.68 sky130_fd_pr__nfet_01v8
M$1198 1013 997 94 94 sky130_fd_pr__nfet_01v8 L=0.15U W=1.3U AS=0.286P
+ AD=0.1755P PS=2.18U PD=1.84U
* device instance $1200 r0 *1 38.25,57.68 sky130_fd_pr__nfet_01v8
M$1200 87 1013 94 94 sky130_fd_pr__nfet_01v8 L=0.15U W=3.9U AS=0.5265P
+ AD=0.60775P PS=5.52U PD=6.42U
* device instance $1206 r0 *1 40.03,62 sky130_fd_pr__nfet_01v8
M$1206 94 1068 1082 1082 sky130_fd_pr__nfet_01v8 L=0.15U W=1.3U AS=0.25675P
+ AD=0.1755P PS=2.74U PD=1.84U
* device instance $1208 r0 *1 40.87,62 sky130_fd_pr__nfet_01v8
M$1208 1084 1035 1082 1082 sky130_fd_pr__nfet_01v8 L=0.15U W=1.3U AS=0.1755P
+ AD=0.25675P PS=1.84U PD=2.74U
* device instance $1210 r0 *1 42.23,62 sky130_fd_pr__nfet_01v8
M$1210 1084 1081 1065 1065 sky130_fd_pr__nfet_01v8 L=0.15U W=1.3U AS=0.25675P
+ AD=0.18525P PS=2.74U PD=1.87U
* device instance $1212 r0 *1 43.1,62 sky130_fd_pr__nfet_01v8
M$1212 94 1063 1065 1065 sky130_fd_pr__nfet_01v8 L=0.15U W=1.3U AS=0.18525P
+ AD=0.25675P PS=1.87U PD=2.09U
* device instance $1214 r0 *1 44.19,62 sky130_fd_pr__nfet_01v8
M$1214 94 1066 1065 1065 sky130_fd_pr__nfet_01v8 L=0.15U W=1.3U AS=0.25675P
+ AD=0.25675P PS=2.09U PD=2.74U
* device instance $1216 r0 *1 42.33,57.68 sky130_fd_pr__nfet_01v8
M$1216 1014 1025 94 94 sky130_fd_pr__nfet_01v8 L=0.15U W=0.65U AS=0.169P
+ AD=0.08775P PS=1.82U PD=0.92U
* device instance $1217 r0 *1 42.75,57.68 sky130_fd_pr__nfet_01v8
M$1217 94 1015 1014 1014 sky130_fd_pr__nfet_01v8 L=0.15U W=0.65U AS=0.08775P
+ AD=0.169P PS=0.92U PD=1.82U
* device instance $1218 r0 *1 45.57,62 sky130_fd_pr__nfet_01v8
M$1218 1015 1081 94 94 sky130_fd_pr__nfet_01v8 L=0.15U W=0.65U AS=0.17225P
+ AD=0.091P PS=1.83U PD=0.93U
* device instance $1219 r0 *1 46,62 sky130_fd_pr__nfet_01v8
M$1219 1095 1068 1015 1015 sky130_fd_pr__nfet_01v8 L=0.15U W=0.65U AS=0.091P
+ AD=0.095875P PS=0.93U PD=0.945U
* device instance $1220 r0 *1 46.445,62 sky130_fd_pr__nfet_01v8
M$1220 94 1069 1095 1095 sky130_fd_pr__nfet_01v8 L=0.15U W=0.65U AS=0.095875P
+ AD=0.17225P PS=0.945U PD=1.83U
* device instance $1221 r0 *1 46.01,57.68 sky130_fd_pr__nfet_01v8
M$1221 94 997 1016 1016 sky130_fd_pr__nfet_01v8 L=0.15U W=0.65U AS=0.169P
+ AD=0.08775P PS=1.82U PD=0.92U
* device instance $1222 r0 *1 46.43,57.68 sky130_fd_pr__nfet_01v8
M$1222 1017 1016 94 94 sky130_fd_pr__nfet_01v8 L=0.15U W=2.6U AS=0.351P
+ AD=0.54275P PS=3.68U PD=4.27U
* device instance $1226 r0 *1 48.7,57.68 sky130_fd_pr__nfet_01v8
M$1226 1018 870 94 94 sky130_fd_pr__nfet_01v8 L=0.15U W=2.6U AS=0.54275P
+ AD=0.351P PS=4.27U PD=3.68U
* device instance $1230 r0 *1 50.38,57.68 sky130_fd_pr__nfet_01v8
M$1230 1018 805 94 94 sky130_fd_pr__nfet_01v8 L=0.15U W=2.6U AS=0.351P
+ AD=0.3575P PS=3.68U PD=3.7U
* device instance $1234 r0 *1 52.08,57.68 sky130_fd_pr__nfet_01v8
M$1234 1018 979 94 94 sky130_fd_pr__nfet_01v8 L=0.15U W=2.6U AS=0.3575P
+ AD=0.44525P PS=3.7U PD=4.62U
* device instance $1238 r0 *1 49.69,62 sky130_fd_pr__nfet_01v8
M$1238 94 1068 1083 1083 sky130_fd_pr__nfet_01v8 L=0.15U W=1.3U AS=0.25675P
+ AD=0.1755P PS=2.74U PD=1.84U
* device instance $1240 r0 *1 50.53,62 sky130_fd_pr__nfet_01v8
M$1240 1085 1069 1083 1083 sky130_fd_pr__nfet_01v8 L=0.15U W=1.3U AS=0.1755P
+ AD=0.25675P PS=1.84U PD=2.74U
* device instance $1242 r0 *1 51.89,62 sky130_fd_pr__nfet_01v8
M$1242 1085 1081 1070 1070 sky130_fd_pr__nfet_01v8 L=0.15U W=1.3U AS=0.2665P
+ AD=0.2145P PS=2.77U PD=1.96U
* device instance $1244 r0 *1 52.85,62 sky130_fd_pr__nfet_01v8
M$1244 94 1066 1070 1070 sky130_fd_pr__nfet_01v8 L=0.15U W=1.3U AS=0.23075P
+ AD=0.28275P PS=2.01U PD=2.82U
* device instance $1246 r0 *1 54.32,57.68 sky130_fd_pr__nfet_01v8
M$1246 1018 1020 1019 1019 sky130_fd_pr__nfet_01v8 L=0.15U W=2.6U AS=0.44525P
+ AD=0.351P PS=4.62U PD=3.68U
* device instance $1250 r0 *1 56,57.68 sky130_fd_pr__nfet_01v8
M$1250 1035 1021 1019 1019 sky130_fd_pr__nfet_01v8 L=0.15U W=2.6U AS=0.351P
+ AD=0.44525P PS=3.68U PD=4.62U
* device instance $1254 r0 *1 60.27,57.68 sky130_fd_pr__nfet_01v8
M$1254 94 1026 1022 1022 sky130_fd_pr__nfet_01v8 L=0.15U W=0.65U AS=0.169P
+ AD=0.10725P PS=1.82U PD=0.98U
* device instance $1255 r0 *1 60.75,57.68 sky130_fd_pr__nfet_01v8
M$1255 1029 919 94 94 sky130_fd_pr__nfet_01v8 L=0.15U W=0.65U AS=0.10725P
+ AD=0.06825P PS=0.98U PD=0.86U
* device instance $1256 r0 *1 61.11,57.68 sky130_fd_pr__nfet_01v8
M$1256 1022 91 1029 1029 sky130_fd_pr__nfet_01v8 L=0.15U W=0.65U AS=0.06825P
+ AD=0.169P PS=0.86U PD=1.82U
* device instance $1257 r0 *1 62.05,57.68 sky130_fd_pr__nfet_01v8
M$1257 1028 1017 1022 1022 sky130_fd_pr__nfet_01v8 L=0.15U W=0.65U AS=0.169P
+ AD=0.10725P PS=1.82U PD=0.98U
* device instance $1258 r0 *1 62.53,57.68 sky130_fd_pr__nfet_01v8
M$1258 94 981 1028 1028 sky130_fd_pr__nfet_01v8 L=0.15U W=0.65U AS=0.10725P
+ AD=0.102375P PS=0.98U PD=0.965U
* device instance $1259 r0 *1 62.995,57.68 sky130_fd_pr__nfet_01v8
M$1259 1038 1022 94 94 sky130_fd_pr__nfet_01v8 L=0.15U W=0.65U AS=0.102375P
+ AD=0.169P PS=0.965U PD=1.82U
* device instance $1260 r0 *1 63.97,57.68 sky130_fd_pr__nfet_01v8
M$1260 1027 939 94 94 sky130_fd_pr__nfet_01v8 L=0.15U W=0.65U AS=0.169P
+ AD=0.08775P PS=1.82U PD=0.92U
* device instance $1261 r0 *1 64.39,57.68 sky130_fd_pr__nfet_01v8
M$1261 1023 1020 1027 1027 sky130_fd_pr__nfet_01v8 L=0.15U W=0.65U AS=0.08775P
+ AD=0.169P PS=0.92U PD=1.82U
* device instance $1262 r0 *1 72.945,62.115 sky130_fd_pr__nfet_01v8
M$1262 1060 1059 94 94 sky130_fd_pr__nfet_01v8 L=0.15U W=0.42U AS=0.10025P
+ AD=0.1092P PS=0.985U PD=1.36U
* device instance $1263 r0 *1 73.43,62 sky130_fd_pr__nfet_01v8
M$1263 949 1059 94 94 sky130_fd_pr__nfet_01v8 L=0.15U W=0.65U AS=0.10025P
+ AD=0.182P PS=0.985U PD=1.86U
* device instance $1264 r0 *1 8.245,63.005 sky130_fd_pr__nfet_01v8
M$1264 94 1117 1199 1199 sky130_fd_pr__nfet_01v8 L=0.15U W=0.42U AS=0.1092P
+ AD=0.1197P PS=1.36U PD=1.41U
* device instance $1265 r0 *1 9.21,63.12 sky130_fd_pr__nfet_01v8
M$1265 1097 1118 1096 1096 sky130_fd_pr__nfet_01v8 L=0.15U W=0.65U AS=0.169P
+ AD=0.092625P PS=1.82U PD=0.935U
* device instance $1266 r0 *1 9.645,63.12 sky130_fd_pr__nfet_01v8
M$1266 1096 1117 1097 1097 sky130_fd_pr__nfet_01v8 L=0.15U W=0.65U AS=0.092625P
+ AD=0.115375P PS=0.935U PD=1.005U
* device instance $1267 r0 *1 10.15,63.12 sky130_fd_pr__nfet_01v8
M$1267 94 1098 1096 1096 sky130_fd_pr__nfet_01v8 L=0.15U W=0.65U AS=0.115375P
+ AD=0.08775P PS=1.005U PD=0.92U
* device instance $1268 r0 *1 10.57,63.12 sky130_fd_pr__nfet_01v8
M$1268 1096 918 94 94 sky130_fd_pr__nfet_01v8 L=0.15U W=0.65U AS=0.08775P
+ AD=0.169P PS=0.92U PD=1.82U
* device instance $1269 r0 *1 9.67,62.115 sky130_fd_pr__nfet_01v8
M$1269 94 937 1040 1040 sky130_fd_pr__nfet_01v8 L=0.15U W=0.42U AS=0.1092P
+ AD=0.0567P PS=1.36U PD=0.69U
* device instance $1270 r0 *1 10.09,62.115 sky130_fd_pr__nfet_01v8
M$1270 1041 1040 94 94 sky130_fd_pr__nfet_01v8 L=0.15U W=0.42U AS=0.0567P
+ AD=0.1092P PS=0.69U PD=1.36U
* device instance $1271 r0 *1 11.03,62.115 sky130_fd_pr__nfet_01v8
M$1271 1042 1080 94 94 sky130_fd_pr__nfet_01v8 L=0.15U W=0.42U AS=0.1092P
+ AD=0.066P PS=1.36U PD=0.745U
* device instance $1272 r0 *1 11.505,62.145 sky130_fd_pr__nfet_01v8
M$1272 1043 1040 1042 1042 sky130_fd_pr__nfet_01v8 L=0.15U W=0.36U AS=0.066P
+ AD=0.0594P PS=0.745U PD=0.69U
* device instance $1273 r0 *1 11.985,62.145 sky130_fd_pr__nfet_01v8
M$1273 1043 1041 1088 1088 sky130_fd_pr__nfet_01v8 L=0.15U W=0.36U AS=0.0687P
+ AD=0.0594P PS=0.76U PD=0.69U
* device instance $1274 r0 *1 12.475,62.115 sky130_fd_pr__nfet_01v8
M$1274 1088 1044 94 94 sky130_fd_pr__nfet_01v8 L=0.15U W=0.42U AS=0.1493P
+ AD=0.0687P PS=1.22U PD=0.76U
* device instance $1275 r0 *1 13.205,62.005 sky130_fd_pr__nfet_01v8
M$1275 1044 1043 94 94 sky130_fd_pr__nfet_01v8 L=0.15U W=0.64U AS=0.1493P
+ AD=0.0989P PS=1.22U PD=0.995U
* device instance $1276 r0 *1 13.71,62.145 sky130_fd_pr__nfet_01v8
M$1276 1061 1041 1044 1044 sky130_fd_pr__nfet_01v8 L=0.15U W=0.36U AS=0.0989P
+ AD=0.0657P PS=0.995U PD=0.725U
* device instance $1277 r0 *1 14.225,62.145 sky130_fd_pr__nfet_01v8
M$1277 1061 1040 1090 1090 sky130_fd_pr__nfet_01v8 L=0.15U W=0.36U AS=0.066P
+ AD=0.0657P PS=0.745U PD=0.725U
* device instance $1278 r0 *1 14.7,62.115 sky130_fd_pr__nfet_01v8
M$1278 94 1045 1090 1090 sky130_fd_pr__nfet_01v8 L=0.15U W=0.42U AS=0.066P
+ AD=0.1197P PS=0.745U PD=1.41U
* device instance $1279 r0 *1 11.53,63.12 sky130_fd_pr__nfet_01v8
M$1279 1125 1119 94 94 sky130_fd_pr__nfet_01v8 L=0.15U W=0.65U AS=0.169P
+ AD=0.08775P PS=1.82U PD=0.92U
* device instance $1280 r0 *1 11.95,63.12 sky130_fd_pr__nfet_01v8
M$1280 109 1099 1125 1125 sky130_fd_pr__nfet_01v8 L=0.15U W=0.65U AS=0.08775P
+ AD=0.169P PS=0.92U PD=1.82U
* device instance $1281 r0 *1 13.305,63.005 sky130_fd_pr__nfet_01v8
M$1281 94 71 1099 1099 sky130_fd_pr__nfet_01v8 L=0.15U W=0.42U AS=0.1092P
+ AD=0.1197P PS=1.36U PD=1.41U
* device instance $1282 r0 *1 17.05,63.12 sky130_fd_pr__nfet_01v8
M$1282 1100 1119 94 94 sky130_fd_pr__nfet_01v8 L=0.15U W=2.6U AS=0.44525P
+ AD=0.351P PS=4.62U PD=3.68U
* device instance $1286 r0 *1 18.73,63.12 sky130_fd_pr__nfet_01v8
M$1286 1100 71 94 94 sky130_fd_pr__nfet_01v8 L=0.15U W=2.6U AS=0.351P
+ AD=0.43225P PS=3.68U PD=4.58U
* device instance $1290 r0 *1 22.255,63.12 sky130_fd_pr__nfet_01v8
M$1290 315 1100 94 94 sky130_fd_pr__nfet_01v8 L=0.15U W=5.2U AS=0.78325P
+ AD=0.923P PS=8.26U PD=8.04U
* device instance $1298 r0 *1 26.295,63.12 sky130_fd_pr__nfet_01v8
M$1298 1101 1062 94 94 sky130_fd_pr__nfet_01v8 L=0.15U W=1.3U AS=0.3965P
+ AD=0.1755P PS=2.52U PD=1.84U
* device instance $1300 r0 *1 27.135,63.12 sky130_fd_pr__nfet_01v8
M$1300 1102 1101 94 94 sky130_fd_pr__nfet_01v8 L=0.15U W=3.9U AS=0.5265P
+ AD=0.60775P PS=5.52U PD=6.42U
* device instance $1306 r0 *1 30.37,63.005 sky130_fd_pr__nfet_01v8
M$1306 94 937 1103 1103 sky130_fd_pr__nfet_01v8 L=0.15U W=0.42U AS=0.1092P
+ AD=0.0567P PS=1.36U PD=0.69U
* device instance $1307 r0 *1 30.79,63.005 sky130_fd_pr__nfet_01v8
M$1307 1104 1103 94 94 sky130_fd_pr__nfet_01v8 L=0.15U W=0.42U AS=0.0567P
+ AD=0.1092P PS=0.69U PD=1.36U
* device instance $1308 r0 *1 31.73,63.005 sky130_fd_pr__nfet_01v8
M$1308 1131 1133 1105 1105 sky130_fd_pr__nfet_01v8 L=0.15U W=0.42U AS=0.1092P
+ AD=0.0441P PS=1.36U PD=0.63U
* device instance $1309 r0 *1 32.09,63.005 sky130_fd_pr__nfet_01v8
M$1309 94 315 1131 1131 sky130_fd_pr__nfet_01v8 L=0.15U W=0.42U AS=0.0441P
+ AD=0.1092P PS=0.63U PD=1.36U
* device instance $1310 r0 *1 34.89,62.975 sky130_fd_pr__nfet_01v8
M$1310 1107 1103 1105 1105 sky130_fd_pr__nfet_01v8 L=0.15U W=0.36U AS=0.1446P
+ AD=0.0522P PS=1.18U PD=0.65U
* device instance $1311 r0 *1 35.33,62.975 sky130_fd_pr__nfet_01v8
M$1311 1129 1104 1107 1107 sky130_fd_pr__nfet_01v8 L=0.15U W=0.36U AS=0.0522P
+ AD=0.0759P PS=0.65U PD=0.8U
* device instance $1312 r0 *1 33.03,63.005 sky130_fd_pr__nfet_01v8
M$1312 94 315 1106 1106 sky130_fd_pr__nfet_01v8 L=0.15U W=0.42U AS=0.1092P
+ AD=0.0609P PS=1.36U PD=0.71U
* device instance $1313 r0 *1 33.47,63.005 sky130_fd_pr__nfet_01v8
M$1313 1130 1106 94 94 sky130_fd_pr__nfet_01v8 L=0.15U W=0.42U AS=0.0609P
+ AD=0.0756P PS=0.71U PD=0.78U
* device instance $1314 r0 *1 33.98,63.005 sky130_fd_pr__nfet_01v8
M$1314 1105 1120 1130 1130 sky130_fd_pr__nfet_01v8 L=0.15U W=0.42U AS=0.0756P
+ AD=0.1446P PS=0.78U PD=1.18U
* device instance $1315 r0 *1 35.86,63.005 sky130_fd_pr__nfet_01v8
M$1315 94 1108 1129 1129 sky130_fd_pr__nfet_01v8 L=0.15U W=0.42U AS=0.0759P
+ AD=0.12095P PS=0.8U PD=1.085U
* device instance $1316 r0 *1 36.455,63.115 sky130_fd_pr__nfet_01v8
M$1316 1108 1107 94 94 sky130_fd_pr__nfet_01v8 L=0.15U W=0.64U AS=0.12095P
+ AD=0.1664P PS=1.085U PD=1.8U
* device instance $1317 r0 *1 37.88,62.975 sky130_fd_pr__nfet_01v8
M$1317 1109 1104 1128 1128 sky130_fd_pr__nfet_01v8 L=0.15U W=0.36U AS=0.0678P
+ AD=0.0684P PS=0.755U PD=0.74U
* device instance $1318 r0 *1 38.41,62.975 sky130_fd_pr__nfet_01v8
M$1318 1127 1103 1109 1109 sky130_fd_pr__nfet_01v8 L=0.15U W=0.36U AS=0.0684P
+ AD=0.066P PS=0.74U PD=0.745U
* device instance $1319 r0 *1 37.395,63.005 sky130_fd_pr__nfet_01v8
M$1319 1128 1108 94 94 sky130_fd_pr__nfet_01v8 L=0.15U W=0.42U AS=0.1092P
+ AD=0.0678P PS=1.36U PD=0.755U
* device instance $1320 r0 *1 38.885,63.005 sky130_fd_pr__nfet_01v8
M$1320 94 1120 1127 1127 sky130_fd_pr__nfet_01v8 L=0.15U W=0.42U AS=0.066P
+ AD=0.1092P PS=0.745U PD=1.36U
* device instance $1321 r0 *1 39.825,63.005 sky130_fd_pr__nfet_01v8
M$1321 94 1109 1120 1120 sky130_fd_pr__nfet_01v8 L=0.15U W=0.42U AS=0.1092P
+ AD=0.10025P PS=1.36U PD=0.985U
* device instance $1322 r0 *1 40.31,63.12 sky130_fd_pr__nfet_01v8
M$1322 996 1109 94 94 sky130_fd_pr__nfet_01v8 L=0.15U W=0.65U AS=0.10025P
+ AD=0.182P PS=0.985U PD=1.86U
* device instance $1323 r0 *1 41.41,63.12 sky130_fd_pr__nfet_01v8
M$1323 94 1065 1110 1110 sky130_fd_pr__nfet_01v8 L=0.15U W=0.65U AS=0.169P
+ AD=0.08775P PS=1.82U PD=0.92U
* device instance $1324 r0 *1 41.83,63.12 sky130_fd_pr__nfet_01v8
M$1324 985 1110 94 94 sky130_fd_pr__nfet_01v8 L=0.15U W=2.6U AS=0.351P
+ AD=0.43225P PS=3.68U PD=4.58U
* device instance $1328 r0 *1 45.59,63.12 sky130_fd_pr__nfet_01v8
M$1328 1112 1111 1081 1081 sky130_fd_pr__nfet_01v8 L=0.15U W=0.65U AS=0.195P
+ AD=0.08775P PS=1.9U PD=0.92U
* device instance $1329 r0 *1 46.01,63.12 sky130_fd_pr__nfet_01v8
M$1329 94 694 1112 1112 sky130_fd_pr__nfet_01v8 L=0.15U W=0.65U AS=0.08775P
+ AD=0.169P PS=0.92U PD=1.82U
* device instance $1330 r0 *1 46.95,63.12 sky130_fd_pr__nfet_01v8
M$1330 94 1121 1112 1112 sky130_fd_pr__nfet_01v8 L=0.15U W=0.65U AS=0.169P
+ AD=0.08775P PS=1.82U PD=0.92U
* device instance $1331 r0 *1 47.37,63.12 sky130_fd_pr__nfet_01v8
M$1331 1126 1121 94 94 sky130_fd_pr__nfet_01v8 L=0.15U W=0.65U AS=0.08775P
+ AD=0.06825P PS=0.92U PD=0.86U
* device instance $1332 r0 *1 47.73,63.12 sky130_fd_pr__nfet_01v8
M$1332 1111 694 1126 1126 sky130_fd_pr__nfet_01v8 L=0.15U W=0.65U AS=0.06825P
+ AD=0.169P PS=0.86U PD=1.82U
* device instance $1333 r0 *1 47.39,62.115 sky130_fd_pr__nfet_01v8
M$1333 1094 1081 1067 1067 sky130_fd_pr__nfet_01v8 L=0.15U W=0.42U AS=0.1092P
+ AD=0.0441P PS=1.36U PD=0.63U
* device instance $1334 r0 *1 47.75,62.115 sky130_fd_pr__nfet_01v8
M$1334 1093 1068 1094 1094 sky130_fd_pr__nfet_01v8 L=0.15U W=0.42U AS=0.0441P
+ AD=0.0441P PS=0.63U PD=0.63U
* device instance $1335 r0 *1 48.11,62.115 sky130_fd_pr__nfet_01v8
M$1335 1093 1069 94 94 sky130_fd_pr__nfet_01v8 L=0.15U W=0.42U AS=0.13165P
+ AD=0.0441P PS=1.14U PD=0.63U
* device instance $1336 r0 *1 48.75,62 sky130_fd_pr__nfet_01v8
M$1336 1025 1067 94 94 sky130_fd_pr__nfet_01v8 L=0.15U W=0.65U AS=0.13165P
+ AD=0.169P PS=1.14U PD=1.82U
* device instance $1337 r0 *1 48.76,63.12 sky130_fd_pr__nfet_01v8
M$1337 1069 1113 94 94 sky130_fd_pr__nfet_01v8 L=0.15U W=2.6U AS=0.43225P
+ AD=0.351P PS=4.58U PD=3.68U
* device instance $1341 r0 *1 50.44,63.12 sky130_fd_pr__nfet_01v8
M$1341 1113 1035 94 94 sky130_fd_pr__nfet_01v8 L=0.15U W=0.65U AS=0.08775P
+ AD=0.169P PS=0.92U PD=1.82U
* device instance $1342 r0 *1 51.765,63.005 sky130_fd_pr__nfet_01v8
M$1342 94 1121 1114 1114 sky130_fd_pr__nfet_01v8 L=0.15U W=0.42U AS=0.1092P
+ AD=0.10025P PS=1.36U PD=0.985U
* device instance $1343 r0 *1 52.25,63.12 sky130_fd_pr__nfet_01v8
M$1343 1066 694 94 94 sky130_fd_pr__nfet_01v8 L=0.15U W=0.65U AS=0.10025P
+ AD=0.08775P PS=0.985U PD=0.92U
* device instance $1344 r0 *1 52.67,63.12 sky130_fd_pr__nfet_01v8
M$1344 94 1114 1066 1066 sky130_fd_pr__nfet_01v8 L=0.15U W=0.65U AS=0.08775P
+ AD=0.169P PS=0.92U PD=1.82U
* device instance $1345 r0 *1 63.49,62.115 sky130_fd_pr__nfet_01v8
M$1345 94 844 1053 1053 sky130_fd_pr__nfet_01v8 L=0.15U W=0.42U AS=0.1092P
+ AD=0.0567P PS=1.36U PD=0.69U
* device instance $1346 r0 *1 63.91,62.115 sky130_fd_pr__nfet_01v8
M$1346 1054 1053 94 94 sky130_fd_pr__nfet_01v8 L=0.15U W=0.42U AS=0.0567P
+ AD=0.1092P PS=0.69U PD=1.36U
* device instance $1347 r0 *1 64.85,62.115 sky130_fd_pr__nfet_01v8
M$1347 1092 1038 1055 1055 sky130_fd_pr__nfet_01v8 L=0.15U W=0.42U AS=0.1092P
+ AD=0.0441P PS=1.36U PD=0.63U
* device instance $1348 r0 *1 65.21,62.115 sky130_fd_pr__nfet_01v8
M$1348 94 315 1092 1092 sky130_fd_pr__nfet_01v8 L=0.15U W=0.42U AS=0.0441P
+ AD=0.1092P PS=0.63U PD=1.36U
* device instance $1349 r0 *1 64.41,63.235 sky130_fd_pr__nfet_01v8
M$1349 1115 1122 94 94 sky130_fd_pr__nfet_01v8 L=0.15U W=0.42U AS=0.10025P
+ AD=0.1092P PS=0.985U PD=1.36U
* device instance $1350 r0 *1 64.895,63.12 sky130_fd_pr__nfet_01v8
M$1350 1124 1123 94 94 sky130_fd_pr__nfet_01v8 L=0.15U W=0.65U AS=0.10025P
+ AD=0.08775P PS=0.985U PD=0.92U
* device instance $1351 r0 *1 65.315,63.12 sky130_fd_pr__nfet_01v8
M$1351 1068 1115 1124 1124 sky130_fd_pr__nfet_01v8 L=0.15U W=0.65U AS=0.08775P
+ AD=0.169P PS=0.92U PD=1.82U
* device instance $1352 r0 *1 66.15,62.115 sky130_fd_pr__nfet_01v8
M$1352 94 315 1056 1056 sky130_fd_pr__nfet_01v8 L=0.15U W=0.42U AS=0.1092P
+ AD=0.0609P PS=1.36U PD=0.71U
* device instance $1353 r0 *1 66.59,62.115 sky130_fd_pr__nfet_01v8
M$1353 1091 1056 94 94 sky130_fd_pr__nfet_01v8 L=0.15U W=0.42U AS=0.0609P
+ AD=0.0756P PS=0.71U PD=0.78U
* device instance $1354 r0 *1 67.1,62.115 sky130_fd_pr__nfet_01v8
M$1354 1055 1060 1091 1091 sky130_fd_pr__nfet_01v8 L=0.15U W=0.42U AS=0.0756P
+ AD=0.1446P PS=0.78U PD=1.18U
* device instance $1355 r0 *1 68.01,62.145 sky130_fd_pr__nfet_01v8
M$1355 1057 1053 1055 1055 sky130_fd_pr__nfet_01v8 L=0.15U W=0.36U AS=0.1446P
+ AD=0.0522P PS=1.18U PD=0.65U
* device instance $1356 r0 *1 68.45,62.145 sky130_fd_pr__nfet_01v8
M$1356 1057 1054 1089 1089 sky130_fd_pr__nfet_01v8 L=0.15U W=0.36U AS=0.0759P
+ AD=0.0522P PS=0.8U PD=0.65U
* device instance $1357 r0 *1 68.98,62.115 sky130_fd_pr__nfet_01v8
M$1357 1089 1058 94 94 sky130_fd_pr__nfet_01v8 L=0.15U W=0.42U AS=0.12095P
+ AD=0.0759P PS=1.085U PD=0.8U
* device instance $1358 r0 *1 69.575,62.005 sky130_fd_pr__nfet_01v8
M$1358 1058 1057 94 94 sky130_fd_pr__nfet_01v8 L=0.15U W=0.64U AS=0.12095P
+ AD=0.1664P PS=1.085U PD=1.8U
* device instance $1359 r0 *1 66.655,63.12 sky130_fd_pr__nfet_01v8
M$1359 369 1116 94 94 sky130_fd_pr__nfet_01v8 L=0.15U W=2.6U AS=0.43225P
+ AD=0.351P PS=4.58U PD=3.68U
* device instance $1363 r0 *1 68.335,63.12 sky130_fd_pr__nfet_01v8
M$1363 1116 1123 94 94 sky130_fd_pr__nfet_01v8 L=0.15U W=0.65U AS=0.08775P
+ AD=0.169P PS=0.92U PD=1.82U
* device instance $1364 r0 *1 70.515,62.115 sky130_fd_pr__nfet_01v8
M$1364 1087 1058 94 94 sky130_fd_pr__nfet_01v8 L=0.15U W=0.42U AS=0.1092P
+ AD=0.0678P PS=1.36U PD=0.755U
* device instance $1365 r0 *1 71,62.145 sky130_fd_pr__nfet_01v8
M$1365 1059 1054 1087 1087 sky130_fd_pr__nfet_01v8 L=0.15U W=0.36U AS=0.0678P
+ AD=0.0684P PS=0.755U PD=0.74U
* device instance $1366 r0 *1 71.53,62.145 sky130_fd_pr__nfet_01v8
M$1366 1059 1053 1086 1086 sky130_fd_pr__nfet_01v8 L=0.15U W=0.36U AS=0.066P
+ AD=0.0684P PS=0.745U PD=0.74U
* device instance $1367 r0 *1 72.005,62.115 sky130_fd_pr__nfet_01v8
M$1367 94 1060 1086 1086 sky130_fd_pr__nfet_01v8 L=0.15U W=0.42U AS=0.066P
+ AD=0.1092P PS=0.745U PD=1.36U
* device instance $1368 r0 *1 5.09,67.44 sky130_fd_pr__nfet_01v8
M$1368 1204 1143 94 94 sky130_fd_pr__nfet_01v8 L=0.15U W=0.65U AS=0.169P
+ AD=0.08775P PS=1.82U PD=0.92U
* device instance $1369 r0 *1 5.51,67.44 sky130_fd_pr__nfet_01v8
M$1369 1118 71 1204 1204 sky130_fd_pr__nfet_01v8 L=0.15U W=0.65U AS=0.08775P
+ AD=0.169P PS=0.92U PD=1.82U
* device instance $1370 r0 *1 8.78,67.555 sky130_fd_pr__nfet_01v8
M$1370 94 1099 1202 1202 sky130_fd_pr__nfet_01v8 L=0.15U W=0.42U AS=0.1113P
+ AD=0.0588P PS=1.37U PD=0.7U
* device instance $1371 r0 *1 9.21,67.555 sky130_fd_pr__nfet_01v8
M$1371 1202 1143 94 94 sky130_fd_pr__nfet_01v8 L=0.15U W=0.42U AS=0.0588P
+ AD=0.0588P PS=0.7U PD=0.7U
* device instance $1372 r0 *1 9.64,67.555 sky130_fd_pr__nfet_01v8
M$1372 1080 1144 1202 1202 sky130_fd_pr__nfet_01v8 L=0.15U W=0.42U AS=0.0588P
+ AD=0.1113P PS=0.7U PD=1.37U
* device instance $1373 r0 *1 10.61,67.44 sky130_fd_pr__nfet_01v8
M$1373 1208 1199 94 94 sky130_fd_pr__nfet_01v8 L=0.15U W=0.65U AS=0.169P
+ AD=0.08775P PS=1.82U PD=0.92U
* device instance $1374 r0 *1 11.03,67.44 sky130_fd_pr__nfet_01v8
M$1374 1098 1119 1208 1208 sky130_fd_pr__nfet_01v8 L=0.15U W=0.65U AS=0.08775P
+ AD=0.169P PS=0.92U PD=1.82U
* device instance $1375 r0 *1 12.04,67.44 sky130_fd_pr__nfet_01v8
M$1375 94 1177 1145 1145 sky130_fd_pr__nfet_01v8 L=0.15U W=0.65U AS=0.2145P
+ AD=0.167375P PS=1.96U PD=1.165U
* device instance $1376 r0 *1 12.705,67.44 sky130_fd_pr__nfet_01v8
M$1376 1210 918 94 94 sky130_fd_pr__nfet_01v8 L=0.15U W=0.65U AS=0.167375P
+ AD=0.0975P PS=1.165U PD=0.95U
* device instance $1377 r0 *1 13.155,67.44 sky130_fd_pr__nfet_01v8
M$1377 1211 1199 1210 1210 sky130_fd_pr__nfet_01v8 L=0.15U W=0.65U AS=0.0975P
+ AD=0.14625P PS=0.95U PD=1.1U
* device instance $1378 r0 *1 13.755,67.44 sky130_fd_pr__nfet_01v8
M$1378 1177 1119 1211 1211 sky130_fd_pr__nfet_01v8 L=0.15U W=0.65U AS=0.14625P
+ AD=0.143P PS=1.1U PD=1.09U
* device instance $1379 r0 *1 14.345,67.44 sky130_fd_pr__nfet_01v8
M$1379 1212 1144 1177 1177 sky130_fd_pr__nfet_01v8 L=0.15U W=0.65U AS=0.143P
+ AD=0.06825P PS=1.09U PD=0.86U
* device instance $1380 r0 *1 14.705,67.44 sky130_fd_pr__nfet_01v8
M$1380 94 1147 1212 1212 sky130_fd_pr__nfet_01v8 L=0.15U W=0.65U AS=0.06825P
+ AD=0.17225P PS=0.86U PD=1.83U
* device instance $1381 r0 *1 15.83,67.415 sky130_fd_pr__nfet_01v8
M$1381 1214 1147 1178 1178 sky130_fd_pr__nfet_01v8 L=0.15U W=0.42U AS=0.1176P
+ AD=0.0567P PS=1.4U PD=0.69U
* device instance $1382 r0 *1 16.25,67.415 sky130_fd_pr__nfet_01v8
M$1382 1214 1100 94 94 sky130_fd_pr__nfet_01v8 L=0.15U W=0.42U AS=0.1118P
+ AD=0.0567P PS=1.04U PD=0.69U
* device instance $1383 r0 *1 16.79,67.44 sky130_fd_pr__nfet_01v8
M$1383 1148 1178 94 94 sky130_fd_pr__nfet_01v8 L=0.15U W=0.65U AS=0.1118P
+ AD=0.182P PS=1.04U PD=1.86U
* device instance $1384 r0 *1 24.46,67.555 sky130_fd_pr__nfet_01v8
M$1384 1216 1179 1149 1149 sky130_fd_pr__nfet_01v8 L=0.15U W=0.42U AS=0.1113P
+ AD=0.0441P PS=1.37U PD=0.63U
* device instance $1385 r0 *1 24.82,67.555 sky130_fd_pr__nfet_01v8
M$1385 94 109 1216 1216 sky130_fd_pr__nfet_01v8 L=0.15U W=0.42U AS=0.0441P
+ AD=0.0966P PS=0.63U PD=0.88U
* device instance $1386 r0 *1 25.43,67.555 sky130_fd_pr__nfet_01v8
M$1386 1150 1149 94 94 sky130_fd_pr__nfet_01v8 L=0.15U W=0.42U AS=0.0966P
+ AD=0.1113P PS=0.88U PD=1.37U
* device instance $1387 r0 *1 26.69,67.44 sky130_fd_pr__nfet_01v8
M$1387 94 1150 1151 1151 sky130_fd_pr__nfet_01v8 L=0.15U W=0.65U AS=0.169P
+ AD=0.10725P PS=1.82U PD=0.98U
* device instance $1388 r0 *1 27.17,67.44 sky130_fd_pr__nfet_01v8
M$1388 1218 875 94 94 sky130_fd_pr__nfet_01v8 L=0.15U W=0.65U AS=0.10725P
+ AD=0.06825P PS=0.98U PD=0.86U
* device instance $1389 r0 *1 27.53,67.44 sky130_fd_pr__nfet_01v8
M$1389 1151 91 1218 1218 sky130_fd_pr__nfet_01v8 L=0.15U W=0.65U AS=0.06825P
+ AD=0.169P PS=0.86U PD=1.82U
* device instance $1390 r0 *1 28.47,67.44 sky130_fd_pr__nfet_01v8
M$1390 1219 1181 1151 1151 sky130_fd_pr__nfet_01v8 L=0.15U W=0.65U AS=0.169P
+ AD=0.10725P PS=1.82U PD=0.98U
* device instance $1391 r0 *1 28.95,67.44 sky130_fd_pr__nfet_01v8
M$1391 94 997 1219 1219 sky130_fd_pr__nfet_01v8 L=0.15U W=0.65U AS=0.10725P
+ AD=0.102375P PS=0.98U PD=0.965U
* device instance $1392 r0 *1 29.415,67.44 sky130_fd_pr__nfet_01v8
M$1392 1133 1151 94 94 sky130_fd_pr__nfet_01v8 L=0.15U W=0.65U AS=0.102375P
+ AD=0.169P PS=0.965U PD=1.82U
* device instance $1393 r0 *1 32.31,67.44 sky130_fd_pr__nfet_01v8
M$1393 1222 1070 1153 1153 sky130_fd_pr__nfet_01v8 L=0.15U W=0.65U AS=0.169P
+ AD=0.06825P PS=1.82U PD=0.86U
* device instance $1394 r0 *1 32.67,67.44 sky130_fd_pr__nfet_01v8
M$1394 94 1048 1222 1222 sky130_fd_pr__nfet_01v8 L=0.15U W=0.65U AS=0.06825P
+ AD=0.08775P PS=0.86U PD=0.92U
* device instance $1395 r0 *1 33.09,67.44 sky130_fd_pr__nfet_01v8
M$1395 1203 1048 94 94 sky130_fd_pr__nfet_01v8 L=0.15U W=0.65U AS=0.08775P
+ AD=0.169P PS=0.92U PD=1.82U
* device instance $1396 r0 *1 34.03,67.44 sky130_fd_pr__nfet_01v8
M$1396 1203 1070 94 94 sky130_fd_pr__nfet_01v8 L=0.15U W=0.65U AS=0.169P
+ AD=0.08775P PS=1.82U PD=0.92U
* device instance $1397 r0 *1 34.45,67.44 sky130_fd_pr__nfet_01v8
M$1397 1181 1153 1203 1203 sky130_fd_pr__nfet_01v8 L=0.15U W=0.65U AS=0.08775P
+ AD=0.195P PS=0.92U PD=1.9U
* device instance $1398 r0 *1 36.81,67.44 sky130_fd_pr__nfet_01v8
M$1398 94 1200 1154 1154 sky130_fd_pr__nfet_01v8 L=0.15U W=0.65U AS=0.169P
+ AD=0.10725P PS=1.82U PD=0.98U
* device instance $1399 r0 *1 37.29,67.44 sky130_fd_pr__nfet_01v8
M$1399 1225 694 94 94 sky130_fd_pr__nfet_01v8 L=0.15U W=0.65U AS=0.10725P
+ AD=0.06825P PS=0.98U PD=0.86U
* device instance $1400 r0 *1 37.65,67.44 sky130_fd_pr__nfet_01v8
M$1400 1154 91 1225 1225 sky130_fd_pr__nfet_01v8 L=0.15U W=0.65U AS=0.06825P
+ AD=0.169P PS=0.86U PD=1.82U
* device instance $1401 r0 *1 38.59,67.44 sky130_fd_pr__nfet_01v8
M$1401 1226 1286 1154 1154 sky130_fd_pr__nfet_01v8 L=0.15U W=0.65U AS=0.169P
+ AD=0.10725P PS=1.82U PD=0.98U
* device instance $1402 r0 *1 39.07,67.44 sky130_fd_pr__nfet_01v8
M$1402 94 1014 1226 1226 sky130_fd_pr__nfet_01v8 L=0.15U W=0.65U AS=0.10725P
+ AD=0.102375P PS=0.98U PD=0.965U
* device instance $1403 r0 *1 39.535,67.44 sky130_fd_pr__nfet_01v8
M$1403 1156 1154 94 94 sky130_fd_pr__nfet_01v8 L=0.15U W=0.65U AS=0.102375P
+ AD=0.169P PS=0.965U PD=1.82U
* device instance $1404 r0 *1 40.49,67.555 sky130_fd_pr__nfet_01v8
M$1404 94 844 1157 1157 sky130_fd_pr__nfet_01v8 L=0.15U W=0.42U AS=0.1092P
+ AD=0.0567P PS=1.36U PD=0.69U
* device instance $1405 r0 *1 40.91,67.555 sky130_fd_pr__nfet_01v8
M$1405 1158 1157 94 94 sky130_fd_pr__nfet_01v8 L=0.15U W=0.42U AS=0.0567P
+ AD=0.1092P PS=0.69U PD=1.36U
* device instance $1406 r0 *1 41.85,67.555 sky130_fd_pr__nfet_01v8
M$1406 1227 1183 1160 1160 sky130_fd_pr__nfet_01v8 L=0.15U W=0.42U AS=0.1092P
+ AD=0.0441P PS=1.36U PD=0.63U
* device instance $1407 r0 *1 42.21,67.555 sky130_fd_pr__nfet_01v8
M$1407 94 1102 1227 1227 sky130_fd_pr__nfet_01v8 L=0.15U W=0.42U AS=0.0441P
+ AD=0.1092P PS=0.63U PD=1.36U
* device instance $1408 r0 *1 43.15,67.555 sky130_fd_pr__nfet_01v8
M$1408 94 1102 1159 1159 sky130_fd_pr__nfet_01v8 L=0.15U W=0.42U AS=0.1092P
+ AD=0.0609P PS=1.36U PD=0.71U
* device instance $1409 r0 *1 43.59,67.555 sky130_fd_pr__nfet_01v8
M$1409 1224 1159 94 94 sky130_fd_pr__nfet_01v8 L=0.15U W=0.42U AS=0.0609P
+ AD=0.0756P PS=0.71U PD=0.78U
* device instance $1410 r0 *1 44.1,67.555 sky130_fd_pr__nfet_01v8
M$1410 1160 1164 1224 1224 sky130_fd_pr__nfet_01v8 L=0.15U W=0.42U AS=0.0756P
+ AD=0.1446P PS=0.78U PD=1.18U
* device instance $1411 r0 *1 45.01,67.585 sky130_fd_pr__nfet_01v8
M$1411 1161 1157 1160 1160 sky130_fd_pr__nfet_01v8 L=0.15U W=0.36U AS=0.1446P
+ AD=0.0522P PS=1.18U PD=0.65U
* device instance $1412 r0 *1 45.45,67.585 sky130_fd_pr__nfet_01v8
M$1412 1161 1158 1223 1223 sky130_fd_pr__nfet_01v8 L=0.15U W=0.36U AS=0.0759P
+ AD=0.0522P PS=0.8U PD=0.65U
* device instance $1413 r0 *1 45.98,67.555 sky130_fd_pr__nfet_01v8
M$1413 1223 1162 94 94 sky130_fd_pr__nfet_01v8 L=0.15U W=0.42U AS=0.12095P
+ AD=0.0759P PS=1.085U PD=0.8U
* device instance $1414 r0 *1 46.575,67.445 sky130_fd_pr__nfet_01v8
M$1414 1162 1161 94 94 sky130_fd_pr__nfet_01v8 L=0.15U W=0.64U AS=0.12095P
+ AD=0.1664P PS=1.085U PD=1.8U
* device instance $1415 r0 *1 47.515,67.555 sky130_fd_pr__nfet_01v8
M$1415 1221 1162 94 94 sky130_fd_pr__nfet_01v8 L=0.15U W=0.42U AS=0.1092P
+ AD=0.0678P PS=1.36U PD=0.755U
* device instance $1416 r0 *1 48,67.585 sky130_fd_pr__nfet_01v8
M$1416 1163 1158 1221 1221 sky130_fd_pr__nfet_01v8 L=0.15U W=0.36U AS=0.0678P
+ AD=0.0684P PS=0.755U PD=0.74U
* device instance $1417 r0 *1 48.53,67.585 sky130_fd_pr__nfet_01v8
M$1417 1163 1157 1220 1220 sky130_fd_pr__nfet_01v8 L=0.15U W=0.36U AS=0.066P
+ AD=0.0684P PS=0.745U PD=0.74U
* device instance $1418 r0 *1 49.005,67.555 sky130_fd_pr__nfet_01v8
M$1418 94 1164 1220 1220 sky130_fd_pr__nfet_01v8 L=0.15U W=0.42U AS=0.066P
+ AD=0.1092P PS=0.745U PD=1.36U
* device instance $1419 r0 *1 49.945,67.555 sky130_fd_pr__nfet_01v8
M$1419 1164 1163 94 94 sky130_fd_pr__nfet_01v8 L=0.15U W=0.42U AS=0.10025P
+ AD=0.1092P PS=0.985U PD=1.36U
* device instance $1420 r0 *1 50.43,67.44 sky130_fd_pr__nfet_01v8
M$1420 694 1163 94 94 sky130_fd_pr__nfet_01v8 L=0.15U W=0.65U AS=0.10025P
+ AD=0.182P PS=0.985U PD=1.86U
* device instance $1421 r0 *1 60.34,67.555 sky130_fd_pr__nfet_01v8
M$1421 1217 1021 1165 1165 sky130_fd_pr__nfet_01v8 L=0.15U W=0.42U AS=0.1113P
+ AD=0.0441P PS=1.37U PD=0.63U
* device instance $1422 r0 *1 60.7,67.555 sky130_fd_pr__nfet_01v8
M$1422 94 1068 1217 1217 sky130_fd_pr__nfet_01v8 L=0.15U W=0.42U AS=0.0441P
+ AD=0.0966P PS=0.63U PD=0.88U
* device instance $1423 r0 *1 61.31,67.555 sky130_fd_pr__nfet_01v8
M$1423 1166 1165 94 94 sky130_fd_pr__nfet_01v8 L=0.15U W=0.42U AS=0.0966P
+ AD=0.1113P PS=0.88U PD=1.37U
* device instance $1424 r0 *1 62.61,67.44 sky130_fd_pr__nfet_01v8
M$1424 1167 1023 94 94 sky130_fd_pr__nfet_01v8 L=0.15U W=0.65U AS=0.169P
+ AD=0.08775P PS=1.82U PD=0.92U
* device instance $1425 r0 *1 63.03,67.44 sky130_fd_pr__nfet_01v8
M$1425 94 1166 1167 1167 sky130_fd_pr__nfet_01v8 L=0.15U W=0.65U AS=0.08775P
+ AD=0.08775P PS=0.92U PD=0.92U
* device instance $1426 r0 *1 63.45,67.44 sky130_fd_pr__nfet_01v8
M$1426 1215 1166 94 94 sky130_fd_pr__nfet_01v8 L=0.15U W=0.65U AS=0.08775P
+ AD=0.08775P PS=0.92U PD=0.92U
* device instance $1427 r0 *1 63.87,67.44 sky130_fd_pr__nfet_01v8
M$1427 1184 1023 1215 1215 sky130_fd_pr__nfet_01v8 L=0.15U W=0.65U AS=0.08775P
+ AD=0.25025P PS=0.92U PD=1.42U
* device instance $1428 r0 *1 64.79,67.44 sky130_fd_pr__nfet_01v8
M$1428 94 1167 1184 1184 sky130_fd_pr__nfet_01v8 L=0.15U W=0.65U AS=0.25025P
+ AD=0.208P PS=1.42U PD=1.94U
* device instance $1429 r0 *1 65.79,67.555 sky130_fd_pr__nfet_01v8
M$1429 94 844 1169 1169 sky130_fd_pr__nfet_01v8 L=0.15U W=0.42U AS=0.1092P
+ AD=0.0567P PS=1.36U PD=0.69U
* device instance $1430 r0 *1 66.21,67.555 sky130_fd_pr__nfet_01v8
M$1430 1170 1169 94 94 sky130_fd_pr__nfet_01v8 L=0.15U W=0.42U AS=0.0567P
+ AD=0.1092P PS=0.69U PD=1.36U
* device instance $1431 r0 *1 67.15,67.555 sky130_fd_pr__nfet_01v8
M$1431 1213 1201 1172 1172 sky130_fd_pr__nfet_01v8 L=0.15U W=0.42U AS=0.1092P
+ AD=0.0441P PS=1.36U PD=0.63U
* device instance $1432 r0 *1 67.51,67.555 sky130_fd_pr__nfet_01v8
M$1432 94 1102 1213 1213 sky130_fd_pr__nfet_01v8 L=0.15U W=0.42U AS=0.0441P
+ AD=0.1092P PS=0.63U PD=1.36U
* device instance $1433 r0 *1 68.45,67.555 sky130_fd_pr__nfet_01v8
M$1433 94 1102 1171 1171 sky130_fd_pr__nfet_01v8 L=0.15U W=0.42U AS=0.1092P
+ AD=0.0609P PS=1.36U PD=0.71U
* device instance $1434 r0 *1 68.89,67.555 sky130_fd_pr__nfet_01v8
M$1434 1209 1171 94 94 sky130_fd_pr__nfet_01v8 L=0.15U W=0.42U AS=0.0609P
+ AD=0.0756P PS=0.71U PD=0.78U
* device instance $1435 r0 *1 69.4,67.555 sky130_fd_pr__nfet_01v8
M$1435 1172 1176 1209 1209 sky130_fd_pr__nfet_01v8 L=0.15U W=0.42U AS=0.0756P
+ AD=0.1446P PS=0.78U PD=1.18U
* device instance $1436 r0 *1 70.31,67.585 sky130_fd_pr__nfet_01v8
M$1436 1173 1169 1172 1172 sky130_fd_pr__nfet_01v8 L=0.15U W=0.36U AS=0.1446P
+ AD=0.0522P PS=1.18U PD=0.65U
* device instance $1437 r0 *1 70.75,67.585 sky130_fd_pr__nfet_01v8
M$1437 1173 1170 1207 1207 sky130_fd_pr__nfet_01v8 L=0.15U W=0.36U AS=0.0759P
+ AD=0.0522P PS=0.8U PD=0.65U
* device instance $1438 r0 *1 71.28,67.555 sky130_fd_pr__nfet_01v8
M$1438 1207 1174 94 94 sky130_fd_pr__nfet_01v8 L=0.15U W=0.42U AS=0.12095P
+ AD=0.0759P PS=1.085U PD=0.8U
* device instance $1439 r0 *1 71.875,67.445 sky130_fd_pr__nfet_01v8
M$1439 1174 1173 94 94 sky130_fd_pr__nfet_01v8 L=0.15U W=0.64U AS=0.12095P
+ AD=0.1664P PS=1.085U PD=1.8U
* device instance $1440 r0 *1 72.815,67.555 sky130_fd_pr__nfet_01v8
M$1440 1206 1174 94 94 sky130_fd_pr__nfet_01v8 L=0.15U W=0.42U AS=0.1092P
+ AD=0.0678P PS=1.36U PD=0.755U
* device instance $1441 r0 *1 73.3,67.585 sky130_fd_pr__nfet_01v8
M$1441 1175 1170 1206 1206 sky130_fd_pr__nfet_01v8 L=0.15U W=0.36U AS=0.0678P
+ AD=0.0684P PS=0.755U PD=0.74U
* device instance $1442 r0 *1 73.83,67.585 sky130_fd_pr__nfet_01v8
M$1442 1175 1169 1205 1205 sky130_fd_pr__nfet_01v8 L=0.15U W=0.36U AS=0.066P
+ AD=0.0684P PS=0.745U PD=0.74U
* device instance $1443 r0 *1 74.305,67.555 sky130_fd_pr__nfet_01v8
M$1443 94 1176 1205 1205 sky130_fd_pr__nfet_01v8 L=0.15U W=0.42U AS=0.066P
+ AD=0.1092P PS=0.745U PD=1.36U
* device instance $1444 r0 *1 75.245,67.555 sky130_fd_pr__nfet_01v8
M$1444 1176 1175 94 94 sky130_fd_pr__nfet_01v8 L=0.15U W=0.42U AS=0.10025P
+ AD=0.1092P PS=0.985U PD=1.36U
* device instance $1445 r0 *1 75.73,67.44 sky130_fd_pr__nfet_01v8
M$1445 1123 1175 94 94 sky130_fd_pr__nfet_01v8 L=0.15U W=0.65U AS=0.10025P
+ AD=0.182P PS=0.985U PD=1.86U
* device instance $1446 r0 *1 5.555,68.56 sky130_fd_pr__nfet_01v8
M$1446 1263 1198 94 94 sky130_fd_pr__nfet_01v8 L=0.15U W=0.65U AS=0.18525P
+ AD=0.089375P PS=1.87U PD=0.925U
* device instance $1447 r0 *1 5.98,68.56 sky130_fd_pr__nfet_01v8
M$1447 1144 1148 1263 1263 sky130_fd_pr__nfet_01v8 L=0.15U W=0.65U AS=0.089375P
+ AD=0.091P PS=0.925U PD=0.93U
* device instance $1448 r0 *1 6.41,68.56 sky130_fd_pr__nfet_01v8
M$1448 1266 1148 1144 1144 sky130_fd_pr__nfet_01v8 L=0.15U W=0.65U AS=0.091P
+ AD=0.06825P PS=0.93U PD=0.86U
* device instance $1449 r0 *1 6.77,68.56 sky130_fd_pr__nfet_01v8
M$1449 94 1198 1266 1266 sky130_fd_pr__nfet_01v8 L=0.15U W=0.65U AS=0.06825P
+ AD=0.10725P PS=0.86U PD=0.98U
* device instance $1450 r0 *1 7.25,68.56 sky130_fd_pr__nfet_01v8
M$1450 1144 1117 94 94 sky130_fd_pr__nfet_01v8 L=0.15U W=1.3U AS=0.195P
+ AD=0.34775P PS=1.9U PD=3.02U
* device instance $1452 r0 *1 8.75,68.445 sky130_fd_pr__nfet_01v8
M$1452 94 937 1228 1228 sky130_fd_pr__nfet_01v8 L=0.15U W=0.42U AS=0.1092P
+ AD=0.0567P PS=1.36U PD=0.69U
* device instance $1453 r0 *1 9.17,68.445 sky130_fd_pr__nfet_01v8
M$1453 1229 1228 94 94 sky130_fd_pr__nfet_01v8 L=0.15U W=0.42U AS=0.0567P
+ AD=0.1092P PS=0.69U PD=1.36U
* device instance $1454 r0 *1 10.67,68.415 sky130_fd_pr__nfet_01v8
M$1454 1231 1228 1230 1230 sky130_fd_pr__nfet_01v8 L=0.15U W=0.36U AS=0.0813P
+ AD=0.0621P PS=0.83U PD=0.705U
* device instance $1455 r0 *1 11.165,68.415 sky130_fd_pr__nfet_01v8
M$1455 1268 1229 1231 1231 sky130_fd_pr__nfet_01v8 L=0.15U W=0.36U AS=0.0621P
+ AD=0.0696P PS=0.705U PD=0.765U
* device instance $1456 r0 *1 12.76,68.415 sky130_fd_pr__nfet_01v8
M$1456 1233 1229 1232 1232 sky130_fd_pr__nfet_01v8 L=0.15U W=0.36U AS=0.0989P
+ AD=0.0684P PS=0.995U PD=0.74U
* device instance $1457 r0 *1 13.29,68.415 sky130_fd_pr__nfet_01v8
M$1457 1270 1228 1233 1233 sky130_fd_pr__nfet_01v8 L=0.15U W=0.36U AS=0.0684P
+ AD=0.066P PS=0.74U PD=0.745U
* device instance $1458 r0 *1 10.11,68.445 sky130_fd_pr__nfet_01v8
M$1458 1230 1145 94 94 sky130_fd_pr__nfet_01v8 L=0.15U W=0.42U AS=0.1092P
+ AD=0.0813P PS=1.36U PD=0.83U
* device instance $1459 r0 *1 11.66,68.445 sky130_fd_pr__nfet_01v8
M$1459 94 1232 1268 1268 sky130_fd_pr__nfet_01v8 L=0.15U W=0.42U AS=0.0696P
+ AD=0.12095P PS=0.765U PD=1.085U
* device instance $1460 r0 *1 13.765,68.445 sky130_fd_pr__nfet_01v8
M$1460 94 1234 1270 1270 sky130_fd_pr__nfet_01v8 L=0.15U W=0.42U AS=0.066P
+ AD=0.1092P PS=0.745U PD=1.36U
* device instance $1461 r0 *1 12.255,68.555 sky130_fd_pr__nfet_01v8
M$1461 1232 1231 94 94 sky130_fd_pr__nfet_01v8 L=0.15U W=0.64U AS=0.12095P
+ AD=0.0989P PS=1.085U PD=0.995U
* device instance $1462 r0 *1 14.71,68.56 sky130_fd_pr__nfet_01v8
M$1462 94 1233 1234 1234 sky130_fd_pr__nfet_01v8 L=0.15U W=0.65U AS=0.169P
+ AD=0.08775P PS=1.82U PD=0.92U
* device instance $1463 r0 *1 15.13,68.56 sky130_fd_pr__nfet_01v8
M$1463 1147 1234 94 94 sky130_fd_pr__nfet_01v8 L=0.15U W=0.65U AS=0.08775P
+ AD=0.169P PS=0.92U PD=1.82U
* device instance $1464 r0 *1 22.09,68.445 sky130_fd_pr__nfet_01v8
M$1464 94 937 1235 1235 sky130_fd_pr__nfet_01v8 L=0.15U W=0.42U AS=0.1092P
+ AD=0.0567P PS=1.36U PD=0.69U
* device instance $1465 r0 *1 22.51,68.445 sky130_fd_pr__nfet_01v8
M$1465 1236 1235 94 94 sky130_fd_pr__nfet_01v8 L=0.15U W=0.42U AS=0.0567P
+ AD=0.1092P PS=0.69U PD=1.36U
* device instance $1466 r0 *1 23.45,68.445 sky130_fd_pr__nfet_01v8
M$1466 1273 1255 1237 1237 sky130_fd_pr__nfet_01v8 L=0.15U W=0.42U AS=0.1092P
+ AD=0.0441P PS=1.36U PD=0.63U
* device instance $1467 r0 *1 23.81,68.445 sky130_fd_pr__nfet_01v8
M$1467 94 1102 1273 1273 sky130_fd_pr__nfet_01v8 L=0.15U W=0.42U AS=0.0441P
+ AD=0.1092P PS=0.63U PD=1.36U
* device instance $1468 r0 *1 26.61,68.415 sky130_fd_pr__nfet_01v8
M$1468 1239 1235 1237 1237 sky130_fd_pr__nfet_01v8 L=0.15U W=0.36U AS=0.1446P
+ AD=0.0522P PS=1.18U PD=0.65U
* device instance $1469 r0 *1 27.05,68.415 sky130_fd_pr__nfet_01v8
M$1469 1276 1236 1239 1239 sky130_fd_pr__nfet_01v8 L=0.15U W=0.36U AS=0.0522P
+ AD=0.0759P PS=0.65U PD=0.8U
* device instance $1470 r0 *1 24.75,68.445 sky130_fd_pr__nfet_01v8
M$1470 94 1102 1238 1238 sky130_fd_pr__nfet_01v8 L=0.15U W=0.42U AS=0.1092P
+ AD=0.0609P PS=1.36U PD=0.71U
* device instance $1471 r0 *1 25.19,68.445 sky130_fd_pr__nfet_01v8
M$1471 1274 1238 94 94 sky130_fd_pr__nfet_01v8 L=0.15U W=0.42U AS=0.0609P
+ AD=0.0756P PS=0.71U PD=0.78U
* device instance $1472 r0 *1 25.7,68.445 sky130_fd_pr__nfet_01v8
M$1472 1237 1256 1274 1274 sky130_fd_pr__nfet_01v8 L=0.15U W=0.42U AS=0.0756P
+ AD=0.1446P PS=0.78U PD=1.18U
* device instance $1473 r0 *1 27.58,68.445 sky130_fd_pr__nfet_01v8
M$1473 94 1240 1276 1276 sky130_fd_pr__nfet_01v8 L=0.15U W=0.42U AS=0.0759P
+ AD=0.12095P PS=0.8U PD=1.085U
* device instance $1474 r0 *1 28.175,68.555 sky130_fd_pr__nfet_01v8
M$1474 1240 1239 94 94 sky130_fd_pr__nfet_01v8 L=0.15U W=0.64U AS=0.12095P
+ AD=0.1664P PS=1.085U PD=1.8U
* device instance $1475 r0 *1 29.6,68.415 sky130_fd_pr__nfet_01v8
M$1475 1241 1236 1279 1279 sky130_fd_pr__nfet_01v8 L=0.15U W=0.36U AS=0.0678P
+ AD=0.0684P PS=0.755U PD=0.74U
* device instance $1476 r0 *1 30.13,68.415 sky130_fd_pr__nfet_01v8
M$1476 1280 1235 1241 1241 sky130_fd_pr__nfet_01v8 L=0.15U W=0.36U AS=0.0684P
+ AD=0.066P PS=0.74U PD=0.745U
* device instance $1477 r0 *1 29.115,68.445 sky130_fd_pr__nfet_01v8
M$1477 1279 1240 94 94 sky130_fd_pr__nfet_01v8 L=0.15U W=0.42U AS=0.1092P
+ AD=0.0678P PS=1.36U PD=0.755U
* device instance $1478 r0 *1 30.605,68.445 sky130_fd_pr__nfet_01v8
M$1478 94 1256 1280 1280 sky130_fd_pr__nfet_01v8 L=0.15U W=0.42U AS=0.066P
+ AD=0.1092P PS=0.745U PD=1.36U
* device instance $1479 r0 *1 31.545,68.445 sky130_fd_pr__nfet_01v8
M$1479 94 1241 1256 1256 sky130_fd_pr__nfet_01v8 L=0.15U W=0.42U AS=0.1092P
+ AD=0.10025P PS=1.36U PD=0.985U
* device instance $1480 r0 *1 32.03,68.56 sky130_fd_pr__nfet_01v8
M$1480 875 1241 94 94 sky130_fd_pr__nfet_01v8 L=0.15U W=0.65U AS=0.10025P
+ AD=0.182P PS=0.985U PD=1.86U
* device instance $1481 r0 *1 33.13,68.56 sky130_fd_pr__nfet_01v8
M$1481 94 997 1257 1257 sky130_fd_pr__nfet_01v8 L=0.15U W=0.65U AS=0.169P
+ AD=0.08775P PS=1.82U PD=0.92U
* device instance $1482 r0 *1 33.55,68.56 sky130_fd_pr__nfet_01v8
M$1482 1286 1257 94 94 sky130_fd_pr__nfet_01v8 L=0.15U W=2.6U AS=0.351P
+ AD=0.43225P PS=3.68U PD=4.58U
* device instance $1486 r0 *1 35.91,68.56 sky130_fd_pr__nfet_01v8
M$1486 1283 1258 94 94 sky130_fd_pr__nfet_01v8 L=0.15U W=0.65U AS=0.169P
+ AD=0.08775P PS=1.82U PD=0.92U
* device instance $1487 r0 *1 36.33,68.56 sky130_fd_pr__nfet_01v8
M$1487 1242 71 1283 1283 sky130_fd_pr__nfet_01v8 L=0.15U W=0.65U AS=0.08775P
+ AD=0.169P PS=0.92U PD=1.82U
* device instance $1488 r0 *1 41.94,68.445 sky130_fd_pr__nfet_01v8
M$1488 1284 1287 1243 1243 sky130_fd_pr__nfet_01v8 L=0.15U W=0.42U AS=0.1113P
+ AD=0.0441P PS=1.37U PD=0.63U
* device instance $1489 r0 *1 42.3,68.445 sky130_fd_pr__nfet_01v8
M$1489 94 109 1284 1284 sky130_fd_pr__nfet_01v8 L=0.15U W=0.42U AS=0.0441P
+ AD=0.0966P PS=0.63U PD=0.88U
* device instance $1490 r0 *1 42.91,68.445 sky130_fd_pr__nfet_01v8
M$1490 1200 1243 94 94 sky130_fd_pr__nfet_01v8 L=0.15U W=0.42U AS=0.0966P
+ AD=0.1113P PS=0.88U PD=1.37U
* device instance $1491 r0 *1 44.63,68.445 sky130_fd_pr__nfet_01v8
M$1491 94 844 1244 1244 sky130_fd_pr__nfet_01v8 L=0.15U W=0.42U AS=0.1092P
+ AD=0.0567P PS=1.36U PD=0.69U
* device instance $1492 r0 *1 45.05,68.445 sky130_fd_pr__nfet_01v8
M$1492 1245 1244 94 94 sky130_fd_pr__nfet_01v8 L=0.15U W=0.42U AS=0.0567P
+ AD=0.1092P PS=0.69U PD=1.36U
* device instance $1493 r0 *1 45.99,68.445 sky130_fd_pr__nfet_01v8
M$1493 1282 1156 1246 1246 sky130_fd_pr__nfet_01v8 L=0.15U W=0.42U AS=0.1092P
+ AD=0.0441P PS=1.36U PD=0.63U
* device instance $1494 r0 *1 46.35,68.445 sky130_fd_pr__nfet_01v8
M$1494 94 315 1282 1282 sky130_fd_pr__nfet_01v8 L=0.15U W=0.42U AS=0.0441P
+ AD=0.1092P PS=0.63U PD=1.36U
* device instance $1495 r0 *1 49.15,68.415 sky130_fd_pr__nfet_01v8
M$1495 1248 1244 1246 1246 sky130_fd_pr__nfet_01v8 L=0.15U W=0.36U AS=0.1446P
+ AD=0.0522P PS=1.18U PD=0.65U
* device instance $1496 r0 *1 49.59,68.415 sky130_fd_pr__nfet_01v8
M$1496 1278 1245 1248 1248 sky130_fd_pr__nfet_01v8 L=0.15U W=0.36U AS=0.0522P
+ AD=0.0759P PS=0.65U PD=0.8U
* device instance $1497 r0 *1 47.29,68.445 sky130_fd_pr__nfet_01v8
M$1497 94 315 1247 1247 sky130_fd_pr__nfet_01v8 L=0.15U W=0.42U AS=0.1092P
+ AD=0.0609P PS=1.36U PD=0.71U
* device instance $1498 r0 *1 47.73,68.445 sky130_fd_pr__nfet_01v8
M$1498 1281 1247 94 94 sky130_fd_pr__nfet_01v8 L=0.15U W=0.42U AS=0.0609P
+ AD=0.0756P PS=0.71U PD=0.78U
* device instance $1499 r0 *1 48.24,68.445 sky130_fd_pr__nfet_01v8
M$1499 1246 1259 1281 1281 sky130_fd_pr__nfet_01v8 L=0.15U W=0.42U AS=0.0756P
+ AD=0.1446P PS=0.78U PD=1.18U
* device instance $1500 r0 *1 50.12,68.445 sky130_fd_pr__nfet_01v8
M$1500 94 1249 1278 1278 sky130_fd_pr__nfet_01v8 L=0.15U W=0.42U AS=0.0759P
+ AD=0.12095P PS=0.8U PD=1.085U
* device instance $1501 r0 *1 50.715,68.555 sky130_fd_pr__nfet_01v8
M$1501 1249 1248 94 94 sky130_fd_pr__nfet_01v8 L=0.15U W=0.64U AS=0.12095P
+ AD=0.1664P PS=1.085U PD=1.8U
* device instance $1502 r0 *1 52.14,68.415 sky130_fd_pr__nfet_01v8
M$1502 1250 1245 1277 1277 sky130_fd_pr__nfet_01v8 L=0.15U W=0.36U AS=0.0678P
+ AD=0.0684P PS=0.755U PD=0.74U
* device instance $1503 r0 *1 52.67,68.415 sky130_fd_pr__nfet_01v8
M$1503 1275 1244 1250 1250 sky130_fd_pr__nfet_01v8 L=0.15U W=0.36U AS=0.0684P
+ AD=0.066P PS=0.74U PD=0.745U
* device instance $1504 r0 *1 51.655,68.445 sky130_fd_pr__nfet_01v8
M$1504 1277 1249 94 94 sky130_fd_pr__nfet_01v8 L=0.15U W=0.42U AS=0.1092P
+ AD=0.0678P PS=1.36U PD=0.755U
* device instance $1505 r0 *1 53.145,68.445 sky130_fd_pr__nfet_01v8
M$1505 94 1259 1275 1275 sky130_fd_pr__nfet_01v8 L=0.15U W=0.42U AS=0.066P
+ AD=0.1092P PS=0.745U PD=1.36U
* device instance $1506 r0 *1 54.085,68.445 sky130_fd_pr__nfet_01v8
M$1506 94 1250 1259 1259 sky130_fd_pr__nfet_01v8 L=0.15U W=0.42U AS=0.1092P
+ AD=0.10025P PS=1.36U PD=0.985U
* device instance $1507 r0 *1 54.57,68.56 sky130_fd_pr__nfet_01v8
M$1507 1121 1250 94 94 sky130_fd_pr__nfet_01v8 L=0.15U W=0.65U AS=0.10025P
+ AD=0.182P PS=0.985U PD=1.86U
* device instance $1508 r0 *1 57.12,68.445 sky130_fd_pr__nfet_01v8
M$1508 1272 1288 1251 1251 sky130_fd_pr__nfet_01v8 L=0.15U W=0.42U AS=0.1113P
+ AD=0.0441P PS=1.37U PD=0.63U
* device instance $1509 r0 *1 57.48,68.445 sky130_fd_pr__nfet_01v8
M$1509 94 109 1272 1272 sky130_fd_pr__nfet_01v8 L=0.15U W=0.42U AS=0.0441P
+ AD=0.0966P PS=0.63U PD=0.88U
* device instance $1510 r0 *1 58.09,68.445 sky130_fd_pr__nfet_01v8
M$1510 1026 1251 94 94 sky130_fd_pr__nfet_01v8 L=0.15U W=0.42U AS=0.0966P
+ AD=0.1113P PS=0.88U PD=1.37U
* device instance $1511 r0 *1 60.27,68.56 sky130_fd_pr__nfet_01v8
M$1511 94 1260 1252 1252 sky130_fd_pr__nfet_01v8 L=0.15U W=0.65U AS=0.169P
+ AD=0.10725P PS=1.82U PD=0.98U
* device instance $1512 r0 *1 60.75,68.56 sky130_fd_pr__nfet_01v8
M$1512 1271 1261 94 94 sky130_fd_pr__nfet_01v8 L=0.15U W=0.65U AS=0.10725P
+ AD=0.06825P PS=0.98U PD=0.86U
* device instance $1513 r0 *1 61.11,68.56 sky130_fd_pr__nfet_01v8
M$1513 1252 91 1271 1271 sky130_fd_pr__nfet_01v8 L=0.15U W=0.65U AS=0.06825P
+ AD=0.169P PS=0.86U PD=1.82U
* device instance $1514 r0 *1 62.05,68.56 sky130_fd_pr__nfet_01v8
M$1514 1269 1017 1252 1252 sky130_fd_pr__nfet_01v8 L=0.15U W=0.65U AS=0.169P
+ AD=0.10725P PS=1.82U PD=0.98U
* device instance $1515 r0 *1 62.53,68.56 sky130_fd_pr__nfet_01v8
M$1515 94 1184 1269 1269 sky130_fd_pr__nfet_01v8 L=0.15U W=0.65U AS=0.10725P
+ AD=0.102375P PS=0.98U PD=0.965U
* device instance $1516 r0 *1 62.995,68.56 sky130_fd_pr__nfet_01v8
M$1516 1290 1252 94 94 sky130_fd_pr__nfet_01v8 L=0.15U W=0.65U AS=0.102375P
+ AD=0.169P PS=0.965U PD=1.82U
* device instance $1517 r0 *1 63.95,68.675 sky130_fd_pr__nfet_01v8
M$1517 1262 1123 94 94 sky130_fd_pr__nfet_01v8 L=0.15U W=0.42U AS=0.10025P
+ AD=0.1092P PS=0.985U PD=1.36U
* device instance $1518 r0 *1 64.435,68.56 sky130_fd_pr__nfet_01v8
M$1518 1267 1122 94 94 sky130_fd_pr__nfet_01v8 L=0.15U W=0.65U AS=0.10025P
+ AD=0.08775P PS=0.985U PD=0.92U
* device instance $1519 r0 *1 64.855,68.56 sky130_fd_pr__nfet_01v8
M$1519 1021 1262 1267 1267 sky130_fd_pr__nfet_01v8 L=0.15U W=0.65U AS=0.08775P
+ AD=0.169P PS=0.92U PD=1.82U
* device instance $1520 r0 *1 68.175,68.445 sky130_fd_pr__nfet_01v8
M$1520 1265 71 94 94 sky130_fd_pr__nfet_01v8 L=0.15U W=0.42U AS=0.11285P
+ AD=0.0693P PS=1.045U PD=0.75U
* device instance $1521 r0 *1 68.655,68.445 sky130_fd_pr__nfet_01v8
M$1521 1253 1291 1265 1265 sky130_fd_pr__nfet_01v8 L=0.15U W=0.42U AS=0.0693P
+ AD=0.09975P PS=0.75U PD=0.895U
* device instance $1522 r0 *1 69.28,68.445 sky130_fd_pr__nfet_01v8
M$1522 1264 1122 1253 1253 sky130_fd_pr__nfet_01v8 L=0.15U W=0.42U AS=0.09975P
+ AD=0.0693P PS=0.895U PD=0.75U
* device instance $1523 r0 *1 69.76,68.445 sky130_fd_pr__nfet_01v8
M$1523 94 1254 1264 1264 sky130_fd_pr__nfet_01v8 L=0.15U W=0.42U AS=0.0693P
+ AD=0.1449P PS=0.75U PD=1.11U
* device instance $1524 r0 *1 70.6,68.445 sky130_fd_pr__nfet_01v8
M$1524 1254 71 94 94 sky130_fd_pr__nfet_01v8 L=0.15U W=0.42U AS=0.1449P
+ AD=0.1092P PS=1.11U PD=1.36U
* device instance $1525 r0 *1 67.63,68.56 sky130_fd_pr__nfet_01v8
M$1525 94 1253 1201 1201 sky130_fd_pr__nfet_01v8 L=0.15U W=0.65U AS=0.169P
+ AD=0.11285P PS=1.82U PD=1.045U
* device instance $1526 r0 *1 8.29,72.995 sky130_fd_pr__nfet_01v8
M$1526 94 937 1307 1307 sky130_fd_pr__nfet_01v8 L=0.15U W=0.42U AS=0.1092P
+ AD=0.0567P PS=1.36U PD=0.69U
* device instance $1527 r0 *1 8.71,72.995 sky130_fd_pr__nfet_01v8
M$1527 1308 1307 94 94 sky130_fd_pr__nfet_01v8 L=0.15U W=0.42U AS=0.0567P
+ AD=0.1092P PS=0.69U PD=1.36U
* device instance $1528 r0 *1 9.65,72.995 sky130_fd_pr__nfet_01v8
M$1528 1309 1097 94 94 sky130_fd_pr__nfet_01v8 L=0.15U W=0.42U AS=0.1092P
+ AD=0.0813P PS=1.36U PD=0.83U
* device instance $1529 r0 *1 10.21,73.025 sky130_fd_pr__nfet_01v8
M$1529 1310 1307 1309 1309 sky130_fd_pr__nfet_01v8 L=0.15U W=0.36U AS=0.0813P
+ AD=0.0621P PS=0.83U PD=0.705U
* device instance $1530 r0 *1 10.705,73.025 sky130_fd_pr__nfet_01v8
M$1530 1310 1308 1341 1341 sky130_fd_pr__nfet_01v8 L=0.15U W=0.36U AS=0.0696P
+ AD=0.0621P PS=0.765U PD=0.705U
* device instance $1531 r0 *1 11.2,72.995 sky130_fd_pr__nfet_01v8
M$1531 1341 1311 94 94 sky130_fd_pr__nfet_01v8 L=0.15U W=0.42U AS=0.12095P
+ AD=0.0696P PS=1.085U PD=0.765U
* device instance $1532 r0 *1 11.795,72.885 sky130_fd_pr__nfet_01v8
M$1532 1311 1310 94 94 sky130_fd_pr__nfet_01v8 L=0.15U W=0.64U AS=0.12095P
+ AD=0.0989P PS=1.085U PD=0.995U
* device instance $1533 r0 *1 12.3,73.025 sky130_fd_pr__nfet_01v8
M$1533 1312 1308 1311 1311 sky130_fd_pr__nfet_01v8 L=0.15U W=0.36U AS=0.0989P
+ AD=0.0684P PS=0.995U PD=0.74U
* device instance $1534 r0 *1 12.83,73.025 sky130_fd_pr__nfet_01v8
M$1534 1312 1307 1342 1342 sky130_fd_pr__nfet_01v8 L=0.15U W=0.36U AS=0.066P
+ AD=0.0684P PS=0.745U PD=0.74U
* device instance $1535 r0 *1 13.305,72.995 sky130_fd_pr__nfet_01v8
M$1535 94 1313 1342 1342 sky130_fd_pr__nfet_01v8 L=0.15U W=0.42U AS=0.066P
+ AD=0.1092P PS=0.745U PD=1.36U
* device instance $1536 r0 *1 14.25,72.88 sky130_fd_pr__nfet_01v8
M$1536 94 1312 1313 1313 sky130_fd_pr__nfet_01v8 L=0.15U W=0.65U AS=0.169P
+ AD=0.08775P PS=1.82U PD=0.92U
* device instance $1537 r0 *1 14.67,72.88 sky130_fd_pr__nfet_01v8
M$1537 1119 1313 94 94 sky130_fd_pr__nfet_01v8 L=0.15U W=0.65U AS=0.08775P
+ AD=0.169P PS=0.92U PD=1.82U
* device instance $1538 r0 *1 26.23,72.88 sky130_fd_pr__nfet_01v8
M$1538 94 1314 1255 1255 sky130_fd_pr__nfet_01v8 L=0.15U W=0.65U AS=0.169P
+ AD=0.11285P PS=1.82U PD=1.045U
* device instance $1539 r0 *1 26.775,72.995 sky130_fd_pr__nfet_01v8
M$1539 1347 71 94 94 sky130_fd_pr__nfet_01v8 L=0.15U W=0.42U AS=0.11285P
+ AD=0.0693P PS=1.045U PD=0.75U
* device instance $1540 r0 *1 27.255,72.995 sky130_fd_pr__nfet_01v8
M$1540 1314 1330 1347 1347 sky130_fd_pr__nfet_01v8 L=0.15U W=0.42U AS=0.0693P
+ AD=0.09975P PS=0.75U PD=0.895U
* device instance $1541 r0 *1 27.88,72.995 sky130_fd_pr__nfet_01v8
M$1541 1348 996 1314 1314 sky130_fd_pr__nfet_01v8 L=0.15U W=0.42U AS=0.09975P
+ AD=0.0693P PS=0.895U PD=0.75U
* device instance $1542 r0 *1 28.36,72.995 sky130_fd_pr__nfet_01v8
M$1542 94 1339 1348 1348 sky130_fd_pr__nfet_01v8 L=0.15U W=0.42U AS=0.0693P
+ AD=0.1449P PS=0.75U PD=1.11U
* device instance $1543 r0 *1 29.2,72.995 sky130_fd_pr__nfet_01v8
M$1543 1339 71 94 94 sky130_fd_pr__nfet_01v8 L=0.15U W=0.42U AS=0.1449P
+ AD=0.1092P PS=1.11U PD=1.36U
* device instance $1544 r0 *1 44.63,72.88 sky130_fd_pr__nfet_01v8
M$1544 94 1315 1183 1183 sky130_fd_pr__nfet_01v8 L=0.15U W=0.65U AS=0.169P
+ AD=0.11285P PS=1.82U PD=1.045U
* device instance $1545 r0 *1 45.175,72.995 sky130_fd_pr__nfet_01v8
M$1545 1351 71 94 94 sky130_fd_pr__nfet_01v8 L=0.15U W=0.42U AS=0.11285P
+ AD=0.0693P PS=1.045U PD=0.75U
* device instance $1546 r0 *1 45.655,72.995 sky130_fd_pr__nfet_01v8
M$1546 1315 1331 1351 1351 sky130_fd_pr__nfet_01v8 L=0.15U W=0.42U AS=0.0693P
+ AD=0.09975P PS=0.75U PD=0.895U
* device instance $1547 r0 *1 46.28,72.995 sky130_fd_pr__nfet_01v8
M$1547 1352 1121 1315 1315 sky130_fd_pr__nfet_01v8 L=0.15U W=0.42U AS=0.09975P
+ AD=0.0693P PS=0.895U PD=0.75U
* device instance $1548 r0 *1 46.76,72.995 sky130_fd_pr__nfet_01v8
M$1548 94 1340 1352 1352 sky130_fd_pr__nfet_01v8 L=0.15U W=0.42U AS=0.0693P
+ AD=0.1449P PS=0.75U PD=1.11U
* device instance $1549 r0 *1 47.6,72.995 sky130_fd_pr__nfet_01v8
M$1549 1340 71 94 94 sky130_fd_pr__nfet_01v8 L=0.15U W=0.42U AS=0.1449P
+ AD=0.1092P PS=1.11U PD=1.36U
* device instance $1550 r0 *1 58.5,72.995 sky130_fd_pr__nfet_01v8
M$1550 1350 1332 1316 1316 sky130_fd_pr__nfet_01v8 L=0.15U W=0.42U AS=0.1113P
+ AD=0.0441P PS=1.37U PD=0.63U
* device instance $1551 r0 *1 58.86,72.995 sky130_fd_pr__nfet_01v8
M$1551 94 109 1350 1350 sky130_fd_pr__nfet_01v8 L=0.15U W=0.42U AS=0.0441P
+ AD=0.0966P PS=0.63U PD=0.88U
* device instance $1552 r0 *1 59.47,72.995 sky130_fd_pr__nfet_01v8
M$1552 1260 1316 94 94 sky130_fd_pr__nfet_01v8 L=0.15U W=0.42U AS=0.0966P
+ AD=0.1113P PS=0.88U PD=1.37U
* device instance $1553 r0 *1 60.73,72.995 sky130_fd_pr__nfet_01v8
M$1553 94 844 1317 1317 sky130_fd_pr__nfet_01v8 L=0.15U W=0.42U AS=0.1092P
+ AD=0.0567P PS=1.36U PD=0.69U
* device instance $1554 r0 *1 61.15,72.995 sky130_fd_pr__nfet_01v8
M$1554 1318 1317 94 94 sky130_fd_pr__nfet_01v8 L=0.15U W=0.42U AS=0.0567P
+ AD=0.1092P PS=0.69U PD=1.36U
* device instance $1555 r0 *1 62.09,72.995 sky130_fd_pr__nfet_01v8
M$1555 1349 1290 1319 1319 sky130_fd_pr__nfet_01v8 L=0.15U W=0.42U AS=0.1092P
+ AD=0.0441P PS=1.36U PD=0.63U
* device instance $1556 r0 *1 62.45,72.995 sky130_fd_pr__nfet_01v8
M$1556 94 315 1349 1349 sky130_fd_pr__nfet_01v8 L=0.15U W=0.42U AS=0.0441P
+ AD=0.1092P PS=0.63U PD=1.36U
* device instance $1557 r0 *1 63.39,72.995 sky130_fd_pr__nfet_01v8
M$1557 94 315 1320 1320 sky130_fd_pr__nfet_01v8 L=0.15U W=0.42U AS=0.1092P
+ AD=0.0609P PS=1.36U PD=0.71U
* device instance $1558 r0 *1 63.83,72.995 sky130_fd_pr__nfet_01v8
M$1558 1346 1320 94 94 sky130_fd_pr__nfet_01v8 L=0.15U W=0.42U AS=0.0609P
+ AD=0.0756P PS=0.71U PD=0.78U
* device instance $1559 r0 *1 64.34,72.995 sky130_fd_pr__nfet_01v8
M$1559 1319 1324 1346 1346 sky130_fd_pr__nfet_01v8 L=0.15U W=0.42U AS=0.0756P
+ AD=0.1446P PS=0.78U PD=1.18U
* device instance $1560 r0 *1 65.25,73.025 sky130_fd_pr__nfet_01v8
M$1560 1321 1317 1319 1319 sky130_fd_pr__nfet_01v8 L=0.15U W=0.36U AS=0.1446P
+ AD=0.0522P PS=1.18U PD=0.65U
* device instance $1561 r0 *1 65.69,73.025 sky130_fd_pr__nfet_01v8
M$1561 1321 1318 1345 1345 sky130_fd_pr__nfet_01v8 L=0.15U W=0.36U AS=0.0759P
+ AD=0.0522P PS=0.8U PD=0.65U
* device instance $1562 r0 *1 66.22,72.995 sky130_fd_pr__nfet_01v8
M$1562 1345 1322 94 94 sky130_fd_pr__nfet_01v8 L=0.15U W=0.42U AS=0.12095P
+ AD=0.0759P PS=1.085U PD=0.8U
* device instance $1563 r0 *1 66.815,72.885 sky130_fd_pr__nfet_01v8
M$1563 1322 1321 94 94 sky130_fd_pr__nfet_01v8 L=0.15U W=0.64U AS=0.12095P
+ AD=0.1664P PS=1.085U PD=1.8U
* device instance $1564 r0 *1 65.79,74 sky130_fd_pr__nfet_01v8
M$1564 94 1123 1353 1353 sky130_fd_pr__nfet_01v8 L=0.15U W=0.65U AS=0.169P
+ AD=0.08775P PS=1.82U PD=0.92U
* device instance $1565 r0 *1 66.21,74 sky130_fd_pr__nfet_01v8
M$1565 1261 1353 94 94 sky130_fd_pr__nfet_01v8 L=0.15U W=2.6U AS=0.351P
+ AD=0.43225P PS=3.68U PD=4.58U
* device instance $1569 r0 *1 67.755,72.995 sky130_fd_pr__nfet_01v8
M$1569 1344 1322 94 94 sky130_fd_pr__nfet_01v8 L=0.15U W=0.42U AS=0.1092P
+ AD=0.0678P PS=1.36U PD=0.755U
* device instance $1570 r0 *1 68.24,73.025 sky130_fd_pr__nfet_01v8
M$1570 1323 1318 1344 1344 sky130_fd_pr__nfet_01v8 L=0.15U W=0.36U AS=0.0678P
+ AD=0.0684P PS=0.755U PD=0.74U
* device instance $1571 r0 *1 68.77,73.025 sky130_fd_pr__nfet_01v8
M$1571 1323 1317 1343 1343 sky130_fd_pr__nfet_01v8 L=0.15U W=0.36U AS=0.066P
+ AD=0.0684P PS=0.745U PD=0.74U
* device instance $1572 r0 *1 69.245,72.995 sky130_fd_pr__nfet_01v8
M$1572 94 1324 1343 1343 sky130_fd_pr__nfet_01v8 L=0.15U W=0.42U AS=0.066P
+ AD=0.1092P PS=0.745U PD=1.36U
* device instance $1573 r0 *1 70.185,72.995 sky130_fd_pr__nfet_01v8
M$1573 1324 1323 94 94 sky130_fd_pr__nfet_01v8 L=0.15U W=0.42U AS=0.10025P
+ AD=0.1092P PS=0.985U PD=1.36U
* device instance $1574 r0 *1 70.67,72.88 sky130_fd_pr__nfet_01v8
M$1574 1122 1323 94 94 sky130_fd_pr__nfet_01v8 L=0.15U W=0.65U AS=0.10025P
+ AD=0.182P PS=0.985U PD=1.86U
* device instance $1575 r0 *1 14.525,4.885 sky130_fd_pr__pfet_01v8
M$1575 10 11 167 167 sky130_fd_pr__pfet_01v8 L=0.15U W=0.64U AS=0.154P
+ AD=0.1728P PS=1.335U PD=1.82U
* device instance $1576 r0 *1 15.01,4.705 sky130_fd_pr__pfet_01v8
M$1576 12 11 167 167 sky130_fd_pr__pfet_01v8 L=0.15U W=1U AS=0.154P AD=0.28P
+ PS=1.335U PD=2.56U
* device instance $1577 r0 *1 70.185,4.885 sky130_fd_pr__pfet_01v8
M$1577 18 19 167 167 sky130_fd_pr__pfet_01v8 L=0.15U W=0.64U AS=0.154P
+ AD=0.1728P PS=1.335U PD=1.82U
* device instance $1578 r0 *1 70.67,4.705 sky130_fd_pr__pfet_01v8
M$1578 20 19 167 167 sky130_fd_pr__pfet_01v8 L=0.15U W=1U AS=0.154P AD=0.28P
+ PS=1.335U PD=2.56U
* device instance $1579 r0 *1 5.07,4.855 sky130_fd_pr__pfet_01v8
M$1579 167 31 6 6 sky130_fd_pr__pfet_01v8 L=0.15U W=0.64U AS=0.1664P AD=0.0864P
+ PS=1.8U PD=0.91U
* device instance $1580 r0 *1 5.49,4.855 sky130_fd_pr__pfet_01v8
M$1580 7 6 167 167 sky130_fd_pr__pfet_01v8 L=0.15U W=0.64U AS=0.0864P
+ AD=0.1664P PS=0.91U PD=1.8U
* device instance $1581 r0 *1 6.43,4.885 sky130_fd_pr__pfet_01v8
M$1581 33 32 8 8 sky130_fd_pr__pfet_01v8 L=0.15U W=0.64U AS=0.1664P AD=0.0672P
+ PS=1.8U PD=0.85U
* device instance $1582 r0 *1 6.79,4.885 sky130_fd_pr__pfet_01v8
M$1582 167 9 33 33 sky130_fd_pr__pfet_01v8 L=0.15U W=0.64U AS=0.0672P
+ AD=0.1664P PS=0.85U PD=1.8U
* device instance $1583 r0 *1 7.73,4.885 sky130_fd_pr__pfet_01v8
M$1583 167 90 9 9 sky130_fd_pr__pfet_01v8 L=0.15U W=0.64U AS=0.1664P AD=0.0928P
+ PS=1.8U PD=0.93U
* device instance $1584 r0 *1 8.17,4.885 sky130_fd_pr__pfet_01v8
M$1584 34 90 167 167 sky130_fd_pr__pfet_01v8 L=0.15U W=0.64U AS=0.0928P
+ AD=0.1152P PS=0.93U PD=1U
* device instance $1585 r0 *1 8.68,4.885 sky130_fd_pr__pfet_01v8
M$1585 8 10 34 34 sky130_fd_pr__pfet_01v8 L=0.15U W=0.64U AS=0.1152P
+ AD=0.15985P PS=1U PD=1.265U
* device instance $1586 r0 *1 9.455,4.995 sky130_fd_pr__pfet_01v8
M$1586 2 7 8 8 sky130_fd_pr__pfet_01v8 L=0.15U W=0.42U AS=0.15985P AD=0.06405P
+ PS=1.265U PD=0.725U
* device instance $1587 r0 *1 9.91,4.995 sky130_fd_pr__pfet_01v8
M$1587 36 6 2 2 sky130_fd_pr__pfet_01v8 L=0.15U W=0.42U AS=0.06405P AD=0.07665P
+ PS=0.725U PD=0.785U
* device instance $1588 r0 *1 10.425,4.995 sky130_fd_pr__pfet_01v8
M$1588 36 3 167 167 sky130_fd_pr__pfet_01v8 L=0.15U W=0.42U AS=0.178875P
+ AD=0.07665P PS=1.26U PD=0.785U
* device instance $1589 r0 *1 11.085,4.83 sky130_fd_pr__pfet_01v8
M$1589 3 2 167 167 sky130_fd_pr__pfet_01v8 L=0.15U W=0.75U AS=0.178875P
+ AD=0.195P PS=1.26U PD=2.02U
* device instance $1590 r0 *1 60.73,4.855 sky130_fd_pr__pfet_01v8
M$1590 167 329 13 13 sky130_fd_pr__pfet_01v8 L=0.15U W=0.64U AS=0.1664P
+ AD=0.0864P PS=1.8U PD=0.91U
* device instance $1591 r0 *1 61.15,4.855 sky130_fd_pr__pfet_01v8
M$1591 15 13 167 167 sky130_fd_pr__pfet_01v8 L=0.15U W=0.64U AS=0.0864P
+ AD=0.1664P PS=0.91U PD=1.8U
* device instance $1592 r0 *1 62.09,4.885 sky130_fd_pr__pfet_01v8
M$1592 42 14 16 16 sky130_fd_pr__pfet_01v8 L=0.15U W=0.64U AS=0.1664P
+ AD=0.0672P PS=1.8U PD=0.85U
* device instance $1593 r0 *1 62.45,4.885 sky130_fd_pr__pfet_01v8
M$1593 167 17 42 42 sky130_fd_pr__pfet_01v8 L=0.15U W=0.64U AS=0.0672P
+ AD=0.1664P PS=0.85U PD=1.8U
* device instance $1594 r0 *1 63.39,4.885 sky130_fd_pr__pfet_01v8
M$1594 167 315 17 17 sky130_fd_pr__pfet_01v8 L=0.15U W=0.64U AS=0.1664P
+ AD=0.0928P PS=1.8U PD=0.93U
* device instance $1595 r0 *1 63.83,4.885 sky130_fd_pr__pfet_01v8
M$1595 41 315 167 167 sky130_fd_pr__pfet_01v8 L=0.15U W=0.64U AS=0.0928P
+ AD=0.1152P PS=0.93U PD=1U
* device instance $1596 r0 *1 64.34,4.885 sky130_fd_pr__pfet_01v8
M$1596 16 18 41 41 sky130_fd_pr__pfet_01v8 L=0.15U W=0.64U AS=0.1152P
+ AD=0.15985P PS=1U PD=1.265U
* device instance $1597 r0 *1 65.115,4.995 sky130_fd_pr__pfet_01v8
M$1597 4 15 16 16 sky130_fd_pr__pfet_01v8 L=0.15U W=0.42U AS=0.15985P
+ AD=0.06405P PS=1.265U PD=0.725U
* device instance $1598 r0 *1 65.57,4.995 sky130_fd_pr__pfet_01v8
M$1598 39 13 4 4 sky130_fd_pr__pfet_01v8 L=0.15U W=0.42U AS=0.06405P
+ AD=0.07665P PS=0.725U PD=0.785U
* device instance $1599 r0 *1 66.085,4.995 sky130_fd_pr__pfet_01v8
M$1599 39 5 167 167 sky130_fd_pr__pfet_01v8 L=0.15U W=0.42U AS=0.178875P
+ AD=0.07665P PS=1.26U PD=0.785U
* device instance $1600 r0 *1 66.745,4.83 sky130_fd_pr__pfet_01v8
M$1600 5 4 167 167 sky130_fd_pr__pfet_01v8 L=0.15U W=0.75U AS=0.178875P
+ AD=0.195P PS=1.26U PD=2.02U
* device instance $1601 r0 *1 6.89,5.995 sky130_fd_pr__pfet_01v8
M$1601 75 65 45 45 sky130_fd_pr__pfet_01v8 L=0.15U W=0.64U AS=0.1664P
+ AD=0.0672P PS=1.8U PD=0.85U
* device instance $1602 r0 *1 7.25,5.995 sky130_fd_pr__pfet_01v8
M$1602 167 46 75 75 sky130_fd_pr__pfet_01v8 L=0.15U W=0.64U AS=0.0672P
+ AD=0.1664P PS=0.85U PD=1.8U
* device instance $1603 r0 *1 9.915,5.885 sky130_fd_pr__pfet_01v8
M$1603 47 44 45 45 sky130_fd_pr__pfet_01v8 L=0.15U W=0.42U AS=0.15985P
+ AD=0.06405P PS=1.265U PD=0.725U
* device instance $1604 r0 *1 10.37,5.885 sky130_fd_pr__pfet_01v8
M$1604 78 43 47 47 sky130_fd_pr__pfet_01v8 L=0.15U W=0.42U AS=0.06405P
+ AD=0.07665P PS=0.725U PD=0.785U
* device instance $1605 r0 *1 10.885,5.885 sky130_fd_pr__pfet_01v8
M$1605 167 48 78 78 sky130_fd_pr__pfet_01v8 L=0.15U W=0.42U AS=0.07665P
+ AD=0.178875P PS=0.785U PD=1.26U
* device instance $1606 r0 *1 8.19,5.995 sky130_fd_pr__pfet_01v8
M$1606 167 315 46 46 sky130_fd_pr__pfet_01v8 L=0.15U W=0.64U AS=0.1664P
+ AD=0.0928P PS=1.8U PD=0.93U
* device instance $1607 r0 *1 8.63,5.995 sky130_fd_pr__pfet_01v8
M$1607 76 315 167 167 sky130_fd_pr__pfet_01v8 L=0.15U W=0.64U AS=0.0928P
+ AD=0.1152P PS=0.93U PD=1U
* device instance $1608 r0 *1 9.14,5.995 sky130_fd_pr__pfet_01v8
M$1608 45 49 76 76 sky130_fd_pr__pfet_01v8 L=0.15U W=0.64U AS=0.1152P
+ AD=0.15985P PS=1U PD=1.265U
* device instance $1609 r0 *1 11.545,6.05 sky130_fd_pr__pfet_01v8
M$1609 48 47 167 167 sky130_fd_pr__pfet_01v8 L=0.15U W=0.75U AS=0.178875P
+ AD=0.195P PS=1.26U PD=2.02U
* device instance $1610 r0 *1 12.025,4.995 sky130_fd_pr__pfet_01v8
M$1610 38 3 167 167 sky130_fd_pr__pfet_01v8 L=0.15U W=0.42U AS=0.1092P
+ AD=0.06405P PS=1.36U PD=0.725U
* device instance $1611 r0 *1 12.48,4.995 sky130_fd_pr__pfet_01v8
M$1611 11 6 38 38 sky130_fd_pr__pfet_01v8 L=0.15U W=0.42U AS=0.06405P
+ AD=0.0567P PS=0.725U PD=0.69U
* device instance $1612 r0 *1 12.9,4.995 sky130_fd_pr__pfet_01v8
M$1612 40 7 11 11 sky130_fd_pr__pfet_01v8 L=0.15U W=0.42U AS=0.0567P AD=0.0882P
+ PS=0.69U PD=0.84U
* device instance $1613 r0 *1 13.47,4.995 sky130_fd_pr__pfet_01v8
M$1613 167 10 40 40 sky130_fd_pr__pfet_01v8 L=0.15U W=0.42U AS=0.0882P
+ AD=0.1113P PS=0.84U PD=1.37U
* device instance $1614 r0 *1 12.485,5.885 sky130_fd_pr__pfet_01v8
M$1614 80 48 167 167 sky130_fd_pr__pfet_01v8 L=0.15U W=0.42U AS=0.1092P
+ AD=0.06405P PS=1.36U PD=0.725U
* device instance $1615 r0 *1 12.94,5.885 sky130_fd_pr__pfet_01v8
M$1615 66 43 80 80 sky130_fd_pr__pfet_01v8 L=0.15U W=0.42U AS=0.06405P
+ AD=0.0567P PS=0.725U PD=0.69U
* device instance $1616 r0 *1 13.36,5.885 sky130_fd_pr__pfet_01v8
M$1616 81 44 66 66 sky130_fd_pr__pfet_01v8 L=0.15U W=0.42U AS=0.0567P
+ AD=0.0882P PS=0.69U PD=0.84U
* device instance $1617 r0 *1 13.93,5.885 sky130_fd_pr__pfet_01v8
M$1617 167 49 81 81 sky130_fd_pr__pfet_01v8 L=0.15U W=0.42U AS=0.0882P
+ AD=0.1113P PS=0.84U PD=1.37U
* device instance $1618 r0 *1 14.985,5.995 sky130_fd_pr__pfet_01v8
M$1618 167 66 49 49 sky130_fd_pr__pfet_01v8 L=0.15U W=0.64U AS=0.1728P
+ AD=0.154P PS=1.82U PD=1.335U
* device instance $1619 r0 *1 15.47,6.175 sky130_fd_pr__pfet_01v8
M$1619 50 66 167 167 sky130_fd_pr__pfet_01v8 L=0.15U W=1U AS=0.154P AD=0.28P
+ PS=1.335U PD=2.56U
* device instance $1620 r0 *1 23.47,6.175 sky130_fd_pr__pfet_01v8
M$1620 52 88 51 51 sky130_fd_pr__pfet_01v8 L=0.15U W=1U AS=0.26P AD=0.135P
+ PS=2.52U PD=1.27U
* device instance $1621 r0 *1 23.89,6.175 sky130_fd_pr__pfet_01v8
M$1621 68 163 52 52 sky130_fd_pr__pfet_01v8 L=0.15U W=1U AS=0.135P AD=0.135P
+ PS=1.27U PD=1.27U
* device instance $1622 r0 *1 24.31,6.175 sky130_fd_pr__pfet_01v8
M$1622 52 91 68 68 sky130_fd_pr__pfet_01v8 L=0.15U W=1U AS=0.135P AD=0.26P
+ PS=1.27U PD=2.52U
* device instance $1623 r0 *1 25.25,6.175 sky130_fd_pr__pfet_01v8
M$1623 68 87 167 167 sky130_fd_pr__pfet_01v8 L=0.15U W=1U AS=0.26P AD=0.165P
+ PS=2.52U PD=1.33U
* device instance $1624 r0 *1 25.73,6.175 sky130_fd_pr__pfet_01v8
M$1624 167 89 68 68 sky130_fd_pr__pfet_01v8 L=0.15U W=1U AS=0.165P AD=0.1575P
+ PS=1.33U PD=1.315U
* device instance $1625 r0 *1 26.195,6.175 sky130_fd_pr__pfet_01v8
M$1625 67 51 167 167 sky130_fd_pr__pfet_01v8 L=0.15U W=1U AS=0.1575P AD=0.26P
+ PS=1.315U PD=2.52U
* device instance $1626 r0 *1 27.665,5.995 sky130_fd_pr__pfet_01v8
M$1626 84 69 167 167 sky130_fd_pr__pfet_01v8 L=0.15U W=0.64U AS=0.1696P
+ AD=0.0768P PS=1.81U PD=0.88U
* device instance $1627 r0 *1 28.055,5.995 sky130_fd_pr__pfet_01v8
M$1627 70 71 84 84 sky130_fd_pr__pfet_01v8 L=0.15U W=0.64U AS=0.0768P
+ AD=0.0896P PS=0.88U PD=0.92U
* device instance $1628 r0 *1 28.485,5.995 sky130_fd_pr__pfet_01v8
M$1628 167 53 70 70 sky130_fd_pr__pfet_01v8 L=0.15U W=0.64U AS=0.0896P
+ AD=0.1824P PS=0.92U PD=1.85U
* device instance $1629 r0 *1 44.67,6.175 sky130_fd_pr__pfet_01v8
M$1629 86 72 54 54 sky130_fd_pr__pfet_01v8 L=0.15U W=1U AS=0.26P AD=0.135P
+ PS=2.52U PD=1.27U
* device instance $1630 r0 *1 45.09,6.175 sky130_fd_pr__pfet_01v8
M$1630 167 55 86 86 sky130_fd_pr__pfet_01v8 L=0.15U W=1U AS=0.135P AD=0.135P
+ PS=1.27U PD=1.27U
* device instance $1631 r0 *1 45.51,6.175 sky130_fd_pr__pfet_01v8
M$1631 56 55 167 167 sky130_fd_pr__pfet_01v8 L=0.15U W=1U AS=0.135P AD=0.135P
+ PS=1.27U PD=1.27U
* device instance $1632 r0 *1 45.93,6.175 sky130_fd_pr__pfet_01v8
M$1632 167 72 56 56 sky130_fd_pr__pfet_01v8 L=0.15U W=1U AS=0.135P AD=0.26P
+ PS=1.27U PD=2.52U
* device instance $1633 r0 *1 46.87,6.175 sky130_fd_pr__pfet_01v8
M$1633 57 54 56 56 sky130_fd_pr__pfet_01v8 L=0.15U W=1U AS=0.26P AD=0.3P
+ PS=2.52U PD=2.6U
* device instance $1634 r0 *1 66.23,5.995 sky130_fd_pr__pfet_01v8
M$1634 85 73 60 60 sky130_fd_pr__pfet_01v8 L=0.15U W=0.64U AS=0.1664P
+ AD=0.0672P PS=1.8U PD=0.85U
* device instance $1635 r0 *1 66.59,5.995 sky130_fd_pr__pfet_01v8
M$1635 167 61 85 85 sky130_fd_pr__pfet_01v8 L=0.15U W=0.64U AS=0.0672P
+ AD=0.1664P PS=0.85U PD=1.8U
* device instance $1636 r0 *1 69.255,5.885 sky130_fd_pr__pfet_01v8
M$1636 62 59 60 60 sky130_fd_pr__pfet_01v8 L=0.15U W=0.42U AS=0.15985P
+ AD=0.06405P PS=1.265U PD=0.725U
* device instance $1637 r0 *1 69.71,5.885 sky130_fd_pr__pfet_01v8
M$1637 82 58 62 62 sky130_fd_pr__pfet_01v8 L=0.15U W=0.42U AS=0.06405P
+ AD=0.07665P PS=0.725U PD=0.785U
* device instance $1638 r0 *1 70.225,5.885 sky130_fd_pr__pfet_01v8
M$1638 167 63 82 82 sky130_fd_pr__pfet_01v8 L=0.15U W=0.42U AS=0.07665P
+ AD=0.178875P PS=0.785U PD=1.26U
* device instance $1639 r0 *1 67.53,5.995 sky130_fd_pr__pfet_01v8
M$1639 167 90 61 61 sky130_fd_pr__pfet_01v8 L=0.15U W=0.64U AS=0.1664P
+ AD=0.0928P PS=1.8U PD=0.93U
* device instance $1640 r0 *1 67.97,5.995 sky130_fd_pr__pfet_01v8
M$1640 83 90 167 167 sky130_fd_pr__pfet_01v8 L=0.15U W=0.64U AS=0.0928P
+ AD=0.1152P PS=0.93U PD=1U
* device instance $1641 r0 *1 68.48,5.995 sky130_fd_pr__pfet_01v8
M$1641 60 64 83 83 sky130_fd_pr__pfet_01v8 L=0.15U W=0.64U AS=0.1152P
+ AD=0.15985P PS=1U PD=1.265U
* device instance $1642 r0 *1 70.885,6.05 sky130_fd_pr__pfet_01v8
M$1642 63 62 167 167 sky130_fd_pr__pfet_01v8 L=0.15U W=0.75U AS=0.178875P
+ AD=0.195P PS=1.26U PD=2.02U
* device instance $1643 r0 *1 67.685,4.995 sky130_fd_pr__pfet_01v8
M$1643 37 5 167 167 sky130_fd_pr__pfet_01v8 L=0.15U W=0.42U AS=0.1092P
+ AD=0.06405P PS=1.36U PD=0.725U
* device instance $1644 r0 *1 68.14,4.995 sky130_fd_pr__pfet_01v8
M$1644 19 13 37 37 sky130_fd_pr__pfet_01v8 L=0.15U W=0.42U AS=0.06405P
+ AD=0.0567P PS=0.725U PD=0.69U
* device instance $1645 r0 *1 68.56,4.995 sky130_fd_pr__pfet_01v8
M$1645 35 15 19 19 sky130_fd_pr__pfet_01v8 L=0.15U W=0.42U AS=0.0567P
+ AD=0.0882P PS=0.69U PD=0.84U
* device instance $1646 r0 *1 69.13,4.995 sky130_fd_pr__pfet_01v8
M$1646 167 18 35 35 sky130_fd_pr__pfet_01v8 L=0.15U W=0.42U AS=0.0882P
+ AD=0.1113P PS=0.84U PD=1.37U
* device instance $1647 r0 *1 71.825,5.885 sky130_fd_pr__pfet_01v8
M$1647 79 63 167 167 sky130_fd_pr__pfet_01v8 L=0.15U W=0.42U AS=0.1092P
+ AD=0.06405P PS=1.36U PD=0.725U
* device instance $1648 r0 *1 72.28,5.885 sky130_fd_pr__pfet_01v8
M$1648 74 58 79 79 sky130_fd_pr__pfet_01v8 L=0.15U W=0.42U AS=0.06405P
+ AD=0.0567P PS=0.725U PD=0.69U
* device instance $1649 r0 *1 72.7,5.885 sky130_fd_pr__pfet_01v8
M$1649 77 59 74 74 sky130_fd_pr__pfet_01v8 L=0.15U W=0.42U AS=0.0567P
+ AD=0.0882P PS=0.69U PD=0.84U
* device instance $1650 r0 *1 73.27,5.885 sky130_fd_pr__pfet_01v8
M$1650 167 64 77 77 sky130_fd_pr__pfet_01v8 L=0.15U W=0.42U AS=0.0882P
+ AD=0.1113P PS=0.84U PD=1.37U
* device instance $1651 r0 *1 74.325,5.995 sky130_fd_pr__pfet_01v8
M$1651 167 74 64 64 sky130_fd_pr__pfet_01v8 L=0.15U W=0.64U AS=0.1728P
+ AD=0.154P PS=1.82U PD=1.335U
* device instance $1652 r0 *1 74.81,6.175 sky130_fd_pr__pfet_01v8
M$1652 136 74 167 167 sky130_fd_pr__pfet_01v8 L=0.15U W=1U AS=0.154P AD=0.28P
+ PS=1.335U PD=2.56U
* device instance $1653 r0 *1 5.53,6.025 sky130_fd_pr__pfet_01v8
M$1653 167 31 43 43 sky130_fd_pr__pfet_01v8 L=0.15U W=0.64U AS=0.1664P
+ AD=0.0864P PS=1.8U PD=0.91U
* device instance $1654 r0 *1 5.95,6.025 sky130_fd_pr__pfet_01v8
M$1654 44 43 167 167 sky130_fd_pr__pfet_01v8 L=0.15U W=0.64U AS=0.0864P
+ AD=0.1664P PS=0.91U PD=1.8U
* device instance $1655 r0 *1 9.21,10.145 sky130_fd_pr__pfet_01v8
M$1655 161 110 111 111 sky130_fd_pr__pfet_01v8 L=0.15U W=1U AS=0.26P AD=0.135P
+ PS=2.52U PD=1.27U
* device instance $1656 r0 *1 9.63,10.145 sky130_fd_pr__pfet_01v8
M$1656 162 12 161 161 sky130_fd_pr__pfet_01v8 L=0.15U W=1U AS=0.135P AD=0.135P
+ PS=1.27U PD=1.27U
* device instance $1657 r0 *1 10.05,10.145 sky130_fd_pr__pfet_01v8
M$1657 161 91 162 162 sky130_fd_pr__pfet_01v8 L=0.15U W=1U AS=0.135P AD=0.26P
+ PS=1.27U PD=2.52U
* device instance $1658 r0 *1 10.99,10.145 sky130_fd_pr__pfet_01v8
M$1658 162 87 167 167 sky130_fd_pr__pfet_01v8 L=0.15U W=1U AS=0.26P AD=0.165P
+ PS=2.52U PD=1.33U
* device instance $1659 r0 *1 11.47,10.145 sky130_fd_pr__pfet_01v8
M$1659 167 129 162 162 sky130_fd_pr__pfet_01v8 L=0.15U W=1U AS=0.165P
+ AD=0.1575P PS=1.33U PD=1.315U
* device instance $1660 r0 *1 11.935,10.145 sky130_fd_pr__pfet_01v8
M$1660 65 111 167 167 sky130_fd_pr__pfet_01v8 L=0.15U W=1U AS=0.1575P AD=0.26P
+ PS=1.315U PD=2.52U
* device instance $1661 r0 *1 25.31,10.295 sky130_fd_pr__pfet_01v8
M$1661 167 31 130 130 sky130_fd_pr__pfet_01v8 L=0.15U W=0.64U AS=0.1664P
+ AD=0.0864P PS=1.8U PD=0.91U
* device instance $1662 r0 *1 25.73,10.295 sky130_fd_pr__pfet_01v8
M$1662 131 130 167 167 sky130_fd_pr__pfet_01v8 L=0.15U W=0.64U AS=0.0864P
+ AD=0.1664P PS=0.91U PD=1.8U
* device instance $1663 r0 *1 26.67,10.325 sky130_fd_pr__pfet_01v8
M$1663 172 70 113 113 sky130_fd_pr__pfet_01v8 L=0.15U W=0.64U AS=0.1664P
+ AD=0.0672P PS=1.8U PD=0.85U
* device instance $1664 r0 *1 27.03,10.325 sky130_fd_pr__pfet_01v8
M$1664 167 132 172 172 sky130_fd_pr__pfet_01v8 L=0.15U W=0.64U AS=0.0672P
+ AD=0.1664P PS=0.85U PD=1.8U
* device instance $1665 r0 *1 27.97,10.325 sky130_fd_pr__pfet_01v8
M$1665 167 90 132 132 sky130_fd_pr__pfet_01v8 L=0.15U W=0.64U AS=0.1664P
+ AD=0.0928P PS=1.8U PD=0.93U
* device instance $1666 r0 *1 28.41,10.325 sky130_fd_pr__pfet_01v8
M$1666 173 90 167 167 sky130_fd_pr__pfet_01v8 L=0.15U W=0.64U AS=0.0928P
+ AD=0.1152P PS=0.93U PD=1U
* device instance $1667 r0 *1 28.92,10.325 sky130_fd_pr__pfet_01v8
M$1667 113 133 173 173 sky130_fd_pr__pfet_01v8 L=0.15U W=0.64U AS=0.1152P
+ AD=0.15985P PS=1U PD=1.265U
* device instance $1668 r0 *1 29.695,10.435 sky130_fd_pr__pfet_01v8
M$1668 114 131 113 113 sky130_fd_pr__pfet_01v8 L=0.15U W=0.42U AS=0.15985P
+ AD=0.06405P PS=1.265U PD=0.725U
* device instance $1669 r0 *1 30.15,10.435 sky130_fd_pr__pfet_01v8
M$1669 174 130 114 114 sky130_fd_pr__pfet_01v8 L=0.15U W=0.42U AS=0.06405P
+ AD=0.07665P PS=0.725U PD=0.785U
* device instance $1670 r0 *1 30.665,10.435 sky130_fd_pr__pfet_01v8
M$1670 174 115 167 167 sky130_fd_pr__pfet_01v8 L=0.15U W=0.42U AS=0.178875P
+ AD=0.07665P PS=1.26U PD=0.785U
* device instance $1671 r0 *1 31.325,10.27 sky130_fd_pr__pfet_01v8
M$1671 115 114 167 167 sky130_fd_pr__pfet_01v8 L=0.15U W=0.75U AS=0.178875P
+ AD=0.195P PS=1.26U PD=2.02U
* device instance $1672 r0 *1 34.765,10.325 sky130_fd_pr__pfet_01v8
M$1672 133 116 167 167 sky130_fd_pr__pfet_01v8 L=0.15U W=0.64U AS=0.154P
+ AD=0.1728P PS=1.335U PD=1.82U
* device instance $1673 r0 *1 35.25,10.145 sky130_fd_pr__pfet_01v8
M$1673 163 116 167 167 sky130_fd_pr__pfet_01v8 L=0.15U W=1U AS=0.154P AD=0.28P
+ PS=1.335U PD=2.56U
* device instance $1674 r0 *1 47.475,10.24 sky130_fd_pr__pfet_01v8
M$1674 171 71 167 167 sky130_fd_pr__pfet_01v8 L=0.15U W=0.42U AS=0.15835P
+ AD=0.07665P PS=1.395U PD=0.785U
* device instance $1675 r0 *1 47.99,10.24 sky130_fd_pr__pfet_01v8
M$1675 121 134 171 171 sky130_fd_pr__pfet_01v8 L=0.15U W=0.42U AS=0.07665P
+ AD=0.1932P PS=0.785U PD=1.34U
* device instance $1676 r0 *1 49.06,10.24 sky130_fd_pr__pfet_01v8
M$1676 170 135 121 121 sky130_fd_pr__pfet_01v8 L=0.15U W=0.42U AS=0.1932P
+ AD=0.0441P PS=1.34U PD=0.63U
* device instance $1677 r0 *1 49.42,10.24 sky130_fd_pr__pfet_01v8
M$1677 167 122 170 170 sky130_fd_pr__pfet_01v8 L=0.15U W=0.42U AS=0.0441P
+ AD=0.0693P PS=0.63U PD=0.75U
* device instance $1678 r0 *1 49.9,10.24 sky130_fd_pr__pfet_01v8
M$1678 122 71 167 167 sky130_fd_pr__pfet_01v8 L=0.15U W=0.42U AS=0.0693P
+ AD=0.1176P PS=0.75U PD=1.4U
* device instance $1679 r0 *1 46.93,10.145 sky130_fd_pr__pfet_01v8
M$1679 167 121 120 120 sky130_fd_pr__pfet_01v8 L=0.15U W=1U AS=0.26P
+ AD=0.15835P PS=2.52U PD=1.395U
* device instance $1680 r0 *1 59.81,10.145 sky130_fd_pr__pfet_01v8
M$1680 165 124 125 125 sky130_fd_pr__pfet_01v8 L=0.15U W=1U AS=0.26P AD=0.135P
+ PS=2.52U PD=1.27U
* device instance $1681 r0 *1 60.23,10.145 sky130_fd_pr__pfet_01v8
M$1681 166 136 165 165 sky130_fd_pr__pfet_01v8 L=0.15U W=1U AS=0.135P AD=0.135P
+ PS=1.27U PD=1.27U
* device instance $1682 r0 *1 60.65,10.145 sky130_fd_pr__pfet_01v8
M$1682 165 91 166 166 sky130_fd_pr__pfet_01v8 L=0.15U W=1U AS=0.135P AD=0.26P
+ PS=1.27U PD=2.52U
* device instance $1683 r0 *1 61.59,10.145 sky130_fd_pr__pfet_01v8
M$1683 166 137 167 167 sky130_fd_pr__pfet_01v8 L=0.15U W=1U AS=0.26P AD=0.165P
+ PS=2.52U PD=1.33U
* device instance $1684 r0 *1 62.07,10.145 sky130_fd_pr__pfet_01v8
M$1684 167 1 166 166 sky130_fd_pr__pfet_01v8 L=0.15U W=1U AS=0.165P AD=0.1575P
+ PS=1.33U PD=1.315U
* device instance $1685 r0 *1 62.535,10.145 sky130_fd_pr__pfet_01v8
M$1685 14 125 167 167 sky130_fd_pr__pfet_01v8 L=0.15U W=1U AS=0.1575P AD=0.26P
+ PS=1.315U PD=2.52U
* device instance $1686 r0 *1 64.87,6.025 sky130_fd_pr__pfet_01v8
M$1686 167 329 58 58 sky130_fd_pr__pfet_01v8 L=0.15U W=0.64U AS=0.1664P
+ AD=0.0864P PS=1.8U PD=0.91U
* device instance $1687 r0 *1 65.29,6.025 sky130_fd_pr__pfet_01v8
M$1687 59 58 167 167 sky130_fd_pr__pfet_01v8 L=0.15U W=0.64U AS=0.0864P
+ AD=0.1664P PS=0.91U PD=1.8U
* device instance $1688 r0 *1 68.175,10.24 sky130_fd_pr__pfet_01v8
M$1688 169 71 167 167 sky130_fd_pr__pfet_01v8 L=0.15U W=0.42U AS=0.15835P
+ AD=0.07665P PS=1.395U PD=0.785U
* device instance $1689 r0 *1 68.69,10.24 sky130_fd_pr__pfet_01v8
M$1689 126 20 169 169 sky130_fd_pr__pfet_01v8 L=0.15U W=0.42U AS=0.07665P
+ AD=0.1932P PS=0.785U PD=1.34U
* device instance $1690 r0 *1 69.76,10.24 sky130_fd_pr__pfet_01v8
M$1690 168 127 126 126 sky130_fd_pr__pfet_01v8 L=0.15U W=0.42U AS=0.1932P
+ AD=0.0441P PS=1.34U PD=0.63U
* device instance $1691 r0 *1 70.12,10.24 sky130_fd_pr__pfet_01v8
M$1691 167 128 168 168 sky130_fd_pr__pfet_01v8 L=0.15U W=0.42U AS=0.0441P
+ AD=0.0693P PS=0.63U PD=0.75U
* device instance $1692 r0 *1 70.6,10.24 sky130_fd_pr__pfet_01v8
M$1692 128 71 167 167 sky130_fd_pr__pfet_01v8 L=0.15U W=0.42U AS=0.0693P
+ AD=0.1176P PS=0.75U PD=1.4U
* device instance $1693 r0 *1 67.63,10.145 sky130_fd_pr__pfet_01v8
M$1693 167 126 73 73 sky130_fd_pr__pfet_01v8 L=0.15U W=1U AS=0.26P AD=0.15835P
+ PS=2.52U PD=1.395U
* device instance $1694 r0 *1 6.98,10.435 sky130_fd_pr__pfet_01v8
M$1694 108 156 167 167 sky130_fd_pr__pfet_01v8 L=0.15U W=0.42U AS=0.1113P
+ AD=0.0609P PS=1.37U PD=0.71U
* device instance $1695 r0 *1 7.42,10.435 sky130_fd_pr__pfet_01v8
M$1695 108 109 167 167 sky130_fd_pr__pfet_01v8 L=0.15U W=0.42U AS=0.1841P
+ AD=0.0609P PS=1.26U PD=0.71U
* device instance $1696 r0 *1 8.19,10.325 sky130_fd_pr__pfet_01v8
M$1696 110 108 167 167 sky130_fd_pr__pfet_01v8 L=0.15U W=0.64U AS=0.1841P
+ AD=0.1696P PS=1.26U PD=1.81U
* device instance $1697 r0 *1 8.375,11.52 sky130_fd_pr__pfet_01v8
M$1697 214 71 167 167 sky130_fd_pr__pfet_01v8 L=0.15U W=0.42U AS=0.15835P
+ AD=0.07665P PS=1.395U PD=0.785U
* device instance $1698 r0 *1 8.89,11.52 sky130_fd_pr__pfet_01v8
M$1698 177 50 214 214 sky130_fd_pr__pfet_01v8 L=0.15U W=0.42U AS=0.07665P
+ AD=0.1932P PS=0.785U PD=1.34U
* device instance $1699 r0 *1 9.96,11.52 sky130_fd_pr__pfet_01v8
M$1699 215 208 177 177 sky130_fd_pr__pfet_01v8 L=0.15U W=0.42U AS=0.1932P
+ AD=0.0441P PS=1.34U PD=0.63U
* device instance $1700 r0 *1 10.32,11.52 sky130_fd_pr__pfet_01v8
M$1700 167 232 215 215 sky130_fd_pr__pfet_01v8 L=0.15U W=0.42U AS=0.0441P
+ AD=0.0693P PS=0.63U PD=0.75U
* device instance $1701 r0 *1 10.8,11.52 sky130_fd_pr__pfet_01v8
M$1701 232 71 167 167 sky130_fd_pr__pfet_01v8 L=0.15U W=0.42U AS=0.0693P
+ AD=0.1176P PS=0.75U PD=1.4U
* device instance $1702 r0 *1 7.83,11.615 sky130_fd_pr__pfet_01v8
M$1702 167 177 32 32 sky130_fd_pr__pfet_01v8 L=0.15U W=1U AS=0.26P AD=0.15835P
+ PS=2.52U PD=1.395U
* device instance $1703 r0 *1 12.47,11.615 sky130_fd_pr__pfet_01v8
M$1703 178 209 167 167 sky130_fd_pr__pfet_01v8 L=0.15U W=1U AS=0.3P AD=0.135P
+ PS=2.6U PD=1.27U
* device instance $1704 r0 *1 12.89,11.615 sky130_fd_pr__pfet_01v8
M$1704 167 230 178 178 sky130_fd_pr__pfet_01v8 L=0.15U W=1U AS=0.135P AD=0.365P
+ PS=1.27U PD=1.73U
* device instance $1705 r0 *1 13.77,11.615 sky130_fd_pr__pfet_01v8
M$1705 216 230 167 167 sky130_fd_pr__pfet_01v8 L=0.15U W=1U AS=0.365P AD=0.105P
+ PS=1.73U PD=1.21U
* device instance $1706 r0 *1 14.13,11.615 sky130_fd_pr__pfet_01v8
M$1706 129 209 216 216 sky130_fd_pr__pfet_01v8 L=0.15U W=1U AS=0.105P AD=0.165P
+ PS=1.21U PD=1.33U
* device instance $1707 r0 *1 14.61,11.615 sky130_fd_pr__pfet_01v8
M$1707 167 178 129 129 sky130_fd_pr__pfet_01v8 L=0.15U W=1U AS=0.165P AD=0.36P
+ PS=1.33U PD=2.72U
* device instance $1708 r0 *1 15.69,11.615 sky130_fd_pr__pfet_01v8
M$1708 217 50 179 179 sky130_fd_pr__pfet_01v8 L=0.15U W=1U AS=0.26P AD=0.135P
+ PS=2.52U PD=1.27U
* device instance $1709 r0 *1 16.11,11.615 sky130_fd_pr__pfet_01v8
M$1709 167 12 217 217 sky130_fd_pr__pfet_01v8 L=0.15U W=1U AS=0.135P AD=0.135P
+ PS=1.27U PD=1.27U
* device instance $1710 r0 *1 16.53,11.615 sky130_fd_pr__pfet_01v8
M$1710 180 12 167 167 sky130_fd_pr__pfet_01v8 L=0.15U W=1U AS=0.135P AD=0.135P
+ PS=1.27U PD=1.27U
* device instance $1711 r0 *1 16.95,11.615 sky130_fd_pr__pfet_01v8
M$1711 167 50 180 180 sky130_fd_pr__pfet_01v8 L=0.15U W=1U AS=0.135P AD=0.26P
+ PS=1.27U PD=2.52U
* device instance $1712 r0 *1 17.89,11.615 sky130_fd_pr__pfet_01v8
M$1712 209 179 180 180 sky130_fd_pr__pfet_01v8 L=0.15U W=1U AS=0.26P AD=0.3P
+ PS=2.52U PD=2.6U
* device instance $1713 r0 *1 20.69,11.435 sky130_fd_pr__pfet_01v8
M$1713 218 67 184 184 sky130_fd_pr__pfet_01v8 L=0.15U W=0.64U AS=0.1664P
+ AD=0.0672P PS=1.8U PD=0.85U
* device instance $1714 r0 *1 21.05,11.435 sky130_fd_pr__pfet_01v8
M$1714 167 183 218 218 sky130_fd_pr__pfet_01v8 L=0.15U W=0.64U AS=0.0672P
+ AD=0.1664P PS=0.85U PD=1.8U
* device instance $1715 r0 *1 23.715,11.325 sky130_fd_pr__pfet_01v8
M$1715 185 182 184 184 sky130_fd_pr__pfet_01v8 L=0.15U W=0.42U AS=0.15985P
+ AD=0.06405P PS=1.265U PD=0.725U
* device instance $1716 r0 *1 24.17,11.325 sky130_fd_pr__pfet_01v8
M$1716 221 181 185 185 sky130_fd_pr__pfet_01v8 L=0.15U W=0.42U AS=0.06405P
+ AD=0.07665P PS=0.725U PD=0.785U
* device instance $1717 r0 *1 24.685,11.325 sky130_fd_pr__pfet_01v8
M$1717 167 186 221 221 sky130_fd_pr__pfet_01v8 L=0.15U W=0.42U AS=0.07665P
+ AD=0.178875P PS=0.785U PD=1.26U
* device instance $1718 r0 *1 21.99,11.435 sky130_fd_pr__pfet_01v8
M$1718 167 315 183 183 sky130_fd_pr__pfet_01v8 L=0.15U W=0.64U AS=0.1664P
+ AD=0.0928P PS=1.8U PD=0.93U
* device instance $1719 r0 *1 22.43,11.435 sky130_fd_pr__pfet_01v8
M$1719 220 315 167 167 sky130_fd_pr__pfet_01v8 L=0.15U W=0.64U AS=0.0928P
+ AD=0.1152P PS=0.93U PD=1U
* device instance $1720 r0 *1 22.94,11.435 sky130_fd_pr__pfet_01v8
M$1720 184 188 220 220 sky130_fd_pr__pfet_01v8 L=0.15U W=0.64U AS=0.1152P
+ AD=0.15985P PS=1U PD=1.265U
* device instance $1721 r0 *1 25.345,11.49 sky130_fd_pr__pfet_01v8
M$1721 186 185 167 167 sky130_fd_pr__pfet_01v8 L=0.15U W=0.75U AS=0.178875P
+ AD=0.195P PS=1.26U PD=2.02U
* device instance $1722 r0 *1 23.08,10.435 sky130_fd_pr__pfet_01v8
M$1722 112 157 167 167 sky130_fd_pr__pfet_01v8 L=0.15U W=0.42U AS=0.1113P
+ AD=0.0609P PS=1.37U PD=0.71U
* device instance $1723 r0 *1 23.52,10.435 sky130_fd_pr__pfet_01v8
M$1723 112 109 167 167 sky130_fd_pr__pfet_01v8 L=0.15U W=0.42U AS=0.1841P
+ AD=0.0609P PS=1.26U PD=0.71U
* device instance $1724 r0 *1 24.29,10.325 sky130_fd_pr__pfet_01v8
M$1724 88 112 167 167 sky130_fd_pr__pfet_01v8 L=0.15U W=0.64U AS=0.1841P
+ AD=0.1696P PS=1.26U PD=1.81U
* device instance $1725 r0 *1 26.285,11.325 sky130_fd_pr__pfet_01v8
M$1725 222 186 167 167 sky130_fd_pr__pfet_01v8 L=0.15U W=0.42U AS=0.1092P
+ AD=0.06405P PS=1.36U PD=0.725U
* device instance $1726 r0 *1 26.74,11.325 sky130_fd_pr__pfet_01v8
M$1726 187 181 222 222 sky130_fd_pr__pfet_01v8 L=0.15U W=0.42U AS=0.06405P
+ AD=0.0567P PS=0.725U PD=0.69U
* device instance $1727 r0 *1 27.16,11.325 sky130_fd_pr__pfet_01v8
M$1727 223 182 187 187 sky130_fd_pr__pfet_01v8 L=0.15U W=0.42U AS=0.0567P
+ AD=0.0882P PS=0.69U PD=0.84U
* device instance $1728 r0 *1 27.73,11.325 sky130_fd_pr__pfet_01v8
M$1728 167 188 223 223 sky130_fd_pr__pfet_01v8 L=0.15U W=0.42U AS=0.0882P
+ AD=0.1113P PS=0.84U PD=1.37U
* device instance $1729 r0 *1 28.785,11.435 sky130_fd_pr__pfet_01v8
M$1729 167 187 188 188 sky130_fd_pr__pfet_01v8 L=0.15U W=0.64U AS=0.1728P
+ AD=0.154P PS=1.82U PD=1.335U
* device instance $1730 r0 *1 29.27,11.615 sky130_fd_pr__pfet_01v8
M$1730 189 187 167 167 sky130_fd_pr__pfet_01v8 L=0.15U W=1U AS=0.154P AD=0.28P
+ PS=1.335U PD=2.56U
* device instance $1731 r0 *1 30.85,11.615 sky130_fd_pr__pfet_01v8
M$1731 53 93 167 167 sky130_fd_pr__pfet_01v8 L=0.15U W=1U AS=0.26P AD=0.135P
+ PS=2.52U PD=1.27U
* device instance $1732 r0 *1 31.27,11.615 sky130_fd_pr__pfet_01v8
M$1732 167 71 53 53 sky130_fd_pr__pfet_01v8 L=0.15U W=1U AS=0.135P AD=0.26P
+ PS=1.27U PD=2.52U
* device instance $1733 r0 *1 32.21,11.535 sky130_fd_pr__pfet_01v8
M$1733 69 189 167 167 sky130_fd_pr__pfet_01v8 L=0.15U W=1.68U AS=0.3318P
+ AD=0.3486P PS=3.31U PD=3.35U
* device instance $1735 r0 *1 32.265,10.435 sky130_fd_pr__pfet_01v8
M$1735 175 115 167 167 sky130_fd_pr__pfet_01v8 L=0.15U W=0.42U AS=0.1092P
+ AD=0.06405P PS=1.36U PD=0.725U
* device instance $1736 r0 *1 32.72,10.435 sky130_fd_pr__pfet_01v8
M$1736 116 130 175 175 sky130_fd_pr__pfet_01v8 L=0.15U W=0.42U AS=0.06405P
+ AD=0.0567P PS=0.725U PD=0.69U
* device instance $1737 r0 *1 33.14,10.435 sky130_fd_pr__pfet_01v8
M$1737 176 131 116 116 sky130_fd_pr__pfet_01v8 L=0.15U W=0.42U AS=0.0567P
+ AD=0.0882P PS=0.69U PD=0.84U
* device instance $1738 r0 *1 33.71,10.435 sky130_fd_pr__pfet_01v8
M$1738 167 133 176 176 sky130_fd_pr__pfet_01v8 L=0.15U W=0.42U AS=0.0882P
+ AD=0.1113P PS=0.84U PD=1.37U
* device instance $1739 r0 *1 33.605,11.615 sky130_fd_pr__pfet_01v8
M$1739 190 163 167 167 sky130_fd_pr__pfet_01v8 L=0.15U W=2U AS=0.44P AD=0.3P
+ PS=3.88U PD=2.6U
* device instance $1740 r0 *1 34.035,11.615 sky130_fd_pr__pfet_01v8
M$1740 72 69 190 190 sky130_fd_pr__pfet_01v8 L=0.15U W=2U AS=0.28P AD=0.315P
+ PS=2.56U PD=2.63U
* device instance $1743 r0 *1 35.435,11.615 sky130_fd_pr__pfet_01v8
M$1743 72 191 167 167 sky130_fd_pr__pfet_01v8 L=0.15U W=2U AS=0.3P AD=0.405P
+ PS=2.6U PD=3.81U
* device instance $1745 r0 *1 37.34,10.435 sky130_fd_pr__pfet_01v8
M$1745 117 158 167 167 sky130_fd_pr__pfet_01v8 L=0.15U W=0.42U AS=0.1113P
+ AD=0.0609P PS=1.37U PD=0.71U
* device instance $1746 r0 *1 37.78,10.435 sky130_fd_pr__pfet_01v8
M$1746 117 109 167 167 sky130_fd_pr__pfet_01v8 L=0.15U W=0.42U AS=0.1841P
+ AD=0.0609P PS=1.26U PD=0.71U
* device instance $1747 r0 *1 38.55,10.325 sky130_fd_pr__pfet_01v8
M$1747 118 117 167 167 sky130_fd_pr__pfet_01v8 L=0.15U W=0.64U AS=0.1841P
+ AD=0.1696P PS=1.26U PD=1.81U
* device instance $1748 r0 *1 40.95,11.615 sky130_fd_pr__pfet_01v8
M$1748 193 164 192 192 sky130_fd_pr__pfet_01v8 L=0.15U W=1U AS=0.26P AD=0.135P
+ PS=2.52U PD=1.27U
* device instance $1749 r0 *1 41.37,11.615 sky130_fd_pr__pfet_01v8
M$1749 210 231 193 193 sky130_fd_pr__pfet_01v8 L=0.15U W=1U AS=0.135P AD=0.135P
+ PS=1.27U PD=1.27U
* device instance $1750 r0 *1 41.79,11.615 sky130_fd_pr__pfet_01v8
M$1750 193 91 210 210 sky130_fd_pr__pfet_01v8 L=0.15U W=1U AS=0.135P AD=0.26P
+ PS=1.27U PD=2.52U
* device instance $1751 r0 *1 42.73,11.615 sky130_fd_pr__pfet_01v8
M$1751 210 137 167 167 sky130_fd_pr__pfet_01v8 L=0.15U W=1U AS=0.26P AD=0.165P
+ PS=2.52U PD=1.33U
* device instance $1752 r0 *1 43.21,11.615 sky130_fd_pr__pfet_01v8
M$1752 167 57 210 210 sky130_fd_pr__pfet_01v8 L=0.15U W=1U AS=0.165P AD=0.1575P
+ PS=1.33U PD=1.315U
* device instance $1753 r0 *1 43.675,11.615 sky130_fd_pr__pfet_01v8
M$1753 194 192 167 167 sky130_fd_pr__pfet_01v8 L=0.15U W=1U AS=0.1575P AD=0.26P
+ PS=1.315U PD=2.52U
* device instance $1754 r0 *1 44.7,10.435 sky130_fd_pr__pfet_01v8
M$1754 119 159 167 167 sky130_fd_pr__pfet_01v8 L=0.15U W=0.42U AS=0.1113P
+ AD=0.0609P PS=1.37U PD=0.71U
* device instance $1755 r0 *1 45.14,10.435 sky130_fd_pr__pfet_01v8
M$1755 119 109 167 167 sky130_fd_pr__pfet_01v8 L=0.15U W=0.42U AS=0.1841P
+ AD=0.0609P PS=1.26U PD=0.71U
* device instance $1756 r0 *1 45.91,10.325 sky130_fd_pr__pfet_01v8
M$1756 164 119 167 167 sky130_fd_pr__pfet_01v8 L=0.15U W=0.64U AS=0.1841P
+ AD=0.1696P PS=1.26U PD=1.81U
* device instance $1757 r0 *1 48.29,11.435 sky130_fd_pr__pfet_01v8
M$1757 226 120 198 198 sky130_fd_pr__pfet_01v8 L=0.15U W=0.64U AS=0.1664P
+ AD=0.0672P PS=1.8U PD=0.85U
* device instance $1758 r0 *1 48.65,11.435 sky130_fd_pr__pfet_01v8
M$1758 167 197 226 226 sky130_fd_pr__pfet_01v8 L=0.15U W=0.64U AS=0.0672P
+ AD=0.1664P PS=0.85U PD=1.8U
* device instance $1759 r0 *1 51.315,11.325 sky130_fd_pr__pfet_01v8
M$1759 199 196 198 198 sky130_fd_pr__pfet_01v8 L=0.15U W=0.42U AS=0.15985P
+ AD=0.06405P PS=1.265U PD=0.725U
* device instance $1760 r0 *1 51.77,11.325 sky130_fd_pr__pfet_01v8
M$1760 229 195 199 199 sky130_fd_pr__pfet_01v8 L=0.15U W=0.42U AS=0.06405P
+ AD=0.07665P PS=0.725U PD=0.785U
* device instance $1761 r0 *1 52.285,11.325 sky130_fd_pr__pfet_01v8
M$1761 167 200 229 229 sky130_fd_pr__pfet_01v8 L=0.15U W=0.42U AS=0.07665P
+ AD=0.178875P PS=0.785U PD=1.26U
* device instance $1762 r0 *1 49.59,11.435 sky130_fd_pr__pfet_01v8
M$1762 167 90 197 197 sky130_fd_pr__pfet_01v8 L=0.15U W=0.64U AS=0.1664P
+ AD=0.0928P PS=1.8U PD=0.93U
* device instance $1763 r0 *1 50.03,11.435 sky130_fd_pr__pfet_01v8
M$1763 227 90 167 167 sky130_fd_pr__pfet_01v8 L=0.15U W=0.64U AS=0.0928P
+ AD=0.1152P PS=0.93U PD=1U
* device instance $1764 r0 *1 50.54,11.435 sky130_fd_pr__pfet_01v8
M$1764 198 202 227 227 sky130_fd_pr__pfet_01v8 L=0.15U W=0.64U AS=0.1152P
+ AD=0.15985P PS=1U PD=1.265U
* device instance $1765 r0 *1 52.945,11.49 sky130_fd_pr__pfet_01v8
M$1765 200 199 167 167 sky130_fd_pr__pfet_01v8 L=0.15U W=0.75U AS=0.178875P
+ AD=0.195P PS=1.26U PD=2.02U
* device instance $1766 r0 *1 53.885,11.325 sky130_fd_pr__pfet_01v8
M$1766 228 200 167 167 sky130_fd_pr__pfet_01v8 L=0.15U W=0.42U AS=0.1092P
+ AD=0.06405P PS=1.36U PD=0.725U
* device instance $1767 r0 *1 54.34,11.325 sky130_fd_pr__pfet_01v8
M$1767 201 195 228 228 sky130_fd_pr__pfet_01v8 L=0.15U W=0.42U AS=0.06405P
+ AD=0.0567P PS=0.725U PD=0.69U
* device instance $1768 r0 *1 54.76,11.325 sky130_fd_pr__pfet_01v8
M$1768 225 196 201 201 sky130_fd_pr__pfet_01v8 L=0.15U W=0.42U AS=0.0567P
+ AD=0.0882P PS=0.69U PD=0.84U
* device instance $1769 r0 *1 55.33,11.325 sky130_fd_pr__pfet_01v8
M$1769 167 202 225 225 sky130_fd_pr__pfet_01v8 L=0.15U W=0.42U AS=0.0882P
+ AD=0.1113P PS=0.84U PD=1.37U
* device instance $1770 r0 *1 56.385,11.435 sky130_fd_pr__pfet_01v8
M$1770 167 201 202 202 sky130_fd_pr__pfet_01v8 L=0.15U W=0.64U AS=0.1728P
+ AD=0.154P PS=1.82U PD=1.335U
* device instance $1771 r0 *1 56.87,11.615 sky130_fd_pr__pfet_01v8
M$1771 231 201 167 167 sky130_fd_pr__pfet_01v8 L=0.15U W=1U AS=0.154P AD=0.28P
+ PS=1.335U PD=2.56U
* device instance $1772 r0 *1 57.58,10.435 sky130_fd_pr__pfet_01v8
M$1772 123 160 167 167 sky130_fd_pr__pfet_01v8 L=0.15U W=0.42U AS=0.1113P
+ AD=0.0609P PS=1.37U PD=0.71U
* device instance $1773 r0 *1 58.02,10.435 sky130_fd_pr__pfet_01v8
M$1773 123 109 167 167 sky130_fd_pr__pfet_01v8 L=0.15U W=0.42U AS=0.1841P
+ AD=0.0609P PS=1.26U PD=0.71U
* device instance $1774 r0 *1 58.79,10.325 sky130_fd_pr__pfet_01v8
M$1774 124 123 167 167 sky130_fd_pr__pfet_01v8 L=0.15U W=0.64U AS=0.1841P
+ AD=0.1696P PS=1.26U PD=1.81U
* device instance $1775 r0 *1 61.69,11.615 sky130_fd_pr__pfet_01v8
M$1775 224 211 203 203 sky130_fd_pr__pfet_01v8 L=0.15U W=1U AS=0.26P AD=0.135P
+ PS=2.52U PD=1.27U
* device instance $1776 r0 *1 62.11,11.615 sky130_fd_pr__pfet_01v8
M$1776 167 212 224 224 sky130_fd_pr__pfet_01v8 L=0.15U W=1U AS=0.135P AD=0.135P
+ PS=1.27U PD=1.27U
* device instance $1777 r0 *1 62.53,11.615 sky130_fd_pr__pfet_01v8
M$1777 204 212 167 167 sky130_fd_pr__pfet_01v8 L=0.15U W=1U AS=0.135P AD=0.135P
+ PS=1.27U PD=1.27U
* device instance $1778 r0 *1 62.95,11.615 sky130_fd_pr__pfet_01v8
M$1778 167 211 204 204 sky130_fd_pr__pfet_01v8 L=0.15U W=1U AS=0.135P AD=0.26P
+ PS=1.27U PD=2.52U
* device instance $1779 r0 *1 63.89,11.615 sky130_fd_pr__pfet_01v8
M$1779 1 203 204 204 sky130_fd_pr__pfet_01v8 L=0.15U W=1U AS=0.26P AD=0.3P
+ PS=2.52U PD=2.6U
* device instance $1780 r0 *1 66.29,11.615 sky130_fd_pr__pfet_01v8
M$1780 219 20 205 205 sky130_fd_pr__pfet_01v8 L=0.15U W=1U AS=0.26P AD=0.135P
+ PS=2.52U PD=1.27U
* device instance $1781 r0 *1 66.71,11.615 sky130_fd_pr__pfet_01v8
M$1781 167 136 219 219 sky130_fd_pr__pfet_01v8 L=0.15U W=1U AS=0.135P AD=0.135P
+ PS=1.27U PD=1.27U
* device instance $1782 r0 *1 67.13,11.615 sky130_fd_pr__pfet_01v8
M$1782 206 136 167 167 sky130_fd_pr__pfet_01v8 L=0.15U W=1U AS=0.135P AD=0.135P
+ PS=1.27U PD=1.27U
* device instance $1783 r0 *1 67.55,11.615 sky130_fd_pr__pfet_01v8
M$1783 167 20 206 206 sky130_fd_pr__pfet_01v8 L=0.15U W=1U AS=0.135P AD=0.26P
+ PS=1.27U PD=2.52U
* device instance $1784 r0 *1 68.49,11.615 sky130_fd_pr__pfet_01v8
M$1784 212 205 206 206 sky130_fd_pr__pfet_01v8 L=0.15U W=1U AS=0.26P AD=0.3P
+ PS=2.52U PD=2.6U
* device instance $1785 r0 *1 69.47,11.905 sky130_fd_pr__pfet_01v8
M$1785 213 136 167 167 sky130_fd_pr__pfet_01v8 L=0.15U W=0.42U AS=0.14575P
+ AD=0.1092P PS=1.335U PD=1.36U
* device instance $1786 r0 *1 69.955,11.615 sky130_fd_pr__pfet_01v8
M$1786 207 20 167 167 sky130_fd_pr__pfet_01v8 L=0.15U W=1U AS=0.14575P
+ AD=0.135P PS=1.335U PD=1.27U
* device instance $1787 r0 *1 70.375,11.615 sky130_fd_pr__pfet_01v8
M$1787 167 213 207 207 sky130_fd_pr__pfet_01v8 L=0.15U W=1U AS=0.135P AD=0.265P
+ PS=1.27U PD=2.53U
* device instance $1788 r0 *1 12.67,15.295 sky130_fd_pr__pfet_01v8
M$1788 167 50 255 255 sky130_fd_pr__pfet_01v8 L=0.15U W=0.42U AS=0.1092P
+ AD=0.1573P PS=1.36U PD=1.39U
* device instance $1789 r0 *1 13.21,15.585 sky130_fd_pr__pfet_01v8
M$1789 284 12 167 167 sky130_fd_pr__pfet_01v8 L=0.15U W=1U AS=0.1573P AD=0.105P
+ PS=1.39U PD=1.21U
* device instance $1790 r0 *1 13.57,15.585 sky130_fd_pr__pfet_01v8
M$1790 256 255 284 284 sky130_fd_pr__pfet_01v8 L=0.15U W=1U AS=0.105P AD=0.26P
+ PS=1.21U PD=2.52U
* device instance $1791 r0 *1 13.82,17.055 sky130_fd_pr__pfet_01v8
M$1791 167 293 292 292 sky130_fd_pr__pfet_01v8 L=0.15U W=1U AS=0.26P AD=0.26P
+ PS=2.52U PD=2.52U
* device instance $1792 r0 *1 14.73,15.665 sky130_fd_pr__pfet_01v8
M$1792 257 209 167 167 sky130_fd_pr__pfet_01v8 L=0.15U W=1.68U AS=0.3318P
+ AD=0.3486P PS=3.31U PD=3.35U
* device instance $1794 r0 *1 14.76,17.055 sky130_fd_pr__pfet_01v8
M$1794 294 256 293 293 sky130_fd_pr__pfet_01v8 L=0.15U W=1U AS=0.26P AD=0.1375P
+ PS=2.52U PD=1.275U
* device instance $1795 r0 *1 15.185,17.055 sky130_fd_pr__pfet_01v8
M$1795 167 230 294 294 sky130_fd_pr__pfet_01v8 L=0.15U W=1U AS=0.1375P AD=0.14P
+ PS=1.275U PD=1.28U
* device instance $1796 r0 *1 15.615,17.055 sky130_fd_pr__pfet_01v8
M$1796 294 257 167 167 sky130_fd_pr__pfet_01v8 L=0.15U W=1U AS=0.14P AD=0.265P
+ PS=1.28U PD=2.53U
* device instance $1797 r0 *1 19.33,11.465 sky130_fd_pr__pfet_01v8
M$1797 167 31 181 181 sky130_fd_pr__pfet_01v8 L=0.15U W=0.64U AS=0.1664P
+ AD=0.0864P PS=1.8U PD=0.91U
* device instance $1798 r0 *1 19.75,11.465 sky130_fd_pr__pfet_01v8
M$1798 182 181 167 167 sky130_fd_pr__pfet_01v8 L=0.15U W=0.64U AS=0.0864P
+ AD=0.1664P PS=0.91U PD=1.8U
* device instance $1799 r0 *1 28.57,15.585 sky130_fd_pr__pfet_01v8
M$1799 258 189 167 167 sky130_fd_pr__pfet_01v8 L=0.15U W=1U AS=0.3P AD=0.135P
+ PS=2.6U PD=1.27U
* device instance $1800 r0 *1 28.99,15.585 sky130_fd_pr__pfet_01v8
M$1800 167 163 258 258 sky130_fd_pr__pfet_01v8 L=0.15U W=1U AS=0.135P AD=0.365P
+ PS=1.27U PD=1.73U
* device instance $1801 r0 *1 29.87,15.585 sky130_fd_pr__pfet_01v8
M$1801 287 163 167 167 sky130_fd_pr__pfet_01v8 L=0.15U W=1U AS=0.365P AD=0.105P
+ PS=1.73U PD=1.21U
* device instance $1802 r0 *1 30.23,15.585 sky130_fd_pr__pfet_01v8
M$1802 276 189 287 287 sky130_fd_pr__pfet_01v8 L=0.15U W=1U AS=0.105P AD=0.165P
+ PS=1.21U PD=1.33U
* device instance $1803 r0 *1 30.71,15.585 sky130_fd_pr__pfet_01v8
M$1803 167 258 276 276 sky130_fd_pr__pfet_01v8 L=0.15U W=1U AS=0.165P AD=0.36P
+ PS=1.33U PD=2.72U
* device instance $1804 r0 *1 31.99,15.295 sky130_fd_pr__pfet_01v8
M$1804 167 191 260 260 sky130_fd_pr__pfet_01v8 L=0.15U W=0.42U AS=0.1092P
+ AD=0.1573P PS=1.36U PD=1.39U
* device instance $1805 r0 *1 32.53,15.585 sky130_fd_pr__pfet_01v8
M$1805 289 275 167 167 sky130_fd_pr__pfet_01v8 L=0.15U W=1U AS=0.1573P
+ AD=0.105P PS=1.39U PD=1.21U
* device instance $1806 r0 *1 32.89,15.585 sky130_fd_pr__pfet_01v8
M$1806 89 260 289 289 sky130_fd_pr__pfet_01v8 L=0.15U W=1U AS=0.105P AD=0.26P
+ PS=1.21U PD=2.52U
* device instance $1807 r0 *1 34.05,15.585 sky130_fd_pr__pfet_01v8
M$1807 191 276 167 167 sky130_fd_pr__pfet_01v8 L=0.15U W=2U AS=0.395P AD=0.27P
+ PS=3.79U PD=2.54U
* device instance $1809 r0 *1 34.89,15.585 sky130_fd_pr__pfet_01v8
M$1809 191 262 167 167 sky130_fd_pr__pfet_01v8 L=0.15U W=2U AS=0.27P AD=0.395P
+ PS=2.54U PD=3.79U
* device instance $1811 r0 *1 34.07,17.055 sky130_fd_pr__pfet_01v8
M$1811 295 276 275 275 sky130_fd_pr__pfet_01v8 L=0.15U W=1U AS=0.265P AD=0.14P
+ PS=2.53U PD=1.28U
* device instance $1812 r0 *1 34.5,17.055 sky130_fd_pr__pfet_01v8
M$1812 167 262 295 295 sky130_fd_pr__pfet_01v8 L=0.15U W=1U AS=0.14P AD=0.1475P
+ PS=1.28U PD=1.295U
* device instance $1813 r0 *1 34.945,17.055 sky130_fd_pr__pfet_01v8
M$1813 295 277 167 167 sky130_fd_pr__pfet_01v8 L=0.15U W=1U AS=0.1475P
+ AD=0.265P PS=1.295U PD=2.53U
* device instance $1814 r0 *1 35.89,17.055 sky130_fd_pr__pfet_01v8
M$1814 312 69 279 279 sky130_fd_pr__pfet_01v8 L=0.15U W=1U AS=0.26P AD=0.105P
+ PS=2.52U PD=1.21U
* device instance $1815 r0 *1 36.25,17.055 sky130_fd_pr__pfet_01v8
M$1815 167 163 312 312 sky130_fd_pr__pfet_01v8 L=0.15U W=1U AS=0.105P AD=0.26P
+ PS=1.21U PD=2.52U
* device instance $1816 r0 *1 36.25,15.585 sky130_fd_pr__pfet_01v8
M$1816 191 277 167 167 sky130_fd_pr__pfet_01v8 L=0.15U W=2U AS=0.395P AD=0.445P
+ PS=3.79U PD=3.89U
* device instance $1818 r0 *1 37.73,15.585 sky130_fd_pr__pfet_01v8
M$1818 282 262 167 167 sky130_fd_pr__pfet_01v8 L=0.15U W=2U AS=0.395P AD=0.27P
+ PS=3.79U PD=2.54U
* device instance $1820 r0 *1 38.57,15.585 sky130_fd_pr__pfet_01v8
M$1820 282 278 167 167 sky130_fd_pr__pfet_01v8 L=0.15U W=2U AS=0.275P AD=0.285P
+ PS=2.55U PD=2.57U
* device instance $1822 r0 *1 39.44,15.585 sky130_fd_pr__pfet_01v8
M$1822 282 276 167 167 sky130_fd_pr__pfet_01v8 L=0.15U W=2U AS=0.28P AD=0.395P
+ PS=2.56U PD=3.79U
* device instance $1824 r0 *1 40.8,15.585 sky130_fd_pr__pfet_01v8
M$1824 282 279 283 283 sky130_fd_pr__pfet_01v8 L=0.15U W=2U AS=0.395P AD=0.395P
+ PS=3.79U PD=2.79U
* device instance $1826 r0 *1 41.89,15.585 sky130_fd_pr__pfet_01v8
M$1826 266 267 283 283 sky130_fd_pr__pfet_01v8 L=0.15U W=2U AS=0.395P AD=0.395P
+ PS=2.79U PD=3.79U
* device instance $1828 r0 *1 45.33,15.295 sky130_fd_pr__pfet_01v8
M$1828 167 134 268 268 sky130_fd_pr__pfet_01v8 L=0.15U W=0.42U AS=0.1092P
+ AD=0.1573P PS=1.36U PD=1.39U
* device instance $1829 r0 *1 45.87,15.585 sky130_fd_pr__pfet_01v8
M$1829 291 231 167 167 sky130_fd_pr__pfet_01v8 L=0.15U W=1U AS=0.1573P
+ AD=0.105P PS=1.39U PD=1.21U
* device instance $1830 r0 *1 46.23,15.585 sky130_fd_pr__pfet_01v8
M$1830 267 268 291 291 sky130_fd_pr__pfet_01v8 L=0.15U W=1U AS=0.105P AD=0.26P
+ PS=1.21U PD=2.52U
* device instance $1831 r0 *1 45.53,16.875 sky130_fd_pr__pfet_01v8
M$1831 314 194 298 298 sky130_fd_pr__pfet_01v8 L=0.15U W=0.64U AS=0.1664P
+ AD=0.0672P PS=1.8U PD=0.85U
* device instance $1832 r0 *1 45.89,16.875 sky130_fd_pr__pfet_01v8
M$1832 167 299 314 314 sky130_fd_pr__pfet_01v8 L=0.15U W=0.64U AS=0.0672P
+ AD=0.1664P PS=0.85U PD=1.8U
* device instance $1833 r0 *1 48.555,16.765 sky130_fd_pr__pfet_01v8
M$1833 300 297 298 298 sky130_fd_pr__pfet_01v8 L=0.15U W=0.42U AS=0.15985P
+ AD=0.06405P PS=1.265U PD=0.725U
* device instance $1834 r0 *1 49.01,16.765 sky130_fd_pr__pfet_01v8
M$1834 307 296 300 300 sky130_fd_pr__pfet_01v8 L=0.15U W=0.42U AS=0.06405P
+ AD=0.07665P PS=0.725U PD=0.785U
* device instance $1835 r0 *1 49.525,16.765 sky130_fd_pr__pfet_01v8
M$1835 167 301 307 307 sky130_fd_pr__pfet_01v8 L=0.15U W=0.42U AS=0.07665P
+ AD=0.178875P PS=0.785U PD=1.26U
* device instance $1836 r0 *1 46.83,16.875 sky130_fd_pr__pfet_01v8
M$1836 167 315 299 299 sky130_fd_pr__pfet_01v8 L=0.15U W=0.64U AS=0.1664P
+ AD=0.0928P PS=1.8U PD=0.93U
* device instance $1837 r0 *1 47.27,16.875 sky130_fd_pr__pfet_01v8
M$1837 313 315 167 167 sky130_fd_pr__pfet_01v8 L=0.15U W=0.64U AS=0.0928P
+ AD=0.1152P PS=0.93U PD=1U
* device instance $1838 r0 *1 47.78,16.875 sky130_fd_pr__pfet_01v8
M$1838 298 303 313 313 sky130_fd_pr__pfet_01v8 L=0.15U W=0.64U AS=0.1152P
+ AD=0.15985P PS=1U PD=1.265U
* device instance $1839 r0 *1 50.185,16.93 sky130_fd_pr__pfet_01v8
M$1839 301 300 167 167 sky130_fd_pr__pfet_01v8 L=0.15U W=0.75U AS=0.178875P
+ AD=0.195P PS=1.26U PD=2.02U
* device instance $1840 r0 *1 46.93,11.465 sky130_fd_pr__pfet_01v8
M$1840 167 329 195 195 sky130_fd_pr__pfet_01v8 L=0.15U W=0.64U AS=0.1664P
+ AD=0.0864P PS=1.8U PD=0.91U
* device instance $1841 r0 *1 47.35,11.465 sky130_fd_pr__pfet_01v8
M$1841 196 195 167 167 sky130_fd_pr__pfet_01v8 L=0.15U W=0.64U AS=0.0864P
+ AD=0.1664P PS=0.91U PD=1.8U
* device instance $1842 r0 *1 47.39,15.585 sky130_fd_pr__pfet_01v8
M$1842 290 280 55 55 sky130_fd_pr__pfet_01v8 L=0.15U W=1U AS=0.26P AD=0.105P
+ PS=2.52U PD=1.21U
* device instance $1843 r0 *1 47.75,15.585 sky130_fd_pr__pfet_01v8
M$1843 167 267 290 290 sky130_fd_pr__pfet_01v8 L=0.15U W=1U AS=0.105P AD=0.26P
+ PS=1.21U PD=2.52U
* device instance $1844 r0 *1 50.39,15.295 sky130_fd_pr__pfet_01v8
M$1844 167 231 269 269 sky130_fd_pr__pfet_01v8 L=0.15U W=0.42U AS=0.1092P
+ AD=0.1573P PS=1.36U PD=1.39U
* device instance $1845 r0 *1 50.93,15.585 sky130_fd_pr__pfet_01v8
M$1845 288 134 167 167 sky130_fd_pr__pfet_01v8 L=0.15U W=1U AS=0.1573P
+ AD=0.105P PS=1.39U PD=1.21U
* device instance $1846 r0 *1 51.29,15.585 sky130_fd_pr__pfet_01v8
M$1846 280 269 288 288 sky130_fd_pr__pfet_01v8 L=0.15U W=1U AS=0.105P AD=0.26P
+ PS=1.21U PD=2.52U
* device instance $1847 r0 *1 51.125,16.765 sky130_fd_pr__pfet_01v8
M$1847 309 301 167 167 sky130_fd_pr__pfet_01v8 L=0.15U W=0.42U AS=0.1092P
+ AD=0.06405P PS=1.36U PD=0.725U
* device instance $1848 r0 *1 51.58,16.765 sky130_fd_pr__pfet_01v8
M$1848 302 296 309 309 sky130_fd_pr__pfet_01v8 L=0.15U W=0.42U AS=0.06405P
+ AD=0.0567P PS=0.725U PD=0.69U
* device instance $1849 r0 *1 52,16.765 sky130_fd_pr__pfet_01v8
M$1849 308 297 302 302 sky130_fd_pr__pfet_01v8 L=0.15U W=0.42U AS=0.0567P
+ AD=0.0882P PS=0.69U PD=0.84U
* device instance $1850 r0 *1 52.57,16.765 sky130_fd_pr__pfet_01v8
M$1850 167 303 308 308 sky130_fd_pr__pfet_01v8 L=0.15U W=0.42U AS=0.0882P
+ AD=0.1113P PS=0.84U PD=1.37U
* device instance $1851 r0 *1 53.625,16.875 sky130_fd_pr__pfet_01v8
M$1851 167 302 303 303 sky130_fd_pr__pfet_01v8 L=0.15U W=0.64U AS=0.1728P
+ AD=0.154P PS=1.82U PD=1.335U
* device instance $1852 r0 *1 54.11,17.055 sky130_fd_pr__pfet_01v8
M$1852 134 302 167 167 sky130_fd_pr__pfet_01v8 L=0.15U W=1U AS=0.154P AD=0.28P
+ PS=1.335U PD=2.56U
* device instance $1853 r0 *1 57.715,15.295 sky130_fd_pr__pfet_01v8
M$1853 286 280 270 270 sky130_fd_pr__pfet_01v8 L=0.15U W=0.42U AS=0.1092P
+ AD=0.0441P PS=1.36U PD=0.63U
* device instance $1854 r0 *1 58.075,15.295 sky130_fd_pr__pfet_01v8
M$1854 167 266 286 286 sky130_fd_pr__pfet_01v8 L=0.15U W=0.42U AS=0.0441P
+ AD=0.14575P PS=0.63U PD=1.335U
* device instance $1855 r0 *1 58.56,15.585 sky130_fd_pr__pfet_01v8
M$1855 271 270 167 167 sky130_fd_pr__pfet_01v8 L=0.15U W=1U AS=0.14575P
+ AD=0.34P PS=1.335U PD=2.68U
* device instance $1856 r0 *1 59.93,17.055 sky130_fd_pr__pfet_01v8
M$1856 167 212 305 305 sky130_fd_pr__pfet_01v8 L=0.15U W=2U AS=0.395P AD=0.27P
+ PS=3.79U PD=2.54U
* device instance $1858 r0 *1 60.77,17.055 sky130_fd_pr__pfet_01v8
M$1858 306 266 305 305 sky130_fd_pr__pfet_01v8 L=0.15U W=2U AS=0.27P AD=0.395P
+ PS=2.54U PD=3.79U
* device instance $1860 r0 *1 62.13,17.055 sky130_fd_pr__pfet_01v8
M$1860 306 280 304 304 sky130_fd_pr__pfet_01v8 L=0.15U W=2U AS=0.395P AD=0.27P
+ PS=3.79U PD=2.54U
* device instance $1862 r0 *1 62.97,17.055 sky130_fd_pr__pfet_01v8
M$1862 167 207 304 304 sky130_fd_pr__pfet_01v8 L=0.15U W=2U AS=0.44P AD=0.51P
+ PS=2.88U PD=3.02U
* device instance $1864 r0 *1 64.29,17.055 sky130_fd_pr__pfet_01v8
M$1864 167 311 304 304 sky130_fd_pr__pfet_01v8 L=0.15U W=2U AS=0.34P AD=0.395P
+ PS=2.68U PD=3.79U
* device instance $1866 r0 *1 63.515,15.765 sky130_fd_pr__pfet_01v8
M$1866 272 207 167 167 sky130_fd_pr__pfet_01v8 L=0.15U W=0.64U AS=0.1824P
+ AD=0.0896P PS=1.85U PD=0.92U
* device instance $1867 r0 *1 63.945,15.765 sky130_fd_pr__pfet_01v8
M$1867 285 271 272 272 sky130_fd_pr__pfet_01v8 L=0.15U W=0.64U AS=0.0896P
+ AD=0.0768P PS=0.92U PD=0.88U
* device instance $1868 r0 *1 64.335,15.765 sky130_fd_pr__pfet_01v8
M$1868 285 212 167 167 sky130_fd_pr__pfet_01v8 L=0.15U W=0.64U AS=0.314P
+ AD=0.0768P PS=1.835U PD=0.88U
* device instance $1869 r0 *1 65.32,15.585 sky130_fd_pr__pfet_01v8
M$1869 211 274 167 167 sky130_fd_pr__pfet_01v8 L=0.15U W=4U AS=0.719P AD=0.54P
+ PS=5.645U PD=5.08U
* device instance $1873 r0 *1 67,15.585 sky130_fd_pr__pfet_01v8
M$1873 274 271 167 167 sky130_fd_pr__pfet_01v8 L=0.15U W=1U AS=0.135P AD=0.26P
+ PS=1.27U PD=2.52U
* device instance $1874 r0 *1 17.03,21.025 sky130_fd_pr__pfet_01v8
M$1874 167 334 335 335 sky130_fd_pr__pfet_01v8 L=0.15U W=1U AS=0.26P AD=0.135P
+ PS=2.52U PD=1.27U
* device instance $1875 r0 *1 17.45,21.025 sky130_fd_pr__pfet_01v8
M$1875 230 335 167 167 sky130_fd_pr__pfet_01v8 L=0.15U W=4U AS=0.54P AD=0.665P
+ PS=5.08U PD=6.33U
* device instance $1879 r0 *1 19.65,21.025 sky130_fd_pr__pfet_01v8
M$1879 167 334 344 344 sky130_fd_pr__pfet_01v8 L=0.15U W=4U AS=0.665P AD=0.54P
+ PS=6.33U PD=5.08U
* device instance $1882 r0 *1 20.91,21.025 sky130_fd_pr__pfet_01v8
M$1882 344 257 167 167 sky130_fd_pr__pfet_01v8 L=0.15U W=4U AS=0.54P AD=0.54P
+ PS=5.08U PD=5.08U
* device instance $1887 r0 *1 23.01,21.025 sky130_fd_pr__pfet_01v8
M$1887 345 337 344 344 sky130_fd_pr__pfet_01v8 L=0.15U W=2U AS=0.27P AD=0.27P
+ PS=2.54U PD=2.54U
* device instance $1889 r0 *1 23.85,21.025 sky130_fd_pr__pfet_01v8
M$1889 349 337 344 344 sky130_fd_pr__pfet_01v8 L=0.15U W=1U AS=0.135P AD=0.15P
+ PS=1.27U PD=1.3U
* device instance $1890 r0 *1 24.3,21.025 sky130_fd_pr__pfet_01v8
M$1890 336 256 349 349 sky130_fd_pr__pfet_01v8 L=0.15U W=1U AS=0.15P AD=0.14P
+ PS=1.3U PD=1.28U
* device instance $1891 r0 *1 24.73,21.025 sky130_fd_pr__pfet_01v8
M$1891 345 256 336 336 sky130_fd_pr__pfet_01v8 L=0.15U W=2U AS=0.28P AD=0.29P
+ PS=2.56U PD=2.58U
* device instance $1893 r0 *1 25.61,21.025 sky130_fd_pr__pfet_01v8
M$1893 350 256 336 336 sky130_fd_pr__pfet_01v8 L=0.15U W=1U AS=0.15P AD=0.155P
+ PS=1.3U PD=1.31U
* device instance $1894 r0 *1 26.07,21.025 sky130_fd_pr__pfet_01v8
M$1894 344 337 350 350 sky130_fd_pr__pfet_01v8 L=0.15U W=1U AS=0.155P AD=0.26P
+ PS=1.31U PD=2.52U
* device instance $1895 r0 *1 27.155,21.025 sky130_fd_pr__pfet_01v8
M$1895 326 310 167 167 sky130_fd_pr__pfet_01v8 L=0.15U W=4U AS=0.685P AD=0.56P
+ PS=6.37U PD=5.12U
* device instance $1899 r0 *1 28.875,21.025 sky130_fd_pr__pfet_01v8
M$1899 31 326 167 167 sky130_fd_pr__pfet_01v8 L=0.15U W=16U AS=2.2375P
+ AD=2.4875P PS=20.475U PD=20.975U
* device instance $1915 r0 *1 36.25,21.025 sky130_fd_pr__pfet_01v8
M$1915 277 327 167 167 sky130_fd_pr__pfet_01v8 L=0.15U W=4U AS=0.795P AD=0.54P
+ PS=5.59U PD=5.08U
* device instance $1919 r0 *1 37.93,21.025 sky130_fd_pr__pfet_01v8
M$1919 327 278 167 167 sky130_fd_pr__pfet_01v8 L=0.15U W=1U AS=0.135P AD=0.26P
+ PS=1.27U PD=2.52U
* device instance $1920 r0 *1 44.17,16.905 sky130_fd_pr__pfet_01v8
M$1920 167 329 296 296 sky130_fd_pr__pfet_01v8 L=0.15U W=0.64U AS=0.1664P
+ AD=0.0864P PS=1.8U PD=0.91U
* device instance $1921 r0 *1 44.59,16.905 sky130_fd_pr__pfet_01v8
M$1921 297 296 167 167 sky130_fd_pr__pfet_01v8 L=0.15U W=0.64U AS=0.0864P
+ AD=0.1664P PS=0.91U PD=1.8U
* device instance $1922 r0 *1 46.475,21.025 sky130_fd_pr__pfet_01v8
M$1922 328 310 167 167 sky130_fd_pr__pfet_01v8 L=0.15U W=4U AS=0.685P AD=0.56P
+ PS=6.37U PD=5.12U
* device instance $1926 r0 *1 48.195,21.025 sky130_fd_pr__pfet_01v8
M$1926 329 328 167 167 sky130_fd_pr__pfet_01v8 L=0.15U W=16U AS=2.2375P
+ AD=2.3625P PS=20.475U PD=21.725U
* device instance $1942 r0 *1 63.51,21.025 sky130_fd_pr__pfet_01v8
M$1942 330 338 167 167 sky130_fd_pr__pfet_01v8 L=0.15U W=1U AS=0.26P AD=0.135P
+ PS=2.52U PD=1.27U
* device instance $1943 r0 *1 63.93,21.025 sky130_fd_pr__pfet_01v8
M$1943 167 311 330 330 sky130_fd_pr__pfet_01v8 L=0.15U W=1U AS=0.135P AD=0.26P
+ PS=1.27U PD=2.52U
* device instance $1944 r0 *1 64.91,21.025 sky130_fd_pr__pfet_01v8
M$1944 331 272 167 167 sky130_fd_pr__pfet_01v8 L=0.15U W=1U AS=0.3P AD=0.135P
+ PS=2.6U PD=1.27U
* device instance $1945 r0 *1 65.33,21.025 sky130_fd_pr__pfet_01v8
M$1945 167 330 331 331 sky130_fd_pr__pfet_01v8 L=0.15U W=1U AS=0.135P AD=0.365P
+ PS=1.27U PD=1.73U
* device instance $1946 r0 *1 66.21,21.025 sky130_fd_pr__pfet_01v8
M$1946 348 330 167 167 sky130_fd_pr__pfet_01v8 L=0.15U W=1U AS=0.365P AD=0.105P
+ PS=1.73U PD=1.21U
* device instance $1947 r0 *1 66.57,21.025 sky130_fd_pr__pfet_01v8
M$1947 346 272 348 348 sky130_fd_pr__pfet_01v8 L=0.15U W=1U AS=0.105P AD=0.165P
+ PS=1.21U PD=1.33U
* device instance $1948 r0 *1 67.05,21.025 sky130_fd_pr__pfet_01v8
M$1948 167 331 346 346 sky130_fd_pr__pfet_01v8 L=0.15U W=1U AS=0.165P AD=0.36P
+ PS=1.33U PD=2.72U
* device instance $1949 r0 *1 68.33,20.735 sky130_fd_pr__pfet_01v8
M$1949 167 339 340 340 sky130_fd_pr__pfet_01v8 L=0.15U W=0.42U AS=0.1092P
+ AD=0.1573P PS=1.36U PD=1.39U
* device instance $1950 r0 *1 68.87,21.025 sky130_fd_pr__pfet_01v8
M$1950 347 341 167 167 sky130_fd_pr__pfet_01v8 L=0.15U W=1U AS=0.1573P
+ AD=0.105P PS=1.39U PD=1.21U
* device instance $1951 r0 *1 69.23,21.025 sky130_fd_pr__pfet_01v8
M$1951 333 340 347 347 sky130_fd_pr__pfet_01v8 L=0.15U W=1U AS=0.105P AD=0.26P
+ PS=1.21U PD=2.52U
* device instance $1952 r0 *1 6.98,22.205 sky130_fd_pr__pfet_01v8
M$1952 351 382 167 167 sky130_fd_pr__pfet_01v8 L=0.15U W=0.42U AS=0.1113P
+ AD=0.0609P PS=1.37U PD=0.71U
* device instance $1953 r0 *1 7.42,22.205 sky130_fd_pr__pfet_01v8
M$1953 167 109 351 351 sky130_fd_pr__pfet_01v8 L=0.15U W=0.42U AS=0.0609P
+ AD=0.1841P PS=0.71U PD=1.26U
* device instance $1954 r0 *1 8.19,22.315 sky130_fd_pr__pfet_01v8
M$1954 352 351 167 167 sky130_fd_pr__pfet_01v8 L=0.15U W=0.64U AS=0.1841P
+ AD=0.1696P PS=1.26U PD=1.81U
* device instance $1955 r0 *1 9.21,22.495 sky130_fd_pr__pfet_01v8
M$1955 354 352 353 353 sky130_fd_pr__pfet_01v8 L=0.15U W=1U AS=0.26P AD=0.135P
+ PS=2.52U PD=1.27U
* device instance $1956 r0 *1 9.63,22.495 sky130_fd_pr__pfet_01v8
M$1956 384 355 354 354 sky130_fd_pr__pfet_01v8 L=0.15U W=1U AS=0.135P AD=0.135P
+ PS=1.27U PD=1.27U
* device instance $1957 r0 *1 10.05,22.495 sky130_fd_pr__pfet_01v8
M$1957 354 91 384 384 sky130_fd_pr__pfet_01v8 L=0.15U W=1U AS=0.135P AD=0.26P
+ PS=1.27U PD=2.52U
* device instance $1958 r0 *1 10.99,22.495 sky130_fd_pr__pfet_01v8
M$1958 384 87 167 167 sky130_fd_pr__pfet_01v8 L=0.15U W=1U AS=0.26P AD=0.165P
+ PS=2.52U PD=1.33U
* device instance $1959 r0 *1 11.47,22.495 sky130_fd_pr__pfet_01v8
M$1959 167 383 384 384 sky130_fd_pr__pfet_01v8 L=0.15U W=1U AS=0.165P
+ AD=0.1575P PS=1.33U PD=1.315U
* device instance $1960 r0 *1 11.935,22.495 sky130_fd_pr__pfet_01v8
M$1960 405 353 167 167 sky130_fd_pr__pfet_01v8 L=0.15U W=1U AS=0.1575P AD=0.26P
+ PS=1.315U PD=2.52U
* device instance $1961 r0 *1 12.93,22.495 sky130_fd_pr__pfet_01v8
M$1961 393 385 356 356 sky130_fd_pr__pfet_01v8 L=0.15U W=1U AS=0.26P AD=0.135P
+ PS=2.52U PD=1.27U
* device instance $1962 r0 *1 13.35,22.495 sky130_fd_pr__pfet_01v8
M$1962 167 292 393 393 sky130_fd_pr__pfet_01v8 L=0.15U W=1U AS=0.135P AD=0.135P
+ PS=1.27U PD=1.27U
* device instance $1963 r0 *1 13.77,22.495 sky130_fd_pr__pfet_01v8
M$1963 357 292 167 167 sky130_fd_pr__pfet_01v8 L=0.15U W=1U AS=0.135P AD=0.135P
+ PS=1.27U PD=1.27U
* device instance $1964 r0 *1 14.19,22.495 sky130_fd_pr__pfet_01v8
M$1964 167 385 357 357 sky130_fd_pr__pfet_01v8 L=0.15U W=1U AS=0.135P AD=0.26P
+ PS=1.27U PD=2.52U
* device instance $1965 r0 *1 15.13,22.495 sky130_fd_pr__pfet_01v8
M$1965 383 356 357 357 sky130_fd_pr__pfet_01v8 L=0.15U W=1U AS=0.26P AD=0.3P
+ PS=2.52U PD=2.6U
* device instance $1966 r0 *1 27.195,22.495 sky130_fd_pr__pfet_01v8
M$1966 358 31 167 167 sky130_fd_pr__pfet_01v8 L=0.15U W=6U AS=1.005P AD=1.045P
+ PS=9.01U PD=9.09U
* device instance $1972 r0 *1 41.41,22.345 sky130_fd_pr__pfet_01v8
M$1972 167 329 359 359 sky130_fd_pr__pfet_01v8 L=0.15U W=0.64U AS=0.1664P
+ AD=0.0864P PS=1.8U PD=0.91U
* device instance $1973 r0 *1 41.83,22.345 sky130_fd_pr__pfet_01v8
M$1973 360 359 167 167 sky130_fd_pr__pfet_01v8 L=0.15U W=0.64U AS=0.0864P
+ AD=0.1664P PS=0.91U PD=1.8U
* device instance $1974 r0 *1 42.77,22.315 sky130_fd_pr__pfet_01v8
M$1974 400 387 362 362 sky130_fd_pr__pfet_01v8 L=0.15U W=0.64U AS=0.1664P
+ AD=0.0672P PS=1.8U PD=0.85U
* device instance $1975 r0 *1 43.13,22.315 sky130_fd_pr__pfet_01v8
M$1975 167 361 400 400 sky130_fd_pr__pfet_01v8 L=0.15U W=0.64U AS=0.0672P
+ AD=0.1664P PS=0.85U PD=1.8U
* device instance $1976 r0 *1 45.795,22.205 sky130_fd_pr__pfet_01v8
M$1976 363 360 362 362 sky130_fd_pr__pfet_01v8 L=0.15U W=0.42U AS=0.15985P
+ AD=0.06405P PS=1.265U PD=0.725U
* device instance $1977 r0 *1 46.25,22.205 sky130_fd_pr__pfet_01v8
M$1977 402 359 363 363 sky130_fd_pr__pfet_01v8 L=0.15U W=0.42U AS=0.06405P
+ AD=0.07665P PS=0.725U PD=0.785U
* device instance $1978 r0 *1 46.765,22.205 sky130_fd_pr__pfet_01v8
M$1978 167 364 402 402 sky130_fd_pr__pfet_01v8 L=0.15U W=0.42U AS=0.07665P
+ AD=0.178875P PS=0.785U PD=1.26U
* device instance $1979 r0 *1 44.07,22.315 sky130_fd_pr__pfet_01v8
M$1979 167 90 361 361 sky130_fd_pr__pfet_01v8 L=0.15U W=0.64U AS=0.1664P
+ AD=0.0928P PS=1.8U PD=0.93U
* device instance $1980 r0 *1 44.51,22.315 sky130_fd_pr__pfet_01v8
M$1980 401 90 167 167 sky130_fd_pr__pfet_01v8 L=0.15U W=0.64U AS=0.0928P
+ AD=0.1152P PS=0.93U PD=1U
* device instance $1981 r0 *1 45.02,22.315 sky130_fd_pr__pfet_01v8
M$1981 362 366 401 401 sky130_fd_pr__pfet_01v8 L=0.15U W=0.64U AS=0.1152P
+ AD=0.15985P PS=1U PD=1.265U
* device instance $1982 r0 *1 47.425,22.37 sky130_fd_pr__pfet_01v8
M$1982 364 363 167 167 sky130_fd_pr__pfet_01v8 L=0.15U W=0.75U AS=0.178875P
+ AD=0.195P PS=1.26U PD=2.02U
* device instance $1983 r0 *1 48.365,22.205 sky130_fd_pr__pfet_01v8
M$1983 403 364 167 167 sky130_fd_pr__pfet_01v8 L=0.15U W=0.42U AS=0.1092P
+ AD=0.06405P PS=1.36U PD=0.725U
* device instance $1984 r0 *1 48.82,22.205 sky130_fd_pr__pfet_01v8
M$1984 365 359 403 403 sky130_fd_pr__pfet_01v8 L=0.15U W=0.42U AS=0.06405P
+ AD=0.0567P PS=0.725U PD=0.69U
* device instance $1985 r0 *1 49.24,22.205 sky130_fd_pr__pfet_01v8
M$1985 404 360 365 365 sky130_fd_pr__pfet_01v8 L=0.15U W=0.42U AS=0.0567P
+ AD=0.0882P PS=0.69U PD=0.84U
* device instance $1986 r0 *1 49.81,22.205 sky130_fd_pr__pfet_01v8
M$1986 167 366 404 404 sky130_fd_pr__pfet_01v8 L=0.15U W=0.42U AS=0.0882P
+ AD=0.1113P PS=0.84U PD=1.37U
* device instance $1987 r0 *1 50.865,22.315 sky130_fd_pr__pfet_01v8
M$1987 167 365 366 366 sky130_fd_pr__pfet_01v8 L=0.15U W=0.64U AS=0.1728P
+ AD=0.154P PS=1.82U PD=1.335U
* device instance $1988 r0 *1 51.35,22.495 sky130_fd_pr__pfet_01v8
M$1988 367 365 167 167 sky130_fd_pr__pfet_01v8 L=0.15U W=1U AS=0.154P AD=0.28P
+ PS=1.335U PD=2.56U
* device instance $1989 r0 *1 53.39,22.495 sky130_fd_pr__pfet_01v8
M$1989 167 369 368 368 sky130_fd_pr__pfet_01v8 L=0.15U W=2U AS=0.415P AD=0.27P
+ PS=3.83U PD=2.54U
* device instance $1991 r0 *1 54.23,22.495 sky130_fd_pr__pfet_01v8
M$1991 370 341 368 368 sky130_fd_pr__pfet_01v8 L=0.15U W=2U AS=0.27P AD=0.415P
+ PS=2.54U PD=3.83U
* device instance $1993 r0 *1 55.63,22.495 sky130_fd_pr__pfet_01v8
M$1993 370 136 371 371 sky130_fd_pr__pfet_01v8 L=0.15U W=2U AS=0.415P AD=0.27P
+ PS=3.83U PD=2.54U
* device instance $1995 r0 *1 56.47,22.495 sky130_fd_pr__pfet_01v8
M$1995 407 231 371 371 sky130_fd_pr__pfet_01v8 L=0.15U W=2U AS=0.27P AD=0.395P
+ PS=2.54U PD=3.79U
* device instance $1997 r0 *1 60.73,22.495 sky130_fd_pr__pfet_01v8
M$1997 373 388 372 372 sky130_fd_pr__pfet_01v8 L=0.15U W=1U AS=0.26P AD=0.135P
+ PS=2.52U PD=1.27U
* device instance $1998 r0 *1 61.15,22.495 sky130_fd_pr__pfet_01v8
M$1998 389 341 373 373 sky130_fd_pr__pfet_01v8 L=0.15U W=1U AS=0.135P AD=0.135P
+ PS=1.27U PD=1.27U
* device instance $1999 r0 *1 61.57,22.495 sky130_fd_pr__pfet_01v8
M$1999 373 91 389 389 sky130_fd_pr__pfet_01v8 L=0.15U W=1U AS=0.135P AD=0.26P
+ PS=1.27U PD=2.52U
* device instance $2000 r0 *1 62.51,22.495 sky130_fd_pr__pfet_01v8
M$2000 389 137 167 167 sky130_fd_pr__pfet_01v8 L=0.15U W=1U AS=0.26P AD=0.165P
+ PS=2.52U PD=1.33U
* device instance $2001 r0 *1 62.99,22.495 sky130_fd_pr__pfet_01v8
M$2001 167 346 389 389 sky130_fd_pr__pfet_01v8 L=0.15U W=1U AS=0.165P
+ AD=0.1575P PS=1.33U PD=1.315U
* device instance $2002 r0 *1 63.455,22.495 sky130_fd_pr__pfet_01v8
M$2002 408 372 167 167 sky130_fd_pr__pfet_01v8 L=0.15U W=1U AS=0.1575P AD=0.26P
+ PS=1.315U PD=2.52U
* device instance $2003 r0 *1 64.41,22.345 sky130_fd_pr__pfet_01v8
M$2003 167 329 374 374 sky130_fd_pr__pfet_01v8 L=0.15U W=0.64U AS=0.1664P
+ AD=0.0864P PS=1.8U PD=0.91U
* device instance $2004 r0 *1 64.83,22.345 sky130_fd_pr__pfet_01v8
M$2004 375 374 167 167 sky130_fd_pr__pfet_01v8 L=0.15U W=0.64U AS=0.0864P
+ AD=0.1664P PS=0.91U PD=1.8U
* device instance $2005 r0 *1 65.77,22.315 sky130_fd_pr__pfet_01v8
M$2005 399 390 377 377 sky130_fd_pr__pfet_01v8 L=0.15U W=0.64U AS=0.1664P
+ AD=0.0672P PS=1.8U PD=0.85U
* device instance $2006 r0 *1 66.13,22.315 sky130_fd_pr__pfet_01v8
M$2006 167 376 399 399 sky130_fd_pr__pfet_01v8 L=0.15U W=0.64U AS=0.0672P
+ AD=0.1664P PS=0.85U PD=1.8U
* device instance $2007 r0 *1 68.795,22.205 sky130_fd_pr__pfet_01v8
M$2007 378 375 377 377 sky130_fd_pr__pfet_01v8 L=0.15U W=0.42U AS=0.15985P
+ AD=0.06405P PS=1.265U PD=0.725U
* device instance $2008 r0 *1 69.25,22.205 sky130_fd_pr__pfet_01v8
M$2008 394 374 378 378 sky130_fd_pr__pfet_01v8 L=0.15U W=0.42U AS=0.06405P
+ AD=0.07665P PS=0.725U PD=0.785U
* device instance $2009 r0 *1 69.765,22.205 sky130_fd_pr__pfet_01v8
M$2009 167 379 394 394 sky130_fd_pr__pfet_01v8 L=0.15U W=0.42U AS=0.07665P
+ AD=0.178875P PS=0.785U PD=1.26U
* device instance $2010 r0 *1 67.07,22.315 sky130_fd_pr__pfet_01v8
M$2010 167 1102 376 376 sky130_fd_pr__pfet_01v8 L=0.15U W=0.64U AS=0.1664P
+ AD=0.0928P PS=1.8U PD=0.93U
* device instance $2011 r0 *1 67.51,22.315 sky130_fd_pr__pfet_01v8
M$2011 398 1102 167 167 sky130_fd_pr__pfet_01v8 L=0.15U W=0.64U AS=0.0928P
+ AD=0.1152P PS=0.93U PD=1U
* device instance $2012 r0 *1 68.02,22.315 sky130_fd_pr__pfet_01v8
M$2012 377 381 398 398 sky130_fd_pr__pfet_01v8 L=0.15U W=0.64U AS=0.1152P
+ AD=0.15985P PS=1U PD=1.265U
* device instance $2013 r0 *1 70.425,22.37 sky130_fd_pr__pfet_01v8
M$2013 379 378 167 167 sky130_fd_pr__pfet_01v8 L=0.15U W=0.75U AS=0.178875P
+ AD=0.195P PS=1.26U PD=2.02U
* device instance $2014 r0 *1 71.365,22.205 sky130_fd_pr__pfet_01v8
M$2014 392 379 167 167 sky130_fd_pr__pfet_01v8 L=0.15U W=0.42U AS=0.1092P
+ AD=0.06405P PS=1.36U PD=0.725U
* device instance $2015 r0 *1 71.82,22.205 sky130_fd_pr__pfet_01v8
M$2015 380 374 392 392 sky130_fd_pr__pfet_01v8 L=0.15U W=0.42U AS=0.06405P
+ AD=0.0567P PS=0.725U PD=0.69U
* device instance $2016 r0 *1 72.24,22.205 sky130_fd_pr__pfet_01v8
M$2016 391 375 380 380 sky130_fd_pr__pfet_01v8 L=0.15U W=0.42U AS=0.0567P
+ AD=0.0882P PS=0.69U PD=0.84U
* device instance $2017 r0 *1 72.81,22.205 sky130_fd_pr__pfet_01v8
M$2017 167 381 391 391 sky130_fd_pr__pfet_01v8 L=0.15U W=0.42U AS=0.0882P
+ AD=0.1113P PS=0.84U PD=1.37U
* device instance $2018 r0 *1 73.865,22.315 sky130_fd_pr__pfet_01v8
M$2018 167 380 381 381 sky130_fd_pr__pfet_01v8 L=0.15U W=0.64U AS=0.1728P
+ AD=0.154P PS=1.82U PD=1.335U
* device instance $2019 r0 *1 74.35,22.495 sky130_fd_pr__pfet_01v8
M$2019 341 380 167 167 sky130_fd_pr__pfet_01v8 L=0.15U W=1U AS=0.154P AD=0.28P
+ PS=1.335U PD=2.56U
* device instance $2020 r0 *1 4.61,26.615 sky130_fd_pr__pfet_01v8
M$2020 167 31 425 425 sky130_fd_pr__pfet_01v8 L=0.15U W=0.64U AS=0.1664P
+ AD=0.0864P PS=1.8U PD=0.91U
* device instance $2021 r0 *1 5.03,26.615 sky130_fd_pr__pfet_01v8
M$2021 426 425 167 167 sky130_fd_pr__pfet_01v8 L=0.15U W=0.64U AS=0.0864P
+ AD=0.1664P PS=0.91U PD=1.8U
* device instance $2022 r0 *1 5.97,26.645 sky130_fd_pr__pfet_01v8
M$2022 464 447 427 427 sky130_fd_pr__pfet_01v8 L=0.15U W=0.64U AS=0.1664P
+ AD=0.0672P PS=1.8U PD=0.85U
* device instance $2023 r0 *1 6.33,26.645 sky130_fd_pr__pfet_01v8
M$2023 167 428 464 464 sky130_fd_pr__pfet_01v8 L=0.15U W=0.64U AS=0.0672P
+ AD=0.1664P PS=0.85U PD=1.8U
* device instance $2024 r0 *1 7.27,26.645 sky130_fd_pr__pfet_01v8
M$2024 167 90 428 428 sky130_fd_pr__pfet_01v8 L=0.15U W=0.64U AS=0.1664P
+ AD=0.0928P PS=1.8U PD=0.93U
* device instance $2025 r0 *1 7.71,26.645 sky130_fd_pr__pfet_01v8
M$2025 466 90 167 167 sky130_fd_pr__pfet_01v8 L=0.15U W=0.64U AS=0.0928P
+ AD=0.1152P PS=0.93U PD=1U
* device instance $2026 r0 *1 8.22,26.645 sky130_fd_pr__pfet_01v8
M$2026 427 448 466 466 sky130_fd_pr__pfet_01v8 L=0.15U W=0.64U AS=0.1152P
+ AD=0.15985P PS=1U PD=1.265U
* device instance $2027 r0 *1 8.995,26.755 sky130_fd_pr__pfet_01v8
M$2027 429 426 427 427 sky130_fd_pr__pfet_01v8 L=0.15U W=0.42U AS=0.15985P
+ AD=0.06405P PS=1.265U PD=0.725U
* device instance $2028 r0 *1 9.45,26.755 sky130_fd_pr__pfet_01v8
M$2028 468 425 429 429 sky130_fd_pr__pfet_01v8 L=0.15U W=0.42U AS=0.06405P
+ AD=0.07665P PS=0.725U PD=0.785U
* device instance $2029 r0 *1 9.965,26.755 sky130_fd_pr__pfet_01v8
M$2029 468 430 167 167 sky130_fd_pr__pfet_01v8 L=0.15U W=0.42U AS=0.178875P
+ AD=0.07665P PS=1.26U PD=0.785U
* device instance $2030 r0 *1 10.625,26.59 sky130_fd_pr__pfet_01v8
M$2030 430 429 167 167 sky130_fd_pr__pfet_01v8 L=0.15U W=0.75U AS=0.178875P
+ AD=0.195P PS=1.26U PD=2.02U
* device instance $2031 r0 *1 11.565,26.755 sky130_fd_pr__pfet_01v8
M$2031 469 430 167 167 sky130_fd_pr__pfet_01v8 L=0.15U W=0.42U AS=0.1092P
+ AD=0.06405P PS=1.36U PD=0.725U
* device instance $2032 r0 *1 12.02,26.755 sky130_fd_pr__pfet_01v8
M$2032 431 425 469 469 sky130_fd_pr__pfet_01v8 L=0.15U W=0.42U AS=0.06405P
+ AD=0.0567P PS=0.725U PD=0.69U
* device instance $2033 r0 *1 12.44,26.755 sky130_fd_pr__pfet_01v8
M$2033 470 426 431 431 sky130_fd_pr__pfet_01v8 L=0.15U W=0.42U AS=0.0567P
+ AD=0.0882P PS=0.69U PD=0.84U
* device instance $2034 r0 *1 13.01,26.755 sky130_fd_pr__pfet_01v8
M$2034 167 448 470 470 sky130_fd_pr__pfet_01v8 L=0.15U W=0.42U AS=0.0882P
+ AD=0.1113P PS=0.84U PD=1.37U
* device instance $2035 r0 *1 14.065,26.645 sky130_fd_pr__pfet_01v8
M$2035 448 431 167 167 sky130_fd_pr__pfet_01v8 L=0.15U W=0.64U AS=0.154P
+ AD=0.1728P PS=1.335U PD=1.82U
* device instance $2036 r0 *1 14.55,26.465 sky130_fd_pr__pfet_01v8
M$2036 355 431 167 167 sky130_fd_pr__pfet_01v8 L=0.15U W=1U AS=0.154P AD=0.28P
+ PS=1.335U PD=2.56U
* device instance $2037 r0 *1 17.49,22.785 sky130_fd_pr__pfet_01v8
M$2037 395 598 386 386 sky130_fd_pr__pfet_01v8 L=0.15U W=0.42U AS=0.1092P
+ AD=0.0693P PS=1.36U PD=0.75U
* device instance $2038 r0 *1 17.97,22.785 sky130_fd_pr__pfet_01v8
M$2038 396 12 395 395 sky130_fd_pr__pfet_01v8 L=0.15U W=0.42U AS=0.0693P
+ AD=0.0441P PS=0.75U PD=0.63U
* device instance $2039 r0 *1 18.33,22.785 sky130_fd_pr__pfet_01v8
M$2039 397 355 396 396 sky130_fd_pr__pfet_01v8 L=0.15U W=0.42U AS=0.0441P
+ AD=0.0693P PS=0.63U PD=0.75U
* device instance $2040 r0 *1 18.81,22.785 sky130_fd_pr__pfet_01v8
M$2040 397 163 167 167 sky130_fd_pr__pfet_01v8 L=0.15U W=0.42U AS=0.14825P
+ AD=0.0693P PS=1.34U PD=0.75U
* device instance $2041 r0 *1 19.3,22.495 sky130_fd_pr__pfet_01v8
M$2041 406 386 167 167 sky130_fd_pr__pfet_01v8 L=0.15U W=1U AS=0.14825P
+ AD=0.27P PS=1.34U PD=2.54U
* device instance $2042 r0 *1 18.19,26.175 sky130_fd_pr__pfet_01v8
M$2042 167 355 432 432 sky130_fd_pr__pfet_01v8 L=0.15U W=0.42U AS=0.1092P
+ AD=0.1573P PS=1.36U PD=1.39U
* device instance $2043 r0 *1 18.73,26.465 sky130_fd_pr__pfet_01v8
M$2043 471 449 167 167 sky130_fd_pr__pfet_01v8 L=0.15U W=1U AS=0.1573P
+ AD=0.105P PS=1.39U PD=1.21U
* device instance $2044 r0 *1 19.09,26.465 sky130_fd_pr__pfet_01v8
M$2044 433 432 471 471 sky130_fd_pr__pfet_01v8 L=0.15U W=1U AS=0.105P AD=0.26P
+ PS=1.21U PD=2.52U
* device instance $2045 r0 *1 20.25,26.465 sky130_fd_pr__pfet_01v8
M$2045 472 433 385 385 sky130_fd_pr__pfet_01v8 L=0.15U W=1U AS=0.26P AD=0.105P
+ PS=2.52U PD=1.21U
* device instance $2046 r0 *1 20.61,26.465 sky130_fd_pr__pfet_01v8
M$2046 167 337 472 472 sky130_fd_pr__pfet_01v8 L=0.15U W=1U AS=0.105P AD=0.26P
+ PS=1.21U PD=2.52U
* device instance $2047 r0 *1 21.87,26.175 sky130_fd_pr__pfet_01v8
M$2047 167 449 434 434 sky130_fd_pr__pfet_01v8 L=0.15U W=0.42U AS=0.1092P
+ AD=0.1573P PS=1.36U PD=1.39U
* device instance $2048 r0 *1 22.41,26.465 sky130_fd_pr__pfet_01v8
M$2048 473 355 167 167 sky130_fd_pr__pfet_01v8 L=0.15U W=1U AS=0.1573P
+ AD=0.105P PS=1.39U PD=1.21U
* device instance $2049 r0 *1 22.77,26.465 sky130_fd_pr__pfet_01v8
M$2049 337 434 473 473 sky130_fd_pr__pfet_01v8 L=0.15U W=1U AS=0.105P AD=0.26P
+ PS=1.21U PD=2.52U
* device instance $2050 r0 *1 34.985,26.465 sky130_fd_pr__pfet_01v8
M$2050 167 436 450 450 sky130_fd_pr__pfet_01v8 L=0.15U W=2U AS=0.41P AD=0.27P
+ PS=3.82U PD=2.54U
* device instance $2052 r0 *1 35.825,26.465 sky130_fd_pr__pfet_01v8
M$2052 167 437 450 450 sky130_fd_pr__pfet_01v8 L=0.15U W=2U AS=0.27P AD=0.415P
+ PS=2.54U PD=3.83U
* device instance $2054 r0 *1 37.225,26.465 sky130_fd_pr__pfet_01v8
M$2054 167 437 463 463 sky130_fd_pr__pfet_01v8 L=0.15U W=2U AS=0.415P AD=0.27P
+ PS=3.83U PD=2.54U
* device instance $2056 r0 *1 38.065,26.465 sky130_fd_pr__pfet_01v8
M$2056 439 436 463 463 sky130_fd_pr__pfet_01v8 L=0.15U W=2U AS=0.2875P
+ AD=0.4125P PS=2.575U PD=3.825U
* device instance $2058 r0 *1 39.46,26.465 sky130_fd_pr__pfet_01v8
M$2058 439 450 167 167 sky130_fd_pr__pfet_01v8 L=0.15U W=2U AS=0.395P AD=0.415P
+ PS=3.79U PD=3.83U
* device instance $2060 r0 *1 46.47,26.465 sky130_fd_pr__pfet_01v8
M$2060 167 329 440 440 sky130_fd_pr__pfet_01v8 L=0.15U W=3U AS=0.53P AD=0.405P
+ PS=5.06U PD=3.81U
* device instance $2063 r0 *1 47.73,26.465 sky130_fd_pr__pfet_01v8
M$2063 441 440 167 167 sky130_fd_pr__pfet_01v8 L=0.15U W=6U AS=0.81P AD=0.81P
+ PS=7.62U PD=7.62U
* device instance $2069 r0 *1 50.25,26.465 sky130_fd_pr__pfet_01v8
M$2069 442 441 167 167 sky130_fd_pr__pfet_01v8 L=0.15U W=16U AS=2.16P AD=2.285P
+ PS=20.32U PD=21.57U
* device instance $2085 r0 *1 61.26,26.755 sky130_fd_pr__pfet_01v8
M$2085 443 462 167 167 sky130_fd_pr__pfet_01v8 L=0.15U W=0.42U AS=0.1113P
+ AD=0.0609P PS=1.37U PD=0.71U
* device instance $2086 r0 *1 61.7,26.755 sky130_fd_pr__pfet_01v8
M$2086 443 109 167 167 sky130_fd_pr__pfet_01v8 L=0.15U W=0.42U AS=0.1841P
+ AD=0.0609P PS=1.26U PD=0.71U
* device instance $2087 r0 *1 62.47,26.645 sky130_fd_pr__pfet_01v8
M$2087 388 443 167 167 sky130_fd_pr__pfet_01v8 L=0.15U W=0.64U AS=0.1841P
+ AD=0.1696P PS=1.26U PD=1.81U
* device instance $2088 r0 *1 63.95,26.545 sky130_fd_pr__pfet_01v8
M$2088 311 333 167 167 sky130_fd_pr__pfet_01v8 L=0.15U W=1.68U AS=0.3318P
+ AD=0.3486P PS=3.31U PD=3.35U
* device instance $2090 r0 *1 65.33,26.175 sky130_fd_pr__pfet_01v8
M$2090 167 339 451 451 sky130_fd_pr__pfet_01v8 L=0.15U W=0.42U AS=0.1092P
+ AD=0.14575P PS=1.36U PD=1.335U
* device instance $2091 r0 *1 65.815,26.465 sky130_fd_pr__pfet_01v8
M$2091 338 341 167 167 sky130_fd_pr__pfet_01v8 L=0.15U W=1U AS=0.14575P
+ AD=0.135P PS=1.335U PD=1.27U
* device instance $2092 r0 *1 66.235,26.465 sky130_fd_pr__pfet_01v8
M$2092 167 451 338 338 sky130_fd_pr__pfet_01v8 L=0.15U W=1U AS=0.135P AD=0.265P
+ PS=1.27U PD=2.53U
* device instance $2093 r0 *1 68.175,26.56 sky130_fd_pr__pfet_01v8
M$2093 467 71 167 167 sky130_fd_pr__pfet_01v8 L=0.15U W=0.42U AS=0.15835P
+ AD=0.07665P PS=1.395U PD=0.785U
* device instance $2094 r0 *1 68.69,26.56 sky130_fd_pr__pfet_01v8
M$2094 444 339 467 467 sky130_fd_pr__pfet_01v8 L=0.15U W=0.42U AS=0.07665P
+ AD=0.1932P PS=0.785U PD=1.34U
* device instance $2095 r0 *1 69.76,26.56 sky130_fd_pr__pfet_01v8
M$2095 465 445 444 444 sky130_fd_pr__pfet_01v8 L=0.15U W=0.42U AS=0.1932P
+ AD=0.0441P PS=1.34U PD=0.63U
* device instance $2096 r0 *1 70.12,26.56 sky130_fd_pr__pfet_01v8
M$2096 167 446 465 465 sky130_fd_pr__pfet_01v8 L=0.15U W=0.42U AS=0.0441P
+ AD=0.0693P PS=0.63U PD=0.75U
* device instance $2097 r0 *1 70.6,26.56 sky130_fd_pr__pfet_01v8
M$2097 446 71 167 167 sky130_fd_pr__pfet_01v8 L=0.15U W=0.42U AS=0.0693P
+ AD=0.1176P PS=0.75U PD=1.4U
* device instance $2098 r0 *1 67.63,26.465 sky130_fd_pr__pfet_01v8
M$2098 167 444 390 390 sky130_fd_pr__pfet_01v8 L=0.15U W=1U AS=0.26P
+ AD=0.15835P PS=2.52U PD=1.395U
* device instance $2099 r0 *1 5.615,27.84 sky130_fd_pr__pfet_01v8
M$2099 500 71 167 167 sky130_fd_pr__pfet_01v8 L=0.15U W=0.42U AS=0.15835P
+ AD=0.07665P PS=1.395U PD=0.785U
* device instance $2100 r0 *1 6.13,27.84 sky130_fd_pr__pfet_01v8
M$2100 474 449 500 500 sky130_fd_pr__pfet_01v8 L=0.15U W=0.42U AS=0.07665P
+ AD=0.1932P PS=0.785U PD=1.34U
* device instance $2101 r0 *1 7.2,27.84 sky130_fd_pr__pfet_01v8
M$2101 501 461 474 474 sky130_fd_pr__pfet_01v8 L=0.15U W=0.42U AS=0.1932P
+ AD=0.0441P PS=1.34U PD=0.63U
* device instance $2102 r0 *1 7.56,27.84 sky130_fd_pr__pfet_01v8
M$2102 167 514 501 501 sky130_fd_pr__pfet_01v8 L=0.15U W=0.42U AS=0.0441P
+ AD=0.0693P PS=0.63U PD=0.75U
* device instance $2103 r0 *1 8.04,27.84 sky130_fd_pr__pfet_01v8
M$2103 514 71 167 167 sky130_fd_pr__pfet_01v8 L=0.15U W=0.42U AS=0.0693P
+ AD=0.1176P PS=0.75U PD=1.4U
* device instance $2104 r0 *1 5.07,27.935 sky130_fd_pr__pfet_01v8
M$2104 167 474 447 447 sky130_fd_pr__pfet_01v8 L=0.15U W=1U AS=0.26P
+ AD=0.15835P PS=2.52U PD=1.395U
* device instance $2105 r0 *1 9.21,27.785 sky130_fd_pr__pfet_01v8
M$2105 167 31 475 475 sky130_fd_pr__pfet_01v8 L=0.15U W=0.64U AS=0.1664P
+ AD=0.0864P PS=1.8U PD=0.91U
* device instance $2106 r0 *1 9.63,27.785 sky130_fd_pr__pfet_01v8
M$2106 476 475 167 167 sky130_fd_pr__pfet_01v8 L=0.15U W=0.64U AS=0.0864P
+ AD=0.1664P PS=0.91U PD=1.8U
* device instance $2107 r0 *1 10.57,27.755 sky130_fd_pr__pfet_01v8
M$2107 503 405 478 478 sky130_fd_pr__pfet_01v8 L=0.15U W=0.64U AS=0.1664P
+ AD=0.0672P PS=1.8U PD=0.85U
* device instance $2108 r0 *1 10.93,27.755 sky130_fd_pr__pfet_01v8
M$2108 167 477 503 503 sky130_fd_pr__pfet_01v8 L=0.15U W=0.64U AS=0.0672P
+ AD=0.1664P PS=0.85U PD=1.8U
* device instance $2109 r0 *1 13.595,27.645 sky130_fd_pr__pfet_01v8
M$2109 479 476 478 478 sky130_fd_pr__pfet_01v8 L=0.15U W=0.42U AS=0.15985P
+ AD=0.06405P PS=1.265U PD=0.725U
* device instance $2110 r0 *1 14.05,27.645 sky130_fd_pr__pfet_01v8
M$2110 507 475 479 479 sky130_fd_pr__pfet_01v8 L=0.15U W=0.42U AS=0.06405P
+ AD=0.07665P PS=0.725U PD=0.785U
* device instance $2111 r0 *1 14.565,27.645 sky130_fd_pr__pfet_01v8
M$2111 167 480 507 507 sky130_fd_pr__pfet_01v8 L=0.15U W=0.42U AS=0.07665P
+ AD=0.178875P PS=0.785U PD=1.26U
* device instance $2112 r0 *1 11.87,27.755 sky130_fd_pr__pfet_01v8
M$2112 167 315 477 477 sky130_fd_pr__pfet_01v8 L=0.15U W=0.64U AS=0.1664P
+ AD=0.0928P PS=1.8U PD=0.93U
* device instance $2113 r0 *1 12.31,27.755 sky130_fd_pr__pfet_01v8
M$2113 505 315 167 167 sky130_fd_pr__pfet_01v8 L=0.15U W=0.64U AS=0.0928P
+ AD=0.1152P PS=0.93U PD=1U
* device instance $2114 r0 *1 12.82,27.755 sky130_fd_pr__pfet_01v8
M$2114 478 482 505 505 sky130_fd_pr__pfet_01v8 L=0.15U W=0.64U AS=0.1152P
+ AD=0.15985P PS=1U PD=1.265U
* device instance $2115 r0 *1 15.225,27.81 sky130_fd_pr__pfet_01v8
M$2115 480 479 167 167 sky130_fd_pr__pfet_01v8 L=0.15U W=0.75U AS=0.178875P
+ AD=0.195P PS=1.26U PD=2.02U
* device instance $2116 r0 *1 16.165,27.645 sky130_fd_pr__pfet_01v8
M$2116 508 480 167 167 sky130_fd_pr__pfet_01v8 L=0.15U W=0.42U AS=0.1092P
+ AD=0.06405P PS=1.36U PD=0.725U
* device instance $2117 r0 *1 16.62,27.645 sky130_fd_pr__pfet_01v8
M$2117 481 475 508 508 sky130_fd_pr__pfet_01v8 L=0.15U W=0.42U AS=0.06405P
+ AD=0.0567P PS=0.725U PD=0.69U
* device instance $2118 r0 *1 17.04,27.645 sky130_fd_pr__pfet_01v8
M$2118 509 476 481 481 sky130_fd_pr__pfet_01v8 L=0.15U W=0.42U AS=0.0567P
+ AD=0.0882P PS=0.69U PD=0.84U
* device instance $2119 r0 *1 17.61,27.645 sky130_fd_pr__pfet_01v8
M$2119 167 482 509 509 sky130_fd_pr__pfet_01v8 L=0.15U W=0.42U AS=0.0882P
+ AD=0.1113P PS=0.84U PD=1.37U
* device instance $2120 r0 *1 18.665,27.755 sky130_fd_pr__pfet_01v8
M$2120 167 481 482 482 sky130_fd_pr__pfet_01v8 L=0.15U W=0.64U AS=0.1728P
+ AD=0.154P PS=1.82U PD=1.335U
* device instance $2121 r0 *1 19.15,27.935 sky130_fd_pr__pfet_01v8
M$2121 449 481 167 167 sky130_fd_pr__pfet_01v8 L=0.15U W=1U AS=0.154P AD=0.28P
+ PS=1.335U PD=2.56U
* device instance $2122 r0 *1 28.08,31.615 sky130_fd_pr__pfet_01v8
M$2122 548 336 534 534 sky130_fd_pr__pfet_01v8 L=0.15U W=0.42U AS=0.1092P
+ AD=0.0441P PS=1.36U PD=0.63U
* device instance $2123 r0 *1 28.44,31.615 sky130_fd_pr__pfet_01v8
M$2123 549 433 548 548 sky130_fd_pr__pfet_01v8 L=0.15U W=0.42U AS=0.0441P
+ AD=0.0693P PS=0.63U PD=0.75U
* device instance $2124 r0 *1 28.92,31.615 sky130_fd_pr__pfet_01v8
M$2124 167 495 549 549 sky130_fd_pr__pfet_01v8 L=0.15U W=0.42U AS=0.0693P
+ AD=0.14825P PS=0.75U PD=1.34U
* device instance $2125 r0 *1 29.41,31.905 sky130_fd_pr__pfet_01v8
M$2125 544 534 167 167 sky130_fd_pr__pfet_01v8 L=0.15U W=1U AS=0.14825P
+ AD=0.28P PS=1.34U PD=2.56U
* device instance $2126 r0 *1 30.91,27.935 sky130_fd_pr__pfet_01v8
M$2126 167 336 494 494 sky130_fd_pr__pfet_01v8 L=0.15U W=4U AS=0.685P AD=0.54P
+ PS=6.37U PD=5.08U
* device instance $2130 r0 *1 32.59,27.935 sky130_fd_pr__pfet_01v8
M$2130 483 433 494 494 sky130_fd_pr__pfet_01v8 L=0.15U W=4U AS=0.54P AD=0.665P
+ PS=5.08U PD=6.33U
* device instance $2134 r0 *1 31.77,31.905 sky130_fd_pr__pfet_01v8
M$2134 437 544 167 167 sky130_fd_pr__pfet_01v8 L=0.15U W=1U AS=0.26P AD=0.135P
+ PS=2.52U PD=1.27U
* device instance $2135 r0 *1 32.19,31.905 sky130_fd_pr__pfet_01v8
M$2135 167 496 437 437 sky130_fd_pr__pfet_01v8 L=0.15U W=1U AS=0.135P AD=0.26P
+ PS=1.27U PD=2.52U
* device instance $2136 r0 *1 34.79,27.935 sky130_fd_pr__pfet_01v8
M$2136 483 495 278 278 sky130_fd_pr__pfet_01v8 L=0.15U W=4U AS=0.665P AD=0.55P
+ PS=6.33U PD=5.1U
* device instance $2140 r0 *1 36.49,27.935 sky130_fd_pr__pfet_01v8
M$2140 167 496 278 278 sky130_fd_pr__pfet_01v8 L=0.15U W=4U AS=0.55P AD=0.54P
+ PS=5.1U PD=5.08U
* device instance $2144 r0 *1 38.17,27.935 sky130_fd_pr__pfet_01v8
M$2144 167 484 278 278 sky130_fd_pr__pfet_01v8 L=0.15U W=4U AS=0.54P AD=0.665P
+ PS=5.08U PD=6.33U
* device instance $2148 r0 *1 35.91,31.905 sky130_fd_pr__pfet_01v8
M$2148 436 262 167 167 sky130_fd_pr__pfet_01v8 L=0.15U W=1U AS=0.26P AD=0.135P
+ PS=2.52U PD=1.27U
* device instance $2149 r0 *1 36.33,31.905 sky130_fd_pr__pfet_01v8
M$2149 167 484 436 436 sky130_fd_pr__pfet_01v8 L=0.15U W=1U AS=0.135P AD=0.26P
+ PS=1.27U PD=2.52U
* device instance $2150 r0 *1 38.19,31.905 sky130_fd_pr__pfet_01v8
M$2150 545 118 535 535 sky130_fd_pr__pfet_01v8 L=0.15U W=1U AS=0.26P AD=0.135P
+ PS=2.52U PD=1.27U
* device instance $2151 r0 *1 38.61,31.905 sky130_fd_pr__pfet_01v8
M$2151 546 367 545 545 sky130_fd_pr__pfet_01v8 L=0.15U W=1U AS=0.135P AD=0.135P
+ PS=1.27U PD=1.27U
* device instance $2152 r0 *1 39.03,31.905 sky130_fd_pr__pfet_01v8
M$2152 545 91 546 546 sky130_fd_pr__pfet_01v8 L=0.15U W=1U AS=0.135P AD=0.26P
+ PS=1.27U PD=2.52U
* device instance $2153 r0 *1 39.97,31.905 sky130_fd_pr__pfet_01v8
M$2153 546 137 167 167 sky130_fd_pr__pfet_01v8 L=0.15U W=1U AS=0.26P AD=0.165P
+ PS=2.52U PD=1.33U
* device instance $2154 r0 *1 40.45,31.905 sky130_fd_pr__pfet_01v8
M$2154 167 439 546 546 sky130_fd_pr__pfet_01v8 L=0.15U W=1U AS=0.165P
+ AD=0.1575P PS=1.33U PD=1.315U
* device instance $2155 r0 *1 40.915,31.905 sky130_fd_pr__pfet_01v8
M$2155 547 535 167 167 sky130_fd_pr__pfet_01v8 L=0.15U W=1U AS=0.1575P AD=0.26P
+ PS=1.315U PD=2.52U
* device instance $2156 r0 *1 41.87,28.225 sky130_fd_pr__pfet_01v8
M$2156 498 497 167 167 sky130_fd_pr__pfet_01v8 L=0.15U W=0.42U AS=0.14575P
+ AD=0.1092P PS=1.335U PD=1.36U
* device instance $2157 r0 *1 42.355,27.935 sky130_fd_pr__pfet_01v8
M$2157 262 367 167 167 sky130_fd_pr__pfet_01v8 L=0.15U W=1U AS=0.14575P
+ AD=0.135P PS=1.335U PD=1.27U
* device instance $2158 r0 *1 42.775,27.935 sky130_fd_pr__pfet_01v8
M$2158 167 498 262 262 sky130_fd_pr__pfet_01v8 L=0.15U W=1U AS=0.135P AD=0.265P
+ PS=1.27U PD=2.53U
* device instance $2159 r0 *1 44.715,27.84 sky130_fd_pr__pfet_01v8
M$2159 513 71 167 167 sky130_fd_pr__pfet_01v8 L=0.15U W=0.42U AS=0.15835P
+ AD=0.07665P PS=1.395U PD=0.785U
* device instance $2160 r0 *1 45.23,27.84 sky130_fd_pr__pfet_01v8
M$2160 485 497 513 513 sky130_fd_pr__pfet_01v8 L=0.15U W=0.42U AS=0.07665P
+ AD=0.1932P PS=0.785U PD=1.34U
* device instance $2161 r0 *1 46.3,27.84 sky130_fd_pr__pfet_01v8
M$2161 512 499 485 485 sky130_fd_pr__pfet_01v8 L=0.15U W=0.42U AS=0.1932P
+ AD=0.0441P PS=1.34U PD=0.63U
* device instance $2162 r0 *1 46.66,27.84 sky130_fd_pr__pfet_01v8
M$2162 167 516 512 512 sky130_fd_pr__pfet_01v8 L=0.15U W=0.42U AS=0.0441P
+ AD=0.0693P PS=0.63U PD=0.75U
* device instance $2163 r0 *1 47.14,27.84 sky130_fd_pr__pfet_01v8
M$2163 516 71 167 167 sky130_fd_pr__pfet_01v8 L=0.15U W=0.42U AS=0.0693P
+ AD=0.1176P PS=0.75U PD=1.4U
* device instance $2164 r0 *1 44.17,27.935 sky130_fd_pr__pfet_01v8
M$2164 167 485 387 387 sky130_fd_pr__pfet_01v8 L=0.15U W=1U AS=0.26P
+ AD=0.15835P PS=2.52U PD=1.395U
* device instance $2165 r0 *1 44.87,31.615 sky130_fd_pr__pfet_01v8
M$2165 167 497 537 537 sky130_fd_pr__pfet_01v8 L=0.15U W=0.42U AS=0.1092P
+ AD=0.1573P PS=1.36U PD=1.39U
* device instance $2166 r0 *1 45.41,31.905 sky130_fd_pr__pfet_01v8
M$2166 551 367 167 167 sky130_fd_pr__pfet_01v8 L=0.15U W=1U AS=0.1573P
+ AD=0.105P PS=1.39U PD=1.21U
* device instance $2167 r0 *1 45.77,31.905 sky130_fd_pr__pfet_01v8
M$2167 536 537 551 551 sky130_fd_pr__pfet_01v8 L=0.15U W=1U AS=0.105P AD=0.26P
+ PS=1.21U PD=2.52U
* device instance $2168 r0 *1 46.995,31.905 sky130_fd_pr__pfet_01v8
M$2168 538 997 167 167 sky130_fd_pr__pfet_01v8 L=0.15U W=2U AS=0.395P AD=0.27P
+ PS=3.79U PD=2.54U
* device instance $2170 r0 *1 47.835,31.905 sky130_fd_pr__pfet_01v8
M$2170 137 538 167 167 sky130_fd_pr__pfet_01v8 L=0.15U W=6U AS=0.81P AD=0.935P
+ PS=7.62U PD=8.87U
* device instance $2176 r0 *1 60.73,27.785 sky130_fd_pr__pfet_01v8
M$2176 167 329 486 486 sky130_fd_pr__pfet_01v8 L=0.15U W=0.64U AS=0.1664P
+ AD=0.0864P PS=1.8U PD=0.91U
* device instance $2177 r0 *1 61.15,27.785 sky130_fd_pr__pfet_01v8
M$2177 487 486 167 167 sky130_fd_pr__pfet_01v8 L=0.15U W=0.64U AS=0.0864P
+ AD=0.1664P PS=0.91U PD=1.8U
* device instance $2178 r0 *1 62.09,27.755 sky130_fd_pr__pfet_01v8
M$2178 511 408 489 489 sky130_fd_pr__pfet_01v8 L=0.15U W=0.64U AS=0.1664P
+ AD=0.0672P PS=1.8U PD=0.85U
* device instance $2179 r0 *1 62.45,27.755 sky130_fd_pr__pfet_01v8
M$2179 167 488 511 511 sky130_fd_pr__pfet_01v8 L=0.15U W=0.64U AS=0.0672P
+ AD=0.1664P PS=0.85U PD=1.8U
* device instance $2180 r0 *1 65.115,27.645 sky130_fd_pr__pfet_01v8
M$2180 490 487 489 489 sky130_fd_pr__pfet_01v8 L=0.15U W=0.42U AS=0.15985P
+ AD=0.06405P PS=1.265U PD=0.725U
* device instance $2181 r0 *1 65.57,27.645 sky130_fd_pr__pfet_01v8
M$2181 506 486 490 490 sky130_fd_pr__pfet_01v8 L=0.15U W=0.42U AS=0.06405P
+ AD=0.07665P PS=0.725U PD=0.785U
* device instance $2182 r0 *1 66.085,27.645 sky130_fd_pr__pfet_01v8
M$2182 167 491 506 506 sky130_fd_pr__pfet_01v8 L=0.15U W=0.42U AS=0.07665P
+ AD=0.178875P PS=0.785U PD=1.26U
* device instance $2183 r0 *1 63.39,27.755 sky130_fd_pr__pfet_01v8
M$2183 167 315 488 488 sky130_fd_pr__pfet_01v8 L=0.15U W=0.64U AS=0.1664P
+ AD=0.0928P PS=1.8U PD=0.93U
* device instance $2184 r0 *1 63.83,27.755 sky130_fd_pr__pfet_01v8
M$2184 510 315 167 167 sky130_fd_pr__pfet_01v8 L=0.15U W=0.64U AS=0.0928P
+ AD=0.1152P PS=0.93U PD=1U
* device instance $2185 r0 *1 64.34,27.755 sky130_fd_pr__pfet_01v8
M$2185 489 493 510 510 sky130_fd_pr__pfet_01v8 L=0.15U W=0.64U AS=0.1152P
+ AD=0.15985P PS=1U PD=1.265U
* device instance $2186 r0 *1 66.745,27.81 sky130_fd_pr__pfet_01v8
M$2186 491 490 167 167 sky130_fd_pr__pfet_01v8 L=0.15U W=0.75U AS=0.178875P
+ AD=0.195P PS=1.26U PD=2.02U
* device instance $2187 r0 *1 67.685,27.645 sky130_fd_pr__pfet_01v8
M$2187 504 491 167 167 sky130_fd_pr__pfet_01v8 L=0.15U W=0.42U AS=0.1092P
+ AD=0.06405P PS=1.36U PD=0.725U
* device instance $2188 r0 *1 68.14,27.645 sky130_fd_pr__pfet_01v8
M$2188 492 486 504 504 sky130_fd_pr__pfet_01v8 L=0.15U W=0.42U AS=0.06405P
+ AD=0.0567P PS=0.725U PD=0.69U
* device instance $2189 r0 *1 68.56,27.645 sky130_fd_pr__pfet_01v8
M$2189 502 487 492 492 sky130_fd_pr__pfet_01v8 L=0.15U W=0.42U AS=0.0567P
+ AD=0.0882P PS=0.69U PD=0.84U
* device instance $2190 r0 *1 69.13,27.645 sky130_fd_pr__pfet_01v8
M$2190 167 493 502 502 sky130_fd_pr__pfet_01v8 L=0.15U W=0.42U AS=0.0882P
+ AD=0.1113P PS=0.84U PD=1.37U
* device instance $2191 r0 *1 70.185,27.755 sky130_fd_pr__pfet_01v8
M$2191 167 492 493 493 sky130_fd_pr__pfet_01v8 L=0.15U W=0.64U AS=0.1728P
+ AD=0.154P PS=1.82U PD=1.335U
* device instance $2192 r0 *1 70.67,27.935 sky130_fd_pr__pfet_01v8
M$2192 339 492 167 167 sky130_fd_pr__pfet_01v8 L=0.15U W=1U AS=0.154P AD=0.28P
+ PS=1.335U PD=2.56U
* device instance $2193 r0 *1 13.35,33.295 sky130_fd_pr__pfet_01v8
M$2193 576 552 167 167 sky130_fd_pr__pfet_01v8 L=0.15U W=1.68U AS=0.3318P
+ AD=0.3486P PS=3.31U PD=3.35U
* device instance $2195 r0 *1 26.285,32.085 sky130_fd_pr__pfet_01v8
M$2195 550 433 167 167 sky130_fd_pr__pfet_01v8 L=0.15U W=0.64U AS=0.1696P
+ AD=0.0768P PS=1.81U PD=0.88U
* device instance $2196 r0 *1 26.675,32.085 sky130_fd_pr__pfet_01v8
M$2196 543 336 550 550 sky130_fd_pr__pfet_01v8 L=0.15U W=0.64U AS=0.0768P
+ AD=0.0896P PS=0.88U PD=0.92U
* device instance $2197 r0 *1 27.105,32.085 sky130_fd_pr__pfet_01v8
M$2197 167 495 543 543 sky130_fd_pr__pfet_01v8 L=0.15U W=0.64U AS=0.0896P
+ AD=0.1824P PS=0.92U PD=1.85U
* device instance $2198 r0 *1 27.155,33.375 sky130_fd_pr__pfet_01v8
M$2198 554 544 167 167 sky130_fd_pr__pfet_01v8 L=0.15U W=1U AS=0.265P AD=0.14P
+ PS=2.53U PD=1.28U
* device instance $2199 r0 *1 27.585,33.375 sky130_fd_pr__pfet_01v8
M$2199 167 543 554 554 sky130_fd_pr__pfet_01v8 L=0.15U W=1U AS=0.14P AD=0.1775P
+ PS=1.28U PD=1.355U
* device instance $2200 r0 *1 28.09,33.375 sky130_fd_pr__pfet_01v8
M$2200 553 554 167 167 sky130_fd_pr__pfet_01v8 L=0.15U W=4U AS=0.5975P
+ AD=0.705P PS=5.195U PD=6.41U
* device instance $2204 r0 *1 41.85,33.195 sky130_fd_pr__pfet_01v8
M$2204 573 547 557 557 sky130_fd_pr__pfet_01v8 L=0.15U W=0.64U AS=0.1664P
+ AD=0.0672P PS=1.8U PD=0.85U
* device instance $2205 r0 *1 42.21,33.195 sky130_fd_pr__pfet_01v8
M$2205 167 558 573 573 sky130_fd_pr__pfet_01v8 L=0.15U W=0.64U AS=0.0672P
+ AD=0.1664P PS=0.85U PD=1.8U
* device instance $2206 r0 *1 41.87,31.985 sky130_fd_pr__pfet_01v8
M$2206 484 536 167 167 sky130_fd_pr__pfet_01v8 L=0.15U W=1.68U AS=0.3318P
+ AD=0.3486P PS=3.31U PD=3.35U
* device instance $2208 r0 *1 44.875,33.085 sky130_fd_pr__pfet_01v8
M$2208 559 556 557 557 sky130_fd_pr__pfet_01v8 L=0.15U W=0.42U AS=0.15985P
+ AD=0.06405P PS=1.265U PD=0.725U
* device instance $2209 r0 *1 45.33,33.085 sky130_fd_pr__pfet_01v8
M$2209 569 555 559 559 sky130_fd_pr__pfet_01v8 L=0.15U W=0.42U AS=0.06405P
+ AD=0.07665P PS=0.725U PD=0.785U
* device instance $2210 r0 *1 45.845,33.085 sky130_fd_pr__pfet_01v8
M$2210 167 560 569 569 sky130_fd_pr__pfet_01v8 L=0.15U W=0.42U AS=0.07665P
+ AD=0.178875P PS=0.785U PD=1.26U
* device instance $2211 r0 *1 43.15,33.195 sky130_fd_pr__pfet_01v8
M$2211 167 315 558 558 sky130_fd_pr__pfet_01v8 L=0.15U W=0.64U AS=0.1664P
+ AD=0.0928P PS=1.8U PD=0.93U
* device instance $2212 r0 *1 43.59,33.195 sky130_fd_pr__pfet_01v8
M$2212 574 315 167 167 sky130_fd_pr__pfet_01v8 L=0.15U W=0.64U AS=0.0928P
+ AD=0.1152P PS=0.93U PD=1U
* device instance $2213 r0 *1 44.1,33.195 sky130_fd_pr__pfet_01v8
M$2213 557 562 574 574 sky130_fd_pr__pfet_01v8 L=0.15U W=0.64U AS=0.1152P
+ AD=0.15985P PS=1U PD=1.265U
* device instance $2214 r0 *1 46.505,33.25 sky130_fd_pr__pfet_01v8
M$2214 560 559 167 167 sky130_fd_pr__pfet_01v8 L=0.15U W=0.75U AS=0.178875P
+ AD=0.195P PS=1.26U PD=2.02U
* device instance $2215 r0 *1 47.445,33.085 sky130_fd_pr__pfet_01v8
M$2215 568 560 167 167 sky130_fd_pr__pfet_01v8 L=0.15U W=0.42U AS=0.1092P
+ AD=0.06405P PS=1.36U PD=0.725U
* device instance $2216 r0 *1 47.9,33.085 sky130_fd_pr__pfet_01v8
M$2216 561 555 568 568 sky130_fd_pr__pfet_01v8 L=0.15U W=0.42U AS=0.06405P
+ AD=0.0567P PS=0.725U PD=0.69U
* device instance $2217 r0 *1 48.32,33.085 sky130_fd_pr__pfet_01v8
M$2217 567 556 561 561 sky130_fd_pr__pfet_01v8 L=0.15U W=0.42U AS=0.0567P
+ AD=0.0882P PS=0.69U PD=0.84U
* device instance $2218 r0 *1 48.89,33.085 sky130_fd_pr__pfet_01v8
M$2218 167 562 567 567 sky130_fd_pr__pfet_01v8 L=0.15U W=0.42U AS=0.0882P
+ AD=0.1113P PS=0.84U PD=1.37U
* device instance $2219 r0 *1 49.945,33.195 sky130_fd_pr__pfet_01v8
M$2219 167 561 562 562 sky130_fd_pr__pfet_01v8 L=0.15U W=0.64U AS=0.1728P
+ AD=0.154P PS=1.82U PD=1.335U
* device instance $2220 r0 *1 50.43,33.375 sky130_fd_pr__pfet_01v8
M$2220 497 561 167 167 sky130_fd_pr__pfet_01v8 L=0.15U W=1U AS=0.154P AD=0.28P
+ PS=1.335U PD=2.56U
* device instance $2221 r0 *1 59.81,33.375 sky130_fd_pr__pfet_01v8
M$2221 167 304 563 563 sky130_fd_pr__pfet_01v8 L=0.15U W=1U AS=0.26P AD=0.135P
+ PS=2.52U PD=1.27U
* device instance $2222 r0 *1 60.23,33.375 sky130_fd_pr__pfet_01v8
M$2222 575 563 167 167 sky130_fd_pr__pfet_01v8 L=0.15U W=4U AS=0.54P AD=0.665P
+ PS=5.08U PD=6.33U
* device instance $2226 r0 *1 62.57,33.375 sky130_fd_pr__pfet_01v8
M$2226 565 570 564 564 sky130_fd_pr__pfet_01v8 L=0.15U W=1U AS=0.26P AD=0.135P
+ PS=2.52U PD=1.27U
* device instance $2227 r0 *1 62.99,33.375 sky130_fd_pr__pfet_01v8
M$2227 566 571 565 565 sky130_fd_pr__pfet_01v8 L=0.15U W=1U AS=0.135P AD=0.135P
+ PS=1.27U PD=1.27U
* device instance $2228 r0 *1 63.41,33.375 sky130_fd_pr__pfet_01v8
M$2228 565 91 566 566 sky130_fd_pr__pfet_01v8 L=0.15U W=1U AS=0.135P AD=0.26P
+ PS=1.27U PD=2.52U
* device instance $2229 r0 *1 64.35,33.375 sky130_fd_pr__pfet_01v8
M$2229 566 87 167 167 sky130_fd_pr__pfet_01v8 L=0.15U W=1U AS=0.26P AD=0.165P
+ PS=2.52U PD=1.33U
* device instance $2230 r0 *1 64.83,33.375 sky130_fd_pr__pfet_01v8
M$2230 167 572 566 566 sky130_fd_pr__pfet_01v8 L=0.15U W=1U AS=0.165P
+ AD=0.1575P PS=1.33U PD=1.315U
* device instance $2231 r0 *1 65.295,33.375 sky130_fd_pr__pfet_01v8
M$2231 712 564 167 167 sky130_fd_pr__pfet_01v8 L=0.15U W=1U AS=0.1575P AD=0.26P
+ PS=1.315U PD=2.52U
* device instance $2232 r0 *1 8.75,37.345 sky130_fd_pr__pfet_01v8
M$2232 611 597 585 585 sky130_fd_pr__pfet_01v8 L=0.15U W=1U AS=0.26P AD=0.135P
+ PS=2.52U PD=1.27U
* device instance $2233 r0 *1 9.17,37.345 sky130_fd_pr__pfet_01v8
M$2233 612 598 611 611 sky130_fd_pr__pfet_01v8 L=0.15U W=1U AS=0.135P AD=0.135P
+ PS=1.27U PD=1.27U
* device instance $2234 r0 *1 9.59,37.345 sky130_fd_pr__pfet_01v8
M$2234 611 91 612 612 sky130_fd_pr__pfet_01v8 L=0.15U W=1U AS=0.135P AD=0.26P
+ PS=1.27U PD=2.52U
* device instance $2235 r0 *1 10.53,37.345 sky130_fd_pr__pfet_01v8
M$2235 612 87 167 167 sky130_fd_pr__pfet_01v8 L=0.15U W=1U AS=0.26P AD=0.165P
+ PS=2.52U PD=1.33U
* device instance $2236 r0 *1 11.01,37.345 sky130_fd_pr__pfet_01v8
M$2236 167 599 612 612 sky130_fd_pr__pfet_01v8 L=0.15U W=1U AS=0.165P
+ AD=0.1575P PS=1.33U PD=1.315U
* device instance $2237 r0 *1 11.475,37.345 sky130_fd_pr__pfet_01v8
M$2237 586 585 167 167 sky130_fd_pr__pfet_01v8 L=0.15U W=1U AS=0.1575P AD=0.26P
+ PS=1.315U PD=2.52U
* device instance $2238 r0 *1 12.53,37.525 sky130_fd_pr__pfet_01v8
M$2238 616 576 587 587 sky130_fd_pr__pfet_01v8 L=0.15U W=0.64U AS=0.1664P
+ AD=0.0672P PS=1.8U PD=0.85U
* device instance $2239 r0 *1 12.89,37.525 sky130_fd_pr__pfet_01v8
M$2239 167 588 616 616 sky130_fd_pr__pfet_01v8 L=0.15U W=0.64U AS=0.0672P
+ AD=0.0864P PS=0.85U PD=0.91U
* device instance $2240 r0 *1 13.31,37.525 sky130_fd_pr__pfet_01v8
M$2240 617 588 167 167 sky130_fd_pr__pfet_01v8 L=0.15U W=0.64U AS=0.0864P
+ AD=0.0672P PS=0.91U PD=0.85U
* device instance $2241 r0 *1 13.67,37.525 sky130_fd_pr__pfet_01v8
M$2241 587 589 617 617 sky130_fd_pr__pfet_01v8 L=0.15U W=0.64U AS=0.0672P
+ AD=0.0864P PS=0.85U PD=0.91U
* device instance $2242 r0 *1 14.09,37.525 sky130_fd_pr__pfet_01v8
M$2242 618 589 587 587 sky130_fd_pr__pfet_01v8 L=0.15U W=0.64U AS=0.0864P
+ AD=0.0672P PS=0.91U PD=0.85U
* device instance $2243 r0 *1 14.45,37.525 sky130_fd_pr__pfet_01v8
M$2243 618 576 167 167 sky130_fd_pr__pfet_01v8 L=0.15U W=0.64U AS=0.237P
+ AD=0.0672P PS=1.6U PD=0.85U
* device instance $2244 r0 *1 15.2,37.345 sky130_fd_pr__pfet_01v8
M$2244 334 587 167 167 sky130_fd_pr__pfet_01v8 L=0.15U W=2U AS=0.372P AD=0.405P
+ PS=2.87U PD=3.81U
* device instance $2246 r0 *1 31.29,37.425 sky130_fd_pr__pfet_01v8
M$2246 495 600 167 167 sky130_fd_pr__pfet_01v8 L=0.15U W=1.68U AS=0.3318P
+ AD=0.3486P PS=3.31U PD=3.35U
* device instance $2248 r0 *1 34.05,37.055 sky130_fd_pr__pfet_01v8
M$2248 167 628 590 590 sky130_fd_pr__pfet_01v8 L=0.15U W=0.42U AS=0.1092P
+ AD=0.14575P PS=1.36U PD=1.335U
* device instance $2249 r0 *1 34.535,37.345 sky130_fd_pr__pfet_01v8
M$2249 496 601 167 167 sky130_fd_pr__pfet_01v8 L=0.15U W=1U AS=0.14575P
+ AD=0.135P PS=1.335U PD=1.27U
* device instance $2250 r0 *1 34.955,37.345 sky130_fd_pr__pfet_01v8
M$2250 167 590 496 496 sky130_fd_pr__pfet_01v8 L=0.15U W=1U AS=0.135P AD=0.265P
+ PS=1.27U PD=2.53U
* device instance $2251 r0 *1 40.49,33.225 sky130_fd_pr__pfet_01v8
M$2251 167 329 555 555 sky130_fd_pr__pfet_01v8 L=0.15U W=0.64U AS=0.1664P
+ AD=0.0864P PS=1.8U PD=0.91U
* device instance $2252 r0 *1 40.91,33.225 sky130_fd_pr__pfet_01v8
M$2252 556 555 167 167 sky130_fd_pr__pfet_01v8 L=0.15U W=0.64U AS=0.0864P
+ AD=0.1664P PS=0.91U PD=1.8U
* device instance $2253 r0 *1 59.42,37.635 sky130_fd_pr__pfet_01v8
M$2253 591 613 167 167 sky130_fd_pr__pfet_01v8 L=0.15U W=0.42U AS=0.1113P
+ AD=0.0609P PS=1.37U PD=0.71U
* device instance $2254 r0 *1 59.86,37.635 sky130_fd_pr__pfet_01v8
M$2254 591 109 167 167 sky130_fd_pr__pfet_01v8 L=0.15U W=0.42U AS=0.1841P
+ AD=0.0609P PS=1.26U PD=0.71U
* device instance $2255 r0 *1 60.63,37.525 sky130_fd_pr__pfet_01v8
M$2255 570 591 167 167 sky130_fd_pr__pfet_01v8 L=0.15U W=0.64U AS=0.1841P
+ AD=0.1696P PS=1.26U PD=1.81U
* device instance $2256 r0 *1 61.67,37.345 sky130_fd_pr__pfet_01v8
M$2256 592 575 167 167 sky130_fd_pr__pfet_01v8 L=0.15U W=1U AS=0.26P AD=0.135P
+ PS=2.52U PD=1.27U
* device instance $2257 r0 *1 62.09,37.345 sky130_fd_pr__pfet_01v8
M$2257 167 338 592 592 sky130_fd_pr__pfet_01v8 L=0.15U W=1U AS=0.135P AD=0.26P
+ PS=1.27U PD=2.52U
* device instance $2258 r0 *1 63.07,37.345 sky130_fd_pr__pfet_01v8
M$2258 593 592 167 167 sky130_fd_pr__pfet_01v8 L=0.15U W=1U AS=0.3P AD=0.135P
+ PS=2.6U PD=1.27U
* device instance $2259 r0 *1 63.49,37.345 sky130_fd_pr__pfet_01v8
M$2259 167 640 593 593 sky130_fd_pr__pfet_01v8 L=0.15U W=1U AS=0.135P AD=0.365P
+ PS=1.27U PD=1.73U
* device instance $2260 r0 *1 64.37,37.345 sky130_fd_pr__pfet_01v8
M$2260 615 640 167 167 sky130_fd_pr__pfet_01v8 L=0.15U W=1U AS=0.365P AD=0.105P
+ PS=1.73U PD=1.21U
* device instance $2261 r0 *1 64.73,37.345 sky130_fd_pr__pfet_01v8
M$2261 572 592 615 615 sky130_fd_pr__pfet_01v8 L=0.15U W=1U AS=0.105P AD=0.165P
+ PS=1.21U PD=1.33U
* device instance $2262 r0 *1 65.21,37.345 sky130_fd_pr__pfet_01v8
M$2262 167 593 572 572 sky130_fd_pr__pfet_01v8 L=0.15U W=1U AS=0.165P AD=0.36P
+ PS=1.33U PD=2.72U
* device instance $2263 r0 *1 66.49,37.055 sky130_fd_pr__pfet_01v8
M$2263 167 643 595 595 sky130_fd_pr__pfet_01v8 L=0.15U W=0.42U AS=0.1092P
+ AD=0.1573P PS=1.36U PD=1.39U
* device instance $2264 r0 *1 67.03,37.345 sky130_fd_pr__pfet_01v8
M$2264 614 571 167 167 sky130_fd_pr__pfet_01v8 L=0.15U W=1U AS=0.1573P
+ AD=0.105P PS=1.39U PD=1.21U
* device instance $2265 r0 *1 67.39,37.345 sky130_fd_pr__pfet_01v8
M$2265 596 595 614 614 sky130_fd_pr__pfet_01v8 L=0.15U W=1U AS=0.105P AD=0.26P
+ PS=1.21U PD=2.52U
* device instance $2266 r0 *1 4.68,38.525 sky130_fd_pr__pfet_01v8
M$2266 620 636 167 167 sky130_fd_pr__pfet_01v8 L=0.15U W=0.42U AS=0.1113P
+ AD=0.0609P PS=1.37U PD=0.71U
* device instance $2267 r0 *1 5.12,38.525 sky130_fd_pr__pfet_01v8
M$2267 167 109 620 620 sky130_fd_pr__pfet_01v8 L=0.15U W=0.42U AS=0.0609P
+ AD=0.1841P PS=0.71U PD=1.26U
* device instance $2268 r0 *1 5.89,38.635 sky130_fd_pr__pfet_01v8
M$2268 597 620 167 167 sky130_fd_pr__pfet_01v8 L=0.15U W=0.64U AS=0.1841P
+ AD=0.1696P PS=1.26U PD=1.81U
* device instance $2269 r0 *1 7.455,38.72 sky130_fd_pr__pfet_01v8
M$2269 647 71 167 167 sky130_fd_pr__pfet_01v8 L=0.15U W=0.42U AS=0.15835P
+ AD=0.07665P PS=1.395U PD=0.785U
* device instance $2270 r0 *1 7.97,38.72 sky130_fd_pr__pfet_01v8
M$2270 621 589 647 647 sky130_fd_pr__pfet_01v8 L=0.15U W=0.42U AS=0.07665P
+ AD=0.1932P PS=0.785U PD=1.34U
* device instance $2271 r0 *1 9.04,38.72 sky130_fd_pr__pfet_01v8
M$2271 648 619 621 621 sky130_fd_pr__pfet_01v8 L=0.15U W=0.42U AS=0.1932P
+ AD=0.0441P PS=1.34U PD=0.63U
* device instance $2272 r0 *1 9.4,38.72 sky130_fd_pr__pfet_01v8
M$2272 167 649 648 648 sky130_fd_pr__pfet_01v8 L=0.15U W=0.42U AS=0.0441P
+ AD=0.0693P PS=0.63U PD=0.75U
* device instance $2273 r0 *1 9.88,38.72 sky130_fd_pr__pfet_01v8
M$2273 649 71 167 167 sky130_fd_pr__pfet_01v8 L=0.15U W=0.42U AS=0.0693P
+ AD=0.1176P PS=0.75U PD=1.4U
* device instance $2274 r0 *1 6.91,38.815 sky130_fd_pr__pfet_01v8
M$2274 167 621 662 662 sky130_fd_pr__pfet_01v8 L=0.15U W=1U AS=0.26P
+ AD=0.15835P PS=2.52U PD=1.395U
* device instance $2275 r0 *1 11.09,38.815 sky130_fd_pr__pfet_01v8
M$2275 622 637 167 167 sky130_fd_pr__pfet_01v8 L=0.15U W=1U AS=0.3P AD=0.135P
+ PS=2.6U PD=1.27U
* device instance $2276 r0 *1 11.51,38.815 sky130_fd_pr__pfet_01v8
M$2276 167 623 622 622 sky130_fd_pr__pfet_01v8 L=0.15U W=1U AS=0.135P AD=0.365P
+ PS=1.27U PD=1.73U
* device instance $2277 r0 *1 12.39,38.815 sky130_fd_pr__pfet_01v8
M$2277 657 623 167 167 sky130_fd_pr__pfet_01v8 L=0.15U W=1U AS=0.365P AD=0.105P
+ PS=1.73U PD=1.21U
* device instance $2278 r0 *1 12.75,38.815 sky130_fd_pr__pfet_01v8
M$2278 599 637 657 657 sky130_fd_pr__pfet_01v8 L=0.15U W=1U AS=0.105P AD=0.165P
+ PS=1.21U PD=1.33U
* device instance $2279 r0 *1 13.23,38.815 sky130_fd_pr__pfet_01v8
M$2279 167 622 599 599 sky130_fd_pr__pfet_01v8 L=0.15U W=1U AS=0.165P AD=0.36P
+ PS=1.33U PD=2.72U
* device instance $2280 r0 *1 14.31,38.815 sky130_fd_pr__pfet_01v8
M$2280 659 589 624 624 sky130_fd_pr__pfet_01v8 L=0.15U W=1U AS=0.26P AD=0.135P
+ PS=2.52U PD=1.27U
* device instance $2281 r0 *1 14.73,38.815 sky130_fd_pr__pfet_01v8
M$2281 167 598 659 659 sky130_fd_pr__pfet_01v8 L=0.15U W=1U AS=0.135P AD=0.135P
+ PS=1.27U PD=1.27U
* device instance $2282 r0 *1 15.15,38.815 sky130_fd_pr__pfet_01v8
M$2282 625 598 167 167 sky130_fd_pr__pfet_01v8 L=0.15U W=1U AS=0.135P AD=0.135P
+ PS=1.27U PD=1.27U
* device instance $2283 r0 *1 15.57,38.815 sky130_fd_pr__pfet_01v8
M$2283 167 589 625 625 sky130_fd_pr__pfet_01v8 L=0.15U W=1U AS=0.135P AD=0.26P
+ PS=1.27U PD=2.52U
* device instance $2284 r0 *1 16.51,38.815 sky130_fd_pr__pfet_01v8
M$2284 637 624 625 625 sky130_fd_pr__pfet_01v8 L=0.15U W=1U AS=0.26P AD=0.3P
+ PS=2.52U PD=2.6U
* device instance $2285 r0 *1 25.77,38.815 sky130_fd_pr__pfet_01v8
M$2285 627 651 626 626 sky130_fd_pr__pfet_01v8 L=0.15U W=1U AS=0.26P AD=0.135P
+ PS=2.52U PD=1.27U
* device instance $2286 r0 *1 26.19,38.815 sky130_fd_pr__pfet_01v8
M$2286 638 628 627 627 sky130_fd_pr__pfet_01v8 L=0.15U W=1U AS=0.135P AD=0.135P
+ PS=1.27U PD=1.27U
* device instance $2287 r0 *1 26.61,38.815 sky130_fd_pr__pfet_01v8
M$2287 627 91 638 638 sky130_fd_pr__pfet_01v8 L=0.15U W=1U AS=0.135P AD=0.26P
+ PS=1.27U PD=2.52U
* device instance $2288 r0 *1 27.55,38.815 sky130_fd_pr__pfet_01v8
M$2288 638 137 167 167 sky130_fd_pr__pfet_01v8 L=0.15U W=1U AS=0.26P AD=0.165P
+ PS=2.52U PD=1.33U
* device instance $2289 r0 *1 28.03,38.815 sky130_fd_pr__pfet_01v8
M$2289 167 553 638 638 sky130_fd_pr__pfet_01v8 L=0.15U W=1U AS=0.165P
+ AD=0.1575P PS=1.33U PD=1.315U
* device instance $2290 r0 *1 28.495,38.815 sky130_fd_pr__pfet_01v8
M$2290 639 626 167 167 sky130_fd_pr__pfet_01v8 L=0.15U W=1U AS=0.1575P AD=0.26P
+ PS=1.315U PD=2.52U
* device instance $2291 r0 *1 30.87,38.815 sky130_fd_pr__pfet_01v8
M$2291 629 601 167 167 sky130_fd_pr__pfet_01v8 L=0.15U W=1U AS=0.3P AD=0.135P
+ PS=2.6U PD=1.27U
* device instance $2292 r0 *1 31.29,38.815 sky130_fd_pr__pfet_01v8
M$2292 167 628 629 629 sky130_fd_pr__pfet_01v8 L=0.15U W=1U AS=0.135P AD=0.365P
+ PS=1.27U PD=1.73U
* device instance $2293 r0 *1 32.17,38.815 sky130_fd_pr__pfet_01v8
M$2293 661 628 167 167 sky130_fd_pr__pfet_01v8 L=0.15U W=1U AS=0.365P AD=0.105P
+ PS=1.73U PD=1.21U
* device instance $2294 r0 *1 32.53,38.815 sky130_fd_pr__pfet_01v8
M$2294 600 601 661 661 sky130_fd_pr__pfet_01v8 L=0.15U W=1U AS=0.105P AD=0.165P
+ PS=1.21U PD=1.33U
* device instance $2295 r0 *1 33.01,38.815 sky130_fd_pr__pfet_01v8
M$2295 167 629 600 600 sky130_fd_pr__pfet_01v8 L=0.15U W=1U AS=0.165P AD=0.36P
+ PS=1.33U PD=2.72U
* device instance $2296 r0 *1 35.435,38.815 sky130_fd_pr__pfet_01v8
M$2296 630 653 167 167 sky130_fd_pr__pfet_01v8 L=0.15U W=4U AS=0.685P AD=0.56P
+ PS=6.37U PD=5.12U
* device instance $2300 r0 *1 37.155,38.815 sky130_fd_pr__pfet_01v8
M$2300 310 630 167 167 sky130_fd_pr__pfet_01v8 L=0.15U W=16U AS=2.2375P
+ AD=2.3625P PS=20.475U PD=21.725U
* device instance $2316 r0 *1 55.67,38.815 sky130_fd_pr__pfet_01v8
M$2316 631 575 167 167 sky130_fd_pr__pfet_01v8 L=0.15U W=1U AS=0.26P AD=0.135P
+ PS=2.52U PD=1.27U
* device instance $2317 r0 *1 56.09,38.815 sky130_fd_pr__pfet_01v8
M$2317 167 338 631 631 sky130_fd_pr__pfet_01v8 L=0.15U W=1U AS=0.135P
+ AD=0.1525P PS=1.27U PD=1.305U
* device instance $2318 r0 *1 56.545,38.815 sky130_fd_pr__pfet_01v8
M$2318 631 640 167 167 sky130_fd_pr__pfet_01v8 L=0.15U W=1U AS=0.1525P
+ AD=0.1625P PS=1.305U PD=1.325U
* device instance $2319 r0 *1 57.02,38.815 sky130_fd_pr__pfet_01v8
M$2319 632 596 631 631 sky130_fd_pr__pfet_01v8 L=0.15U W=1U AS=0.1625P AD=0.27P
+ PS=1.325U PD=2.54U
* device instance $2320 r0 *1 59.35,38.815 sky130_fd_pr__pfet_01v8
M$2320 641 338 167 167 sky130_fd_pr__pfet_01v8 L=0.15U W=1U AS=0.26P AD=0.1375P
+ PS=2.52U PD=1.275U
* device instance $2321 r0 *1 59.775,38.815 sky130_fd_pr__pfet_01v8
M$2321 167 304 641 641 sky130_fd_pr__pfet_01v8 L=0.15U W=1U AS=0.1375P AD=0.14P
+ PS=1.275U PD=1.28U
* device instance $2322 r0 *1 60.205,38.815 sky130_fd_pr__pfet_01v8
M$2322 641 640 167 167 sky130_fd_pr__pfet_01v8 L=0.15U W=1U AS=0.14P AD=0.165P
+ PS=1.28U PD=1.33U
* device instance $2323 r0 *1 60.685,38.815 sky130_fd_pr__pfet_01v8
M$2323 660 596 641 641 sky130_fd_pr__pfet_01v8 L=0.15U W=1U AS=0.165P
+ AD=0.1725P PS=1.33U PD=1.345U
* device instance $2324 r0 *1 61.18,38.815 sky130_fd_pr__pfet_01v8
M$2324 642 654 660 660 sky130_fd_pr__pfet_01v8 L=0.15U W=1U AS=0.1725P AD=0.26P
+ PS=1.345U PD=2.52U
* device instance $2325 r0 *1 64.45,38.815 sky130_fd_pr__pfet_01v8
M$2325 633 643 167 167 sky130_fd_pr__pfet_01v8 L=0.15U W=1U AS=0.3P AD=0.135P
+ PS=2.6U PD=1.27U
* device instance $2326 r0 *1 64.87,38.815 sky130_fd_pr__pfet_01v8
M$2326 167 571 633 633 sky130_fd_pr__pfet_01v8 L=0.15U W=1U AS=0.135P AD=0.365P
+ PS=1.27U PD=1.73U
* device instance $2327 r0 *1 65.75,38.815 sky130_fd_pr__pfet_01v8
M$2327 658 571 167 167 sky130_fd_pr__pfet_01v8 L=0.15U W=1U AS=0.365P AD=0.105P
+ PS=1.73U PD=1.21U
* device instance $2328 r0 *1 66.11,38.815 sky130_fd_pr__pfet_01v8
M$2328 640 643 658 658 sky130_fd_pr__pfet_01v8 L=0.15U W=1U AS=0.105P AD=0.165P
+ PS=1.21U PD=1.33U
* device instance $2329 r0 *1 66.59,38.815 sky130_fd_pr__pfet_01v8
M$2329 167 633 640 640 sky130_fd_pr__pfet_01v8 L=0.15U W=1U AS=0.165P AD=0.36P
+ PS=1.33U PD=2.72U
* device instance $2330 r0 *1 68.635,38.72 sky130_fd_pr__pfet_01v8
M$2330 646 71 167 167 sky130_fd_pr__pfet_01v8 L=0.15U W=0.42U AS=0.15835P
+ AD=0.07665P PS=1.395U PD=0.785U
* device instance $2331 r0 *1 69.15,38.72 sky130_fd_pr__pfet_01v8
M$2331 635 643 646 646 sky130_fd_pr__pfet_01v8 L=0.15U W=0.42U AS=0.07665P
+ AD=0.1932P PS=0.785U PD=1.34U
* device instance $2332 r0 *1 70.22,38.72 sky130_fd_pr__pfet_01v8
M$2332 645 644 635 635 sky130_fd_pr__pfet_01v8 L=0.15U W=0.42U AS=0.1932P
+ AD=0.0441P PS=1.34U PD=0.63U
* device instance $2333 r0 *1 70.58,38.72 sky130_fd_pr__pfet_01v8
M$2333 167 656 645 645 sky130_fd_pr__pfet_01v8 L=0.15U W=0.42U AS=0.0441P
+ AD=0.0693P PS=0.63U PD=0.75U
* device instance $2334 r0 *1 71.06,38.72 sky130_fd_pr__pfet_01v8
M$2334 656 71 167 167 sky130_fd_pr__pfet_01v8 L=0.15U W=0.42U AS=0.0693P
+ AD=0.1176P PS=0.75U PD=1.4U
* device instance $2335 r0 *1 68.09,38.815 sky130_fd_pr__pfet_01v8
M$2335 167 635 634 634 sky130_fd_pr__pfet_01v8 L=0.15U W=1U AS=0.26P
+ AD=0.15835P PS=2.52U PD=1.395U
* device instance $2336 r0 *1 2.77,42.935 sky130_fd_pr__pfet_01v8
M$2336 167 937 678 678 sky130_fd_pr__pfet_01v8 L=0.15U W=0.64U AS=0.1664P
+ AD=0.0864P PS=1.8U PD=0.91U
* device instance $2337 r0 *1 3.19,42.935 sky130_fd_pr__pfet_01v8
M$2337 679 678 167 167 sky130_fd_pr__pfet_01v8 L=0.15U W=0.64U AS=0.0864P
+ AD=0.1664P PS=0.91U PD=1.8U
* device instance $2338 r0 *1 4.13,42.965 sky130_fd_pr__pfet_01v8
M$2338 741 662 680 680 sky130_fd_pr__pfet_01v8 L=0.15U W=0.64U AS=0.1664P
+ AD=0.0672P PS=1.8U PD=0.85U
* device instance $2339 r0 *1 4.49,42.965 sky130_fd_pr__pfet_01v8
M$2339 167 681 741 741 sky130_fd_pr__pfet_01v8 L=0.15U W=0.64U AS=0.0672P
+ AD=0.1664P PS=0.85U PD=1.8U
* device instance $2340 r0 *1 5.43,42.965 sky130_fd_pr__pfet_01v8
M$2340 167 90 681 681 sky130_fd_pr__pfet_01v8 L=0.15U W=0.64U AS=0.1664P
+ AD=0.0928P PS=1.8U PD=0.93U
* device instance $2341 r0 *1 5.87,42.965 sky130_fd_pr__pfet_01v8
M$2341 742 90 167 167 sky130_fd_pr__pfet_01v8 L=0.15U W=0.64U AS=0.0928P
+ AD=0.1152P PS=0.93U PD=1U
* device instance $2342 r0 *1 6.38,42.965 sky130_fd_pr__pfet_01v8
M$2342 680 705 742 742 sky130_fd_pr__pfet_01v8 L=0.15U W=0.64U AS=0.1152P
+ AD=0.15985P PS=1U PD=1.265U
* device instance $2343 r0 *1 7.155,43.075 sky130_fd_pr__pfet_01v8
M$2343 682 679 680 680 sky130_fd_pr__pfet_01v8 L=0.15U W=0.42U AS=0.15985P
+ AD=0.06405P PS=1.265U PD=0.725U
* device instance $2344 r0 *1 7.61,43.075 sky130_fd_pr__pfet_01v8
M$2344 743 678 682 682 sky130_fd_pr__pfet_01v8 L=0.15U W=0.42U AS=0.06405P
+ AD=0.07665P PS=0.725U PD=0.785U
* device instance $2345 r0 *1 8.125,43.075 sky130_fd_pr__pfet_01v8
M$2345 743 683 167 167 sky130_fd_pr__pfet_01v8 L=0.15U W=0.42U AS=0.178875P
+ AD=0.07665P PS=1.26U PD=0.785U
* device instance $2346 r0 *1 8.785,42.91 sky130_fd_pr__pfet_01v8
M$2346 683 682 167 167 sky130_fd_pr__pfet_01v8 L=0.15U W=0.75U AS=0.178875P
+ AD=0.195P PS=1.26U PD=2.02U
* device instance $2347 r0 *1 12.225,42.965 sky130_fd_pr__pfet_01v8
M$2347 705 684 167 167 sky130_fd_pr__pfet_01v8 L=0.15U W=0.64U AS=0.154P
+ AD=0.1728P PS=1.335U PD=1.82U
* device instance $2348 r0 *1 12.71,42.785 sky130_fd_pr__pfet_01v8
M$2348 552 684 167 167 sky130_fd_pr__pfet_01v8 L=0.15U W=1U AS=0.154P AD=0.28P
+ PS=1.335U PD=2.56U
* device instance $2349 r0 *1 13.81,42.785 sky130_fd_pr__pfet_01v8
M$2349 167 552 706 706 sky130_fd_pr__pfet_01v8 L=0.15U W=1U AS=0.26P AD=0.135P
+ PS=2.52U PD=1.27U
* device instance $2350 r0 *1 14.23,42.785 sky130_fd_pr__pfet_01v8
M$2350 598 706 167 167 sky130_fd_pr__pfet_01v8 L=0.15U W=4U AS=0.54P AD=0.665P
+ PS=5.08U PD=6.33U
* device instance $2354 r0 *1 17.03,42.785 sky130_fd_pr__pfet_01v8
M$2354 167 588 707 707 sky130_fd_pr__pfet_01v8 L=0.15U W=1U AS=0.26P AD=0.135P
+ PS=2.52U PD=1.27U
* device instance $2355 r0 *1 17.45,42.785 sky130_fd_pr__pfet_01v8
M$2355 623 707 167 167 sky130_fd_pr__pfet_01v8 L=0.15U W=4U AS=0.54P
+ AD=0.742525P PS=5.08U PD=5.66U
* device instance $2359 r0 *1 19.71,43.075 sky130_fd_pr__pfet_01v8
M$2359 685 733 167 167 sky130_fd_pr__pfet_01v8 L=0.15U W=0.42U AS=0.337525P
+ AD=0.0609P PS=1.85U PD=0.71U
* device instance $2360 r0 *1 20.15,43.075 sky130_fd_pr__pfet_01v8
M$2360 685 109 167 167 sky130_fd_pr__pfet_01v8 L=0.15U W=0.42U AS=0.1841P
+ AD=0.0609P PS=1.26U PD=0.71U
* device instance $2361 r0 *1 20.92,42.965 sky130_fd_pr__pfet_01v8
M$2361 651 685 167 167 sky130_fd_pr__pfet_01v8 L=0.15U W=0.64U AS=0.1841P
+ AD=0.1696P PS=1.26U PD=1.81U
* device instance $2362 r0 *1 26.23,42.935 sky130_fd_pr__pfet_01v8
M$2362 167 937 686 686 sky130_fd_pr__pfet_01v8 L=0.15U W=0.64U AS=0.1664P
+ AD=0.0864P PS=1.8U PD=0.91U
* device instance $2363 r0 *1 26.65,42.935 sky130_fd_pr__pfet_01v8
M$2363 687 686 167 167 sky130_fd_pr__pfet_01v8 L=0.15U W=0.64U AS=0.0864P
+ AD=0.1664P PS=0.91U PD=1.8U
* device instance $2364 r0 *1 27.59,42.965 sky130_fd_pr__pfet_01v8
M$2364 747 708 688 688 sky130_fd_pr__pfet_01v8 L=0.15U W=0.64U AS=0.1664P
+ AD=0.0672P PS=1.8U PD=0.85U
* device instance $2365 r0 *1 27.95,42.965 sky130_fd_pr__pfet_01v8
M$2365 167 689 747 747 sky130_fd_pr__pfet_01v8 L=0.15U W=0.64U AS=0.0672P
+ AD=0.1664P PS=0.85U PD=1.8U
* device instance $2366 r0 *1 28.89,42.965 sky130_fd_pr__pfet_01v8
M$2366 167 90 689 689 sky130_fd_pr__pfet_01v8 L=0.15U W=0.64U AS=0.1664P
+ AD=0.0928P PS=1.8U PD=0.93U
* device instance $2367 r0 *1 29.33,42.965 sky130_fd_pr__pfet_01v8
M$2367 748 90 167 167 sky130_fd_pr__pfet_01v8 L=0.15U W=0.64U AS=0.0928P
+ AD=0.1152P PS=0.93U PD=1U
* device instance $2368 r0 *1 29.84,42.965 sky130_fd_pr__pfet_01v8
M$2368 688 709 748 748 sky130_fd_pr__pfet_01v8 L=0.15U W=0.64U AS=0.1152P
+ AD=0.15985P PS=1U PD=1.265U
* device instance $2369 r0 *1 30.615,43.075 sky130_fd_pr__pfet_01v8
M$2369 690 687 688 688 sky130_fd_pr__pfet_01v8 L=0.15U W=0.42U AS=0.15985P
+ AD=0.06405P PS=1.265U PD=0.725U
* device instance $2370 r0 *1 31.07,43.075 sky130_fd_pr__pfet_01v8
M$2370 750 686 690 690 sky130_fd_pr__pfet_01v8 L=0.15U W=0.42U AS=0.06405P
+ AD=0.07665P PS=0.725U PD=0.785U
* device instance $2371 r0 *1 31.585,43.075 sky130_fd_pr__pfet_01v8
M$2371 750 691 167 167 sky130_fd_pr__pfet_01v8 L=0.15U W=0.42U AS=0.178875P
+ AD=0.07665P PS=1.26U PD=0.785U
* device instance $2372 r0 *1 32.245,42.91 sky130_fd_pr__pfet_01v8
M$2372 691 690 167 167 sky130_fd_pr__pfet_01v8 L=0.15U W=0.75U AS=0.178875P
+ AD=0.195P PS=1.26U PD=2.02U
* device instance $2373 r0 *1 35.685,42.965 sky130_fd_pr__pfet_01v8
M$2373 709 692 167 167 sky130_fd_pr__pfet_01v8 L=0.15U W=0.64U AS=0.154P
+ AD=0.1728P PS=1.335U PD=1.82U
* device instance $2374 r0 *1 36.17,42.785 sky130_fd_pr__pfet_01v8
M$2374 628 692 167 167 sky130_fd_pr__pfet_01v8 L=0.15U W=1U AS=0.154P AD=0.28P
+ PS=1.335U PD=2.56U
* device instance $2375 r0 *1 44.63,42.785 sky130_fd_pr__pfet_01v8
M$2375 754 628 693 693 sky130_fd_pr__pfet_01v8 L=0.15U W=1U AS=0.26P AD=0.13P
+ PS=2.52U PD=1.26U
* device instance $2376 r0 *1 45.04,42.785 sky130_fd_pr__pfet_01v8
M$2376 755 367 754 754 sky130_fd_pr__pfet_01v8 L=0.15U W=1U AS=0.13P AD=0.19P
+ PS=1.26U PD=1.38U
* device instance $2377 r0 *1 45.57,42.785 sky130_fd_pr__pfet_01v8
M$2377 756 710 755 755 sky130_fd_pr__pfet_01v8 L=0.15U W=1U AS=0.19P AD=0.135P
+ PS=1.38U PD=1.27U
* device instance $2378 r0 *1 45.99,42.785 sky130_fd_pr__pfet_01v8
M$2378 167 694 756 756 sky130_fd_pr__pfet_01v8 L=0.15U W=1U AS=0.135P AD=0.26P
+ PS=1.27U PD=2.52U
* device instance $2379 r0 *1 49.23,42.785 sky130_fd_pr__pfet_01v8
M$2379 876 693 167 167 sky130_fd_pr__pfet_01v8 L=0.15U W=1U AS=0.26P AD=0.135P
+ PS=2.52U PD=1.27U
* device instance $2380 r0 *1 49.65,42.785 sky130_fd_pr__pfet_01v8
M$2380 167 695 876 876 sky130_fd_pr__pfet_01v8 L=0.15U W=1U AS=0.135P AD=0.165P
+ PS=1.27U PD=1.33U
* device instance $2381 r0 *1 50.13,42.785 sky130_fd_pr__pfet_01v8
M$2381 876 407 167 167 sky130_fd_pr__pfet_01v8 L=0.15U W=1U AS=0.165P AD=0.26P
+ PS=1.33U PD=2.52U
* device instance $2382 r0 *1 57.55,42.785 sky130_fd_pr__pfet_01v8
M$2382 696 711 167 167 sky130_fd_pr__pfet_01v8 L=0.15U W=1U AS=0.3P AD=0.135P
+ PS=2.6U PD=1.27U
* device instance $2383 r0 *1 57.97,42.785 sky130_fd_pr__pfet_01v8
M$2383 167 632 696 696 sky130_fd_pr__pfet_01v8 L=0.15U W=1U AS=0.135P AD=0.365P
+ PS=1.27U PD=1.73U
* device instance $2384 r0 *1 58.85,42.785 sky130_fd_pr__pfet_01v8
M$2384 759 632 167 167 sky130_fd_pr__pfet_01v8 L=0.15U W=1U AS=0.365P AD=0.105P
+ PS=1.73U PD=1.21U
* device instance $2385 r0 *1 59.21,42.785 sky130_fd_pr__pfet_01v8
M$2385 734 711 759 759 sky130_fd_pr__pfet_01v8 L=0.15U W=1U AS=0.105P AD=0.165P
+ PS=1.21U PD=1.33U
* device instance $2386 r0 *1 59.69,42.785 sky130_fd_pr__pfet_01v8
M$2386 167 696 734 734 sky130_fd_pr__pfet_01v8 L=0.15U W=1U AS=0.165P AD=0.36P
+ PS=1.33U PD=2.72U
* device instance $2387 r0 *1 60.73,42.935 sky130_fd_pr__pfet_01v8
M$2387 167 844 698 698 sky130_fd_pr__pfet_01v8 L=0.15U W=0.64U AS=0.1664P
+ AD=0.0864P PS=1.8U PD=0.91U
* device instance $2388 r0 *1 61.15,42.935 sky130_fd_pr__pfet_01v8
M$2388 699 698 167 167 sky130_fd_pr__pfet_01v8 L=0.15U W=0.64U AS=0.0864P
+ AD=0.1664P PS=0.91U PD=1.8U
* device instance $2389 r0 *1 62.09,42.965 sky130_fd_pr__pfet_01v8
M$2389 758 712 700 700 sky130_fd_pr__pfet_01v8 L=0.15U W=0.64U AS=0.1664P
+ AD=0.0672P PS=1.8U PD=0.85U
* device instance $2390 r0 *1 62.45,42.965 sky130_fd_pr__pfet_01v8
M$2390 167 701 758 758 sky130_fd_pr__pfet_01v8 L=0.15U W=0.64U AS=0.0672P
+ AD=0.1664P PS=0.85U PD=1.8U
* device instance $2391 r0 *1 63.39,42.965 sky130_fd_pr__pfet_01v8
M$2391 167 315 701 701 sky130_fd_pr__pfet_01v8 L=0.15U W=0.64U AS=0.1664P
+ AD=0.0928P PS=1.8U PD=0.93U
* device instance $2392 r0 *1 63.83,42.965 sky130_fd_pr__pfet_01v8
M$2392 757 315 167 167 sky130_fd_pr__pfet_01v8 L=0.15U W=0.64U AS=0.0928P
+ AD=0.1152P PS=0.93U PD=1U
* device instance $2393 r0 *1 64.34,42.965 sky130_fd_pr__pfet_01v8
M$2393 700 713 757 757 sky130_fd_pr__pfet_01v8 L=0.15U W=0.64U AS=0.1152P
+ AD=0.15985P PS=1U PD=1.265U
* device instance $2394 r0 *1 65.115,43.075 sky130_fd_pr__pfet_01v8
M$2394 702 699 700 700 sky130_fd_pr__pfet_01v8 L=0.15U W=0.42U AS=0.15985P
+ AD=0.06405P PS=1.265U PD=0.725U
* device instance $2395 r0 *1 65.57,43.075 sky130_fd_pr__pfet_01v8
M$2395 753 698 702 702 sky130_fd_pr__pfet_01v8 L=0.15U W=0.42U AS=0.06405P
+ AD=0.07665P PS=0.725U PD=0.785U
* device instance $2396 r0 *1 66.085,43.075 sky130_fd_pr__pfet_01v8
M$2396 753 703 167 167 sky130_fd_pr__pfet_01v8 L=0.15U W=0.42U AS=0.178875P
+ AD=0.07665P PS=1.26U PD=0.785U
* device instance $2397 r0 *1 66.745,42.91 sky130_fd_pr__pfet_01v8
M$2397 703 702 167 167 sky130_fd_pr__pfet_01v8 L=0.15U W=0.75U AS=0.178875P
+ AD=0.195P PS=1.26U PD=2.02U
* device instance $2398 r0 *1 70.185,42.965 sky130_fd_pr__pfet_01v8
M$2398 713 704 167 167 sky130_fd_pr__pfet_01v8 L=0.15U W=0.64U AS=0.154P
+ AD=0.1728P PS=1.335U PD=1.82U
* device instance $2399 r0 *1 70.67,42.785 sky130_fd_pr__pfet_01v8
M$2399 643 704 167 167 sky130_fd_pr__pfet_01v8 L=0.15U W=1U AS=0.154P AD=0.28P
+ PS=1.335U PD=2.56U
* device instance $2400 r0 *1 9.725,43.075 sky130_fd_pr__pfet_01v8
M$2400 744 683 167 167 sky130_fd_pr__pfet_01v8 L=0.15U W=0.42U AS=0.1092P
+ AD=0.06405P PS=1.36U PD=0.725U
* device instance $2401 r0 *1 10.18,43.075 sky130_fd_pr__pfet_01v8
M$2401 684 678 744 744 sky130_fd_pr__pfet_01v8 L=0.15U W=0.42U AS=0.06405P
+ AD=0.0567P PS=0.725U PD=0.69U
* device instance $2402 r0 *1 10.6,43.075 sky130_fd_pr__pfet_01v8
M$2402 745 679 684 684 sky130_fd_pr__pfet_01v8 L=0.15U W=0.42U AS=0.0567P
+ AD=0.0882P PS=0.69U PD=0.84U
* device instance $2403 r0 *1 11.17,43.075 sky130_fd_pr__pfet_01v8
M$2403 167 705 745 745 sky130_fd_pr__pfet_01v8 L=0.15U W=0.42U AS=0.0882P
+ AD=0.1113P PS=0.84U PD=1.37U
* device instance $2404 r0 *1 10.57,44.075 sky130_fd_pr__pfet_01v8
M$2404 785 586 764 764 sky130_fd_pr__pfet_01v8 L=0.15U W=0.64U AS=0.1664P
+ AD=0.0672P PS=1.8U PD=0.85U
* device instance $2405 r0 *1 10.93,44.075 sky130_fd_pr__pfet_01v8
M$2405 167 735 785 785 sky130_fd_pr__pfet_01v8 L=0.15U W=0.64U AS=0.0672P
+ AD=0.1664P PS=0.85U PD=1.8U
* device instance $2406 r0 *1 13.595,43.965 sky130_fd_pr__pfet_01v8
M$2406 765 763 764 764 sky130_fd_pr__pfet_01v8 L=0.15U W=0.42U AS=0.15985P
+ AD=0.06405P PS=1.265U PD=0.725U
* device instance $2407 r0 *1 14.05,43.965 sky130_fd_pr__pfet_01v8
M$2407 789 762 765 765 sky130_fd_pr__pfet_01v8 L=0.15U W=0.42U AS=0.06405P
+ AD=0.07665P PS=0.725U PD=0.785U
* device instance $2408 r0 *1 14.565,43.965 sky130_fd_pr__pfet_01v8
M$2408 167 766 789 789 sky130_fd_pr__pfet_01v8 L=0.15U W=0.42U AS=0.07665P
+ AD=0.178875P PS=0.785U PD=1.26U
* device instance $2409 r0 *1 11.87,44.075 sky130_fd_pr__pfet_01v8
M$2409 167 315 735 735 sky130_fd_pr__pfet_01v8 L=0.15U W=0.64U AS=0.1664P
+ AD=0.0928P PS=1.8U PD=0.93U
* device instance $2410 r0 *1 12.31,44.075 sky130_fd_pr__pfet_01v8
M$2410 787 315 167 167 sky130_fd_pr__pfet_01v8 L=0.15U W=0.64U AS=0.0928P
+ AD=0.1152P PS=0.93U PD=1U
* device instance $2411 r0 *1 12.82,44.075 sky130_fd_pr__pfet_01v8
M$2411 764 736 787 787 sky130_fd_pr__pfet_01v8 L=0.15U W=0.64U AS=0.1152P
+ AD=0.15985P PS=1U PD=1.265U
* device instance $2412 r0 *1 15.225,44.13 sky130_fd_pr__pfet_01v8
M$2412 766 765 167 167 sky130_fd_pr__pfet_01v8 L=0.15U W=0.75U AS=0.178875P
+ AD=0.195P PS=1.26U PD=2.02U
* device instance $2413 r0 *1 16.165,43.965 sky130_fd_pr__pfet_01v8
M$2413 791 766 167 167 sky130_fd_pr__pfet_01v8 L=0.15U W=0.42U AS=0.1092P
+ AD=0.06405P PS=1.36U PD=0.725U
* device instance $2414 r0 *1 16.62,43.965 sky130_fd_pr__pfet_01v8
M$2414 767 762 791 791 sky130_fd_pr__pfet_01v8 L=0.15U W=0.42U AS=0.06405P
+ AD=0.0567P PS=0.725U PD=0.69U
* device instance $2415 r0 *1 17.04,43.965 sky130_fd_pr__pfet_01v8
M$2415 792 763 767 767 sky130_fd_pr__pfet_01v8 L=0.15U W=0.42U AS=0.0567P
+ AD=0.0882P PS=0.69U PD=0.84U
* device instance $2416 r0 *1 17.61,43.965 sky130_fd_pr__pfet_01v8
M$2416 167 736 792 792 sky130_fd_pr__pfet_01v8 L=0.15U W=0.42U AS=0.0882P
+ AD=0.1113P PS=0.84U PD=1.37U
* device instance $2417 r0 *1 18.665,44.075 sky130_fd_pr__pfet_01v8
M$2417 167 767 736 736 sky130_fd_pr__pfet_01v8 L=0.15U W=0.64U AS=0.1728P
+ AD=0.154P PS=1.82U PD=1.335U
* device instance $2418 r0 *1 19.15,44.255 sky130_fd_pr__pfet_01v8
M$2418 589 767 167 167 sky130_fd_pr__pfet_01v8 L=0.15U W=1U AS=0.154P AD=0.28P
+ PS=1.335U PD=2.56U
* device instance $2419 r0 *1 26.775,44.16 sky130_fd_pr__pfet_01v8
M$2419 795 71 167 167 sky130_fd_pr__pfet_01v8 L=0.15U W=0.42U AS=0.15835P
+ AD=0.07665P PS=1.395U PD=0.785U
* device instance $2420 r0 *1 27.29,44.16 sky130_fd_pr__pfet_01v8
M$2420 760 601 795 795 sky130_fd_pr__pfet_01v8 L=0.15U W=0.42U AS=0.07665P
+ AD=0.1932P PS=0.785U PD=1.34U
* device instance $2421 r0 *1 28.36,44.16 sky130_fd_pr__pfet_01v8
M$2421 796 768 760 760 sky130_fd_pr__pfet_01v8 L=0.15U W=0.42U AS=0.1932P
+ AD=0.0441P PS=1.34U PD=0.63U
* device instance $2422 r0 *1 28.72,44.16 sky130_fd_pr__pfet_01v8
M$2422 167 810 796 796 sky130_fd_pr__pfet_01v8 L=0.15U W=0.42U AS=0.0441P
+ AD=0.0693P PS=0.63U PD=0.75U
* device instance $2423 r0 *1 29.2,44.16 sky130_fd_pr__pfet_01v8
M$2423 810 71 167 167 sky130_fd_pr__pfet_01v8 L=0.15U W=0.42U AS=0.0693P
+ AD=0.1176P PS=0.75U PD=1.4U
* device instance $2424 r0 *1 26.23,44.255 sky130_fd_pr__pfet_01v8
M$2424 167 760 708 708 sky130_fd_pr__pfet_01v8 L=0.15U W=1U AS=0.26P
+ AD=0.15835P PS=2.52U PD=1.395U
* device instance $2425 r0 *1 33.185,43.075 sky130_fd_pr__pfet_01v8
M$2425 751 691 167 167 sky130_fd_pr__pfet_01v8 L=0.15U W=0.42U AS=0.1092P
+ AD=0.06405P PS=1.36U PD=0.725U
* device instance $2426 r0 *1 33.64,43.075 sky130_fd_pr__pfet_01v8
M$2426 692 686 751 751 sky130_fd_pr__pfet_01v8 L=0.15U W=0.42U AS=0.06405P
+ AD=0.0567P PS=0.725U PD=0.69U
* device instance $2427 r0 *1 34.06,43.075 sky130_fd_pr__pfet_01v8
M$2427 752 687 692 692 sky130_fd_pr__pfet_01v8 L=0.15U W=0.42U AS=0.0567P
+ AD=0.0882P PS=0.69U PD=0.84U
* device instance $2428 r0 *1 34.63,43.075 sky130_fd_pr__pfet_01v8
M$2428 167 709 752 752 sky130_fd_pr__pfet_01v8 L=0.15U W=0.42U AS=0.0882P
+ AD=0.1113P PS=0.84U PD=1.37U
* device instance $2429 r0 *1 34.95,44.075 sky130_fd_pr__pfet_01v8
M$2429 797 802 771 771 sky130_fd_pr__pfet_01v8 L=0.15U W=0.64U AS=0.1664P
+ AD=0.0672P PS=1.8U PD=0.85U
* device instance $2430 r0 *1 35.31,44.075 sky130_fd_pr__pfet_01v8
M$2430 167 737 797 797 sky130_fd_pr__pfet_01v8 L=0.15U W=0.64U AS=0.0672P
+ AD=0.1664P PS=0.85U PD=1.8U
* device instance $2431 r0 *1 37.975,43.965 sky130_fd_pr__pfet_01v8
M$2431 772 770 771 771 sky130_fd_pr__pfet_01v8 L=0.15U W=0.42U AS=0.15985P
+ AD=0.06405P PS=1.265U PD=0.725U
* device instance $2432 r0 *1 38.43,43.965 sky130_fd_pr__pfet_01v8
M$2432 799 769 772 772 sky130_fd_pr__pfet_01v8 L=0.15U W=0.42U AS=0.06405P
+ AD=0.07665P PS=0.725U PD=0.785U
* device instance $2433 r0 *1 38.945,43.965 sky130_fd_pr__pfet_01v8
M$2433 167 773 799 799 sky130_fd_pr__pfet_01v8 L=0.15U W=0.42U AS=0.07665P
+ AD=0.178875P PS=0.785U PD=1.26U
* device instance $2434 r0 *1 36.25,44.075 sky130_fd_pr__pfet_01v8
M$2434 167 90 737 737 sky130_fd_pr__pfet_01v8 L=0.15U W=0.64U AS=0.1664P
+ AD=0.0928P PS=1.8U PD=0.93U
* device instance $2435 r0 *1 36.69,44.075 sky130_fd_pr__pfet_01v8
M$2435 798 90 167 167 sky130_fd_pr__pfet_01v8 L=0.15U W=0.64U AS=0.0928P
+ AD=0.1152P PS=0.93U PD=1U
* device instance $2436 r0 *1 37.2,44.075 sky130_fd_pr__pfet_01v8
M$2436 771 738 798 798 sky130_fd_pr__pfet_01v8 L=0.15U W=0.64U AS=0.1152P
+ AD=0.15985P PS=1U PD=1.265U
* device instance $2437 r0 *1 39.605,44.13 sky130_fd_pr__pfet_01v8
M$2437 773 772 167 167 sky130_fd_pr__pfet_01v8 L=0.15U W=0.75U AS=0.178875P
+ AD=0.195P PS=1.26U PD=2.02U
* device instance $2438 r0 *1 40.545,43.965 sky130_fd_pr__pfet_01v8
M$2438 800 773 167 167 sky130_fd_pr__pfet_01v8 L=0.15U W=0.42U AS=0.1092P
+ AD=0.06405P PS=1.36U PD=0.725U
* device instance $2439 r0 *1 41,43.965 sky130_fd_pr__pfet_01v8
M$2439 774 769 800 800 sky130_fd_pr__pfet_01v8 L=0.15U W=0.42U AS=0.06405P
+ AD=0.0567P PS=0.725U PD=0.69U
* device instance $2440 r0 *1 41.42,43.965 sky130_fd_pr__pfet_01v8
M$2440 801 770 774 774 sky130_fd_pr__pfet_01v8 L=0.15U W=0.42U AS=0.0567P
+ AD=0.0882P PS=0.69U PD=0.84U
* device instance $2441 r0 *1 41.99,43.965 sky130_fd_pr__pfet_01v8
M$2441 167 738 801 801 sky130_fd_pr__pfet_01v8 L=0.15U W=0.42U AS=0.0882P
+ AD=0.1113P PS=0.84U PD=1.37U
* device instance $2442 r0 *1 43.045,44.075 sky130_fd_pr__pfet_01v8
M$2442 167 774 738 738 sky130_fd_pr__pfet_01v8 L=0.15U W=0.64U AS=0.1728P
+ AD=0.154P PS=1.82U PD=1.335U
* device instance $2443 r0 *1 43.53,44.255 sky130_fd_pr__pfet_01v8
M$2443 710 774 167 167 sky130_fd_pr__pfet_01v8 L=0.15U W=1U AS=0.154P AD=0.28P
+ PS=1.335U PD=2.56U
* device instance $2444 r0 *1 44.63,44.255 sky130_fd_pr__pfet_01v8
M$2444 761 803 775 775 sky130_fd_pr__pfet_01v8 L=0.15U W=1U AS=0.26P AD=0.135P
+ PS=2.52U PD=1.27U
* device instance $2445 r0 *1 45.05,44.255 sky130_fd_pr__pfet_01v8
M$2445 776 710 761 761 sky130_fd_pr__pfet_01v8 L=0.15U W=1U AS=0.135P AD=0.135P
+ PS=1.27U PD=1.27U
* device instance $2446 r0 *1 45.47,44.255 sky130_fd_pr__pfet_01v8
M$2446 761 91 776 776 sky130_fd_pr__pfet_01v8 L=0.15U W=1U AS=0.135P AD=0.26P
+ PS=1.27U PD=2.52U
* device instance $2447 r0 *1 46.41,44.255 sky130_fd_pr__pfet_01v8
M$2447 776 137 167 167 sky130_fd_pr__pfet_01v8 L=0.15U W=1U AS=0.26P AD=0.165P
+ PS=2.52U PD=1.33U
* device instance $2448 r0 *1 46.89,44.255 sky130_fd_pr__pfet_01v8
M$2448 167 734 776 776 sky130_fd_pr__pfet_01v8 L=0.15U W=1U AS=0.165P
+ AD=0.1575P PS=1.33U PD=1.315U
* device instance $2449 r0 *1 47.355,44.255 sky130_fd_pr__pfet_01v8
M$2449 811 775 167 167 sky130_fd_pr__pfet_01v8 L=0.15U W=1U AS=0.1575P AD=0.26P
+ PS=1.315U PD=2.52U
* device instance $2450 r0 *1 48.31,44.175 sky130_fd_pr__pfet_01v8
M$2450 777 804 167 167 sky130_fd_pr__pfet_01v8 L=0.15U W=1.68U AS=0.3318P
+ AD=0.3486P PS=3.31U PD=3.35U
* device instance $2452 r0 *1 49.69,44.255 sky130_fd_pr__pfet_01v8
M$2452 809 777 654 654 sky130_fd_pr__pfet_01v8 L=0.15U W=1U AS=0.26P AD=0.105P
+ PS=2.52U PD=1.21U
* device instance $2453 r0 *1 50.05,44.255 sky130_fd_pr__pfet_01v8
M$2453 167 710 809 809 sky130_fd_pr__pfet_01v8 L=0.15U W=1U AS=0.105P AD=0.26P
+ PS=1.21U PD=2.52U
* device instance $2454 r0 *1 51.31,44.545 sky130_fd_pr__pfet_01v8
M$2454 778 710 167 167 sky130_fd_pr__pfet_01v8 L=0.15U W=0.42U AS=0.1573P
+ AD=0.1092P PS=1.39U PD=1.36U
* device instance $2455 r0 *1 51.85,44.255 sky130_fd_pr__pfet_01v8
M$2455 808 804 167 167 sky130_fd_pr__pfet_01v8 L=0.15U W=1U AS=0.1573P
+ AD=0.105P PS=1.39U PD=1.21U
* device instance $2456 r0 *1 52.21,44.255 sky130_fd_pr__pfet_01v8
M$2456 805 778 808 808 sky130_fd_pr__pfet_01v8 L=0.15U W=1U AS=0.105P AD=0.26P
+ PS=1.21U PD=2.52U
* device instance $2457 r0 *1 56.59,44.255 sky130_fd_pr__pfet_01v8
M$2457 807 805 711 711 sky130_fd_pr__pfet_01v8 L=0.15U W=1U AS=0.26P AD=0.105P
+ PS=2.52U PD=1.21U
* device instance $2458 r0 *1 56.95,44.255 sky130_fd_pr__pfet_01v8
M$2458 167 654 807 807 sky130_fd_pr__pfet_01v8 L=0.15U W=1U AS=0.105P AD=0.26P
+ PS=1.21U PD=2.52U
* device instance $2459 r0 *1 61.19,44.255 sky130_fd_pr__pfet_01v8
M$2459 806 571 695 695 sky130_fd_pr__pfet_01v8 L=0.15U W=1U AS=0.26P AD=0.105P
+ PS=2.52U PD=1.21U
* device instance $2460 r0 *1 61.55,44.255 sky130_fd_pr__pfet_01v8
M$2460 167 919 806 806 sky130_fd_pr__pfet_01v8 L=0.15U W=1U AS=0.105P AD=0.26P
+ PS=1.21U PD=2.52U
* device instance $2461 r0 *1 66.23,44.075 sky130_fd_pr__pfet_01v8
M$2461 794 634 781 781 sky130_fd_pr__pfet_01v8 L=0.15U W=0.64U AS=0.1664P
+ AD=0.0672P PS=1.8U PD=0.85U
* device instance $2462 r0 *1 66.59,44.075 sky130_fd_pr__pfet_01v8
M$2462 167 739 794 794 sky130_fd_pr__pfet_01v8 L=0.15U W=0.64U AS=0.0672P
+ AD=0.1664P PS=0.85U PD=1.8U
* device instance $2463 r0 *1 69.255,43.965 sky130_fd_pr__pfet_01v8
M$2463 782 780 781 781 sky130_fd_pr__pfet_01v8 L=0.15U W=0.42U AS=0.15985P
+ AD=0.06405P PS=1.265U PD=0.725U
* device instance $2464 r0 *1 69.71,43.965 sky130_fd_pr__pfet_01v8
M$2464 790 779 782 782 sky130_fd_pr__pfet_01v8 L=0.15U W=0.42U AS=0.06405P
+ AD=0.07665P PS=0.725U PD=0.785U
* device instance $2465 r0 *1 70.225,43.965 sky130_fd_pr__pfet_01v8
M$2465 167 783 790 790 sky130_fd_pr__pfet_01v8 L=0.15U W=0.42U AS=0.07665P
+ AD=0.178875P PS=0.785U PD=1.26U
* device instance $2466 r0 *1 67.53,44.075 sky130_fd_pr__pfet_01v8
M$2466 167 1102 739 739 sky130_fd_pr__pfet_01v8 L=0.15U W=0.64U AS=0.1664P
+ AD=0.0928P PS=1.8U PD=0.93U
* device instance $2467 r0 *1 67.97,44.075 sky130_fd_pr__pfet_01v8
M$2467 793 1102 167 167 sky130_fd_pr__pfet_01v8 L=0.15U W=0.64U AS=0.0928P
+ AD=0.1152P PS=0.93U PD=1U
* device instance $2468 r0 *1 68.48,44.075 sky130_fd_pr__pfet_01v8
M$2468 781 740 793 793 sky130_fd_pr__pfet_01v8 L=0.15U W=0.64U AS=0.1152P
+ AD=0.15985P PS=1U PD=1.265U
* device instance $2469 r0 *1 70.885,44.13 sky130_fd_pr__pfet_01v8
M$2469 783 782 167 167 sky130_fd_pr__pfet_01v8 L=0.15U W=0.75U AS=0.178875P
+ AD=0.195P PS=1.26U PD=2.02U
* device instance $2470 r0 *1 67.685,43.075 sky130_fd_pr__pfet_01v8
M$2470 749 703 167 167 sky130_fd_pr__pfet_01v8 L=0.15U W=0.42U AS=0.1092P
+ AD=0.06405P PS=1.36U PD=0.725U
* device instance $2471 r0 *1 68.14,43.075 sky130_fd_pr__pfet_01v8
M$2471 704 698 749 749 sky130_fd_pr__pfet_01v8 L=0.15U W=0.42U AS=0.06405P
+ AD=0.0567P PS=0.725U PD=0.69U
* device instance $2472 r0 *1 68.56,43.075 sky130_fd_pr__pfet_01v8
M$2472 746 699 704 704 sky130_fd_pr__pfet_01v8 L=0.15U W=0.42U AS=0.0567P
+ AD=0.0882P PS=0.69U PD=0.84U
* device instance $2473 r0 *1 69.13,43.075 sky130_fd_pr__pfet_01v8
M$2473 167 713 746 746 sky130_fd_pr__pfet_01v8 L=0.15U W=0.42U AS=0.0882P
+ AD=0.1113P PS=0.84U PD=1.37U
* device instance $2474 r0 *1 71.825,43.965 sky130_fd_pr__pfet_01v8
M$2474 788 783 167 167 sky130_fd_pr__pfet_01v8 L=0.15U W=0.42U AS=0.1092P
+ AD=0.06405P PS=1.36U PD=0.725U
* device instance $2475 r0 *1 72.28,43.965 sky130_fd_pr__pfet_01v8
M$2475 784 779 788 788 sky130_fd_pr__pfet_01v8 L=0.15U W=0.42U AS=0.06405P
+ AD=0.0567P PS=0.725U PD=0.69U
* device instance $2476 r0 *1 72.7,43.965 sky130_fd_pr__pfet_01v8
M$2476 786 780 784 784 sky130_fd_pr__pfet_01v8 L=0.15U W=0.42U AS=0.0567P
+ AD=0.0882P PS=0.69U PD=0.84U
* device instance $2477 r0 *1 73.27,43.965 sky130_fd_pr__pfet_01v8
M$2477 167 740 786 786 sky130_fd_pr__pfet_01v8 L=0.15U W=0.42U AS=0.0882P
+ AD=0.1113P PS=0.84U PD=1.37U
* device instance $2478 r0 *1 74.325,44.075 sky130_fd_pr__pfet_01v8
M$2478 167 784 740 740 sky130_fd_pr__pfet_01v8 L=0.15U W=0.64U AS=0.1728P
+ AD=0.154P PS=1.82U PD=1.335U
* device instance $2479 r0 *1 74.81,44.255 sky130_fd_pr__pfet_01v8
M$2479 571 784 167 167 sky130_fd_pr__pfet_01v8 L=0.15U W=1U AS=0.154P AD=0.28P
+ PS=1.335U PD=2.56U
* device instance $2480 r0 *1 7.83,48.225 sky130_fd_pr__pfet_01v8
M$2480 871 862 831 831 sky130_fd_pr__pfet_01v8 L=0.15U W=1U AS=0.26P AD=0.135P
+ PS=2.52U PD=1.27U
* device instance $2481 r0 *1 8.25,48.225 sky130_fd_pr__pfet_01v8
M$2481 872 863 871 871 sky130_fd_pr__pfet_01v8 L=0.15U W=1U AS=0.135P AD=0.135P
+ PS=1.27U PD=1.27U
* device instance $2482 r0 *1 8.67,48.225 sky130_fd_pr__pfet_01v8
M$2482 871 91 872 872 sky130_fd_pr__pfet_01v8 L=0.15U W=1U AS=0.135P AD=0.26P
+ PS=1.27U PD=2.52U
* device instance $2483 r0 *1 9.21,44.105 sky130_fd_pr__pfet_01v8
M$2483 167 937 762 762 sky130_fd_pr__pfet_01v8 L=0.15U W=0.64U AS=0.1664P
+ AD=0.0864P PS=1.8U PD=0.91U
* device instance $2484 r0 *1 9.63,44.105 sky130_fd_pr__pfet_01v8
M$2484 763 762 167 167 sky130_fd_pr__pfet_01v8 L=0.15U W=0.64U AS=0.0864P
+ AD=0.1664P PS=0.91U PD=1.8U
* device instance $2485 r0 *1 9.61,48.225 sky130_fd_pr__pfet_01v8
M$2485 872 87 167 167 sky130_fd_pr__pfet_01v8 L=0.15U W=1U AS=0.26P AD=0.165P
+ PS=2.52U PD=1.33U
* device instance $2486 r0 *1 10.09,48.225 sky130_fd_pr__pfet_01v8
M$2486 167 864 872 872 sky130_fd_pr__pfet_01v8 L=0.15U W=1U AS=0.165P
+ AD=0.1575P PS=1.33U PD=1.315U
* device instance $2487 r0 *1 10.555,48.225 sky130_fd_pr__pfet_01v8
M$2487 873 831 167 167 sky130_fd_pr__pfet_01v8 L=0.15U W=1U AS=0.1575P AD=0.26P
+ PS=1.315U PD=2.52U
* device instance $2488 r0 *1 11.51,48.225 sky130_fd_pr__pfet_01v8
M$2488 167 865 832 832 sky130_fd_pr__pfet_01v8 L=0.15U W=1U AS=0.26P AD=0.26P
+ PS=2.52U PD=2.52U
* device instance $2489 r0 *1 12.45,48.225 sky130_fd_pr__pfet_01v8
M$2489 588 832 167 167 sky130_fd_pr__pfet_01v8 L=0.15U W=4U AS=0.665P
+ AD=0.5475P PS=6.33U PD=5.095U
* device instance $2493 r0 *1 14.145,48.225 sky130_fd_pr__pfet_01v8
M$2493 588 834 167 167 sky130_fd_pr__pfet_01v8 L=0.15U W=4U AS=0.5475P
+ AD=0.795P PS=5.095U PD=6.59U
* device instance $2497 r0 *1 25.77,48.375 sky130_fd_pr__pfet_01v8
M$2497 167 937 835 835 sky130_fd_pr__pfet_01v8 L=0.15U W=0.64U AS=0.1664P
+ AD=0.0864P PS=1.8U PD=0.91U
* device instance $2498 r0 *1 26.19,48.375 sky130_fd_pr__pfet_01v8
M$2498 836 835 167 167 sky130_fd_pr__pfet_01v8 L=0.15U W=0.64U AS=0.0864P
+ AD=0.1664P PS=0.91U PD=1.8U
* device instance $2499 r0 *1 27.13,48.405 sky130_fd_pr__pfet_01v8
M$2499 879 639 837 837 sky130_fd_pr__pfet_01v8 L=0.15U W=0.64U AS=0.1664P
+ AD=0.0672P PS=1.8U PD=0.85U
* device instance $2500 r0 *1 27.49,48.405 sky130_fd_pr__pfet_01v8
M$2500 167 838 879 879 sky130_fd_pr__pfet_01v8 L=0.15U W=0.64U AS=0.0672P
+ AD=0.1664P PS=0.85U PD=1.8U
* device instance $2501 r0 *1 28.43,48.405 sky130_fd_pr__pfet_01v8
M$2501 167 315 838 838 sky130_fd_pr__pfet_01v8 L=0.15U W=0.64U AS=0.1664P
+ AD=0.0928P PS=1.8U PD=0.93U
* device instance $2502 r0 *1 28.87,48.405 sky130_fd_pr__pfet_01v8
M$2502 880 315 167 167 sky130_fd_pr__pfet_01v8 L=0.15U W=0.64U AS=0.0928P
+ AD=0.1152P PS=0.93U PD=1U
* device instance $2503 r0 *1 29.38,48.405 sky130_fd_pr__pfet_01v8
M$2503 837 866 880 880 sky130_fd_pr__pfet_01v8 L=0.15U W=0.64U AS=0.1152P
+ AD=0.15985P PS=1U PD=1.265U
* device instance $2504 r0 *1 30.155,48.515 sky130_fd_pr__pfet_01v8
M$2504 839 836 837 837 sky130_fd_pr__pfet_01v8 L=0.15U W=0.42U AS=0.15985P
+ AD=0.06405P PS=1.265U PD=0.725U
* device instance $2505 r0 *1 30.61,48.515 sky130_fd_pr__pfet_01v8
M$2505 881 835 839 839 sky130_fd_pr__pfet_01v8 L=0.15U W=0.42U AS=0.06405P
+ AD=0.07665P PS=0.725U PD=0.785U
* device instance $2506 r0 *1 31.125,48.515 sky130_fd_pr__pfet_01v8
M$2506 881 840 167 167 sky130_fd_pr__pfet_01v8 L=0.15U W=0.42U AS=0.178875P
+ AD=0.07665P PS=1.26U PD=0.785U
* device instance $2507 r0 *1 31.785,48.35 sky130_fd_pr__pfet_01v8
M$2507 840 839 167 167 sky130_fd_pr__pfet_01v8 L=0.15U W=0.75U AS=0.178875P
+ AD=0.195P PS=1.26U PD=2.02U
* device instance $2508 r0 *1 32.725,48.515 sky130_fd_pr__pfet_01v8
M$2508 882 840 167 167 sky130_fd_pr__pfet_01v8 L=0.15U W=0.42U AS=0.1092P
+ AD=0.06405P PS=1.36U PD=0.725U
* device instance $2509 r0 *1 33.18,48.515 sky130_fd_pr__pfet_01v8
M$2509 841 835 882 882 sky130_fd_pr__pfet_01v8 L=0.15U W=0.42U AS=0.06405P
+ AD=0.0567P PS=0.725U PD=0.69U
* device instance $2510 r0 *1 33.6,48.515 sky130_fd_pr__pfet_01v8
M$2510 883 836 841 841 sky130_fd_pr__pfet_01v8 L=0.15U W=0.42U AS=0.0567P
+ AD=0.0882P PS=0.69U PD=0.84U
* device instance $2511 r0 *1 34.17,48.515 sky130_fd_pr__pfet_01v8
M$2511 167 866 883 883 sky130_fd_pr__pfet_01v8 L=0.15U W=0.42U AS=0.0882P
+ AD=0.1113P PS=0.84U PD=1.37U
* device instance $2512 r0 *1 33.59,44.105 sky130_fd_pr__pfet_01v8
M$2512 167 937 769 769 sky130_fd_pr__pfet_01v8 L=0.15U W=0.64U AS=0.1664P
+ AD=0.0864P PS=1.8U PD=0.91U
* device instance $2513 r0 *1 34.01,44.105 sky130_fd_pr__pfet_01v8
M$2513 770 769 167 167 sky130_fd_pr__pfet_01v8 L=0.15U W=0.64U AS=0.0864P
+ AD=0.1664P PS=0.91U PD=1.8U
* device instance $2514 r0 *1 35.225,48.405 sky130_fd_pr__pfet_01v8
M$2514 866 841 167 167 sky130_fd_pr__pfet_01v8 L=0.15U W=0.64U AS=0.154P
+ AD=0.1728P PS=1.335U PD=1.82U
* device instance $2515 r0 *1 35.71,48.225 sky130_fd_pr__pfet_01v8
M$2515 601 841 167 167 sky130_fd_pr__pfet_01v8 L=0.15U W=1U AS=0.154P AD=0.28P
+ PS=1.335U PD=2.56U
* device instance $2516 r0 *1 41.005,48.405 sky130_fd_pr__pfet_01v8
M$2516 884 777 167 167 sky130_fd_pr__pfet_01v8 L=0.15U W=0.64U AS=0.1696P
+ AD=0.0768P PS=1.81U PD=0.88U
* device instance $2517 r0 *1 41.395,48.405 sky130_fd_pr__pfet_01v8
M$2517 802 71 884 884 sky130_fd_pr__pfet_01v8 L=0.15U W=0.64U AS=0.0768P
+ AD=0.0896P PS=0.88U PD=0.92U
* device instance $2518 r0 *1 41.825,48.405 sky130_fd_pr__pfet_01v8
M$2518 167 1242 802 802 sky130_fd_pr__pfet_01v8 L=0.15U W=0.64U AS=0.0896P
+ AD=0.1824P PS=0.92U PD=1.85U
* device instance $2519 r0 *1 44.63,48.375 sky130_fd_pr__pfet_01v8
M$2519 167 844 843 843 sky130_fd_pr__pfet_01v8 L=0.15U W=0.64U AS=0.1664P
+ AD=0.0864P PS=1.8U PD=0.91U
* device instance $2520 r0 *1 45.05,48.375 sky130_fd_pr__pfet_01v8
M$2520 845 843 167 167 sky130_fd_pr__pfet_01v8 L=0.15U W=0.64U AS=0.0864P
+ AD=0.1664P PS=0.91U PD=1.8U
* device instance $2521 r0 *1 45.99,48.405 sky130_fd_pr__pfet_01v8
M$2521 886 811 846 846 sky130_fd_pr__pfet_01v8 L=0.15U W=0.64U AS=0.1664P
+ AD=0.0672P PS=1.8U PD=0.85U
* device instance $2522 r0 *1 46.35,48.405 sky130_fd_pr__pfet_01v8
M$2522 167 847 886 886 sky130_fd_pr__pfet_01v8 L=0.15U W=0.64U AS=0.0672P
+ AD=0.1664P PS=0.85U PD=1.8U
* device instance $2523 r0 *1 47.29,48.405 sky130_fd_pr__pfet_01v8
M$2523 167 315 847 847 sky130_fd_pr__pfet_01v8 L=0.15U W=0.64U AS=0.1664P
+ AD=0.0928P PS=1.8U PD=0.93U
* device instance $2524 r0 *1 47.73,48.405 sky130_fd_pr__pfet_01v8
M$2524 888 315 167 167 sky130_fd_pr__pfet_01v8 L=0.15U W=0.64U AS=0.0928P
+ AD=0.1152P PS=0.93U PD=1U
* device instance $2525 r0 *1 48.24,48.405 sky130_fd_pr__pfet_01v8
M$2525 846 867 888 888 sky130_fd_pr__pfet_01v8 L=0.15U W=0.64U AS=0.1152P
+ AD=0.15985P PS=1U PD=1.265U
* device instance $2526 r0 *1 49.015,48.515 sky130_fd_pr__pfet_01v8
M$2526 848 845 846 846 sky130_fd_pr__pfet_01v8 L=0.15U W=0.42U AS=0.15985P
+ AD=0.06405P PS=1.265U PD=0.725U
* device instance $2527 r0 *1 49.47,48.515 sky130_fd_pr__pfet_01v8
M$2527 889 843 848 848 sky130_fd_pr__pfet_01v8 L=0.15U W=0.42U AS=0.06405P
+ AD=0.07665P PS=0.725U PD=0.785U
* device instance $2528 r0 *1 49.985,48.515 sky130_fd_pr__pfet_01v8
M$2528 889 849 167 167 sky130_fd_pr__pfet_01v8 L=0.15U W=0.42U AS=0.178875P
+ AD=0.07665P PS=1.26U PD=0.785U
* device instance $2529 r0 *1 50.645,48.35 sky130_fd_pr__pfet_01v8
M$2529 849 848 167 167 sky130_fd_pr__pfet_01v8 L=0.15U W=0.75U AS=0.178875P
+ AD=0.195P PS=1.26U PD=2.02U
* device instance $2530 r0 *1 51.585,48.515 sky130_fd_pr__pfet_01v8
M$2530 887 849 167 167 sky130_fd_pr__pfet_01v8 L=0.15U W=0.42U AS=0.1092P
+ AD=0.06405P PS=1.36U PD=0.725U
* device instance $2531 r0 *1 52.04,48.515 sky130_fd_pr__pfet_01v8
M$2531 850 843 887 887 sky130_fd_pr__pfet_01v8 L=0.15U W=0.42U AS=0.06405P
+ AD=0.0567P PS=0.725U PD=0.69U
* device instance $2532 r0 *1 52.46,48.515 sky130_fd_pr__pfet_01v8
M$2532 885 845 850 850 sky130_fd_pr__pfet_01v8 L=0.15U W=0.42U AS=0.0567P
+ AD=0.0882P PS=0.69U PD=0.84U
* device instance $2533 r0 *1 53.03,48.515 sky130_fd_pr__pfet_01v8
M$2533 167 867 885 885 sky130_fd_pr__pfet_01v8 L=0.15U W=0.42U AS=0.0882P
+ AD=0.1113P PS=0.84U PD=1.37U
* device instance $2534 r0 *1 54.085,48.405 sky130_fd_pr__pfet_01v8
M$2534 867 850 167 167 sky130_fd_pr__pfet_01v8 L=0.15U W=0.64U AS=0.154P
+ AD=0.1728P PS=1.335U PD=1.82U
* device instance $2535 r0 *1 54.57,48.225 sky130_fd_pr__pfet_01v8
M$2535 804 850 167 167 sky130_fd_pr__pfet_01v8 L=0.15U W=1U AS=0.154P AD=0.28P
+ PS=1.335U PD=2.56U
* device instance $2536 r0 *1 61.65,48.225 sky130_fd_pr__pfet_01v8
M$2536 167 642 851 851 sky130_fd_pr__pfet_01v8 L=0.15U W=1U AS=0.26P AD=0.135P
+ PS=2.52U PD=1.27U
* device instance $2537 r0 *1 62.07,48.225 sky130_fd_pr__pfet_01v8
M$2537 870 851 167 167 sky130_fd_pr__pfet_01v8 L=0.15U W=4U AS=0.54P AD=0.665P
+ PS=5.08U PD=6.33U
* device instance $2541 r0 *1 64.87,44.105 sky130_fd_pr__pfet_01v8
M$2541 167 844 779 779 sky130_fd_pr__pfet_01v8 L=0.15U W=0.64U AS=0.1664P
+ AD=0.0864P PS=1.8U PD=0.91U
* device instance $2542 r0 *1 65.29,44.105 sky130_fd_pr__pfet_01v8
M$2542 780 779 167 167 sky130_fd_pr__pfet_01v8 L=0.15U W=0.64U AS=0.0864P
+ AD=0.1664P PS=0.91U PD=1.8U
* device instance $2543 r0 *1 4.68,49.405 sky130_fd_pr__pfet_01v8
M$2543 890 907 167 167 sky130_fd_pr__pfet_01v8 L=0.15U W=0.42U AS=0.1113P
+ AD=0.0609P PS=1.37U PD=0.71U
* device instance $2544 r0 *1 5.12,49.405 sky130_fd_pr__pfet_01v8
M$2544 167 109 890 890 sky130_fd_pr__pfet_01v8 L=0.15U W=0.42U AS=0.0609P
+ AD=0.1841P PS=0.71U PD=1.26U
* device instance $2545 r0 *1 5.89,49.515 sky130_fd_pr__pfet_01v8
M$2545 862 890 167 167 sky130_fd_pr__pfet_01v8 L=0.15U W=0.64U AS=0.1841P
+ AD=0.1696P PS=1.26U PD=1.81U
* device instance $2546 r0 *1 7.455,49.6 sky130_fd_pr__pfet_01v8
M$2546 911 71 167 167 sky130_fd_pr__pfet_01v8 L=0.15U W=0.42U AS=0.15835P
+ AD=0.07665P PS=1.395U PD=0.785U
* device instance $2547 r0 *1 7.97,49.6 sky130_fd_pr__pfet_01v8
M$2547 874 908 911 911 sky130_fd_pr__pfet_01v8 L=0.15U W=0.42U AS=0.07665P
+ AD=0.1932P PS=0.785U PD=1.34U
* device instance $2548 r0 *1 9.04,49.6 sky130_fd_pr__pfet_01v8
M$2548 912 916 874 874 sky130_fd_pr__pfet_01v8 L=0.15U W=0.42U AS=0.1932P
+ AD=0.0441P PS=1.34U PD=0.63U
* device instance $2549 r0 *1 9.4,49.6 sky130_fd_pr__pfet_01v8
M$2549 167 917 912 912 sky130_fd_pr__pfet_01v8 L=0.15U W=0.42U AS=0.0441P
+ AD=0.0693P PS=0.63U PD=0.75U
* device instance $2550 r0 *1 9.88,49.6 sky130_fd_pr__pfet_01v8
M$2550 917 71 167 167 sky130_fd_pr__pfet_01v8 L=0.15U W=0.42U AS=0.0693P
+ AD=0.1176P PS=0.75U PD=1.4U
* device instance $2551 r0 *1 6.91,49.695 sky130_fd_pr__pfet_01v8
M$2551 167 874 891 891 sky130_fd_pr__pfet_01v8 L=0.15U W=1U AS=0.26P
+ AD=0.15835P PS=2.52U PD=1.395U
* device instance $2552 r0 *1 11.09,49.695 sky130_fd_pr__pfet_01v8
M$2552 913 863 892 892 sky130_fd_pr__pfet_01v8 L=0.15U W=1U AS=0.26P AD=0.135P
+ PS=2.52U PD=1.27U
* device instance $2553 r0 *1 11.51,49.695 sky130_fd_pr__pfet_01v8
M$2553 167 908 913 913 sky130_fd_pr__pfet_01v8 L=0.15U W=1U AS=0.135P AD=0.135P
+ PS=1.27U PD=1.27U
* device instance $2554 r0 *1 11.93,49.695 sky130_fd_pr__pfet_01v8
M$2554 893 908 167 167 sky130_fd_pr__pfet_01v8 L=0.15U W=1U AS=0.135P AD=0.135P
+ PS=1.27U PD=1.27U
* device instance $2555 r0 *1 12.35,49.695 sky130_fd_pr__pfet_01v8
M$2555 167 863 893 893 sky130_fd_pr__pfet_01v8 L=0.15U W=1U AS=0.135P AD=0.26P
+ PS=1.27U PD=2.52U
* device instance $2556 r0 *1 12.225,53.845 sky130_fd_pr__pfet_01v8
M$2556 945 935 167 167 sky130_fd_pr__pfet_01v8 L=0.15U W=0.64U AS=0.154P
+ AD=0.1728P PS=1.335U PD=1.82U
* device instance $2557 r0 *1 12.71,53.665 sky130_fd_pr__pfet_01v8
M$2557 834 935 167 167 sky130_fd_pr__pfet_01v8 L=0.15U W=1U AS=0.154P AD=0.28P
+ PS=1.335U PD=2.56U
* device instance $2558 r0 *1 13.29,49.695 sky130_fd_pr__pfet_01v8
M$2558 864 892 893 893 sky130_fd_pr__pfet_01v8 L=0.15U W=1U AS=0.26P AD=0.3P
+ PS=2.52U PD=2.6U
* device instance $2559 r0 *1 13.81,53.665 sky130_fd_pr__pfet_01v8
M$2559 167 865 946 946 sky130_fd_pr__pfet_01v8 L=0.15U W=1U AS=0.26P AD=0.135P
+ PS=2.52U PD=1.27U
* device instance $2560 r0 *1 14.23,53.665 sky130_fd_pr__pfet_01v8
M$2560 908 946 167 167 sky130_fd_pr__pfet_01v8 L=0.15U W=4U AS=0.54P AD=0.665P
+ PS=5.08U PD=6.33U
* device instance $2564 r0 *1 17.03,53.665 sky130_fd_pr__pfet_01v8
M$2564 167 834 947 947 sky130_fd_pr__pfet_01v8 L=0.15U W=1U AS=0.26P AD=0.135P
+ PS=2.52U PD=1.27U
* device instance $2565 r0 *1 17.45,53.665 sky130_fd_pr__pfet_01v8
M$2565 863 947 167 167 sky130_fd_pr__pfet_01v8 L=0.15U W=4U AS=0.54P AD=0.795P
+ PS=5.08U PD=5.59U
* device instance $2569 r0 *1 19.64,53.665 sky130_fd_pr__pfet_01v8
M$2569 937 936 167 167 sky130_fd_pr__pfet_01v8 L=0.15U W=16U AS=2.4875P
+ AD=2.2375P PS=20.975U PD=20.475U
* device instance $2585 r0 *1 26.515,53.665 sky130_fd_pr__pfet_01v8
M$2585 936 310 167 167 sky130_fd_pr__pfet_01v8 L=0.15U W=4U AS=0.56P AD=0.685P
+ PS=5.12U PD=6.37U
* device instance $2589 r0 *1 21.19,49.695 sky130_fd_pr__pfet_01v8
M$2589 167 863 894 894 sky130_fd_pr__pfet_01v8 L=0.15U W=4U AS=0.685P AD=0.54P
+ PS=6.37U PD=5.08U
* device instance $2593 r0 *1 22.87,49.695 sky130_fd_pr__pfet_01v8
M$2593 895 875 894 894 sky130_fd_pr__pfet_01v8 L=0.15U W=4U AS=0.54P AD=0.665P
+ PS=5.08U PD=6.33U
* device instance $2597 r0 *1 25.07,49.695 sky130_fd_pr__pfet_01v8
M$2597 895 876 896 896 sky130_fd_pr__pfet_01v8 L=0.15U W=4U AS=0.665P AD=0.54P
+ PS=6.33U PD=5.08U
* device instance $2601 r0 *1 26.75,49.695 sky130_fd_pr__pfet_01v8
M$2601 918 406 896 896 sky130_fd_pr__pfet_01v8 L=0.15U W=4U AS=0.54P AD=0.665P
+ PS=5.08U PD=6.33U
* device instance $2605 r0 *1 43.32,49.405 sky130_fd_pr__pfet_01v8
M$2605 897 909 167 167 sky130_fd_pr__pfet_01v8 L=0.15U W=0.42U AS=0.1113P
+ AD=0.0609P PS=1.37U PD=0.71U
* device instance $2606 r0 *1 43.76,49.405 sky130_fd_pr__pfet_01v8
M$2606 167 109 897 897 sky130_fd_pr__pfet_01v8 L=0.15U W=0.42U AS=0.0609P
+ AD=0.1841P PS=0.71U PD=1.26U
* device instance $2607 r0 *1 44.53,49.515 sky130_fd_pr__pfet_01v8
M$2607 803 897 167 167 sky130_fd_pr__pfet_01v8 L=0.15U W=0.64U AS=0.1841P
+ AD=0.1696P PS=1.26U PD=1.81U
* device instance $2608 r0 *1 56.13,53.665 sky130_fd_pr__pfet_01v8
M$2608 964 948 938 938 sky130_fd_pr__pfet_01v8 L=0.15U W=1U AS=0.26P AD=0.135P
+ PS=2.52U PD=1.27U
* device instance $2609 r0 *1 56.55,53.665 sky130_fd_pr__pfet_01v8
M$2609 965 805 964 964 sky130_fd_pr__pfet_01v8 L=0.15U W=1U AS=0.135P AD=0.135P
+ PS=1.27U PD=1.27U
* device instance $2610 r0 *1 56.97,53.665 sky130_fd_pr__pfet_01v8
M$2610 167 979 965 965 sky130_fd_pr__pfet_01v8 L=0.15U W=1U AS=0.135P AD=0.4P
+ PS=1.27U PD=1.8U
* device instance $2611 r0 *1 57.92,53.665 sky130_fd_pr__pfet_01v8
M$2611 939 938 167 167 sky130_fd_pr__pfet_01v8 L=0.15U W=4U AS=0.805P AD=0.87P
+ PS=5.61U PD=5.74U
* device instance $2615 r0 *1 60.26,53.665 sky130_fd_pr__pfet_01v8
M$2615 948 940 167 167 sky130_fd_pr__pfet_01v8 L=0.15U W=4U AS=0.87P AD=0.54P
+ PS=5.74U PD=5.08U
* device instance $2619 r0 *1 61.94,53.665 sky130_fd_pr__pfet_01v8
M$2619 940 870 167 167 sky130_fd_pr__pfet_01v8 L=0.15U W=1U AS=0.135P AD=0.26P
+ PS=1.27U PD=2.52U
* device instance $2620 r0 *1 64.87,49.545 sky130_fd_pr__pfet_01v8
M$2620 167 844 898 898 sky130_fd_pr__pfet_01v8 L=0.15U W=0.64U AS=0.1664P
+ AD=0.0864P PS=1.8U PD=0.91U
* device instance $2621 r0 *1 65.29,49.545 sky130_fd_pr__pfet_01v8
M$2621 899 898 167 167 sky130_fd_pr__pfet_01v8 L=0.15U W=0.64U AS=0.0864P
+ AD=0.1664P PS=0.91U PD=1.8U
* device instance $2622 r0 *1 66.23,49.515 sky130_fd_pr__pfet_01v8
M$2622 915 910 900 900 sky130_fd_pr__pfet_01v8 L=0.15U W=0.64U AS=0.1664P
+ AD=0.0672P PS=1.8U PD=0.85U
* device instance $2623 r0 *1 66.59,49.515 sky130_fd_pr__pfet_01v8
M$2623 167 877 915 915 sky130_fd_pr__pfet_01v8 L=0.15U W=0.64U AS=0.0672P
+ AD=0.1664P PS=0.85U PD=1.8U
* device instance $2624 r0 *1 69.255,49.405 sky130_fd_pr__pfet_01v8
M$2624 901 899 900 900 sky130_fd_pr__pfet_01v8 L=0.15U W=0.42U AS=0.15985P
+ AD=0.06405P PS=1.265U PD=0.725U
* device instance $2625 r0 *1 69.71,49.405 sky130_fd_pr__pfet_01v8
M$2625 906 898 901 901 sky130_fd_pr__pfet_01v8 L=0.15U W=0.42U AS=0.06405P
+ AD=0.07665P PS=0.725U PD=0.785U
* device instance $2626 r0 *1 70.225,49.405 sky130_fd_pr__pfet_01v8
M$2626 167 902 906 906 sky130_fd_pr__pfet_01v8 L=0.15U W=0.42U AS=0.07665P
+ AD=0.178875P PS=0.785U PD=1.26U
* device instance $2627 r0 *1 67.53,49.515 sky130_fd_pr__pfet_01v8
M$2627 167 1102 877 877 sky130_fd_pr__pfet_01v8 L=0.15U W=0.64U AS=0.1664P
+ AD=0.0928P PS=1.8U PD=0.93U
* device instance $2628 r0 *1 67.97,49.515 sky130_fd_pr__pfet_01v8
M$2628 914 1102 167 167 sky130_fd_pr__pfet_01v8 L=0.15U W=0.64U AS=0.0928P
+ AD=0.1152P PS=0.93U PD=1U
* device instance $2629 r0 *1 68.48,49.515 sky130_fd_pr__pfet_01v8
M$2629 900 878 914 914 sky130_fd_pr__pfet_01v8 L=0.15U W=0.64U AS=0.1152P
+ AD=0.15985P PS=1U PD=1.265U
* device instance $2630 r0 *1 70.885,49.57 sky130_fd_pr__pfet_01v8
M$2630 902 901 167 167 sky130_fd_pr__pfet_01v8 L=0.15U W=0.75U AS=0.178875P
+ AD=0.195P PS=1.26U PD=2.02U
* device instance $2631 r0 *1 68.175,53.76 sky130_fd_pr__pfet_01v8
M$2631 961 71 167 167 sky130_fd_pr__pfet_01v8 L=0.15U W=0.42U AS=0.15835P
+ AD=0.07665P PS=1.395U PD=0.785U
* device instance $2632 r0 *1 68.69,53.76 sky130_fd_pr__pfet_01v8
M$2632 941 949 961 961 sky130_fd_pr__pfet_01v8 L=0.15U W=0.42U AS=0.07665P
+ AD=0.1932P PS=0.785U PD=1.34U
* device instance $2633 r0 *1 69.76,53.76 sky130_fd_pr__pfet_01v8
M$2633 958 942 941 941 sky130_fd_pr__pfet_01v8 L=0.15U W=0.42U AS=0.1932P
+ AD=0.0441P PS=1.34U PD=0.63U
* device instance $2634 r0 *1 70.12,53.76 sky130_fd_pr__pfet_01v8
M$2634 167 943 958 958 sky130_fd_pr__pfet_01v8 L=0.15U W=0.42U AS=0.0441P
+ AD=0.0693P PS=0.63U PD=0.75U
* device instance $2635 r0 *1 70.6,53.76 sky130_fd_pr__pfet_01v8
M$2635 943 71 167 167 sky130_fd_pr__pfet_01v8 L=0.15U W=0.42U AS=0.0693P
+ AD=0.1176P PS=0.75U PD=1.4U
* device instance $2636 r0 *1 67.63,53.665 sky130_fd_pr__pfet_01v8
M$2636 167 941 910 910 sky130_fd_pr__pfet_01v8 L=0.15U W=1U AS=0.26P
+ AD=0.15835P PS=2.52U PD=1.395U
* device instance $2637 r0 *1 71.825,49.405 sky130_fd_pr__pfet_01v8
M$2637 905 902 167 167 sky130_fd_pr__pfet_01v8 L=0.15U W=0.42U AS=0.1092P
+ AD=0.06405P PS=1.36U PD=0.725U
* device instance $2638 r0 *1 72.28,49.405 sky130_fd_pr__pfet_01v8
M$2638 903 898 905 905 sky130_fd_pr__pfet_01v8 L=0.15U W=0.42U AS=0.06405P
+ AD=0.0567P PS=0.725U PD=0.69U
* device instance $2639 r0 *1 72.7,49.405 sky130_fd_pr__pfet_01v8
M$2639 904 899 903 903 sky130_fd_pr__pfet_01v8 L=0.15U W=0.42U AS=0.0567P
+ AD=0.0882P PS=0.69U PD=0.84U
* device instance $2640 r0 *1 73.27,49.405 sky130_fd_pr__pfet_01v8
M$2640 167 878 904 904 sky130_fd_pr__pfet_01v8 L=0.15U W=0.42U AS=0.0882P
+ AD=0.1113P PS=0.84U PD=1.37U
* device instance $2641 r0 *1 74.325,49.515 sky130_fd_pr__pfet_01v8
M$2641 167 903 878 878 sky130_fd_pr__pfet_01v8 L=0.15U W=0.64U AS=0.1728P
+ AD=0.154P PS=1.82U PD=1.335U
* device instance $2642 r0 *1 74.81,49.695 sky130_fd_pr__pfet_01v8
M$2642 919 903 167 167 sky130_fd_pr__pfet_01v8 L=0.15U W=1U AS=0.154P AD=0.28P
+ PS=1.335U PD=2.56U
* device instance $2643 r0 *1 2.77,53.815 sky130_fd_pr__pfet_01v8
M$2643 167 937 930 930 sky130_fd_pr__pfet_01v8 L=0.15U W=0.64U AS=0.1664P
+ AD=0.0864P PS=1.8U PD=0.91U
* device instance $2644 r0 *1 3.19,53.815 sky130_fd_pr__pfet_01v8
M$2644 931 930 167 167 sky130_fd_pr__pfet_01v8 L=0.15U W=0.64U AS=0.0864P
+ AD=0.1664P PS=0.91U PD=1.8U
* device instance $2645 r0 *1 4.13,53.845 sky130_fd_pr__pfet_01v8
M$2645 957 891 932 932 sky130_fd_pr__pfet_01v8 L=0.15U W=0.64U AS=0.1664P
+ AD=0.0672P PS=1.8U PD=0.85U
* device instance $2646 r0 *1 4.49,53.845 sky130_fd_pr__pfet_01v8
M$2646 167 944 957 957 sky130_fd_pr__pfet_01v8 L=0.15U W=0.64U AS=0.0672P
+ AD=0.1664P PS=0.85U PD=1.8U
* device instance $2647 r0 *1 5.43,53.845 sky130_fd_pr__pfet_01v8
M$2647 167 90 944 944 sky130_fd_pr__pfet_01v8 L=0.15U W=0.64U AS=0.1664P
+ AD=0.0928P PS=1.8U PD=0.93U
* device instance $2648 r0 *1 5.87,53.845 sky130_fd_pr__pfet_01v8
M$2648 959 90 167 167 sky130_fd_pr__pfet_01v8 L=0.15U W=0.64U AS=0.0928P
+ AD=0.1152P PS=0.93U PD=1U
* device instance $2649 r0 *1 6.38,53.845 sky130_fd_pr__pfet_01v8
M$2649 932 945 959 959 sky130_fd_pr__pfet_01v8 L=0.15U W=0.64U AS=0.1152P
+ AD=0.15985P PS=1U PD=1.265U
* device instance $2650 r0 *1 7.155,53.955 sky130_fd_pr__pfet_01v8
M$2650 933 931 932 932 sky130_fd_pr__pfet_01v8 L=0.15U W=0.42U AS=0.15985P
+ AD=0.06405P PS=1.265U PD=0.725U
* device instance $2651 r0 *1 7.61,53.955 sky130_fd_pr__pfet_01v8
M$2651 960 930 933 933 sky130_fd_pr__pfet_01v8 L=0.15U W=0.42U AS=0.06405P
+ AD=0.07665P PS=0.725U PD=0.785U
* device instance $2652 r0 *1 8.125,53.955 sky130_fd_pr__pfet_01v8
M$2652 960 934 167 167 sky130_fd_pr__pfet_01v8 L=0.15U W=0.42U AS=0.178875P
+ AD=0.07665P PS=1.26U PD=0.785U
* device instance $2653 r0 *1 8.785,53.79 sky130_fd_pr__pfet_01v8
M$2653 934 933 167 167 sky130_fd_pr__pfet_01v8 L=0.15U W=0.75U AS=0.178875P
+ AD=0.195P PS=1.26U PD=2.02U
* device instance $2654 r0 *1 9.725,53.955 sky130_fd_pr__pfet_01v8
M$2654 962 934 167 167 sky130_fd_pr__pfet_01v8 L=0.15U W=0.42U AS=0.1092P
+ AD=0.06405P PS=1.36U PD=0.725U
* device instance $2655 r0 *1 10.18,53.955 sky130_fd_pr__pfet_01v8
M$2655 935 930 962 962 sky130_fd_pr__pfet_01v8 L=0.15U W=0.42U AS=0.06405P
+ AD=0.0567P PS=0.725U PD=0.69U
* device instance $2656 r0 *1 10.6,53.955 sky130_fd_pr__pfet_01v8
M$2656 963 931 935 935 sky130_fd_pr__pfet_01v8 L=0.15U W=0.42U AS=0.0567P
+ AD=0.0882P PS=0.69U PD=0.84U
* device instance $2657 r0 *1 11.17,53.955 sky130_fd_pr__pfet_01v8
M$2657 167 945 963 963 sky130_fd_pr__pfet_01v8 L=0.15U W=0.42U AS=0.0882P
+ AD=0.1113P PS=0.84U PD=1.37U
* device instance $2658 r0 *1 10.57,54.955 sky130_fd_pr__pfet_01v8
M$2658 987 873 968 968 sky130_fd_pr__pfet_01v8 L=0.15U W=0.64U AS=0.1664P
+ AD=0.0672P PS=1.8U PD=0.85U
* device instance $2659 r0 *1 10.93,54.955 sky130_fd_pr__pfet_01v8
M$2659 167 969 987 987 sky130_fd_pr__pfet_01v8 L=0.15U W=0.64U AS=0.0672P
+ AD=0.1664P PS=0.85U PD=1.8U
* device instance $2660 r0 *1 13.595,54.845 sky130_fd_pr__pfet_01v8
M$2660 970 967 968 968 sky130_fd_pr__pfet_01v8 L=0.15U W=0.42U AS=0.15985P
+ AD=0.06405P PS=1.265U PD=0.725U
* device instance $2661 r0 *1 14.05,54.845 sky130_fd_pr__pfet_01v8
M$2661 990 966 970 970 sky130_fd_pr__pfet_01v8 L=0.15U W=0.42U AS=0.06405P
+ AD=0.07665P PS=0.725U PD=0.785U
* device instance $2662 r0 *1 14.565,54.845 sky130_fd_pr__pfet_01v8
M$2662 167 971 990 990 sky130_fd_pr__pfet_01v8 L=0.15U W=0.42U AS=0.07665P
+ AD=0.178875P PS=0.785U PD=1.26U
* device instance $2663 r0 *1 11.87,54.955 sky130_fd_pr__pfet_01v8
M$2663 167 315 969 969 sky130_fd_pr__pfet_01v8 L=0.15U W=0.64U AS=0.1664P
+ AD=0.0928P PS=1.8U PD=0.93U
* device instance $2664 r0 *1 12.31,54.955 sky130_fd_pr__pfet_01v8
M$2664 989 315 167 167 sky130_fd_pr__pfet_01v8 L=0.15U W=0.64U AS=0.0928P
+ AD=0.1152P PS=0.93U PD=1U
* device instance $2665 r0 *1 12.82,54.955 sky130_fd_pr__pfet_01v8
M$2665 968 973 989 989 sky130_fd_pr__pfet_01v8 L=0.15U W=0.64U AS=0.1152P
+ AD=0.15985P PS=1U PD=1.265U
* device instance $2666 r0 *1 15.225,55.01 sky130_fd_pr__pfet_01v8
M$2666 971 970 167 167 sky130_fd_pr__pfet_01v8 L=0.15U W=0.75U AS=0.178875P
+ AD=0.195P PS=1.26U PD=2.02U
* device instance $2667 r0 *1 16.165,54.845 sky130_fd_pr__pfet_01v8
M$2667 991 971 167 167 sky130_fd_pr__pfet_01v8 L=0.15U W=0.42U AS=0.1092P
+ AD=0.06405P PS=1.36U PD=0.725U
* device instance $2668 r0 *1 16.62,54.845 sky130_fd_pr__pfet_01v8
M$2668 972 966 991 991 sky130_fd_pr__pfet_01v8 L=0.15U W=0.42U AS=0.06405P
+ AD=0.0567P PS=0.725U PD=0.69U
* device instance $2669 r0 *1 17.04,54.845 sky130_fd_pr__pfet_01v8
M$2669 992 967 972 972 sky130_fd_pr__pfet_01v8 L=0.15U W=0.42U AS=0.0567P
+ AD=0.0882P PS=0.69U PD=0.84U
* device instance $2670 r0 *1 17.61,54.845 sky130_fd_pr__pfet_01v8
M$2670 167 973 992 992 sky130_fd_pr__pfet_01v8 L=0.15U W=0.42U AS=0.0882P
+ AD=0.1113P PS=0.84U PD=1.37U
* device instance $2671 r0 *1 18.665,54.955 sky130_fd_pr__pfet_01v8
M$2671 167 972 973 973 sky130_fd_pr__pfet_01v8 L=0.15U W=0.64U AS=0.1728P
+ AD=0.154P PS=1.82U PD=1.335U
* device instance $2672 r0 *1 19.15,55.135 sky130_fd_pr__pfet_01v8
M$2672 865 972 167 167 sky130_fd_pr__pfet_01v8 L=0.15U W=1U AS=0.154P AD=0.28P
+ PS=1.335U PD=2.56U
* device instance $2673 r0 *1 28.31,55.425 sky130_fd_pr__pfet_01v8
M$2673 984 875 167 167 sky130_fd_pr__pfet_01v8 L=0.15U W=0.42U AS=0.1573P
+ AD=0.1092P PS=1.39U PD=1.36U
* device instance $2674 r0 *1 28.85,55.135 sky130_fd_pr__pfet_01v8
M$2674 993 996 167 167 sky130_fd_pr__pfet_01v8 L=0.15U W=1U AS=0.1573P
+ AD=0.105P PS=1.39U PD=1.21U
* device instance $2675 r0 *1 29.21,55.135 sky130_fd_pr__pfet_01v8
M$2675 995 984 993 993 sky130_fd_pr__pfet_01v8 L=0.15U W=1U AS=0.105P AD=0.26P
+ PS=1.21U PD=2.52U
* device instance $2676 r0 *1 30.85,55.135 sky130_fd_pr__pfet_01v8
M$2676 167 985 974 974 sky130_fd_pr__pfet_01v8 L=0.15U W=4U AS=0.685P AD=0.54P
+ PS=6.37U PD=5.08U
* device instance $2680 r0 *1 32.53,55.135 sky130_fd_pr__pfet_01v8
M$2680 975 109 974 974 sky130_fd_pr__pfet_01v8 L=0.15U W=4U AS=0.54P AD=0.665P
+ PS=5.08U PD=6.33U
* device instance $2683 r0 *1 33.79,55.135 sky130_fd_pr__pfet_01v8
M$2683 997 995 975 975 sky130_fd_pr__pfet_01v8 L=0.15U W=4U AS=0.54P AD=0.54P
+ PS=5.08U PD=5.08U
* device instance $2688 r0 *1 42.815,55.135 sky130_fd_pr__pfet_01v8
M$2688 167 844 976 976 sky130_fd_pr__pfet_01v8 L=0.15U W=3U AS=0.545P AD=0.545P
+ PS=5.09U PD=5.09U
* device instance $2691 r0 *1 44.635,55.135 sky130_fd_pr__pfet_01v8
M$2691 977 310 167 167 sky130_fd_pr__pfet_01v8 L=0.15U W=4U AS=0.685P AD=0.56P
+ PS=6.37U PD=5.12U
* device instance $2695 r0 *1 46.355,55.135 sky130_fd_pr__pfet_01v8
M$2695 844 977 167 167 sky130_fd_pr__pfet_01v8 L=0.15U W=16U AS=2.2375P
+ AD=2.3625P PS=20.475U PD=21.725U
* device instance $2711 r0 *1 59.405,54.955 sky130_fd_pr__pfet_01v8
M$2711 994 805 167 167 sky130_fd_pr__pfet_01v8 L=0.15U W=0.64U AS=0.1696P
+ AD=0.0768P PS=1.81U PD=0.88U
* device instance $2712 r0 *1 59.795,54.955 sky130_fd_pr__pfet_01v8
M$2712 978 948 994 994 sky130_fd_pr__pfet_01v8 L=0.15U W=0.64U AS=0.0768P
+ AD=0.0896P PS=0.88U PD=0.92U
* device instance $2713 r0 *1 60.225,54.955 sky130_fd_pr__pfet_01v8
M$2713 167 979 978 978 sky130_fd_pr__pfet_01v8 L=0.15U W=0.64U AS=0.0896P
+ AD=0.1824P PS=0.92U PD=1.85U
* device instance $2714 r0 *1 62.115,55.135 sky130_fd_pr__pfet_01v8
M$2714 980 939 167 167 sky130_fd_pr__pfet_01v8 L=0.15U W=1U AS=0.265P AD=0.14P
+ PS=2.53U PD=1.28U
* device instance $2715 r0 *1 62.545,55.135 sky130_fd_pr__pfet_01v8
M$2715 167 978 980 980 sky130_fd_pr__pfet_01v8 L=0.15U W=1U AS=0.14P AD=0.1775P
+ PS=1.28U PD=1.355U
* device instance $2716 r0 *1 63.05,55.135 sky130_fd_pr__pfet_01v8
M$2716 981 980 167 167 sky130_fd_pr__pfet_01v8 L=0.15U W=4U AS=0.5975P
+ AD=0.705P PS=5.195U PD=6.41U
* device instance $2720 r0 *1 65.33,55.055 sky130_fd_pr__pfet_01v8
M$2720 979 982 167 167 sky130_fd_pr__pfet_01v8 L=0.15U W=1.68U AS=0.3318P
+ AD=0.3486P PS=3.31U PD=3.35U
* device instance $2722 r0 *1 66.71,55.425 sky130_fd_pr__pfet_01v8
M$2722 986 919 167 167 sky130_fd_pr__pfet_01v8 L=0.15U W=0.42U AS=0.14575P
+ AD=0.1092P PS=1.335U PD=1.36U
* device instance $2723 r0 *1 67.195,55.135 sky130_fd_pr__pfet_01v8
M$2723 1020 949 167 167 sky130_fd_pr__pfet_01v8 L=0.15U W=1U AS=0.14575P
+ AD=0.135P PS=1.335U PD=1.27U
* device instance $2724 r0 *1 67.615,55.135 sky130_fd_pr__pfet_01v8
M$2724 167 986 1020 1020 sky130_fd_pr__pfet_01v8 L=0.15U W=1U AS=0.135P
+ AD=0.265P PS=1.27U PD=2.53U
* device instance $2725 r0 *1 69.05,55.135 sky130_fd_pr__pfet_01v8
M$2725 983 949 167 167 sky130_fd_pr__pfet_01v8 L=0.15U W=1U AS=0.3P AD=0.135P
+ PS=2.6U PD=1.27U
* device instance $2726 r0 *1 69.47,55.135 sky130_fd_pr__pfet_01v8
M$2726 167 919 983 983 sky130_fd_pr__pfet_01v8 L=0.15U W=1U AS=0.135P AD=0.365P
+ PS=1.27U PD=1.73U
* device instance $2727 r0 *1 70.35,55.135 sky130_fd_pr__pfet_01v8
M$2727 988 919 167 167 sky130_fd_pr__pfet_01v8 L=0.15U W=1U AS=0.365P AD=0.105P
+ PS=1.73U PD=1.21U
* device instance $2728 r0 *1 70.71,55.135 sky130_fd_pr__pfet_01v8
M$2728 982 949 988 988 sky130_fd_pr__pfet_01v8 L=0.15U W=1U AS=0.105P AD=0.165P
+ PS=1.21U PD=1.33U
* device instance $2729 r0 *1 71.19,55.135 sky130_fd_pr__pfet_01v8
M$2729 167 983 982 982 sky130_fd_pr__pfet_01v8 L=0.15U W=1U AS=0.165P AD=0.36P
+ PS=1.33U PD=2.72U
* device instance $2730 r0 *1 9.21,54.985 sky130_fd_pr__pfet_01v8
M$2730 167 937 966 966 sky130_fd_pr__pfet_01v8 L=0.15U W=0.64U AS=0.1664P
+ AD=0.0864P PS=1.8U PD=0.91U
* device instance $2731 r0 *1 9.63,54.985 sky130_fd_pr__pfet_01v8
M$2731 967 966 167 167 sky130_fd_pr__pfet_01v8 L=0.15U W=0.64U AS=0.0864P
+ AD=0.1664P PS=0.91U PD=1.8U
* device instance $2732 r0 *1 11.03,60.285 sky130_fd_pr__pfet_01v8
M$2732 1042 1080 167 167 sky130_fd_pr__pfet_01v8 L=0.15U W=0.42U AS=0.1092P
+ AD=0.0672P PS=1.36U PD=0.74U
* device instance $2733 r0 *1 11.5,60.285 sky130_fd_pr__pfet_01v8
M$2733 1043 1041 1042 1042 sky130_fd_pr__pfet_01v8 L=0.15U W=0.42U AS=0.0672P
+ AD=0.06615P PS=0.74U PD=0.735U
* device instance $2734 r0 *1 11.965,60.285 sky130_fd_pr__pfet_01v8
M$2734 1071 1040 1043 1043 sky130_fd_pr__pfet_01v8 L=0.15U W=0.42U AS=0.06615P
+ AD=0.0693P PS=0.735U PD=0.75U
* device instance $2735 r0 *1 12.445,60.285 sky130_fd_pr__pfet_01v8
M$2735 167 1044 1071 1071 sky130_fd_pr__pfet_01v8 L=0.15U W=0.42U AS=0.0693P
+ AD=0.178875P PS=0.75U PD=1.26U
* device instance $2736 r0 *1 13.58,60.285 sky130_fd_pr__pfet_01v8
M$2736 1061 1040 1044 1044 sky130_fd_pr__pfet_01v8 L=0.15U W=0.42U AS=0.1095P
+ AD=0.0567P PS=1.075U PD=0.69U
* device instance $2737 r0 *1 14,60.285 sky130_fd_pr__pfet_01v8
M$2737 1073 1041 1061 1061 sky130_fd_pr__pfet_01v8 L=0.15U W=0.42U AS=0.0567P
+ AD=0.09135P PS=0.69U PD=0.855U
* device instance $2738 r0 *1 14.585,60.285 sky130_fd_pr__pfet_01v8
M$2738 167 1045 1073 1073 sky130_fd_pr__pfet_01v8 L=0.15U W=0.42U AS=0.09135P
+ AD=0.1218P PS=0.855U PD=1.42U
* device instance $2739 r0 *1 13.105,60.45 sky130_fd_pr__pfet_01v8
M$2739 1044 1043 167 167 sky130_fd_pr__pfet_01v8 L=0.15U W=0.75U AS=0.178875P
+ AD=0.1095P PS=1.26U PD=1.075U
* device instance $2740 r0 *1 15.665,60.575 sky130_fd_pr__pfet_01v8
M$2740 167 1061 1045 1045 sky130_fd_pr__pfet_01v8 L=0.15U W=1U AS=0.28P
+ AD=0.1625P PS=2.56U PD=1.325U
* device instance $2741 r0 *1 16.14,60.575 sky130_fd_pr__pfet_01v8
M$2741 71 1045 167 167 sky130_fd_pr__pfet_01v8 L=0.15U W=4U AS=0.575P
+ AD=0.6925P PS=5.15U PD=6.385U
* device instance $2745 r0 *1 20.73,60.575 sky130_fd_pr__pfet_01v8
M$2745 167 1100 1046 1046 sky130_fd_pr__pfet_01v8 L=0.15U W=4U AS=0.685P
+ AD=0.54P PS=6.37U PD=5.08U
* device instance $2749 r0 *1 22.41,60.575 sky130_fd_pr__pfet_01v8
M$2749 1062 1008 1046 1046 sky130_fd_pr__pfet_01v8 L=0.15U W=4U AS=0.54P
+ AD=0.675P PS=5.08U PD=6.35U
* device instance $2753 r0 *1 24.84,60.575 sky130_fd_pr__pfet_01v8
M$2753 90 1047 167 167 sky130_fd_pr__pfet_01v8 L=0.15U W=8U AS=1.205P AD=1.08P
+ PS=11.41U PD=10.16U
* device instance $2761 r0 *1 28.2,60.575 sky130_fd_pr__pfet_01v8
M$2761 1047 1062 167 167 sky130_fd_pr__pfet_01v8 L=0.15U W=3U AS=0.405P
+ AD=0.53P PS=3.81U PD=5.06U
* device instance $2764 r0 *1 24.87,59.105 sky130_fd_pr__pfet_01v8
M$2764 167 71 1030 1030 sky130_fd_pr__pfet_01v8 L=0.15U W=2U AS=0.415P AD=0.27P
+ PS=3.83U PD=2.54U
* device instance $2766 r0 *1 25.71,59.105 sky130_fd_pr__pfet_01v8
M$2766 1031 995 1030 1030 sky130_fd_pr__pfet_01v8 L=0.15U W=2U AS=0.27P
+ AD=0.415P PS=2.54U PD=3.83U
* device instance $2768 r0 *1 27.09,59.105 sky130_fd_pr__pfet_01v8
M$2768 1008 1024 1031 1031 sky130_fd_pr__pfet_01v8 L=0.15U W=2U AS=0.395P
+ AD=0.395P PS=3.79U PD=3.79U
* device instance $2770 r0 *1 28.65,59.105 sky130_fd_pr__pfet_01v8
M$2770 167 109 1009 1009 sky130_fd_pr__pfet_01v8 L=0.15U W=1U AS=0.38P
+ AD=0.135P PS=2.76U PD=1.27U
* device instance $2771 r0 *1 29.07,59.105 sky130_fd_pr__pfet_01v8
M$2771 91 1010 167 167 sky130_fd_pr__pfet_01v8 L=0.15U W=4U AS=0.54P AD=0.54P
+ PS=5.08U PD=5.08U
* device instance $2775 r0 *1 30.75,59.105 sky130_fd_pr__pfet_01v8
M$2775 1010 1009 167 167 sky130_fd_pr__pfet_01v8 L=0.15U W=2U AS=0.27P
+ AD=0.395P PS=2.54U PD=3.79U
* device instance $2777 r0 *1 32.11,59.105 sky130_fd_pr__pfet_01v8
M$2777 1010 1024 1032 1032 sky130_fd_pr__pfet_01v8 L=0.15U W=2U AS=0.395P
+ AD=0.27P PS=3.79U PD=2.54U
* device instance $2779 r0 *1 32.95,59.105 sky130_fd_pr__pfet_01v8
M$2779 167 995 1032 1032 sky130_fd_pr__pfet_01v8 L=0.15U W=2U AS=0.27P
+ AD=0.415P PS=2.54U PD=3.83U
* device instance $2781 r0 *1 32.21,60.575 sky130_fd_pr__pfet_01v8
M$2781 1076 995 1048 1048 sky130_fd_pr__pfet_01v8 L=0.15U W=1U AS=0.26P
+ AD=0.105P PS=2.52U PD=1.21U
* device instance $2782 r0 *1 32.57,60.575 sky130_fd_pr__pfet_01v8
M$2782 167 1063 1076 1076 sky130_fd_pr__pfet_01v8 L=0.15U W=1U AS=0.105P
+ AD=0.26P PS=1.21U PD=2.52U
* device instance $2783 r0 *1 33.83,60.865 sky130_fd_pr__pfet_01v8
M$2783 1064 996 167 167 sky130_fd_pr__pfet_01v8 L=0.15U W=0.42U AS=0.1573P
+ AD=0.1092P PS=1.39U PD=1.36U
* device instance $2784 r0 *1 34.37,60.575 sky130_fd_pr__pfet_01v8
M$2784 1078 875 167 167 sky130_fd_pr__pfet_01v8 L=0.15U W=1U AS=0.1573P
+ AD=0.105P PS=1.39U PD=1.21U
* device instance $2785 r0 *1 34.73,60.575 sky130_fd_pr__pfet_01v8
M$2785 1063 1064 1078 1078 sky130_fd_pr__pfet_01v8 L=0.15U W=1U AS=0.105P
+ AD=0.26P PS=1.21U PD=2.52U
* device instance $2786 r0 *1 34.97,59.105 sky130_fd_pr__pfet_01v8
M$2786 167 985 1012 1012 sky130_fd_pr__pfet_01v8 L=0.15U W=1U AS=0.26P
+ AD=0.135P PS=2.52U PD=1.27U
* device instance $2787 r0 *1 35.39,59.105 sky130_fd_pr__pfet_01v8
M$2787 1024 1012 167 167 sky130_fd_pr__pfet_01v8 L=0.15U W=4U AS=0.54P AD=0.71P
+ PS=5.08U PD=5.42U
* device instance $2791 r0 *1 37.41,59.105 sky130_fd_pr__pfet_01v8
M$2791 1013 997 167 167 sky130_fd_pr__pfet_01v8 L=0.15U W=2U AS=0.44P AD=0.27P
+ PS=2.88U PD=2.54U
* device instance $2793 r0 *1 38.25,59.105 sky130_fd_pr__pfet_01v8
M$2793 87 1013 167 167 sky130_fd_pr__pfet_01v8 L=0.15U W=6U AS=0.81P AD=0.935P
+ PS=7.62U PD=8.87U
* device instance $2799 r0 *1 40.03,60.575 sky130_fd_pr__pfet_01v8
M$2799 1049 1068 167 167 sky130_fd_pr__pfet_01v8 L=0.15U W=2U AS=0.395P
+ AD=0.27P PS=3.79U PD=2.54U
* device instance $2801 r0 *1 40.87,60.575 sky130_fd_pr__pfet_01v8
M$2801 1049 1035 167 167 sky130_fd_pr__pfet_01v8 L=0.15U W=2U AS=0.275P
+ AD=0.285P PS=2.55U PD=2.57U
* device instance $2803 r0 *1 41.74,60.575 sky130_fd_pr__pfet_01v8
M$2803 1049 1081 167 167 sky130_fd_pr__pfet_01v8 L=0.15U W=2U AS=0.28P
+ AD=0.395P PS=2.56U PD=3.79U
* device instance $2805 r0 *1 42.33,59.105 sky130_fd_pr__pfet_01v8
M$2805 1039 1025 1014 1014 sky130_fd_pr__pfet_01v8 L=0.15U W=1U AS=0.26P
+ AD=0.105P PS=2.52U PD=1.21U
* device instance $2806 r0 *1 42.69,59.105 sky130_fd_pr__pfet_01v8
M$2806 167 1015 1039 1039 sky130_fd_pr__pfet_01v8 L=0.15U W=1U AS=0.105P
+ AD=0.26P PS=1.21U PD=2.52U
* device instance $2807 r0 *1 43.1,60.575 sky130_fd_pr__pfet_01v8
M$2807 1049 1063 1050 1050 sky130_fd_pr__pfet_01v8 L=0.15U W=2U AS=0.395P
+ AD=0.395P PS=3.79U PD=2.79U
* device instance $2809 r0 *1 44.19,60.575 sky130_fd_pr__pfet_01v8
M$2809 1065 1066 1050 1050 sky130_fd_pr__pfet_01v8 L=0.15U W=2U AS=0.395P
+ AD=0.395P PS=2.79U PD=3.79U
* device instance $2811 r0 *1 45.57,60.575 sky130_fd_pr__pfet_01v8
M$2811 1051 1081 1015 1015 sky130_fd_pr__pfet_01v8 L=0.15U W=1U AS=0.265P
+ AD=0.14P PS=2.53U PD=1.28U
* device instance $2812 r0 *1 46,60.575 sky130_fd_pr__pfet_01v8
M$2812 167 1068 1051 1051 sky130_fd_pr__pfet_01v8 L=0.15U W=1U AS=0.14P
+ AD=0.1475P PS=1.28U PD=1.295U
* device instance $2813 r0 *1 46.445,60.575 sky130_fd_pr__pfet_01v8
M$2813 1051 1069 167 167 sky130_fd_pr__pfet_01v8 L=0.15U W=1U AS=0.1475P
+ AD=0.265P PS=1.295U PD=2.53U
* device instance $2814 r0 *1 46.01,59.105 sky130_fd_pr__pfet_01v8
M$2814 167 997 1016 1016 sky130_fd_pr__pfet_01v8 L=0.15U W=1U AS=0.26P
+ AD=0.135P PS=2.52U PD=1.27U
* device instance $2815 r0 *1 46.43,59.105 sky130_fd_pr__pfet_01v8
M$2815 1017 1016 167 167 sky130_fd_pr__pfet_01v8 L=0.15U W=4U AS=0.54P
+ AD=0.665P PS=5.08U PD=6.33U
* device instance $2819 r0 *1 48.7,59.105 sky130_fd_pr__pfet_01v8
M$2819 167 870 1033 1033 sky130_fd_pr__pfet_01v8 L=0.15U W=4U AS=0.685P
+ AD=0.54P PS=6.37U PD=5.08U
* device instance $2823 r0 *1 50.38,59.105 sky130_fd_pr__pfet_01v8
M$2823 1034 805 1033 1033 sky130_fd_pr__pfet_01v8 L=0.15U W=4U AS=0.54P
+ AD=0.665P PS=5.08U PD=6.33U
* device instance $2827 r0 *1 49.69,60.575 sky130_fd_pr__pfet_01v8
M$2827 167 1068 1052 1052 sky130_fd_pr__pfet_01v8 L=0.15U W=2U AS=0.395P
+ AD=0.27P PS=3.79U PD=2.54U
* device instance $2829 r0 *1 50.53,60.575 sky130_fd_pr__pfet_01v8
M$2829 167 1069 1052 1052 sky130_fd_pr__pfet_01v8 L=0.15U W=2U AS=0.27P
+ AD=0.27P PS=2.54U PD=2.54U
* device instance $2831 r0 *1 51.37,60.575 sky130_fd_pr__pfet_01v8
M$2831 167 1081 1052 1052 sky130_fd_pr__pfet_01v8 L=0.15U W=2U AS=0.545P
+ AD=0.59P PS=3.09U PD=3.18U
* device instance $2833 r0 *1 52.85,60.575 sky130_fd_pr__pfet_01v8
M$2833 1070 1066 1052 1052 sky130_fd_pr__pfet_01v8 L=0.15U W=2U AS=0.355P
+ AD=0.435P PS=2.71U PD=3.87U
* device instance $2835 r0 *1 52.58,59.105 sky130_fd_pr__pfet_01v8
M$2835 1034 979 1035 1035 sky130_fd_pr__pfet_01v8 L=0.15U W=4U AS=0.665P
+ AD=0.55P PS=6.33U PD=5.1U
* device instance $2839 r0 *1 54.28,59.105 sky130_fd_pr__pfet_01v8
M$2839 167 1020 1035 1035 sky130_fd_pr__pfet_01v8 L=0.15U W=4U AS=0.55P
+ AD=0.54P PS=5.1U PD=5.08U
* device instance $2843 r0 *1 55.96,59.105 sky130_fd_pr__pfet_01v8
M$2843 167 1021 1035 1035 sky130_fd_pr__pfet_01v8 L=0.15U W=4U AS=0.54P
+ AD=0.665P PS=5.08U PD=6.33U
* device instance $2847 r0 *1 60.27,59.105 sky130_fd_pr__pfet_01v8
M$2847 1036 1026 1022 1022 sky130_fd_pr__pfet_01v8 L=0.15U W=1U AS=0.26P
+ AD=0.135P PS=2.52U PD=1.27U
* device instance $2848 r0 *1 60.69,59.105 sky130_fd_pr__pfet_01v8
M$2848 1037 919 1036 1036 sky130_fd_pr__pfet_01v8 L=0.15U W=1U AS=0.135P
+ AD=0.135P PS=1.27U PD=1.27U
* device instance $2849 r0 *1 61.11,59.105 sky130_fd_pr__pfet_01v8
M$2849 1036 91 1037 1037 sky130_fd_pr__pfet_01v8 L=0.15U W=1U AS=0.135P
+ AD=0.26P PS=1.27U PD=2.52U
* device instance $2850 r0 *1 62.05,59.105 sky130_fd_pr__pfet_01v8
M$2850 1037 1017 167 167 sky130_fd_pr__pfet_01v8 L=0.15U W=1U AS=0.26P
+ AD=0.165P PS=2.52U PD=1.33U
* device instance $2851 r0 *1 62.53,59.105 sky130_fd_pr__pfet_01v8
M$2851 167 981 1037 1037 sky130_fd_pr__pfet_01v8 L=0.15U W=1U AS=0.165P
+ AD=0.1575P PS=1.33U PD=1.315U
* device instance $2852 r0 *1 62.995,59.105 sky130_fd_pr__pfet_01v8
M$2852 1038 1022 167 167 sky130_fd_pr__pfet_01v8 L=0.15U W=1U AS=0.1575P
+ AD=0.26P PS=1.315U PD=2.52U
* device instance $2853 r0 *1 63.97,59.105 sky130_fd_pr__pfet_01v8
M$2853 1023 939 167 167 sky130_fd_pr__pfet_01v8 L=0.15U W=1U AS=0.26P AD=0.135P
+ PS=2.52U PD=1.27U
* device instance $2854 r0 *1 64.39,59.105 sky130_fd_pr__pfet_01v8
M$2854 167 1020 1023 1023 sky130_fd_pr__pfet_01v8 L=0.15U W=1U AS=0.135P
+ AD=0.26P PS=1.27U PD=2.52U
* device instance $2855 r0 *1 64.85,60.395 sky130_fd_pr__pfet_01v8
M$2855 1079 1038 1055 1055 sky130_fd_pr__pfet_01v8 L=0.15U W=0.64U AS=0.1664P
+ AD=0.0672P PS=1.8U PD=0.85U
* device instance $2856 r0 *1 65.21,60.395 sky130_fd_pr__pfet_01v8
M$2856 167 1056 1079 1079 sky130_fd_pr__pfet_01v8 L=0.15U W=0.64U AS=0.0672P
+ AD=0.1664P PS=0.85U PD=1.8U
* device instance $2857 r0 *1 67.875,60.285 sky130_fd_pr__pfet_01v8
M$2857 1057 1054 1055 1055 sky130_fd_pr__pfet_01v8 L=0.15U W=0.42U AS=0.15985P
+ AD=0.06405P PS=1.265U PD=0.725U
* device instance $2858 r0 *1 68.33,60.285 sky130_fd_pr__pfet_01v8
M$2858 1075 1053 1057 1057 sky130_fd_pr__pfet_01v8 L=0.15U W=0.42U AS=0.06405P
+ AD=0.07665P PS=0.725U PD=0.785U
* device instance $2859 r0 *1 68.845,60.285 sky130_fd_pr__pfet_01v8
M$2859 167 1058 1075 1075 sky130_fd_pr__pfet_01v8 L=0.15U W=0.42U AS=0.07665P
+ AD=0.178875P PS=0.785U PD=1.26U
* device instance $2860 r0 *1 66.15,60.395 sky130_fd_pr__pfet_01v8
M$2860 167 315 1056 1056 sky130_fd_pr__pfet_01v8 L=0.15U W=0.64U AS=0.1664P
+ AD=0.0928P PS=1.8U PD=0.93U
* device instance $2861 r0 *1 66.59,60.395 sky130_fd_pr__pfet_01v8
M$2861 1077 315 167 167 sky130_fd_pr__pfet_01v8 L=0.15U W=0.64U AS=0.0928P
+ AD=0.1152P PS=0.93U PD=1U
* device instance $2862 r0 *1 67.1,60.395 sky130_fd_pr__pfet_01v8
M$2862 1055 1060 1077 1077 sky130_fd_pr__pfet_01v8 L=0.15U W=0.64U AS=0.1152P
+ AD=0.15985P PS=1U PD=1.265U
* device instance $2863 r0 *1 69.505,60.45 sky130_fd_pr__pfet_01v8
M$2863 1058 1057 167 167 sky130_fd_pr__pfet_01v8 L=0.15U W=0.75U AS=0.178875P
+ AD=0.195P PS=1.26U PD=2.02U
* device instance $2864 r0 *1 70.445,60.285 sky130_fd_pr__pfet_01v8
M$2864 1074 1058 167 167 sky130_fd_pr__pfet_01v8 L=0.15U W=0.42U AS=0.1092P
+ AD=0.06405P PS=1.36U PD=0.725U
* device instance $2865 r0 *1 70.9,60.285 sky130_fd_pr__pfet_01v8
M$2865 1059 1053 1074 1074 sky130_fd_pr__pfet_01v8 L=0.15U W=0.42U AS=0.06405P
+ AD=0.0567P PS=0.725U PD=0.69U
* device instance $2866 r0 *1 71.32,60.285 sky130_fd_pr__pfet_01v8
M$2866 1072 1054 1059 1059 sky130_fd_pr__pfet_01v8 L=0.15U W=0.42U AS=0.0567P
+ AD=0.0882P PS=0.69U PD=0.84U
* device instance $2867 r0 *1 71.89,60.285 sky130_fd_pr__pfet_01v8
M$2867 167 1060 1072 1072 sky130_fd_pr__pfet_01v8 L=0.15U W=0.42U AS=0.0882P
+ AD=0.1113P PS=0.84U PD=1.37U
* device instance $2868 r0 *1 72.945,60.395 sky130_fd_pr__pfet_01v8
M$2868 167 1059 1060 1060 sky130_fd_pr__pfet_01v8 L=0.15U W=0.64U AS=0.1728P
+ AD=0.154P PS=1.82U PD=1.335U
* device instance $2869 r0 *1 73.43,60.575 sky130_fd_pr__pfet_01v8
M$2869 949 1059 167 167 sky130_fd_pr__pfet_01v8 L=0.15U W=1U AS=0.154P AD=0.28P
+ PS=1.335U PD=2.56U
* device instance $2870 r0 *1 7.83,64.625 sky130_fd_pr__pfet_01v8
M$2870 1199 1117 167 167 sky130_fd_pr__pfet_01v8 L=0.15U W=1.68U AS=0.3318P
+ AD=0.3486P PS=3.31U PD=3.35U
* device instance $2872 r0 *1 9.21,64.545 sky130_fd_pr__pfet_01v8
M$2872 1134 1118 167 167 sky130_fd_pr__pfet_01v8 L=0.15U W=1U AS=0.26P
+ AD=0.1125P PS=2.52U PD=1.225U
* device instance $2873 r0 *1 9.585,64.545 sky130_fd_pr__pfet_01v8
M$2873 1097 1117 1134 1134 sky130_fd_pr__pfet_01v8 L=0.15U W=1U AS=0.1125P
+ AD=0.2325P PS=1.225U PD=1.465U
* device instance $2874 r0 *1 10.2,64.545 sky130_fd_pr__pfet_01v8
M$2874 1135 1098 1097 1097 sky130_fd_pr__pfet_01v8 L=0.15U W=1U AS=0.2325P
+ AD=0.105P PS=1.465U PD=1.21U
* device instance $2875 r0 *1 10.56,64.545 sky130_fd_pr__pfet_01v8
M$2875 167 918 1135 1135 sky130_fd_pr__pfet_01v8 L=0.15U W=1U AS=0.105P
+ AD=0.27P PS=1.21U PD=2.54U
* device instance $2876 r0 *1 9.67,60.425 sky130_fd_pr__pfet_01v8
M$2876 167 937 1040 1040 sky130_fd_pr__pfet_01v8 L=0.15U W=0.64U AS=0.1664P
+ AD=0.0864P PS=1.8U PD=0.91U
* device instance $2877 r0 *1 10.09,60.425 sky130_fd_pr__pfet_01v8
M$2877 1041 1040 167 167 sky130_fd_pr__pfet_01v8 L=0.15U W=0.64U AS=0.0864P
+ AD=0.1664P PS=0.91U PD=1.8U
* device instance $2878 r0 *1 11.53,64.545 sky130_fd_pr__pfet_01v8
M$2878 109 1119 167 167 sky130_fd_pr__pfet_01v8 L=0.15U W=1U AS=0.26P AD=0.135P
+ PS=2.52U PD=1.27U
* device instance $2879 r0 *1 11.95,64.545 sky130_fd_pr__pfet_01v8
M$2879 167 1099 109 109 sky130_fd_pr__pfet_01v8 L=0.15U W=1U AS=0.135P AD=0.26P
+ PS=1.27U PD=2.52U
* device instance $2880 r0 *1 12.89,64.625 sky130_fd_pr__pfet_01v8
M$2880 1099 71 167 167 sky130_fd_pr__pfet_01v8 L=0.15U W=1.68U AS=0.3318P
+ AD=0.3486P PS=3.31U PD=3.35U
* device instance $2882 r0 *1 17.05,64.545 sky130_fd_pr__pfet_01v8
M$2882 167 1119 1132 1132 sky130_fd_pr__pfet_01v8 L=0.15U W=4U AS=0.685P
+ AD=0.54P PS=6.37U PD=5.08U
* device instance $2886 r0 *1 18.73,64.545 sky130_fd_pr__pfet_01v8
M$2886 1100 71 1132 1132 sky130_fd_pr__pfet_01v8 L=0.15U W=4U AS=0.54P
+ AD=0.675P PS=5.08U PD=6.35U
* device instance $2890 r0 *1 22.255,64.545 sky130_fd_pr__pfet_01v8
M$2890 315 1100 167 167 sky130_fd_pr__pfet_01v8 L=0.15U W=8U AS=1.205P AD=1.42P
+ PS=11.41U PD=10.84U
* device instance $2898 r0 *1 26.295,64.545 sky130_fd_pr__pfet_01v8
M$2898 1101 1062 167 167 sky130_fd_pr__pfet_01v8 L=0.15U W=2U AS=0.61P AD=0.27P
+ PS=3.22U PD=2.54U
* device instance $2900 r0 *1 27.135,64.545 sky130_fd_pr__pfet_01v8
M$2900 1102 1101 167 167 sky130_fd_pr__pfet_01v8 L=0.15U W=6U AS=0.81P
+ AD=0.935P PS=7.62U PD=8.87U
* device instance $2906 r0 *1 30.37,64.695 sky130_fd_pr__pfet_01v8
M$2906 167 937 1103 1103 sky130_fd_pr__pfet_01v8 L=0.15U W=0.64U AS=0.1664P
+ AD=0.0864P PS=1.8U PD=0.91U
* device instance $2907 r0 *1 30.79,64.695 sky130_fd_pr__pfet_01v8
M$2907 1104 1103 167 167 sky130_fd_pr__pfet_01v8 L=0.15U W=0.64U AS=0.0864P
+ AD=0.1664P PS=0.91U PD=1.8U
* device instance $2908 r0 *1 31.73,64.725 sky130_fd_pr__pfet_01v8
M$2908 1137 1133 1105 1105 sky130_fd_pr__pfet_01v8 L=0.15U W=0.64U AS=0.1664P
+ AD=0.0672P PS=1.8U PD=0.85U
* device instance $2909 r0 *1 32.09,64.725 sky130_fd_pr__pfet_01v8
M$2909 167 1106 1137 1137 sky130_fd_pr__pfet_01v8 L=0.15U W=0.64U AS=0.0672P
+ AD=0.1664P PS=0.85U PD=1.8U
* device instance $2910 r0 *1 33.03,64.725 sky130_fd_pr__pfet_01v8
M$2910 167 315 1106 1106 sky130_fd_pr__pfet_01v8 L=0.15U W=0.64U AS=0.1664P
+ AD=0.0928P PS=1.8U PD=0.93U
* device instance $2911 r0 *1 33.47,64.725 sky130_fd_pr__pfet_01v8
M$2911 1138 315 167 167 sky130_fd_pr__pfet_01v8 L=0.15U W=0.64U AS=0.0928P
+ AD=0.1152P PS=0.93U PD=1U
* device instance $2912 r0 *1 33.98,64.725 sky130_fd_pr__pfet_01v8
M$2912 1105 1120 1138 1138 sky130_fd_pr__pfet_01v8 L=0.15U W=0.64U AS=0.1152P
+ AD=0.15985P PS=1U PD=1.265U
* device instance $2913 r0 *1 34.755,64.835 sky130_fd_pr__pfet_01v8
M$2913 1107 1104 1105 1105 sky130_fd_pr__pfet_01v8 L=0.15U W=0.42U AS=0.15985P
+ AD=0.06405P PS=1.265U PD=0.725U
* device instance $2914 r0 *1 35.21,64.835 sky130_fd_pr__pfet_01v8
M$2914 1139 1103 1107 1107 sky130_fd_pr__pfet_01v8 L=0.15U W=0.42U AS=0.06405P
+ AD=0.07665P PS=0.725U PD=0.785U
* device instance $2915 r0 *1 35.725,64.835 sky130_fd_pr__pfet_01v8
M$2915 1139 1108 167 167 sky130_fd_pr__pfet_01v8 L=0.15U W=0.42U AS=0.178875P
+ AD=0.07665P PS=1.26U PD=0.785U
* device instance $2916 r0 *1 36.385,64.67 sky130_fd_pr__pfet_01v8
M$2916 1108 1107 167 167 sky130_fd_pr__pfet_01v8 L=0.15U W=0.75U AS=0.178875P
+ AD=0.195P PS=1.26U PD=2.02U
* device instance $2917 r0 *1 39.825,64.725 sky130_fd_pr__pfet_01v8
M$2917 1120 1109 167 167 sky130_fd_pr__pfet_01v8 L=0.15U W=0.64U AS=0.154P
+ AD=0.1728P PS=1.335U PD=1.82U
* device instance $2918 r0 *1 40.31,64.545 sky130_fd_pr__pfet_01v8
M$2918 996 1109 167 167 sky130_fd_pr__pfet_01v8 L=0.15U W=1U AS=0.154P AD=0.28P
+ PS=1.335U PD=2.56U
* device instance $2919 r0 *1 41.41,64.545 sky130_fd_pr__pfet_01v8
M$2919 167 1065 1110 1110 sky130_fd_pr__pfet_01v8 L=0.15U W=1U AS=0.26P
+ AD=0.135P PS=2.52U PD=1.27U
* device instance $2920 r0 *1 41.83,64.545 sky130_fd_pr__pfet_01v8
M$2920 985 1110 167 167 sky130_fd_pr__pfet_01v8 L=0.15U W=4U AS=0.54P AD=0.665P
+ PS=5.08U PD=6.33U
* device instance $2924 r0 *1 45.65,64.545 sky130_fd_pr__pfet_01v8
M$2924 1081 1111 167 167 sky130_fd_pr__pfet_01v8 L=0.15U W=1U AS=0.36P
+ AD=0.165P PS=2.72U PD=1.33U
* device instance $2925 r0 *1 46.13,64.545 sky130_fd_pr__pfet_01v8
M$2925 1142 694 1081 1081 sky130_fd_pr__pfet_01v8 L=0.15U W=1U AS=0.165P
+ AD=0.105P PS=1.33U PD=1.21U
* device instance $2926 r0 *1 46.49,64.545 sky130_fd_pr__pfet_01v8
M$2926 167 1121 1142 1142 sky130_fd_pr__pfet_01v8 L=0.15U W=1U AS=0.105P
+ AD=0.365P PS=1.21U PD=1.73U
* device instance $2927 r0 *1 47.37,64.545 sky130_fd_pr__pfet_01v8
M$2927 1111 1121 167 167 sky130_fd_pr__pfet_01v8 L=0.15U W=1U AS=0.365P
+ AD=0.135P PS=1.73U PD=1.27U
* device instance $2928 r0 *1 47.79,64.545 sky130_fd_pr__pfet_01v8
M$2928 167 694 1111 1111 sky130_fd_pr__pfet_01v8 L=0.15U W=1U AS=0.135P
+ AD=0.41P PS=1.27U PD=1.82U
* device instance $2929 r0 *1 48.76,64.545 sky130_fd_pr__pfet_01v8
M$2929 1069 1113 167 167 sky130_fd_pr__pfet_01v8 L=0.15U W=4U AS=0.815P
+ AD=0.54P PS=5.63U PD=5.08U
* device instance $2933 r0 *1 50.44,64.545 sky130_fd_pr__pfet_01v8
M$2933 1113 1035 167 167 sky130_fd_pr__pfet_01v8 L=0.15U W=1U AS=0.135P
+ AD=0.26P PS=1.27U PD=2.52U
* device instance $2934 r0 *1 47.39,60.85 sky130_fd_pr__pfet_01v8
M$2934 167 1081 1067 1067 sky130_fd_pr__pfet_01v8 L=0.15U W=0.42U AS=0.1092P
+ AD=0.0567P PS=1.36U PD=0.69U
* device instance $2935 r0 *1 47.81,60.85 sky130_fd_pr__pfet_01v8
M$2935 1067 1068 167 167 sky130_fd_pr__pfet_01v8 L=0.15U W=0.42U AS=0.0567P
+ AD=0.06615P PS=0.69U PD=0.735U
* device instance $2936 r0 *1 48.275,60.85 sky130_fd_pr__pfet_01v8
M$2936 1067 1069 167 167 sky130_fd_pr__pfet_01v8 L=0.15U W=0.42U AS=0.142225P
+ AD=0.06615P PS=1.335U PD=0.735U
* device instance $2937 r0 *1 48.75,60.575 sky130_fd_pr__pfet_01v8
M$2937 1025 1067 167 167 sky130_fd_pr__pfet_01v8 L=0.15U W=1U AS=0.142225P
+ AD=0.26P PS=1.335U PD=2.52U
* device instance $2938 r0 *1 51.77,64.255 sky130_fd_pr__pfet_01v8
M$2938 167 1121 1114 1114 sky130_fd_pr__pfet_01v8 L=0.15U W=0.42U AS=0.1092P
+ AD=0.1573P PS=1.36U PD=1.39U
* device instance $2939 r0 *1 52.31,64.545 sky130_fd_pr__pfet_01v8
M$2939 1136 694 167 167 sky130_fd_pr__pfet_01v8 L=0.15U W=1U AS=0.1573P
+ AD=0.105P PS=1.39U PD=1.21U
* device instance $2940 r0 *1 52.67,64.545 sky130_fd_pr__pfet_01v8
M$2940 1066 1114 1136 1136 sky130_fd_pr__pfet_01v8 L=0.15U W=1U AS=0.105P
+ AD=0.26P PS=1.21U PD=2.52U
* device instance $2941 r0 *1 63.49,60.425 sky130_fd_pr__pfet_01v8
M$2941 167 844 1053 1053 sky130_fd_pr__pfet_01v8 L=0.15U W=0.64U AS=0.1664P
+ AD=0.0864P PS=1.8U PD=0.91U
* device instance $2942 r0 *1 63.91,60.425 sky130_fd_pr__pfet_01v8
M$2942 1054 1053 167 167 sky130_fd_pr__pfet_01v8 L=0.15U W=0.64U AS=0.0864P
+ AD=0.1664P PS=0.91U PD=1.8U
* device instance $2943 r0 *1 64.41,64.255 sky130_fd_pr__pfet_01v8
M$2943 167 1122 1115 1115 sky130_fd_pr__pfet_01v8 L=0.15U W=0.42U AS=0.1092P
+ AD=0.14575P PS=1.36U PD=1.335U
* device instance $2944 r0 *1 64.895,64.545 sky130_fd_pr__pfet_01v8
M$2944 1068 1123 167 167 sky130_fd_pr__pfet_01v8 L=0.15U W=1U AS=0.14575P
+ AD=0.135P PS=1.335U PD=1.27U
* device instance $2945 r0 *1 65.315,64.545 sky130_fd_pr__pfet_01v8
M$2945 167 1115 1068 1068 sky130_fd_pr__pfet_01v8 L=0.15U W=1U AS=0.135P
+ AD=0.595P PS=1.27U PD=2.19U
* device instance $2946 r0 *1 66.655,64.545 sky130_fd_pr__pfet_01v8
M$2946 369 1116 167 167 sky130_fd_pr__pfet_01v8 L=0.15U W=4U AS=1P AD=0.54P
+ PS=6U PD=5.08U
* device instance $2950 r0 *1 68.335,64.545 sky130_fd_pr__pfet_01v8
M$2950 1116 1123 167 167 sky130_fd_pr__pfet_01v8 L=0.15U W=1U AS=0.135P
+ AD=0.26P PS=1.27U PD=2.52U
* device instance $2951 r0 *1 5.09,66.015 sky130_fd_pr__pfet_01v8
M$2951 1118 1143 167 167 sky130_fd_pr__pfet_01v8 L=0.15U W=1U AS=0.26P
+ AD=0.135P PS=2.52U PD=1.27U
* device instance $2952 r0 *1 5.51,66.015 sky130_fd_pr__pfet_01v8
M$2952 167 71 1118 1118 sky130_fd_pr__pfet_01v8 L=0.15U W=1U AS=0.135P AD=0.26P
+ PS=1.27U PD=2.52U
* device instance $2953 r0 *1 8.805,65.835 sky130_fd_pr__pfet_01v8
M$2953 1185 1099 167 167 sky130_fd_pr__pfet_01v8 L=0.15U W=0.64U AS=0.1696P
+ AD=0.0768P PS=1.81U PD=0.88U
* device instance $2954 r0 *1 9.195,65.835 sky130_fd_pr__pfet_01v8
M$2954 1080 1143 1185 1185 sky130_fd_pr__pfet_01v8 L=0.15U W=0.64U AS=0.0768P
+ AD=0.0896P PS=0.88U PD=0.92U
* device instance $2955 r0 *1 9.625,65.835 sky130_fd_pr__pfet_01v8
M$2955 167 1144 1080 1080 sky130_fd_pr__pfet_01v8 L=0.15U W=0.64U AS=0.0896P
+ AD=0.1824P PS=0.92U PD=1.85U
* device instance $2956 r0 *1 10.61,66.015 sky130_fd_pr__pfet_01v8
M$2956 1098 1199 167 167 sky130_fd_pr__pfet_01v8 L=0.15U W=1U AS=0.26P
+ AD=0.135P PS=2.52U PD=1.27U
* device instance $2957 r0 *1 11.03,66.015 sky130_fd_pr__pfet_01v8
M$2957 167 1119 1098 1098 sky130_fd_pr__pfet_01v8 L=0.15U W=1U AS=0.135P
+ AD=0.26P PS=1.27U PD=2.52U
* device instance $2958 r0 *1 12.04,66.015 sky130_fd_pr__pfet_01v8
M$2958 167 1177 1145 1145 sky130_fd_pr__pfet_01v8 L=0.15U W=1U AS=0.33P
+ AD=0.2425P PS=2.66U PD=1.485U
* device instance $2959 r0 *1 12.675,66.015 sky130_fd_pr__pfet_01v8
M$2959 1146 918 167 167 sky130_fd_pr__pfet_01v8 L=0.15U W=1U AS=0.2425P
+ AD=0.165P PS=1.485U PD=1.33U
* device instance $2960 r0 *1 13.155,66.015 sky130_fd_pr__pfet_01v8
M$2960 167 1199 1146 1146 sky130_fd_pr__pfet_01v8 L=0.15U W=1U AS=0.165P
+ AD=0.225P PS=1.33U PD=1.45U
* device instance $2961 r0 *1 13.755,66.015 sky130_fd_pr__pfet_01v8
M$2961 1146 1119 167 167 sky130_fd_pr__pfet_01v8 L=0.15U W=1U AS=0.225P
+ AD=0.185P PS=1.45U PD=1.37U
* device instance $2962 r0 *1 14.275,66.015 sky130_fd_pr__pfet_01v8
M$2962 1177 1144 1146 1146 sky130_fd_pr__pfet_01v8 L=0.15U W=1U AS=0.185P
+ AD=0.14P PS=1.37U PD=1.28U
* device instance $2963 r0 *1 14.705,66.015 sky130_fd_pr__pfet_01v8
M$2963 1146 1147 1177 1177 sky130_fd_pr__pfet_01v8 L=0.15U W=1U AS=0.14P
+ AD=0.265P PS=1.28U PD=2.53U
* device instance $2964 r0 *1 24.46,65.725 sky130_fd_pr__pfet_01v8
M$2964 1149 1179 167 167 sky130_fd_pr__pfet_01v8 L=0.15U W=0.42U AS=0.1113P
+ AD=0.0609P PS=1.37U PD=0.71U
* device instance $2965 r0 *1 24.9,65.725 sky130_fd_pr__pfet_01v8
M$2965 167 109 1149 1149 sky130_fd_pr__pfet_01v8 L=0.15U W=0.42U AS=0.0609P
+ AD=0.1841P PS=0.71U PD=1.26U
* device instance $2966 r0 *1 25.67,65.835 sky130_fd_pr__pfet_01v8
M$2966 1150 1149 167 167 sky130_fd_pr__pfet_01v8 L=0.15U W=0.64U AS=0.1841P
+ AD=0.1696P PS=1.26U PD=1.81U
* device instance $2967 r0 *1 26.69,66.015 sky130_fd_pr__pfet_01v8
M$2967 1152 1150 1151 1151 sky130_fd_pr__pfet_01v8 L=0.15U W=1U AS=0.26P
+ AD=0.135P PS=2.52U PD=1.27U
* device instance $2968 r0 *1 27.11,66.015 sky130_fd_pr__pfet_01v8
M$2968 1180 875 1152 1152 sky130_fd_pr__pfet_01v8 L=0.15U W=1U AS=0.135P
+ AD=0.135P PS=1.27U PD=1.27U
* device instance $2969 r0 *1 27.53,66.015 sky130_fd_pr__pfet_01v8
M$2969 1152 91 1180 1180 sky130_fd_pr__pfet_01v8 L=0.15U W=1U AS=0.135P
+ AD=0.26P PS=1.27U PD=2.52U
* device instance $2970 r0 *1 28.47,66.015 sky130_fd_pr__pfet_01v8
M$2970 1180 1181 167 167 sky130_fd_pr__pfet_01v8 L=0.15U W=1U AS=0.26P
+ AD=0.165P PS=2.52U PD=1.33U
* device instance $2971 r0 *1 28.95,66.015 sky130_fd_pr__pfet_01v8
M$2971 167 997 1180 1180 sky130_fd_pr__pfet_01v8 L=0.15U W=1U AS=0.165P
+ AD=0.1575P PS=1.33U PD=1.315U
* device instance $2972 r0 *1 29.415,66.015 sky130_fd_pr__pfet_01v8
M$2972 1133 1151 167 167 sky130_fd_pr__pfet_01v8 L=0.15U W=1U AS=0.1575P
+ AD=0.26P PS=1.315U PD=2.52U
* device instance $2973 r0 *1 32.25,66.015 sky130_fd_pr__pfet_01v8
M$2973 1153 1070 167 167 sky130_fd_pr__pfet_01v8 L=0.15U W=1U AS=0.3P AD=0.135P
+ PS=2.6U PD=1.27U
* device instance $2974 r0 *1 32.67,66.015 sky130_fd_pr__pfet_01v8
M$2974 167 1048 1153 1153 sky130_fd_pr__pfet_01v8 L=0.15U W=1U AS=0.135P
+ AD=0.365P PS=1.27U PD=1.73U
* device instance $2975 r0 *1 33.55,66.015 sky130_fd_pr__pfet_01v8
M$2975 1191 1048 167 167 sky130_fd_pr__pfet_01v8 L=0.15U W=1U AS=0.365P
+ AD=0.105P PS=1.73U PD=1.21U
* device instance $2976 r0 *1 33.91,66.015 sky130_fd_pr__pfet_01v8
M$2976 1181 1070 1191 1191 sky130_fd_pr__pfet_01v8 L=0.15U W=1U AS=0.105P
+ AD=0.165P PS=1.21U PD=1.33U
* device instance $2977 r0 *1 34.39,66.015 sky130_fd_pr__pfet_01v8
M$2977 167 1153 1181 1181 sky130_fd_pr__pfet_01v8 L=0.15U W=1U AS=0.165P
+ AD=0.36P PS=1.33U PD=2.72U
* device instance $2978 r0 *1 36.81,66.015 sky130_fd_pr__pfet_01v8
M$2978 1155 1200 1154 1154 sky130_fd_pr__pfet_01v8 L=0.15U W=1U AS=0.26P
+ AD=0.135P PS=2.52U PD=1.27U
* device instance $2979 r0 *1 37.23,66.015 sky130_fd_pr__pfet_01v8
M$2979 1182 694 1155 1155 sky130_fd_pr__pfet_01v8 L=0.15U W=1U AS=0.135P
+ AD=0.135P PS=1.27U PD=1.27U
* device instance $2980 r0 *1 37.65,66.015 sky130_fd_pr__pfet_01v8
M$2980 1155 91 1182 1182 sky130_fd_pr__pfet_01v8 L=0.15U W=1U AS=0.135P
+ AD=0.26P PS=1.27U PD=2.52U
* device instance $2981 r0 *1 37.325,64.835 sky130_fd_pr__pfet_01v8
M$2981 1140 1108 167 167 sky130_fd_pr__pfet_01v8 L=0.15U W=0.42U AS=0.1092P
+ AD=0.06405P PS=1.36U PD=0.725U
* device instance $2982 r0 *1 37.78,64.835 sky130_fd_pr__pfet_01v8
M$2982 1109 1103 1140 1140 sky130_fd_pr__pfet_01v8 L=0.15U W=0.42U AS=0.06405P
+ AD=0.0567P PS=0.725U PD=0.69U
* device instance $2983 r0 *1 38.2,64.835 sky130_fd_pr__pfet_01v8
M$2983 1141 1104 1109 1109 sky130_fd_pr__pfet_01v8 L=0.15U W=0.42U AS=0.0567P
+ AD=0.0882P PS=0.69U PD=0.84U
* device instance $2984 r0 *1 38.77,64.835 sky130_fd_pr__pfet_01v8
M$2984 167 1120 1141 1141 sky130_fd_pr__pfet_01v8 L=0.15U W=0.42U AS=0.0882P
+ AD=0.1113P PS=0.84U PD=1.37U
* device instance $2985 r0 *1 38.59,66.015 sky130_fd_pr__pfet_01v8
M$2985 1182 1286 167 167 sky130_fd_pr__pfet_01v8 L=0.15U W=1U AS=0.26P
+ AD=0.165P PS=2.52U PD=1.33U
* device instance $2986 r0 *1 39.07,66.015 sky130_fd_pr__pfet_01v8
M$2986 167 1014 1182 1182 sky130_fd_pr__pfet_01v8 L=0.15U W=1U AS=0.165P
+ AD=0.1575P PS=1.33U PD=1.315U
* device instance $2987 r0 *1 39.535,66.015 sky130_fd_pr__pfet_01v8
M$2987 1156 1154 167 167 sky130_fd_pr__pfet_01v8 L=0.15U W=1U AS=0.1575P
+ AD=0.26P PS=1.315U PD=2.52U
* device instance $2988 r0 *1 41.85,65.835 sky130_fd_pr__pfet_01v8
M$2988 1193 1183 1160 1160 sky130_fd_pr__pfet_01v8 L=0.15U W=0.64U AS=0.1664P
+ AD=0.0672P PS=1.8U PD=0.85U
* device instance $2989 r0 *1 42.21,65.835 sky130_fd_pr__pfet_01v8
M$2989 167 1159 1193 1193 sky130_fd_pr__pfet_01v8 L=0.15U W=0.64U AS=0.0672P
+ AD=0.1664P PS=0.85U PD=1.8U
* device instance $2990 r0 *1 44.875,65.725 sky130_fd_pr__pfet_01v8
M$2990 1161 1158 1160 1160 sky130_fd_pr__pfet_01v8 L=0.15U W=0.42U AS=0.15985P
+ AD=0.06405P PS=1.265U PD=0.725U
* device instance $2991 r0 *1 45.33,65.725 sky130_fd_pr__pfet_01v8
M$2991 1195 1157 1161 1161 sky130_fd_pr__pfet_01v8 L=0.15U W=0.42U AS=0.06405P
+ AD=0.07665P PS=0.725U PD=0.785U
* device instance $2992 r0 *1 45.845,65.725 sky130_fd_pr__pfet_01v8
M$2992 167 1162 1195 1195 sky130_fd_pr__pfet_01v8 L=0.15U W=0.42U AS=0.07665P
+ AD=0.178875P PS=0.785U PD=1.26U
* device instance $2993 r0 *1 43.15,65.835 sky130_fd_pr__pfet_01v8
M$2993 167 1102 1159 1159 sky130_fd_pr__pfet_01v8 L=0.15U W=0.64U AS=0.1664P
+ AD=0.0928P PS=1.8U PD=0.93U
* device instance $2994 r0 *1 43.59,65.835 sky130_fd_pr__pfet_01v8
M$2994 1194 1102 167 167 sky130_fd_pr__pfet_01v8 L=0.15U W=0.64U AS=0.0928P
+ AD=0.1152P PS=0.93U PD=1U
* device instance $2995 r0 *1 44.1,65.835 sky130_fd_pr__pfet_01v8
M$2995 1160 1164 1194 1194 sky130_fd_pr__pfet_01v8 L=0.15U W=0.64U AS=0.1152P
+ AD=0.15985P PS=1U PD=1.265U
* device instance $2996 r0 *1 46.505,65.89 sky130_fd_pr__pfet_01v8
M$2996 1162 1161 167 167 sky130_fd_pr__pfet_01v8 L=0.15U W=0.75U AS=0.178875P
+ AD=0.195P PS=1.26U PD=2.02U
* device instance $2997 r0 *1 47.445,65.725 sky130_fd_pr__pfet_01v8
M$2997 1196 1162 167 167 sky130_fd_pr__pfet_01v8 L=0.15U W=0.42U AS=0.1092P
+ AD=0.06405P PS=1.36U PD=0.725U
* device instance $2998 r0 *1 47.9,65.725 sky130_fd_pr__pfet_01v8
M$2998 1163 1157 1196 1196 sky130_fd_pr__pfet_01v8 L=0.15U W=0.42U AS=0.06405P
+ AD=0.0567P PS=0.725U PD=0.69U
* device instance $2999 r0 *1 48.32,65.725 sky130_fd_pr__pfet_01v8
M$2999 1197 1158 1163 1163 sky130_fd_pr__pfet_01v8 L=0.15U W=0.42U AS=0.0567P
+ AD=0.0882P PS=0.69U PD=0.84U
* device instance $3000 r0 *1 48.89,65.725 sky130_fd_pr__pfet_01v8
M$3000 167 1164 1197 1197 sky130_fd_pr__pfet_01v8 L=0.15U W=0.42U AS=0.0882P
+ AD=0.1113P PS=0.84U PD=1.37U
* device instance $3001 r0 *1 49.945,65.835 sky130_fd_pr__pfet_01v8
M$3001 167 1163 1164 1164 sky130_fd_pr__pfet_01v8 L=0.15U W=0.64U AS=0.1728P
+ AD=0.154P PS=1.82U PD=1.335U
* device instance $3002 r0 *1 50.43,66.015 sky130_fd_pr__pfet_01v8
M$3002 694 1163 167 167 sky130_fd_pr__pfet_01v8 L=0.15U W=1U AS=0.154P AD=0.28P
+ PS=1.335U PD=2.56U
* device instance $3003 r0 *1 60.34,65.725 sky130_fd_pr__pfet_01v8
M$3003 1165 1021 167 167 sky130_fd_pr__pfet_01v8 L=0.15U W=0.42U AS=0.1113P
+ AD=0.0609P PS=1.37U PD=0.71U
* device instance $3004 r0 *1 60.78,65.725 sky130_fd_pr__pfet_01v8
M$3004 167 1068 1165 1165 sky130_fd_pr__pfet_01v8 L=0.15U W=0.42U AS=0.0609P
+ AD=0.1841P PS=0.71U PD=1.26U
* device instance $3005 r0 *1 61.55,65.835 sky130_fd_pr__pfet_01v8
M$3005 1166 1165 167 167 sky130_fd_pr__pfet_01v8 L=0.15U W=0.64U AS=0.1841P
+ AD=0.1696P PS=1.26U PD=1.81U
* device instance $3006 r0 *1 62.61,66.015 sky130_fd_pr__pfet_01v8
M$3006 1192 1023 1167 1167 sky130_fd_pr__pfet_01v8 L=0.15U W=1U AS=0.26P
+ AD=0.135P PS=2.52U PD=1.27U
* device instance $3007 r0 *1 63.03,66.015 sky130_fd_pr__pfet_01v8
M$3007 167 1166 1192 1192 sky130_fd_pr__pfet_01v8 L=0.15U W=1U AS=0.135P
+ AD=0.135P PS=1.27U PD=1.27U
* device instance $3008 r0 *1 63.45,66.015 sky130_fd_pr__pfet_01v8
M$3008 1168 1166 167 167 sky130_fd_pr__pfet_01v8 L=0.15U W=1U AS=0.135P
+ AD=0.135P PS=1.27U PD=1.27U
* device instance $3009 r0 *1 63.87,66.015 sky130_fd_pr__pfet_01v8
M$3009 167 1023 1168 1168 sky130_fd_pr__pfet_01v8 L=0.15U W=1U AS=0.135P
+ AD=0.26P PS=1.27U PD=2.52U
* device instance $3010 r0 *1 64.81,66.015 sky130_fd_pr__pfet_01v8
M$3010 1184 1167 1168 1168 sky130_fd_pr__pfet_01v8 L=0.15U W=1U AS=0.26P
+ AD=0.3P PS=2.52U PD=2.6U
* device instance $3011 r0 *1 67.15,65.835 sky130_fd_pr__pfet_01v8
M$3011 1190 1201 1172 1172 sky130_fd_pr__pfet_01v8 L=0.15U W=0.64U AS=0.1664P
+ AD=0.0672P PS=1.8U PD=0.85U
* device instance $3012 r0 *1 67.51,65.835 sky130_fd_pr__pfet_01v8
M$3012 167 1171 1190 1190 sky130_fd_pr__pfet_01v8 L=0.15U W=0.64U AS=0.0672P
+ AD=0.1664P PS=0.85U PD=1.8U
* device instance $3013 r0 *1 70.175,65.725 sky130_fd_pr__pfet_01v8
M$3013 1173 1170 1172 1172 sky130_fd_pr__pfet_01v8 L=0.15U W=0.42U AS=0.15985P
+ AD=0.06405P PS=1.265U PD=0.725U
* device instance $3014 r0 *1 70.63,65.725 sky130_fd_pr__pfet_01v8
M$3014 1188 1169 1173 1173 sky130_fd_pr__pfet_01v8 L=0.15U W=0.42U AS=0.06405P
+ AD=0.07665P PS=0.725U PD=0.785U
* device instance $3015 r0 *1 71.145,65.725 sky130_fd_pr__pfet_01v8
M$3015 167 1174 1188 1188 sky130_fd_pr__pfet_01v8 L=0.15U W=0.42U AS=0.07665P
+ AD=0.178875P PS=0.785U PD=1.26U
* device instance $3016 r0 *1 68.45,65.835 sky130_fd_pr__pfet_01v8
M$3016 167 1102 1171 1171 sky130_fd_pr__pfet_01v8 L=0.15U W=0.64U AS=0.1664P
+ AD=0.0928P PS=1.8U PD=0.93U
* device instance $3017 r0 *1 68.89,65.835 sky130_fd_pr__pfet_01v8
M$3017 1189 1102 167 167 sky130_fd_pr__pfet_01v8 L=0.15U W=0.64U AS=0.0928P
+ AD=0.1152P PS=0.93U PD=1U
* device instance $3018 r0 *1 69.4,65.835 sky130_fd_pr__pfet_01v8
M$3018 1172 1176 1189 1189 sky130_fd_pr__pfet_01v8 L=0.15U W=0.64U AS=0.1152P
+ AD=0.15985P PS=1U PD=1.265U
* device instance $3019 r0 *1 71.805,65.89 sky130_fd_pr__pfet_01v8
M$3019 1174 1173 167 167 sky130_fd_pr__pfet_01v8 L=0.15U W=0.75U AS=0.178875P
+ AD=0.195P PS=1.26U PD=2.02U
* device instance $3020 r0 *1 72.745,65.725 sky130_fd_pr__pfet_01v8
M$3020 1187 1174 167 167 sky130_fd_pr__pfet_01v8 L=0.15U W=0.42U AS=0.1092P
+ AD=0.06405P PS=1.36U PD=0.725U
* device instance $3021 r0 *1 73.2,65.725 sky130_fd_pr__pfet_01v8
M$3021 1175 1169 1187 1187 sky130_fd_pr__pfet_01v8 L=0.15U W=0.42U AS=0.06405P
+ AD=0.0567P PS=0.725U PD=0.69U
* device instance $3022 r0 *1 73.62,65.725 sky130_fd_pr__pfet_01v8
M$3022 1186 1170 1175 1175 sky130_fd_pr__pfet_01v8 L=0.15U W=0.42U AS=0.0567P
+ AD=0.0882P PS=0.69U PD=0.84U
* device instance $3023 r0 *1 74.19,65.725 sky130_fd_pr__pfet_01v8
M$3023 167 1176 1186 1186 sky130_fd_pr__pfet_01v8 L=0.15U W=0.42U AS=0.0882P
+ AD=0.1113P PS=0.84U PD=1.37U
* device instance $3024 r0 *1 75.245,65.835 sky130_fd_pr__pfet_01v8
M$3024 167 1175 1176 1176 sky130_fd_pr__pfet_01v8 L=0.15U W=0.64U AS=0.1728P
+ AD=0.154P PS=1.82U PD=1.335U
* device instance $3025 r0 *1 75.73,66.015 sky130_fd_pr__pfet_01v8
M$3025 1123 1175 167 167 sky130_fd_pr__pfet_01v8 L=0.15U W=1U AS=0.154P
+ AD=0.28P PS=1.335U PD=2.56U
* device instance $3026 r0 *1 5.55,69.985 sky130_fd_pr__pfet_01v8
M$3026 167 1198 1285 1285 sky130_fd_pr__pfet_01v8 L=0.15U W=2U AS=0.415P
+ AD=0.275P PS=3.83U PD=2.55U
* device instance $3027 r0 *1 5.98,69.985 sky130_fd_pr__pfet_01v8
M$3027 1285 1148 167 167 sky130_fd_pr__pfet_01v8 L=0.15U W=2U AS=0.28P
+ AD=0.275P PS=2.56U PD=2.55U
* device instance $3030 r0 *1 7.25,69.985 sky130_fd_pr__pfet_01v8
M$3030 1144 1117 1285 1285 sky130_fd_pr__pfet_01v8 L=0.15U W=2U AS=0.27P
+ AD=0.495P PS=2.54U PD=3.99U
* device instance $3032 r0 *1 8.75,70.135 sky130_fd_pr__pfet_01v8
M$3032 167 937 1228 1228 sky130_fd_pr__pfet_01v8 L=0.15U W=0.64U AS=0.1664P
+ AD=0.0864P PS=1.8U PD=0.91U
* device instance $3033 r0 *1 9.17,70.135 sky130_fd_pr__pfet_01v8
M$3033 1229 1228 167 167 sky130_fd_pr__pfet_01v8 L=0.15U W=0.64U AS=0.0864P
+ AD=0.1664P PS=0.91U PD=1.8U
* device instance $3034 r0 *1 10.11,70.275 sky130_fd_pr__pfet_01v8
M$3034 1230 1145 167 167 sky130_fd_pr__pfet_01v8 L=0.15U W=0.42U AS=0.1092P
+ AD=0.05775P PS=1.36U PD=0.695U
* device instance $3035 r0 *1 10.535,70.275 sky130_fd_pr__pfet_01v8
M$3035 1231 1229 1230 1230 sky130_fd_pr__pfet_01v8 L=0.15U W=0.42U AS=0.05775P
+ AD=0.06825P PS=0.695U PD=0.745U
* device instance $3036 r0 *1 11.01,70.275 sky130_fd_pr__pfet_01v8
M$3036 1295 1228 1231 1231 sky130_fd_pr__pfet_01v8 L=0.15U W=0.42U AS=0.06825P
+ AD=0.07665P PS=0.745U PD=0.785U
* device instance $3037 r0 *1 11.525,70.275 sky130_fd_pr__pfet_01v8
M$3037 1295 1232 167 167 sky130_fd_pr__pfet_01v8 L=0.15U W=0.42U AS=0.178875P
+ AD=0.07665P PS=1.26U PD=0.785U
* device instance $3038 r0 *1 12.185,70.11 sky130_fd_pr__pfet_01v8
M$3038 1232 1231 167 167 sky130_fd_pr__pfet_01v8 L=0.15U W=0.75U AS=0.178875P
+ AD=0.1095P PS=1.26U PD=1.075U
* device instance $3039 r0 *1 12.66,70.275 sky130_fd_pr__pfet_01v8
M$3039 1233 1228 1232 1232 sky130_fd_pr__pfet_01v8 L=0.15U W=0.42U AS=0.1095P
+ AD=0.0567P PS=1.075U PD=0.69U
* device instance $3040 r0 *1 13.08,70.275 sky130_fd_pr__pfet_01v8
M$3040 1296 1229 1233 1233 sky130_fd_pr__pfet_01v8 L=0.15U W=0.42U AS=0.0567P
+ AD=0.0882P PS=0.69U PD=0.84U
* device instance $3041 r0 *1 13.65,70.275 sky130_fd_pr__pfet_01v8
M$3041 167 1234 1296 1296 sky130_fd_pr__pfet_01v8 L=0.15U W=0.42U AS=0.0882P
+ AD=0.1113P PS=0.84U PD=1.37U
* device instance $3042 r0 *1 14.7,69.985 sky130_fd_pr__pfet_01v8
M$3042 167 1233 1234 1234 sky130_fd_pr__pfet_01v8 L=0.15U W=1U AS=0.27P
+ AD=0.135P PS=2.54U PD=1.27U
* device instance $3043 r0 *1 15.12,69.985 sky130_fd_pr__pfet_01v8
M$3043 1147 1234 167 167 sky130_fd_pr__pfet_01v8 L=0.15U W=1U AS=0.135P
+ AD=0.26P PS=1.27U PD=2.52U
* device instance $3044 r0 *1 15.83,65.935 sky130_fd_pr__pfet_01v8
M$3044 1178 1147 167 167 sky130_fd_pr__pfet_01v8 L=0.15U W=0.42U AS=0.1176P
+ AD=0.0567P PS=1.4U PD=0.69U
* device instance $3045 r0 *1 16.25,65.935 sky130_fd_pr__pfet_01v8
M$3045 1178 1100 167 167 sky130_fd_pr__pfet_01v8 L=0.15U W=0.42U AS=0.16655P
+ AD=0.0567P PS=1.39U PD=0.69U
* device instance $3046 r0 *1 16.79,66.015 sky130_fd_pr__pfet_01v8
M$3046 1148 1178 167 167 sky130_fd_pr__pfet_01v8 L=0.15U W=1U AS=0.16655P
+ AD=0.475P PS=1.39U PD=2.95U
* device instance $3047 r0 *1 22.09,70.135 sky130_fd_pr__pfet_01v8
M$3047 167 937 1235 1235 sky130_fd_pr__pfet_01v8 L=0.15U W=0.64U AS=0.1664P
+ AD=0.0864P PS=1.8U PD=0.91U
* device instance $3048 r0 *1 22.51,70.135 sky130_fd_pr__pfet_01v8
M$3048 1236 1235 167 167 sky130_fd_pr__pfet_01v8 L=0.15U W=0.64U AS=0.0864P
+ AD=0.1664P PS=0.91U PD=1.8U
* device instance $3049 r0 *1 23.45,70.165 sky130_fd_pr__pfet_01v8
M$3049 1297 1255 1237 1237 sky130_fd_pr__pfet_01v8 L=0.15U W=0.64U AS=0.1664P
+ AD=0.0672P PS=1.8U PD=0.85U
* device instance $3050 r0 *1 23.81,70.165 sky130_fd_pr__pfet_01v8
M$3050 167 1238 1297 1297 sky130_fd_pr__pfet_01v8 L=0.15U W=0.64U AS=0.0672P
+ AD=0.1664P PS=0.85U PD=1.8U
* device instance $3051 r0 *1 24.75,70.165 sky130_fd_pr__pfet_01v8
M$3051 167 1102 1238 1238 sky130_fd_pr__pfet_01v8 L=0.15U W=0.64U AS=0.1664P
+ AD=0.0928P PS=1.8U PD=0.93U
* device instance $3052 r0 *1 25.19,70.165 sky130_fd_pr__pfet_01v8
M$3052 1298 1102 167 167 sky130_fd_pr__pfet_01v8 L=0.15U W=0.64U AS=0.0928P
+ AD=0.1152P PS=0.93U PD=1U
* device instance $3053 r0 *1 25.7,70.165 sky130_fd_pr__pfet_01v8
M$3053 1237 1256 1298 1298 sky130_fd_pr__pfet_01v8 L=0.15U W=0.64U AS=0.1152P
+ AD=0.15985P PS=1U PD=1.265U
* device instance $3054 r0 *1 26.475,70.275 sky130_fd_pr__pfet_01v8
M$3054 1239 1236 1237 1237 sky130_fd_pr__pfet_01v8 L=0.15U W=0.42U AS=0.15985P
+ AD=0.06405P PS=1.265U PD=0.725U
* device instance $3055 r0 *1 26.93,70.275 sky130_fd_pr__pfet_01v8
M$3055 1299 1235 1239 1239 sky130_fd_pr__pfet_01v8 L=0.15U W=0.42U AS=0.06405P
+ AD=0.07665P PS=0.725U PD=0.785U
* device instance $3056 r0 *1 27.445,70.275 sky130_fd_pr__pfet_01v8
M$3056 1299 1240 167 167 sky130_fd_pr__pfet_01v8 L=0.15U W=0.42U AS=0.178875P
+ AD=0.07665P PS=1.26U PD=0.785U
* device instance $3057 r0 *1 28.105,70.11 sky130_fd_pr__pfet_01v8
M$3057 1240 1239 167 167 sky130_fd_pr__pfet_01v8 L=0.15U W=0.75U AS=0.178875P
+ AD=0.195P PS=1.26U PD=2.02U
* device instance $3058 r0 *1 29.045,70.275 sky130_fd_pr__pfet_01v8
M$3058 1300 1240 167 167 sky130_fd_pr__pfet_01v8 L=0.15U W=0.42U AS=0.1092P
+ AD=0.06405P PS=1.36U PD=0.725U
* device instance $3059 r0 *1 29.5,70.275 sky130_fd_pr__pfet_01v8
M$3059 1241 1235 1300 1300 sky130_fd_pr__pfet_01v8 L=0.15U W=0.42U AS=0.06405P
+ AD=0.0567P PS=0.725U PD=0.69U
* device instance $3060 r0 *1 29.92,70.275 sky130_fd_pr__pfet_01v8
M$3060 1301 1236 1241 1241 sky130_fd_pr__pfet_01v8 L=0.15U W=0.42U AS=0.0567P
+ AD=0.0882P PS=0.69U PD=0.84U
* device instance $3061 r0 *1 30.49,70.275 sky130_fd_pr__pfet_01v8
M$3061 167 1256 1301 1301 sky130_fd_pr__pfet_01v8 L=0.15U W=0.42U AS=0.0882P
+ AD=0.1113P PS=0.84U PD=1.37U
* device instance $3062 r0 *1 31.545,70.165 sky130_fd_pr__pfet_01v8
M$3062 1256 1241 167 167 sky130_fd_pr__pfet_01v8 L=0.15U W=0.64U AS=0.154P
+ AD=0.1728P PS=1.335U PD=1.82U
* device instance $3063 r0 *1 32.03,69.985 sky130_fd_pr__pfet_01v8
M$3063 875 1241 167 167 sky130_fd_pr__pfet_01v8 L=0.15U W=1U AS=0.154P AD=0.28P
+ PS=1.335U PD=2.56U
* device instance $3064 r0 *1 33.13,69.985 sky130_fd_pr__pfet_01v8
M$3064 167 997 1257 1257 sky130_fd_pr__pfet_01v8 L=0.15U W=1U AS=0.26P
+ AD=0.135P PS=2.52U PD=1.27U
* device instance $3065 r0 *1 33.55,69.985 sky130_fd_pr__pfet_01v8
M$3065 1286 1257 167 167 sky130_fd_pr__pfet_01v8 L=0.15U W=4U AS=0.54P
+ AD=0.665P PS=5.08U PD=6.33U
* device instance $3069 r0 *1 35.91,69.985 sky130_fd_pr__pfet_01v8
M$3069 1242 1258 167 167 sky130_fd_pr__pfet_01v8 L=0.15U W=1U AS=0.26P
+ AD=0.135P PS=2.52U PD=1.27U
* device instance $3070 r0 *1 36.33,69.985 sky130_fd_pr__pfet_01v8
M$3070 167 71 1242 1242 sky130_fd_pr__pfet_01v8 L=0.15U W=1U AS=0.135P AD=0.26P
+ PS=1.27U PD=2.52U
* device instance $3071 r0 *1 40.49,65.865 sky130_fd_pr__pfet_01v8
M$3071 167 844 1157 1157 sky130_fd_pr__pfet_01v8 L=0.15U W=0.64U AS=0.1664P
+ AD=0.0864P PS=1.8U PD=0.91U
* device instance $3072 r0 *1 40.91,65.865 sky130_fd_pr__pfet_01v8
M$3072 1158 1157 167 167 sky130_fd_pr__pfet_01v8 L=0.15U W=0.64U AS=0.0864P
+ AD=0.1664P PS=0.91U PD=1.8U
* device instance $3073 r0 *1 41.94,70.275 sky130_fd_pr__pfet_01v8
M$3073 1243 1287 167 167 sky130_fd_pr__pfet_01v8 L=0.15U W=0.42U AS=0.1113P
+ AD=0.0609P PS=1.37U PD=0.71U
* device instance $3074 r0 *1 42.38,70.275 sky130_fd_pr__pfet_01v8
M$3074 1243 109 167 167 sky130_fd_pr__pfet_01v8 L=0.15U W=0.42U AS=0.1841P
+ AD=0.0609P PS=1.26U PD=0.71U
* device instance $3075 r0 *1 43.15,70.165 sky130_fd_pr__pfet_01v8
M$3075 1200 1243 167 167 sky130_fd_pr__pfet_01v8 L=0.15U W=0.64U AS=0.1841P
+ AD=0.1696P PS=1.26U PD=1.81U
* device instance $3076 r0 *1 44.63,70.135 sky130_fd_pr__pfet_01v8
M$3076 167 844 1244 1244 sky130_fd_pr__pfet_01v8 L=0.15U W=0.64U AS=0.1664P
+ AD=0.0864P PS=1.8U PD=0.91U
* device instance $3077 r0 *1 45.05,70.135 sky130_fd_pr__pfet_01v8
M$3077 1245 1244 167 167 sky130_fd_pr__pfet_01v8 L=0.15U W=0.64U AS=0.0864P
+ AD=0.1664P PS=0.91U PD=1.8U
* device instance $3078 r0 *1 45.99,70.165 sky130_fd_pr__pfet_01v8
M$3078 1304 1156 1246 1246 sky130_fd_pr__pfet_01v8 L=0.15U W=0.64U AS=0.1664P
+ AD=0.0672P PS=1.8U PD=0.85U
* device instance $3079 r0 *1 46.35,70.165 sky130_fd_pr__pfet_01v8
M$3079 167 1247 1304 1304 sky130_fd_pr__pfet_01v8 L=0.15U W=0.64U AS=0.0672P
+ AD=0.1664P PS=0.85U PD=1.8U
* device instance $3080 r0 *1 47.29,70.165 sky130_fd_pr__pfet_01v8
M$3080 167 315 1247 1247 sky130_fd_pr__pfet_01v8 L=0.15U W=0.64U AS=0.1664P
+ AD=0.0928P PS=1.8U PD=0.93U
* device instance $3081 r0 *1 47.73,70.165 sky130_fd_pr__pfet_01v8
M$3081 1306 315 167 167 sky130_fd_pr__pfet_01v8 L=0.15U W=0.64U AS=0.0928P
+ AD=0.1152P PS=0.93U PD=1U
* device instance $3082 r0 *1 48.24,70.165 sky130_fd_pr__pfet_01v8
M$3082 1246 1259 1306 1306 sky130_fd_pr__pfet_01v8 L=0.15U W=0.64U AS=0.1152P
+ AD=0.15985P PS=1U PD=1.265U
* device instance $3083 r0 *1 49.015,70.275 sky130_fd_pr__pfet_01v8
M$3083 1248 1245 1246 1246 sky130_fd_pr__pfet_01v8 L=0.15U W=0.42U AS=0.15985P
+ AD=0.06405P PS=1.265U PD=0.725U
* device instance $3084 r0 *1 49.47,70.275 sky130_fd_pr__pfet_01v8
M$3084 1305 1244 1248 1248 sky130_fd_pr__pfet_01v8 L=0.15U W=0.42U AS=0.06405P
+ AD=0.07665P PS=0.725U PD=0.785U
* device instance $3085 r0 *1 49.985,70.275 sky130_fd_pr__pfet_01v8
M$3085 1305 1249 167 167 sky130_fd_pr__pfet_01v8 L=0.15U W=0.42U AS=0.178875P
+ AD=0.07665P PS=1.26U PD=0.785U
* device instance $3086 r0 *1 50.645,70.11 sky130_fd_pr__pfet_01v8
M$3086 1249 1248 167 167 sky130_fd_pr__pfet_01v8 L=0.15U W=0.75U AS=0.178875P
+ AD=0.195P PS=1.26U PD=2.02U
* device instance $3087 r0 *1 51.585,70.275 sky130_fd_pr__pfet_01v8
M$3087 1303 1249 167 167 sky130_fd_pr__pfet_01v8 L=0.15U W=0.42U AS=0.1092P
+ AD=0.06405P PS=1.36U PD=0.725U
* device instance $3088 r0 *1 52.04,70.275 sky130_fd_pr__pfet_01v8
M$3088 1250 1244 1303 1303 sky130_fd_pr__pfet_01v8 L=0.15U W=0.42U AS=0.06405P
+ AD=0.0567P PS=0.725U PD=0.69U
* device instance $3089 r0 *1 52.46,70.275 sky130_fd_pr__pfet_01v8
M$3089 1302 1245 1250 1250 sky130_fd_pr__pfet_01v8 L=0.15U W=0.42U AS=0.0567P
+ AD=0.0882P PS=0.69U PD=0.84U
* device instance $3090 r0 *1 53.03,70.275 sky130_fd_pr__pfet_01v8
M$3090 167 1259 1302 1302 sky130_fd_pr__pfet_01v8 L=0.15U W=0.42U AS=0.0882P
+ AD=0.1113P PS=0.84U PD=1.37U
* device instance $3091 r0 *1 54.085,70.165 sky130_fd_pr__pfet_01v8
M$3091 1259 1250 167 167 sky130_fd_pr__pfet_01v8 L=0.15U W=0.64U AS=0.154P
+ AD=0.1728P PS=1.335U PD=1.82U
* device instance $3092 r0 *1 54.57,69.985 sky130_fd_pr__pfet_01v8
M$3092 1121 1250 167 167 sky130_fd_pr__pfet_01v8 L=0.15U W=1U AS=0.154P
+ AD=0.28P PS=1.335U PD=2.56U
* device instance $3093 r0 *1 57.12,70.275 sky130_fd_pr__pfet_01v8
M$3093 1251 1288 167 167 sky130_fd_pr__pfet_01v8 L=0.15U W=0.42U AS=0.1113P
+ AD=0.0609P PS=1.37U PD=0.71U
* device instance $3094 r0 *1 57.56,70.275 sky130_fd_pr__pfet_01v8
M$3094 1251 109 167 167 sky130_fd_pr__pfet_01v8 L=0.15U W=0.42U AS=0.1841P
+ AD=0.0609P PS=1.26U PD=0.71U
* device instance $3095 r0 *1 58.33,70.165 sky130_fd_pr__pfet_01v8
M$3095 1026 1251 167 167 sky130_fd_pr__pfet_01v8 L=0.15U W=0.64U AS=0.1841P
+ AD=0.1696P PS=1.26U PD=1.81U
* device instance $3096 r0 *1 60.27,69.985 sky130_fd_pr__pfet_01v8
M$3096 1292 1260 1252 1252 sky130_fd_pr__pfet_01v8 L=0.15U W=1U AS=0.26P
+ AD=0.135P PS=2.52U PD=1.27U
* device instance $3097 r0 *1 60.69,69.985 sky130_fd_pr__pfet_01v8
M$3097 1289 1261 1292 1292 sky130_fd_pr__pfet_01v8 L=0.15U W=1U AS=0.135P
+ AD=0.135P PS=1.27U PD=1.27U
* device instance $3098 r0 *1 61.11,69.985 sky130_fd_pr__pfet_01v8
M$3098 1292 91 1289 1289 sky130_fd_pr__pfet_01v8 L=0.15U W=1U AS=0.135P
+ AD=0.26P PS=1.27U PD=2.52U
* device instance $3099 r0 *1 62.05,69.985 sky130_fd_pr__pfet_01v8
M$3099 1289 1017 167 167 sky130_fd_pr__pfet_01v8 L=0.15U W=1U AS=0.26P
+ AD=0.165P PS=2.52U PD=1.33U
* device instance $3100 r0 *1 62.53,69.985 sky130_fd_pr__pfet_01v8
M$3100 167 1184 1289 1289 sky130_fd_pr__pfet_01v8 L=0.15U W=1U AS=0.165P
+ AD=0.1575P PS=1.33U PD=1.315U
* device instance $3101 r0 *1 62.995,69.985 sky130_fd_pr__pfet_01v8
M$3101 1290 1252 167 167 sky130_fd_pr__pfet_01v8 L=0.15U W=1U AS=0.1575P
+ AD=0.26P PS=1.315U PD=2.52U
* device instance $3102 r0 *1 63.95,69.695 sky130_fd_pr__pfet_01v8
M$3102 167 1123 1262 1262 sky130_fd_pr__pfet_01v8 L=0.15U W=0.42U AS=0.1092P
+ AD=0.14575P PS=1.36U PD=1.335U
* device instance $3103 r0 *1 64.435,69.985 sky130_fd_pr__pfet_01v8
M$3103 1021 1122 167 167 sky130_fd_pr__pfet_01v8 L=0.15U W=1U AS=0.14575P
+ AD=0.135P PS=1.335U PD=1.27U
* device instance $3104 r0 *1 64.855,69.985 sky130_fd_pr__pfet_01v8
M$3104 167 1262 1021 1021 sky130_fd_pr__pfet_01v8 L=0.15U W=1U AS=0.135P
+ AD=0.265P PS=1.27U PD=2.53U
* device instance $3105 r0 *1 65.79,65.865 sky130_fd_pr__pfet_01v8
M$3105 167 844 1169 1169 sky130_fd_pr__pfet_01v8 L=0.15U W=0.64U AS=0.1664P
+ AD=0.0864P PS=1.8U PD=0.91U
* device instance $3106 r0 *1 66.21,65.865 sky130_fd_pr__pfet_01v8
M$3106 1170 1169 167 167 sky130_fd_pr__pfet_01v8 L=0.15U W=0.64U AS=0.0864P
+ AD=0.1664P PS=0.91U PD=1.8U
* device instance $3107 r0 *1 68.175,70.08 sky130_fd_pr__pfet_01v8
M$3107 1294 71 167 167 sky130_fd_pr__pfet_01v8 L=0.15U W=0.42U AS=0.15835P
+ AD=0.07665P PS=1.395U PD=0.785U
* device instance $3108 r0 *1 68.69,70.08 sky130_fd_pr__pfet_01v8
M$3108 1253 1122 1294 1294 sky130_fd_pr__pfet_01v8 L=0.15U W=0.42U AS=0.07665P
+ AD=0.1932P PS=0.785U PD=1.34U
* device instance $3109 r0 *1 69.76,70.08 sky130_fd_pr__pfet_01v8
M$3109 1293 1291 1253 1253 sky130_fd_pr__pfet_01v8 L=0.15U W=0.42U AS=0.1932P
+ AD=0.0441P PS=1.34U PD=0.63U
* device instance $3110 r0 *1 70.12,70.08 sky130_fd_pr__pfet_01v8
M$3110 167 1254 1293 1293 sky130_fd_pr__pfet_01v8 L=0.15U W=0.42U AS=0.0441P
+ AD=0.0693P PS=0.63U PD=0.75U
* device instance $3111 r0 *1 70.6,70.08 sky130_fd_pr__pfet_01v8
M$3111 1254 71 167 167 sky130_fd_pr__pfet_01v8 L=0.15U W=0.42U AS=0.0693P
+ AD=0.1176P PS=0.75U PD=1.4U
* device instance $3112 r0 *1 67.63,69.985 sky130_fd_pr__pfet_01v8
M$3112 167 1253 1201 1201 sky130_fd_pr__pfet_01v8 L=0.15U W=1U AS=0.26P
+ AD=0.15835P PS=2.52U PD=1.395U
* device instance $3113 r0 *1 8.29,71.305 sky130_fd_pr__pfet_01v8
M$3113 167 937 1307 1307 sky130_fd_pr__pfet_01v8 L=0.15U W=0.64U AS=0.1664P
+ AD=0.0864P PS=1.8U PD=0.91U
* device instance $3114 r0 *1 8.71,71.305 sky130_fd_pr__pfet_01v8
M$3114 1308 1307 167 167 sky130_fd_pr__pfet_01v8 L=0.15U W=0.64U AS=0.0864P
+ AD=0.1664P PS=0.91U PD=1.8U
* device instance $3115 r0 *1 9.65,71.165 sky130_fd_pr__pfet_01v8
M$3115 1309 1097 167 167 sky130_fd_pr__pfet_01v8 L=0.15U W=0.42U AS=0.1092P
+ AD=0.05775P PS=1.36U PD=0.695U
* device instance $3116 r0 *1 10.075,71.165 sky130_fd_pr__pfet_01v8
M$3116 1310 1308 1309 1309 sky130_fd_pr__pfet_01v8 L=0.15U W=0.42U AS=0.05775P
+ AD=0.06825P PS=0.695U PD=0.745U
* device instance $3117 r0 *1 10.55,71.165 sky130_fd_pr__pfet_01v8
M$3117 1325 1307 1310 1310 sky130_fd_pr__pfet_01v8 L=0.15U W=0.42U AS=0.06825P
+ AD=0.07665P PS=0.745U PD=0.785U
* device instance $3118 r0 *1 11.065,71.165 sky130_fd_pr__pfet_01v8
M$3118 167 1311 1325 1325 sky130_fd_pr__pfet_01v8 L=0.15U W=0.42U AS=0.07665P
+ AD=0.178875P PS=0.785U PD=1.26U
* device instance $3119 r0 *1 12.2,71.165 sky130_fd_pr__pfet_01v8
M$3119 1312 1307 1311 1311 sky130_fd_pr__pfet_01v8 L=0.15U W=0.42U AS=0.1095P
+ AD=0.0567P PS=1.075U PD=0.69U
* device instance $3120 r0 *1 12.62,71.165 sky130_fd_pr__pfet_01v8
M$3120 1327 1308 1312 1312 sky130_fd_pr__pfet_01v8 L=0.15U W=0.42U AS=0.0567P
+ AD=0.0882P PS=0.69U PD=0.84U
* device instance $3121 r0 *1 13.19,71.165 sky130_fd_pr__pfet_01v8
M$3121 167 1313 1327 1327 sky130_fd_pr__pfet_01v8 L=0.15U W=0.42U AS=0.0882P
+ AD=0.1113P PS=0.84U PD=1.37U
* device instance $3122 r0 *1 11.725,71.33 sky130_fd_pr__pfet_01v8
M$3122 1311 1310 167 167 sky130_fd_pr__pfet_01v8 L=0.15U W=0.75U AS=0.178875P
+ AD=0.1095P PS=1.26U PD=1.075U
* device instance $3123 r0 *1 14.24,71.455 sky130_fd_pr__pfet_01v8
M$3123 167 1312 1313 1313 sky130_fd_pr__pfet_01v8 L=0.15U W=1U AS=0.27P
+ AD=0.135P PS=2.54U PD=1.27U
* device instance $3124 r0 *1 14.66,71.455 sky130_fd_pr__pfet_01v8
M$3124 1119 1313 167 167 sky130_fd_pr__pfet_01v8 L=0.15U W=1U AS=0.135P
+ AD=0.26P PS=1.27U PD=2.52U
* device instance $3125 r0 *1 26.775,71.36 sky130_fd_pr__pfet_01v8
M$3125 1335 71 167 167 sky130_fd_pr__pfet_01v8 L=0.15U W=0.42U AS=0.15835P
+ AD=0.07665P PS=1.395U PD=0.785U
* device instance $3126 r0 *1 27.29,71.36 sky130_fd_pr__pfet_01v8
M$3126 1314 996 1335 1335 sky130_fd_pr__pfet_01v8 L=0.15U W=0.42U AS=0.07665P
+ AD=0.1932P PS=0.785U PD=1.34U
* device instance $3127 r0 *1 28.36,71.36 sky130_fd_pr__pfet_01v8
M$3127 1336 1330 1314 1314 sky130_fd_pr__pfet_01v8 L=0.15U W=0.42U AS=0.1932P
+ AD=0.0441P PS=1.34U PD=0.63U
* device instance $3128 r0 *1 28.72,71.36 sky130_fd_pr__pfet_01v8
M$3128 167 1339 1336 1336 sky130_fd_pr__pfet_01v8 L=0.15U W=0.42U AS=0.0441P
+ AD=0.0693P PS=0.63U PD=0.75U
* device instance $3129 r0 *1 29.2,71.36 sky130_fd_pr__pfet_01v8
M$3129 1339 71 167 167 sky130_fd_pr__pfet_01v8 L=0.15U W=0.42U AS=0.0693P
+ AD=0.1176P PS=0.75U PD=1.4U
* device instance $3130 r0 *1 26.23,71.455 sky130_fd_pr__pfet_01v8
M$3130 167 1314 1255 1255 sky130_fd_pr__pfet_01v8 L=0.15U W=1U AS=0.26P
+ AD=0.15835P PS=2.52U PD=1.395U
* device instance $3131 r0 *1 45.175,71.36 sky130_fd_pr__pfet_01v8
M$3131 1337 71 167 167 sky130_fd_pr__pfet_01v8 L=0.15U W=0.42U AS=0.15835P
+ AD=0.07665P PS=1.395U PD=0.785U
* device instance $3132 r0 *1 45.69,71.36 sky130_fd_pr__pfet_01v8
M$3132 1315 1121 1337 1337 sky130_fd_pr__pfet_01v8 L=0.15U W=0.42U AS=0.07665P
+ AD=0.1932P PS=0.785U PD=1.34U
* device instance $3133 r0 *1 46.76,71.36 sky130_fd_pr__pfet_01v8
M$3133 1338 1331 1315 1315 sky130_fd_pr__pfet_01v8 L=0.15U W=0.42U AS=0.1932P
+ AD=0.0441P PS=1.34U PD=0.63U
* device instance $3134 r0 *1 47.12,71.36 sky130_fd_pr__pfet_01v8
M$3134 167 1340 1338 1338 sky130_fd_pr__pfet_01v8 L=0.15U W=0.42U AS=0.0441P
+ AD=0.0693P PS=0.63U PD=0.75U
* device instance $3135 r0 *1 47.6,71.36 sky130_fd_pr__pfet_01v8
M$3135 1340 71 167 167 sky130_fd_pr__pfet_01v8 L=0.15U W=0.42U AS=0.0693P
+ AD=0.1176P PS=0.75U PD=1.4U
* device instance $3136 r0 *1 44.63,71.455 sky130_fd_pr__pfet_01v8
M$3136 167 1315 1183 1183 sky130_fd_pr__pfet_01v8 L=0.15U W=1U AS=0.26P
+ AD=0.15835P PS=2.52U PD=1.395U
* device instance $3137 r0 *1 58.5,71.165 sky130_fd_pr__pfet_01v8
M$3137 1316 1332 167 167 sky130_fd_pr__pfet_01v8 L=0.15U W=0.42U AS=0.1113P
+ AD=0.0609P PS=1.37U PD=0.71U
* device instance $3138 r0 *1 58.94,71.165 sky130_fd_pr__pfet_01v8
M$3138 167 109 1316 1316 sky130_fd_pr__pfet_01v8 L=0.15U W=0.42U AS=0.0609P
+ AD=0.1841P PS=0.71U PD=1.26U
* device instance $3139 r0 *1 59.71,71.275 sky130_fd_pr__pfet_01v8
M$3139 1260 1316 167 167 sky130_fd_pr__pfet_01v8 L=0.15U W=0.64U AS=0.1841P
+ AD=0.1696P PS=1.26U PD=1.81U
* device instance $3140 r0 *1 60.73,71.305 sky130_fd_pr__pfet_01v8
M$3140 167 844 1317 1317 sky130_fd_pr__pfet_01v8 L=0.15U W=0.64U AS=0.1664P
+ AD=0.0864P PS=1.8U PD=0.91U
* device instance $3141 r0 *1 61.15,71.305 sky130_fd_pr__pfet_01v8
M$3141 1318 1317 167 167 sky130_fd_pr__pfet_01v8 L=0.15U W=0.64U AS=0.0864P
+ AD=0.1664P PS=0.91U PD=1.8U
* device instance $3142 r0 *1 62.09,71.275 sky130_fd_pr__pfet_01v8
M$3142 1334 1290 1319 1319 sky130_fd_pr__pfet_01v8 L=0.15U W=0.64U AS=0.1664P
+ AD=0.0672P PS=1.8U PD=0.85U
* device instance $3143 r0 *1 62.45,71.275 sky130_fd_pr__pfet_01v8
M$3143 167 1320 1334 1334 sky130_fd_pr__pfet_01v8 L=0.15U W=0.64U AS=0.0672P
+ AD=0.1664P PS=0.85U PD=1.8U
* device instance $3144 r0 *1 65.115,71.165 sky130_fd_pr__pfet_01v8
M$3144 1321 1318 1319 1319 sky130_fd_pr__pfet_01v8 L=0.15U W=0.42U AS=0.15985P
+ AD=0.06405P PS=1.265U PD=0.725U
* device instance $3145 r0 *1 65.57,71.165 sky130_fd_pr__pfet_01v8
M$3145 1329 1317 1321 1321 sky130_fd_pr__pfet_01v8 L=0.15U W=0.42U AS=0.06405P
+ AD=0.07665P PS=0.725U PD=0.785U
* device instance $3146 r0 *1 66.085,71.165 sky130_fd_pr__pfet_01v8
M$3146 167 1322 1329 1329 sky130_fd_pr__pfet_01v8 L=0.15U W=0.42U AS=0.07665P
+ AD=0.178875P PS=0.785U PD=1.26U
* device instance $3147 r0 *1 63.39,71.275 sky130_fd_pr__pfet_01v8
M$3147 167 315 1320 1320 sky130_fd_pr__pfet_01v8 L=0.15U W=0.64U AS=0.1664P
+ AD=0.0928P PS=1.8U PD=0.93U
* device instance $3148 r0 *1 63.83,71.275 sky130_fd_pr__pfet_01v8
M$3148 1333 315 167 167 sky130_fd_pr__pfet_01v8 L=0.15U W=0.64U AS=0.0928P
+ AD=0.1152P PS=0.93U PD=1U
* device instance $3149 r0 *1 64.34,71.275 sky130_fd_pr__pfet_01v8
M$3149 1319 1324 1333 1333 sky130_fd_pr__pfet_01v8 L=0.15U W=0.64U AS=0.1152P
+ AD=0.15985P PS=1U PD=1.265U
* device instance $3150 r0 *1 66.745,71.33 sky130_fd_pr__pfet_01v8
M$3150 1322 1321 167 167 sky130_fd_pr__pfet_01v8 L=0.15U W=0.75U AS=0.178875P
+ AD=0.195P PS=1.26U PD=2.02U
* device instance $3151 r0 *1 65.79,75.425 sky130_fd_pr__pfet_01v8
M$3151 167 1123 1353 1353 sky130_fd_pr__pfet_01v8 L=0.15U W=1U AS=0.26P
+ AD=0.135P PS=2.52U PD=1.27U
* device instance $3152 r0 *1 66.21,75.425 sky130_fd_pr__pfet_01v8
M$3152 1261 1353 167 167 sky130_fd_pr__pfet_01v8 L=0.15U W=4U AS=0.54P
+ AD=0.665P PS=5.08U PD=6.33U
* device instance $3156 r0 *1 67.685,71.165 sky130_fd_pr__pfet_01v8
M$3156 1328 1322 167 167 sky130_fd_pr__pfet_01v8 L=0.15U W=0.42U AS=0.1092P
+ AD=0.06405P PS=1.36U PD=0.725U
* device instance $3157 r0 *1 68.14,71.165 sky130_fd_pr__pfet_01v8
M$3157 1323 1317 1328 1328 sky130_fd_pr__pfet_01v8 L=0.15U W=0.42U AS=0.06405P
+ AD=0.0567P PS=0.725U PD=0.69U
* device instance $3158 r0 *1 68.56,71.165 sky130_fd_pr__pfet_01v8
M$3158 1326 1318 1323 1323 sky130_fd_pr__pfet_01v8 L=0.15U W=0.42U AS=0.0567P
+ AD=0.0882P PS=0.69U PD=0.84U
* device instance $3159 r0 *1 69.13,71.165 sky130_fd_pr__pfet_01v8
M$3159 167 1324 1326 1326 sky130_fd_pr__pfet_01v8 L=0.15U W=0.42U AS=0.0882P
+ AD=0.1113P PS=0.84U PD=1.37U
* device instance $3160 r0 *1 70.185,71.275 sky130_fd_pr__pfet_01v8
M$3160 167 1323 1324 1324 sky130_fd_pr__pfet_01v8 L=0.15U W=0.64U AS=0.1728P
+ AD=0.154P PS=1.82U PD=1.335U
* device instance $3161 r0 *1 70.67,71.455 sky130_fd_pr__pfet_01v8
M$3161 1122 1323 167 167 sky130_fd_pr__pfet_01v8 L=0.15U W=1U AS=0.154P
+ AD=0.28P PS=1.335U PD=2.56U
.ENDS gcd
