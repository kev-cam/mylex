* cell gcd
.SUBCKT gcd
* net 1 resp_msg[8]
* net 14 dpath.a_mux$out\[8\]
* net 16 ctrl$a_reg_en\[0\]
* net 20 dpath.a_lt_b$in0\[8\]
* net 31 clknet_2_0__leaf_clk
* net 32 dpath.b_mux$out\[2\]
* net 50 dpath.a_lt_b$in0\[2\]
* net 53 _075_
* net 55 _069_
* net 57 resp_msg[7]
* net 65 dpath.a_mux$out\[2\]
* net 67 dpath.a_mux$out\[6\]
* net 69 _004_
* net 70 dpath.b_mux$out\[6\]
* net 71 req_rdy
* net 72 _048_
* net 73 dpath.b_mux$out\[8\]
* net 87 net2
* net 88 _089_
* net 89 resp_msg[6]
* net 90 _080_
* net 92 req_msg[6]
* net 93 net1
* net 94 VSS
* net 109 _076_
* net 110 _093_
* net 119 _088_
* net 120 dpath.b_mux$out\[7\]
* net 124 _087_
* net 127 req_msg[8]
* net 129 dpath.a_lt_b$in1\[2\]
* net 130 resp_msg[2]
* net 135 dpath.a_lt_b$in0\[7\]
* net 136 req_msg[7]
* net 137 dpath.a_lt_b$in1\[8\]
* net 138 net6
* net 157 req_msg[18]
* net 158 req_msg[22]
* net 159 req_msg[21]
* net 160 req_msg[23]
* net 161 req_msg[24]
* net 164 dpath.a_lt_b$in1\[6\]
* net 165 _090_
* net 168 VDD
* net 190 dpath.a_lt_b$in0\[6\]
* net 192 _047_
* net 195 dpath.a_mux$out\[7\]
* net 208 _022_
* net 209 req_msg[2]
* net 210 _040_
* net 212 net32
* net 213 _023_
* net 231 net9
* net 232 dpath.a_lt_b$in1\[7\]
* net 257 _036_
* net 258 _041_
* net 263 _030_
* net 267 _049_
* net 268 _024_
* net 272 _050_
* net 273 _051_
* net 276 _070_
* net 277 _027_
* net 278 net11
* net 279 _046_
* net 280 _026_
* net 281 _025_
* net 293 _042_
* net 305 _052_
* net 311 clknet_0_clk
* net 312 _020_
* net 329 clknet_2_1__leaf_clk
* net 330 _068_
* net 333 _019_
* net 334 _039_
* net 336 _043_
* net 337 _034_
* net 338 _021_
* net 339 dpath.a_lt_b$in0\[9\]
* net 341 dpath.a_lt_b$in1\[9\]
* net 346 resp_msg[9]
* net 351 _092_
* net 354 dpath.a_lt_b$in1\[3\]
* net 366 dpath.a_lt_b$in1\[5\]
* net 380 req_msg[19]
* net 381 resp_msg[3]
* net 384 _073_
* net 386 dpath.b_mux$out\[5\]
* net 387 net52
* net 388 _086_
* net 390 dpath.b_mux$out\[9\]
* net 405 dpath.a_mux$out\[3\]
* net 406 _103_
* net 407 _100_
* net 408 dpath.a_mux$out\[9\]
* net 433 _035_
* net 436 _071_
* net 437 _045_
* net 439 resp_msg[5]
* net 445 req_msg[9]
* net 447 dpath.b_mux$out\[3\]
* net 449 dpath.a_lt_b$in0\[3\]
* net 461 req_msg[3]
* net 462 req_msg[25]
* net 484 _029_
* net 495 _033_
* net 496 _031_
* net 497 dpath.a_lt_b$in0\[5\]
* net 499 req_msg[5]
* net 536 _028_
* net 543 _072_
* net 544 _044_
* net 547 dpath.a_mux$out\[5\]
* net 552 dpath.a_lt_b$in1\[1\]
* net 553 _005_
* net 554 resp_msg[4]
* net 568 dpath.a_mux$out\[10\]
* net 572 _085_
* net 573 dpath.a_lt_b$in1\[10\]
* net 574 resp_msg[10]
* net 577 net8
* net 587 dpath.a_mux$out\[1\]
* net 589 _037_
* net 590 dpath.a_lt_b$in0\[1\]
* net 593 _053_
* net 597 _017_
* net 598 _094_
* net 599 net16
* net 600 resp_msg[1]
* net 601 _032_
* net 602 dpath.a_lt_b$in0\[4\]
* net 614 req_msg[26]
* net 620 req_msg[1]
* net 624 net12
* net 629 dpath.a_lt_b$in1\[4\]
* net 633 _054_
* net 635 dpath.b_mux$out\[10\]
* net 637 req_msg[17]
* net 638 _038_
* net 640 dpath.a_mux$out\[4\]
* net 641 _018_
* net 643 _055_
* net 644 dpath.a_lt_b$in0\[10\]
* net 645 req_msg[10]
* net 652 _091_
* net 654 clk
* net 655 _015_
* net 663 dpath.b_mux$out\[1\]
* net 694 dpath.a_lt_b$in1\[14\]
* net 695 _099_
* net 708 dpath.b_mux$out\[4\]
* net 710 dpath.a_lt_b$in1\[11\]
* net 711 _067_
* net 732 req_msg[20]
* net 733 _101_
* net 734 resp_msg[11]
* net 773 _003_
* net 782 req_msg[4]
* net 783 dpath.b_mux$out\[11\]
* net 784 _084_
* net 786 dpath.a_lt_b$in0\[11\]
* net 788 _016_
* net 811 dpath.a_mux$out\[11\]
* net 834 dpath.a_lt_b$in1\[0\]
* net 851 net3
* net 862 _095_
* net 863 net13
* net 864 resp_msg[0]
* net 865 dpath.a_lt_b$in0\[0\]
* net 872 dpath.a_mux$out\[0\]
* net 885 dpath.b_mux$out\[0\]
* net 890 dpath.a_lt_b$in1\[15\]
* net 893 _102_
* net 906 req_msg[16]
* net 907 req_msg[27]
* net 908 dpath.b_mux$out\[12\]
* net 914 req_msg[0]
* net 915 net7
* net 917 _104_
* net 918 dpath.a_lt_b$in1\[12\]
* net 936 clknet_2_2__leaf_clk
* net 938 _056_
* net 941 req_msg[12]
* net 947 net30
* net 948 dpath.a_lt_b$in0\[12\]
* net 977 _066_
* net 978 _014_
* net 980 resp_msg[12]
* net 981 _013_
* net 984 net4
* net 994 _062_
* net 995 dpath.a_lt_b$in0\[15\]
* net 996 clknet_2_3__leaf_clk
* net 997 _079_
* net 1008 _078_
* net 1014 resp_msg[14]
* net 1015 _064_
* net 1017 net15
* net 1020 _012_
* net 1021 _010_
* net 1023 _057_
* net 1024 net10
* net 1025 _059_
* net 1026 _083_
* net 1034 _058_
* net 1037 dpath.a_mux$out\[12\]
* net 1048 _063_
* net 1062 ctrl$b_reg_en\[0\]
* net 1063 _061_
* net 1065 _077_
* net 1066 _008_
* net 1068 _011_
* net 1069 net28
* net 1070 _060_
* net 1080 _000_
* net 1081 _009_
* net 1097 _002_
* net 1098 _105_
* net 1099 _006_
* net 1100 _096_
* net 1102 net5
* net 1117 reset
* net 1118 _106_
* net 1119 ctrl.state.out\[2\]
* net 1121 dpath.a_lt_b$in0\[14\]
* net 1122 dpath.a_lt_b$in0\[13\]
* net 1123 dpath.a_lt_b$in1\[13\]
* net 1133 dpath.a_mux$out\[15\]
* net 1143 req_val
* net 1144 _097_
* net 1145 _001_
* net 1147 ctrl.state.out\[1\]
* net 1148 resp_val
* net 1150 _098_
* net 1156 dpath.a_mux$out\[14\]
* net 1166 _065_
* net 1179 req_msg[31]
* net 1181 resp_msg[15]
* net 1183 dpath.b_mux$out\[14\]
* net 1184 resp_msg[13]
* net 1198 resp_rdy
* net 1199 _007_
* net 1200 _081_
* net 1201 dpath.b_mux$out\[13\]
* net 1242 _074_
* net 1255 dpath.b_mux$out\[15\]
* net 1258 req_msg[11]
* net 1260 _082_
* net 1261 net53
* net 1286 net14
* net 1287 req_msg[30]
* net 1288 req_msg[28]
* net 1290 dpath.a_mux$out\[13\]
* net 1291 req_msg[13]
* net 1330 req_msg[15]
* net 1331 req_msg[14]
* net 1332 req_msg[29]
* device instance $1 r0 *1 5.07,3.165 sky130_fd_pr__nfet_01v8
M$1 94 31 8 8 sky130_fd_pr__nfet_01v8 L=0.15U W=0.42U AS=0.1092P AD=0.0567P
+ PS=1.36U PD=0.69U
* device instance $2 r0 *1 5.49,3.165 sky130_fd_pr__nfet_01v8
M$2 9 8 94 94 sky130_fd_pr__nfet_01v8 L=0.15U W=0.42U AS=0.0567P AD=0.1092P
+ PS=0.69U PD=1.36U
* device instance $3 r0 *1 6.43,3.165 sky130_fd_pr__nfet_01v8
M$3 21 32 2 2 sky130_fd_pr__nfet_01v8 L=0.15U W=0.42U AS=0.1092P AD=0.0441P
+ PS=1.36U PD=0.63U
* device instance $4 r0 *1 6.79,3.165 sky130_fd_pr__nfet_01v8
M$4 94 93 21 21 sky130_fd_pr__nfet_01v8 L=0.15U W=0.42U AS=0.0441P AD=0.1092P
+ PS=0.63U PD=1.36U
* device instance $5 r0 *1 9.59,3.135 sky130_fd_pr__nfet_01v8
M$5 3 8 2 2 sky130_fd_pr__nfet_01v8 L=0.15U W=0.36U AS=0.1446P AD=0.0522P
+ PS=1.18U PD=0.65U
* device instance $6 r0 *1 10.03,3.135 sky130_fd_pr__nfet_01v8
M$6 26 9 3 3 sky130_fd_pr__nfet_01v8 L=0.15U W=0.36U AS=0.0522P AD=0.0759P
+ PS=0.65U PD=0.8U
* device instance $7 r0 *1 7.73,3.165 sky130_fd_pr__nfet_01v8
M$7 94 93 10 10 sky130_fd_pr__nfet_01v8 L=0.15U W=0.42U AS=0.1092P AD=0.0609P
+ PS=1.36U PD=0.71U
* device instance $8 r0 *1 8.17,3.165 sky130_fd_pr__nfet_01v8
M$8 24 10 94 94 sky130_fd_pr__nfet_01v8 L=0.15U W=0.42U AS=0.0609P AD=0.0756P
+ PS=0.71U PD=0.78U
* device instance $9 r0 *1 8.68,3.165 sky130_fd_pr__nfet_01v8
M$9 2 11 24 24 sky130_fd_pr__nfet_01v8 L=0.15U W=0.42U AS=0.0756P AD=0.1446P
+ PS=0.78U PD=1.18U
* device instance $10 r0 *1 10.56,3.165 sky130_fd_pr__nfet_01v8
M$10 94 4 26 26 sky130_fd_pr__nfet_01v8 L=0.15U W=0.42U AS=0.0759P AD=0.12095P
+ PS=0.8U PD=1.085U
* device instance $11 r0 *1 11.155,3.275 sky130_fd_pr__nfet_01v8
M$11 4 3 94 94 sky130_fd_pr__nfet_01v8 L=0.15U W=0.64U AS=0.12095P AD=0.1664P
+ PS=1.085U PD=1.8U
* device instance $12 r0 *1 12.58,3.135 sky130_fd_pr__nfet_01v8
M$12 12 9 28 28 sky130_fd_pr__nfet_01v8 L=0.15U W=0.36U AS=0.0678P AD=0.0684P
+ PS=0.755U PD=0.74U
* device instance $13 r0 *1 13.11,3.135 sky130_fd_pr__nfet_01v8
M$13 30 8 12 12 sky130_fd_pr__nfet_01v8 L=0.15U W=0.36U AS=0.0684P AD=0.066P
+ PS=0.74U PD=0.745U
* device instance $14 r0 *1 12.095,3.165 sky130_fd_pr__nfet_01v8
M$14 28 4 94 94 sky130_fd_pr__nfet_01v8 L=0.15U W=0.42U AS=0.1092P AD=0.0678P
+ PS=1.36U PD=0.755U
* device instance $15 r0 *1 13.585,3.165 sky130_fd_pr__nfet_01v8
M$15 94 11 30 30 sky130_fd_pr__nfet_01v8 L=0.15U W=0.42U AS=0.066P AD=0.1092P
+ PS=0.745U PD=1.36U
* device instance $16 r0 *1 14.525,3.165 sky130_fd_pr__nfet_01v8
M$16 94 12 11 11 sky130_fd_pr__nfet_01v8 L=0.15U W=0.42U AS=0.1092P AD=0.10025P
+ PS=1.36U PD=0.985U
* device instance $17 r0 *1 15.01,3.28 sky130_fd_pr__nfet_01v8
M$17 129 12 94 94 sky130_fd_pr__nfet_01v8 L=0.15U W=0.65U AS=0.10025P AD=0.182P
+ PS=0.985U PD=1.86U
* device instance $18 r0 *1 60.73,3.165 sky130_fd_pr__nfet_01v8
M$18 94 329 13 13 sky130_fd_pr__nfet_01v8 L=0.15U W=0.42U AS=0.1092P AD=0.0567P
+ PS=1.36U PD=0.69U
* device instance $19 r0 *1 61.15,3.165 sky130_fd_pr__nfet_01v8
M$19 15 13 94 94 sky130_fd_pr__nfet_01v8 L=0.15U W=0.42U AS=0.0567P AD=0.1092P
+ PS=0.69U PD=1.36U
* device instance $20 r0 *1 62.09,3.165 sky130_fd_pr__nfet_01v8
M$20 29 14 5 5 sky130_fd_pr__nfet_01v8 L=0.15U W=0.42U AS=0.1092P AD=0.0441P
+ PS=1.36U PD=0.63U
* device instance $21 r0 *1 62.45,3.165 sky130_fd_pr__nfet_01v8
M$21 94 16 29 29 sky130_fd_pr__nfet_01v8 L=0.15U W=0.42U AS=0.0441P AD=0.1092P
+ PS=0.63U PD=1.36U
* device instance $22 r0 *1 65.25,3.135 sky130_fd_pr__nfet_01v8
M$22 6 13 5 5 sky130_fd_pr__nfet_01v8 L=0.15U W=0.36U AS=0.1446P AD=0.0522P
+ PS=1.18U PD=0.65U
* device instance $23 r0 *1 65.69,3.135 sky130_fd_pr__nfet_01v8
M$23 25 15 6 6 sky130_fd_pr__nfet_01v8 L=0.15U W=0.36U AS=0.0522P AD=0.0759P
+ PS=0.65U PD=0.8U
* device instance $24 r0 *1 63.39,3.165 sky130_fd_pr__nfet_01v8
M$24 94 16 17 17 sky130_fd_pr__nfet_01v8 L=0.15U W=0.42U AS=0.1092P AD=0.0609P
+ PS=1.36U PD=0.71U
* device instance $25 r0 *1 63.83,3.165 sky130_fd_pr__nfet_01v8
M$25 27 17 94 94 sky130_fd_pr__nfet_01v8 L=0.15U W=0.42U AS=0.0609P AD=0.0756P
+ PS=0.71U PD=0.78U
* device instance $26 r0 *1 64.34,3.165 sky130_fd_pr__nfet_01v8
M$26 5 18 27 27 sky130_fd_pr__nfet_01v8 L=0.15U W=0.42U AS=0.0756P AD=0.1446P
+ PS=0.78U PD=1.18U
* device instance $27 r0 *1 66.22,3.165 sky130_fd_pr__nfet_01v8
M$27 94 7 25 25 sky130_fd_pr__nfet_01v8 L=0.15U W=0.42U AS=0.0759P AD=0.12095P
+ PS=0.8U PD=1.085U
* device instance $28 r0 *1 66.815,3.275 sky130_fd_pr__nfet_01v8
M$28 7 6 94 94 sky130_fd_pr__nfet_01v8 L=0.15U W=0.64U AS=0.12095P AD=0.1664P
+ PS=1.085U PD=1.8U
* device instance $29 r0 *1 68.24,3.135 sky130_fd_pr__nfet_01v8
M$29 19 15 23 23 sky130_fd_pr__nfet_01v8 L=0.15U W=0.36U AS=0.0678P AD=0.0684P
+ PS=0.755U PD=0.74U
* device instance $30 r0 *1 68.77,3.135 sky130_fd_pr__nfet_01v8
M$30 22 13 19 19 sky130_fd_pr__nfet_01v8 L=0.15U W=0.36U AS=0.0684P AD=0.066P
+ PS=0.74U PD=0.745U
* device instance $31 r0 *1 67.755,3.165 sky130_fd_pr__nfet_01v8
M$31 23 7 94 94 sky130_fd_pr__nfet_01v8 L=0.15U W=0.42U AS=0.1092P AD=0.0678P
+ PS=1.36U PD=0.755U
* device instance $32 r0 *1 69.245,3.165 sky130_fd_pr__nfet_01v8
M$32 94 18 22 22 sky130_fd_pr__nfet_01v8 L=0.15U W=0.42U AS=0.066P AD=0.1092P
+ PS=0.745U PD=1.36U
* device instance $33 r0 *1 70.185,3.165 sky130_fd_pr__nfet_01v8
M$33 94 19 18 18 sky130_fd_pr__nfet_01v8 L=0.15U W=0.42U AS=0.1092P AD=0.10025P
+ PS=1.36U PD=0.985U
* device instance $34 r0 *1 70.67,3.28 sky130_fd_pr__nfet_01v8
M$34 20 19 94 94 sky130_fd_pr__nfet_01v8 L=0.15U W=0.65U AS=0.10025P AD=0.182P
+ PS=0.985U PD=1.86U
* device instance $35 r0 *1 5.53,7.715 sky130_fd_pr__nfet_01v8
M$35 94 31 43 43 sky130_fd_pr__nfet_01v8 L=0.15U W=0.42U AS=0.1092P AD=0.0567P
+ PS=1.36U PD=0.69U
* device instance $36 r0 *1 5.95,7.715 sky130_fd_pr__nfet_01v8
M$36 44 43 94 94 sky130_fd_pr__nfet_01v8 L=0.15U W=0.42U AS=0.0567P AD=0.1092P
+ PS=0.69U PD=1.36U
* device instance $37 r0 *1 6.89,7.715 sky130_fd_pr__nfet_01v8
M$37 95 65 45 45 sky130_fd_pr__nfet_01v8 L=0.15U W=0.42U AS=0.1092P AD=0.0441P
+ PS=1.36U PD=0.63U
* device instance $38 r0 *1 7.25,7.715 sky130_fd_pr__nfet_01v8
M$38 94 16 95 95 sky130_fd_pr__nfet_01v8 L=0.15U W=0.42U AS=0.0441P AD=0.1092P
+ PS=0.63U PD=1.36U
* device instance $39 r0 *1 8.19,7.715 sky130_fd_pr__nfet_01v8
M$39 94 16 46 46 sky130_fd_pr__nfet_01v8 L=0.15U W=0.42U AS=0.1092P AD=0.0609P
+ PS=1.36U PD=0.71U
* device instance $40 r0 *1 8.63,7.715 sky130_fd_pr__nfet_01v8
M$40 97 46 94 94 sky130_fd_pr__nfet_01v8 L=0.15U W=0.42U AS=0.0609P AD=0.0756P
+ PS=0.71U PD=0.78U
* device instance $41 r0 *1 9.14,7.715 sky130_fd_pr__nfet_01v8
M$41 45 49 97 97 sky130_fd_pr__nfet_01v8 L=0.15U W=0.42U AS=0.0756P AD=0.1446P
+ PS=0.78U PD=1.18U
* device instance $42 r0 *1 10.05,7.745 sky130_fd_pr__nfet_01v8
M$42 47 43 45 45 sky130_fd_pr__nfet_01v8 L=0.15U W=0.36U AS=0.1446P AD=0.0522P
+ PS=1.18U PD=0.65U
* device instance $43 r0 *1 10.49,7.745 sky130_fd_pr__nfet_01v8
M$43 47 44 99 99 sky130_fd_pr__nfet_01v8 L=0.15U W=0.36U AS=0.0759P AD=0.0522P
+ PS=0.8U PD=0.65U
* device instance $44 r0 *1 11.02,7.715 sky130_fd_pr__nfet_01v8
M$44 99 48 94 94 sky130_fd_pr__nfet_01v8 L=0.15U W=0.42U AS=0.12095P AD=0.0759P
+ PS=1.085U PD=0.8U
* device instance $45 r0 *1 11.615,7.605 sky130_fd_pr__nfet_01v8
M$45 48 47 94 94 sky130_fd_pr__nfet_01v8 L=0.15U W=0.64U AS=0.12095P AD=0.1664P
+ PS=1.085U PD=1.8U
* device instance $46 r0 *1 12.555,7.715 sky130_fd_pr__nfet_01v8
M$46 101 48 94 94 sky130_fd_pr__nfet_01v8 L=0.15U W=0.42U AS=0.1092P AD=0.0678P
+ PS=1.36U PD=0.755U
* device instance $47 r0 *1 13.04,7.745 sky130_fd_pr__nfet_01v8
M$47 66 44 101 101 sky130_fd_pr__nfet_01v8 L=0.15U W=0.36U AS=0.0678P
+ AD=0.0684P PS=0.755U PD=0.74U
* device instance $48 r0 *1 13.57,7.745 sky130_fd_pr__nfet_01v8
M$48 66 43 102 102 sky130_fd_pr__nfet_01v8 L=0.15U W=0.36U AS=0.066P AD=0.0684P
+ PS=0.745U PD=0.74U
* device instance $49 r0 *1 14.045,7.715 sky130_fd_pr__nfet_01v8
M$49 94 49 102 102 sky130_fd_pr__nfet_01v8 L=0.15U W=0.42U AS=0.066P AD=0.1092P
+ PS=0.745U PD=1.36U
* device instance $50 r0 *1 14.985,7.715 sky130_fd_pr__nfet_01v8
M$50 49 66 94 94 sky130_fd_pr__nfet_01v8 L=0.15U W=0.42U AS=0.10025P AD=0.1092P
+ PS=0.985U PD=1.36U
* device instance $51 r0 *1 15.47,7.6 sky130_fd_pr__nfet_01v8
M$51 50 66 94 94 sky130_fd_pr__nfet_01v8 L=0.15U W=0.65U AS=0.10025P AD=0.182P
+ PS=0.985U PD=1.86U
* device instance $52 r0 *1 23.47,7.6 sky130_fd_pr__nfet_01v8
M$52 94 88 51 51 sky130_fd_pr__nfet_01v8 L=0.15U W=0.65U AS=0.169P AD=0.10725P
+ PS=1.82U PD=0.98U
* device instance $53 r0 *1 23.95,7.6 sky130_fd_pr__nfet_01v8
M$53 105 164 94 94 sky130_fd_pr__nfet_01v8 L=0.15U W=0.65U AS=0.10725P
+ AD=0.06825P PS=0.98U PD=0.86U
* device instance $54 r0 *1 24.31,7.6 sky130_fd_pr__nfet_01v8
M$54 51 90 105 105 sky130_fd_pr__nfet_01v8 L=0.15U W=0.65U AS=0.06825P
+ AD=0.169P PS=0.86U PD=1.82U
* device instance $55 r0 *1 25.25,7.6 sky130_fd_pr__nfet_01v8
M$55 106 87 51 51 sky130_fd_pr__nfet_01v8 L=0.15U W=0.65U AS=0.169P AD=0.10725P
+ PS=1.82U PD=0.98U
* device instance $56 r0 *1 25.73,7.6 sky130_fd_pr__nfet_01v8
M$56 94 89 106 106 sky130_fd_pr__nfet_01v8 L=0.15U W=0.65U AS=0.10725P
+ AD=0.102375P PS=0.98U PD=0.965U
* device instance $57 r0 *1 26.195,7.6 sky130_fd_pr__nfet_01v8
M$57 67 51 94 94 sky130_fd_pr__nfet_01v8 L=0.15U W=0.65U AS=0.102375P AD=0.169P
+ PS=0.965U PD=1.82U
* device instance $58 r0 *1 27.64,7.715 sky130_fd_pr__nfet_01v8
M$58 94 69 91 91 sky130_fd_pr__nfet_01v8 L=0.15U W=0.42U AS=0.1113P AD=0.0588P
+ PS=1.37U PD=0.7U
* device instance $59 r0 *1 28.07,7.715 sky130_fd_pr__nfet_01v8
M$59 91 71 94 94 sky130_fd_pr__nfet_01v8 L=0.15U W=0.42U AS=0.0588P AD=0.0588P
+ PS=0.7U PD=0.7U
* device instance $60 r0 *1 28.5,7.715 sky130_fd_pr__nfet_01v8
M$60 70 53 91 91 sky130_fd_pr__nfet_01v8 L=0.15U W=0.42U AS=0.0588P AD=0.1113P
+ PS=0.7U PD=1.37U
* device instance $61 r0 *1 44.67,7.6 sky130_fd_pr__nfet_01v8
M$61 54 72 94 94 sky130_fd_pr__nfet_01v8 L=0.15U W=0.65U AS=0.169P AD=0.08775P
+ PS=1.82U PD=0.92U
* device instance $62 r0 *1 45.09,7.6 sky130_fd_pr__nfet_01v8
M$62 94 55 54 54 sky130_fd_pr__nfet_01v8 L=0.15U W=0.65U AS=0.08775P
+ AD=0.08775P PS=0.92U PD=0.92U
* device instance $63 r0 *1 45.51,7.6 sky130_fd_pr__nfet_01v8
M$63 107 55 94 94 sky130_fd_pr__nfet_01v8 L=0.15U W=0.65U AS=0.08775P
+ AD=0.08775P PS=0.92U PD=0.92U
* device instance $64 r0 *1 45.93,7.6 sky130_fd_pr__nfet_01v8
M$64 57 72 107 107 sky130_fd_pr__nfet_01v8 L=0.15U W=0.65U AS=0.08775P
+ AD=0.25025P PS=0.92U PD=1.42U
* device instance $65 r0 *1 46.85,7.6 sky130_fd_pr__nfet_01v8
M$65 94 54 57 57 sky130_fd_pr__nfet_01v8 L=0.15U W=0.65U AS=0.25025P AD=0.208P
+ PS=1.42U PD=1.94U
* device instance $66 r0 *1 64.87,7.715 sky130_fd_pr__nfet_01v8
M$66 94 329 58 58 sky130_fd_pr__nfet_01v8 L=0.15U W=0.42U AS=0.1092P AD=0.0567P
+ PS=1.36U PD=0.69U
* device instance $67 r0 *1 65.29,7.715 sky130_fd_pr__nfet_01v8
M$67 59 58 94 94 sky130_fd_pr__nfet_01v8 L=0.15U W=0.42U AS=0.0567P AD=0.1092P
+ PS=0.69U PD=1.36U
* device instance $68 r0 *1 66.23,7.715 sky130_fd_pr__nfet_01v8
M$68 104 73 60 60 sky130_fd_pr__nfet_01v8 L=0.15U W=0.42U AS=0.1092P AD=0.0441P
+ PS=1.36U PD=0.63U
* device instance $69 r0 *1 66.59,7.715 sky130_fd_pr__nfet_01v8
M$69 94 93 104 104 sky130_fd_pr__nfet_01v8 L=0.15U W=0.42U AS=0.0441P
+ AD=0.1092P PS=0.63U PD=1.36U
* device instance $70 r0 *1 67.53,7.715 sky130_fd_pr__nfet_01v8
M$70 94 93 61 61 sky130_fd_pr__nfet_01v8 L=0.15U W=0.42U AS=0.1092P AD=0.0609P
+ PS=1.36U PD=0.71U
* device instance $71 r0 *1 67.97,7.715 sky130_fd_pr__nfet_01v8
M$71 103 61 94 94 sky130_fd_pr__nfet_01v8 L=0.15U W=0.42U AS=0.0609P AD=0.0756P
+ PS=0.71U PD=0.78U
* device instance $72 r0 *1 68.48,7.715 sky130_fd_pr__nfet_01v8
M$72 60 64 103 103 sky130_fd_pr__nfet_01v8 L=0.15U W=0.42U AS=0.0756P
+ AD=0.1446P PS=0.78U PD=1.18U
* device instance $73 r0 *1 69.39,7.745 sky130_fd_pr__nfet_01v8
M$73 62 58 60 60 sky130_fd_pr__nfet_01v8 L=0.15U W=0.36U AS=0.1446P AD=0.0522P
+ PS=1.18U PD=0.65U
* device instance $74 r0 *1 69.83,7.745 sky130_fd_pr__nfet_01v8
M$74 62 59 100 100 sky130_fd_pr__nfet_01v8 L=0.15U W=0.36U AS=0.0759P
+ AD=0.0522P PS=0.8U PD=0.65U
* device instance $75 r0 *1 70.36,7.715 sky130_fd_pr__nfet_01v8
M$75 100 63 94 94 sky130_fd_pr__nfet_01v8 L=0.15U W=0.42U AS=0.12095P
+ AD=0.0759P PS=1.085U PD=0.8U
* device instance $76 r0 *1 70.955,7.605 sky130_fd_pr__nfet_01v8
M$76 63 62 94 94 sky130_fd_pr__nfet_01v8 L=0.15U W=0.64U AS=0.12095P AD=0.1664P
+ PS=1.085U PD=1.8U
* device instance $77 r0 *1 71.895,7.715 sky130_fd_pr__nfet_01v8
M$77 98 63 94 94 sky130_fd_pr__nfet_01v8 L=0.15U W=0.42U AS=0.1092P AD=0.0678P
+ PS=1.36U PD=0.755U
* device instance $78 r0 *1 72.38,7.745 sky130_fd_pr__nfet_01v8
M$78 74 59 98 98 sky130_fd_pr__nfet_01v8 L=0.15U W=0.36U AS=0.0678P AD=0.0684P
+ PS=0.755U PD=0.74U
* device instance $79 r0 *1 72.91,7.745 sky130_fd_pr__nfet_01v8
M$79 74 58 96 96 sky130_fd_pr__nfet_01v8 L=0.15U W=0.36U AS=0.066P AD=0.0684P
+ PS=0.745U PD=0.74U
* device instance $80 r0 *1 73.385,7.715 sky130_fd_pr__nfet_01v8
M$80 94 64 96 96 sky130_fd_pr__nfet_01v8 L=0.15U W=0.42U AS=0.066P AD=0.1092P
+ PS=0.745U PD=1.36U
* device instance $81 r0 *1 74.325,7.715 sky130_fd_pr__nfet_01v8
M$81 64 74 94 94 sky130_fd_pr__nfet_01v8 L=0.15U W=0.42U AS=0.10025P AD=0.1092P
+ PS=0.985U PD=1.36U
* device instance $82 r0 *1 74.81,7.6 sky130_fd_pr__nfet_01v8
M$82 137 74 94 94 sky130_fd_pr__nfet_01v8 L=0.15U W=0.65U AS=0.10025P AD=0.182P
+ PS=0.985U PD=1.86U
* device instance $83 r0 *1 6.98,8.605 sky130_fd_pr__nfet_01v8
M$83 139 157 108 108 sky130_fd_pr__nfet_01v8 L=0.15U W=0.42U AS=0.1113P
+ AD=0.0441P PS=1.37U PD=0.63U
* device instance $84 r0 *1 7.34,8.605 sky130_fd_pr__nfet_01v8
M$84 94 109 139 139 sky130_fd_pr__nfet_01v8 L=0.15U W=0.42U AS=0.0441P
+ AD=0.0966P PS=0.63U PD=0.88U
* device instance $85 r0 *1 7.95,8.605 sky130_fd_pr__nfet_01v8
M$85 110 108 94 94 sky130_fd_pr__nfet_01v8 L=0.15U W=0.42U AS=0.0966P
+ AD=0.1113P PS=0.88U PD=1.37U
* device instance $86 r0 *1 9.21,8.72 sky130_fd_pr__nfet_01v8
M$86 94 110 111 111 sky130_fd_pr__nfet_01v8 L=0.15U W=0.65U AS=0.169P
+ AD=0.10725P PS=1.82U PD=0.98U
* device instance $87 r0 *1 9.69,8.72 sky130_fd_pr__nfet_01v8
M$87 142 129 94 94 sky130_fd_pr__nfet_01v8 L=0.15U W=0.65U AS=0.10725P
+ AD=0.06825P PS=0.98U PD=0.86U
* device instance $88 r0 *1 10.05,8.72 sky130_fd_pr__nfet_01v8
M$88 111 90 142 142 sky130_fd_pr__nfet_01v8 L=0.15U W=0.65U AS=0.06825P
+ AD=0.169P PS=0.86U PD=1.82U
* device instance $89 r0 *1 10.99,8.72 sky130_fd_pr__nfet_01v8
M$89 143 87 111 111 sky130_fd_pr__nfet_01v8 L=0.15U W=0.65U AS=0.169P
+ AD=0.10725P PS=1.82U PD=0.98U
* device instance $90 r0 *1 11.47,8.72 sky130_fd_pr__nfet_01v8
M$90 94 130 143 143 sky130_fd_pr__nfet_01v8 L=0.15U W=0.65U AS=0.10725P
+ AD=0.102375P PS=0.98U PD=0.965U
* device instance $91 r0 *1 11.935,8.72 sky130_fd_pr__nfet_01v8
M$91 65 111 94 94 sky130_fd_pr__nfet_01v8 L=0.15U W=0.65U AS=0.102375P
+ AD=0.169P PS=0.965U PD=1.82U
* device instance $92 r0 *1 23.08,8.605 sky130_fd_pr__nfet_01v8
M$92 145 158 112 112 sky130_fd_pr__nfet_01v8 L=0.15U W=0.42U AS=0.1113P
+ AD=0.0441P PS=1.37U PD=0.63U
* device instance $93 r0 *1 23.44,8.605 sky130_fd_pr__nfet_01v8
M$93 94 109 145 145 sky130_fd_pr__nfet_01v8 L=0.15U W=0.42U AS=0.0441P
+ AD=0.0966P PS=0.63U PD=0.88U
* device instance $94 r0 *1 24.05,8.605 sky130_fd_pr__nfet_01v8
M$94 88 112 94 94 sky130_fd_pr__nfet_01v8 L=0.15U W=0.42U AS=0.0966P AD=0.1113P
+ PS=0.88U PD=1.37U
* device instance $95 r0 *1 25.31,8.605 sky130_fd_pr__nfet_01v8
M$95 94 31 131 131 sky130_fd_pr__nfet_01v8 L=0.15U W=0.42U AS=0.1092P
+ AD=0.0567P PS=1.36U PD=0.69U
* device instance $96 r0 *1 25.73,8.605 sky130_fd_pr__nfet_01v8
M$96 132 131 94 94 sky130_fd_pr__nfet_01v8 L=0.15U W=0.42U AS=0.0567P
+ AD=0.1092P PS=0.69U PD=1.36U
* device instance $97 r0 *1 26.67,8.605 sky130_fd_pr__nfet_01v8
M$97 148 70 113 113 sky130_fd_pr__nfet_01v8 L=0.15U W=0.42U AS=0.1092P
+ AD=0.0441P PS=1.36U PD=0.63U
* device instance $98 r0 *1 27.03,8.605 sky130_fd_pr__nfet_01v8
M$98 94 93 148 148 sky130_fd_pr__nfet_01v8 L=0.15U W=0.42U AS=0.0441P
+ AD=0.1092P PS=0.63U PD=1.36U
* device instance $99 r0 *1 29.83,8.575 sky130_fd_pr__nfet_01v8
M$99 114 131 113 113 sky130_fd_pr__nfet_01v8 L=0.15U W=0.36U AS=0.1446P
+ AD=0.0522P PS=1.18U PD=0.65U
* device instance $100 r0 *1 30.27,8.575 sky130_fd_pr__nfet_01v8
M$100 150 132 114 114 sky130_fd_pr__nfet_01v8 L=0.15U W=0.36U AS=0.0522P
+ AD=0.0759P PS=0.65U PD=0.8U
* device instance $101 r0 *1 27.97,8.605 sky130_fd_pr__nfet_01v8
M$101 94 93 133 133 sky130_fd_pr__nfet_01v8 L=0.15U W=0.42U AS=0.1092P
+ AD=0.0609P PS=1.36U PD=0.71U
* device instance $102 r0 *1 28.41,8.605 sky130_fd_pr__nfet_01v8
M$102 149 133 94 94 sky130_fd_pr__nfet_01v8 L=0.15U W=0.42U AS=0.0609P
+ AD=0.0756P PS=0.71U PD=0.78U
* device instance $103 r0 *1 28.92,8.605 sky130_fd_pr__nfet_01v8
M$103 113 134 149 149 sky130_fd_pr__nfet_01v8 L=0.15U W=0.42U AS=0.0756P
+ AD=0.1446P PS=0.78U PD=1.18U
* device instance $104 r0 *1 30.8,8.605 sky130_fd_pr__nfet_01v8
M$104 94 115 150 150 sky130_fd_pr__nfet_01v8 L=0.15U W=0.42U AS=0.0759P
+ AD=0.12095P PS=0.8U PD=1.085U
* device instance $105 r0 *1 31.395,8.715 sky130_fd_pr__nfet_01v8
M$105 115 114 94 94 sky130_fd_pr__nfet_01v8 L=0.15U W=0.64U AS=0.12095P
+ AD=0.1664P PS=1.085U PD=1.8U
* device instance $106 r0 *1 32.82,8.575 sky130_fd_pr__nfet_01v8
M$106 116 132 153 153 sky130_fd_pr__nfet_01v8 L=0.15U W=0.36U AS=0.0678P
+ AD=0.0684P PS=0.755U PD=0.74U
* device instance $107 r0 *1 33.35,8.575 sky130_fd_pr__nfet_01v8
M$107 154 131 116 116 sky130_fd_pr__nfet_01v8 L=0.15U W=0.36U AS=0.0684P
+ AD=0.066P PS=0.74U PD=0.745U
* device instance $108 r0 *1 32.335,8.605 sky130_fd_pr__nfet_01v8
M$108 153 115 94 94 sky130_fd_pr__nfet_01v8 L=0.15U W=0.42U AS=0.1092P
+ AD=0.0678P PS=1.36U PD=0.755U
* device instance $109 r0 *1 33.825,8.605 sky130_fd_pr__nfet_01v8
M$109 94 134 154 154 sky130_fd_pr__nfet_01v8 L=0.15U W=0.42U AS=0.066P
+ AD=0.1092P PS=0.745U PD=1.36U
* device instance $110 r0 *1 34.765,8.605 sky130_fd_pr__nfet_01v8
M$110 94 116 134 134 sky130_fd_pr__nfet_01v8 L=0.15U W=0.42U AS=0.1092P
+ AD=0.10025P PS=1.36U PD=0.985U
* device instance $111 r0 *1 35.25,8.72 sky130_fd_pr__nfet_01v8
M$111 164 116 94 94 sky130_fd_pr__nfet_01v8 L=0.15U W=0.65U AS=0.10025P
+ AD=0.182P PS=0.985U PD=1.86U
* device instance $112 r0 *1 37.34,8.605 sky130_fd_pr__nfet_01v8
M$112 155 159 117 117 sky130_fd_pr__nfet_01v8 L=0.15U W=0.42U AS=0.1113P
+ AD=0.0441P PS=1.37U PD=0.63U
* device instance $113 r0 *1 37.7,8.605 sky130_fd_pr__nfet_01v8
M$113 94 109 155 155 sky130_fd_pr__nfet_01v8 L=0.15U W=0.42U AS=0.0441P
+ AD=0.0966P PS=0.63U PD=0.88U
* device instance $114 r0 *1 38.31,8.605 sky130_fd_pr__nfet_01v8
M$114 165 117 94 94 sky130_fd_pr__nfet_01v8 L=0.15U W=0.42U AS=0.0966P
+ AD=0.1113P PS=0.88U PD=1.37U
* device instance $115 r0 *1 44.7,8.605 sky130_fd_pr__nfet_01v8
M$115 156 160 118 118 sky130_fd_pr__nfet_01v8 L=0.15U W=0.42U AS=0.1113P
+ AD=0.0441P PS=1.37U PD=0.63U
* device instance $116 r0 *1 45.06,8.605 sky130_fd_pr__nfet_01v8
M$116 94 109 156 156 sky130_fd_pr__nfet_01v8 L=0.15U W=0.42U AS=0.0441P
+ AD=0.0966P PS=0.63U PD=0.88U
* device instance $117 r0 *1 45.67,8.605 sky130_fd_pr__nfet_01v8
M$117 119 118 94 94 sky130_fd_pr__nfet_01v8 L=0.15U W=0.42U AS=0.0966P
+ AD=0.1113P PS=0.88U PD=1.37U
* device instance $118 r0 *1 47.475,8.605 sky130_fd_pr__nfet_01v8
M$118 152 71 94 94 sky130_fd_pr__nfet_01v8 L=0.15U W=0.42U AS=0.11285P
+ AD=0.0693P PS=1.045U PD=0.75U
* device instance $119 r0 *1 47.955,8.605 sky130_fd_pr__nfet_01v8
M$119 121 136 152 152 sky130_fd_pr__nfet_01v8 L=0.15U W=0.42U AS=0.0693P
+ AD=0.09975P PS=0.75U PD=0.895U
* device instance $120 r0 *1 48.58,8.605 sky130_fd_pr__nfet_01v8
M$120 151 135 121 121 sky130_fd_pr__nfet_01v8 L=0.15U W=0.42U AS=0.09975P
+ AD=0.0693P PS=0.895U PD=0.75U
* device instance $121 r0 *1 49.06,8.605 sky130_fd_pr__nfet_01v8
M$121 94 122 151 151 sky130_fd_pr__nfet_01v8 L=0.15U W=0.42U AS=0.0693P
+ AD=0.1449P PS=0.75U PD=1.11U
* device instance $122 r0 *1 49.9,8.605 sky130_fd_pr__nfet_01v8
M$122 122 71 94 94 sky130_fd_pr__nfet_01v8 L=0.15U W=0.42U AS=0.1449P
+ AD=0.1092P PS=1.11U PD=1.36U
* device instance $123 r0 *1 46.93,8.72 sky130_fd_pr__nfet_01v8
M$123 94 121 120 120 sky130_fd_pr__nfet_01v8 L=0.15U W=0.65U AS=0.169P
+ AD=0.11285P PS=1.82U PD=1.045U
* device instance $124 r0 *1 57.58,8.605 sky130_fd_pr__nfet_01v8
M$124 147 161 123 123 sky130_fd_pr__nfet_01v8 L=0.15U W=0.42U AS=0.1113P
+ AD=0.0441P PS=1.37U PD=0.63U
* device instance $125 r0 *1 57.94,8.605 sky130_fd_pr__nfet_01v8
M$125 94 109 147 147 sky130_fd_pr__nfet_01v8 L=0.15U W=0.42U AS=0.0441P
+ AD=0.0966P PS=0.63U PD=0.88U
* device instance $126 r0 *1 58.55,8.605 sky130_fd_pr__nfet_01v8
M$126 124 123 94 94 sky130_fd_pr__nfet_01v8 L=0.15U W=0.42U AS=0.0966P
+ AD=0.1113P PS=0.88U PD=1.37U
* device instance $127 r0 *1 59.81,8.72 sky130_fd_pr__nfet_01v8
M$127 94 124 125 125 sky130_fd_pr__nfet_01v8 L=0.15U W=0.65U AS=0.169P
+ AD=0.10725P PS=1.82U PD=0.98U
* device instance $128 r0 *1 60.29,8.72 sky130_fd_pr__nfet_01v8
M$128 146 137 94 94 sky130_fd_pr__nfet_01v8 L=0.15U W=0.65U AS=0.10725P
+ AD=0.06825P PS=0.98U PD=0.86U
* device instance $129 r0 *1 60.65,8.72 sky130_fd_pr__nfet_01v8
M$129 125 90 146 146 sky130_fd_pr__nfet_01v8 L=0.15U W=0.65U AS=0.06825P
+ AD=0.169P PS=0.86U PD=1.82U
* device instance $130 r0 *1 61.59,8.72 sky130_fd_pr__nfet_01v8
M$130 144 138 125 125 sky130_fd_pr__nfet_01v8 L=0.15U W=0.65U AS=0.169P
+ AD=0.10725P PS=1.82U PD=0.98U
* device instance $131 r0 *1 62.07,8.72 sky130_fd_pr__nfet_01v8
M$131 94 1 144 144 sky130_fd_pr__nfet_01v8 L=0.15U W=0.65U AS=0.10725P
+ AD=0.102375P PS=0.98U PD=0.965U
* device instance $132 r0 *1 62.535,8.72 sky130_fd_pr__nfet_01v8
M$132 14 125 94 94 sky130_fd_pr__nfet_01v8 L=0.15U W=0.65U AS=0.102375P
+ AD=0.169P PS=0.965U PD=1.82U
* device instance $133 r0 *1 68.175,8.605 sky130_fd_pr__nfet_01v8
M$133 141 71 94 94 sky130_fd_pr__nfet_01v8 L=0.15U W=0.42U AS=0.11285P
+ AD=0.0693P PS=1.045U PD=0.75U
* device instance $134 r0 *1 68.655,8.605 sky130_fd_pr__nfet_01v8
M$134 126 127 141 141 sky130_fd_pr__nfet_01v8 L=0.15U W=0.42U AS=0.0693P
+ AD=0.09975P PS=0.75U PD=0.895U
* device instance $135 r0 *1 69.28,8.605 sky130_fd_pr__nfet_01v8
M$135 140 20 126 126 sky130_fd_pr__nfet_01v8 L=0.15U W=0.42U AS=0.09975P
+ AD=0.0693P PS=0.895U PD=0.75U
* device instance $136 r0 *1 69.76,8.605 sky130_fd_pr__nfet_01v8
M$136 94 128 140 140 sky130_fd_pr__nfet_01v8 L=0.15U W=0.42U AS=0.0693P
+ AD=0.1449P PS=0.75U PD=1.11U
* device instance $137 r0 *1 70.6,8.605 sky130_fd_pr__nfet_01v8
M$137 128 71 94 94 sky130_fd_pr__nfet_01v8 L=0.15U W=0.42U AS=0.1449P
+ AD=0.1092P PS=1.11U PD=1.36U
* device instance $138 r0 *1 67.63,8.72 sky130_fd_pr__nfet_01v8
M$138 94 126 73 73 sky130_fd_pr__nfet_01v8 L=0.15U W=0.65U AS=0.169P
+ AD=0.11285P PS=1.82U PD=1.045U
* device instance $139 r0 *1 7.83,13.04 sky130_fd_pr__nfet_01v8
M$139 94 178 32 32 sky130_fd_pr__nfet_01v8 L=0.15U W=0.65U AS=0.169P
+ AD=0.11285P PS=1.82U PD=1.045U
* device instance $140 r0 *1 8.375,13.155 sky130_fd_pr__nfet_01v8
M$140 236 71 94 94 sky130_fd_pr__nfet_01v8 L=0.15U W=0.42U AS=0.11285P
+ AD=0.0693P PS=1.045U PD=0.75U
* device instance $141 r0 *1 8.855,13.155 sky130_fd_pr__nfet_01v8
M$141 178 209 236 236 sky130_fd_pr__nfet_01v8 L=0.15U W=0.42U AS=0.0693P
+ AD=0.09975P PS=0.75U PD=0.895U
* device instance $142 r0 *1 9.48,13.155 sky130_fd_pr__nfet_01v8
M$142 237 50 178 178 sky130_fd_pr__nfet_01v8 L=0.15U W=0.42U AS=0.09975P
+ AD=0.0693P PS=0.895U PD=0.75U
* device instance $143 r0 *1 9.96,13.155 sky130_fd_pr__nfet_01v8
M$143 94 233 237 237 sky130_fd_pr__nfet_01v8 L=0.15U W=0.42U AS=0.0693P
+ AD=0.1449P PS=0.75U PD=1.11U
* device instance $144 r0 *1 10.8,13.155 sky130_fd_pr__nfet_01v8
M$144 233 71 94 94 sky130_fd_pr__nfet_01v8 L=0.15U W=0.42U AS=0.1449P
+ AD=0.1092P PS=1.11U PD=1.36U
* device instance $145 r0 *1 12.53,13.04 sky130_fd_pr__nfet_01v8
M$145 239 210 179 179 sky130_fd_pr__nfet_01v8 L=0.15U W=0.65U AS=0.169P
+ AD=0.06825P PS=1.82U PD=0.86U
* device instance $146 r0 *1 12.89,13.04 sky130_fd_pr__nfet_01v8
M$146 94 231 239 239 sky130_fd_pr__nfet_01v8 L=0.15U W=0.65U AS=0.06825P
+ AD=0.08775P PS=0.86U PD=0.92U
* device instance $147 r0 *1 13.31,13.04 sky130_fd_pr__nfet_01v8
M$147 234 231 94 94 sky130_fd_pr__nfet_01v8 L=0.15U W=0.65U AS=0.08775P
+ AD=0.169P PS=0.92U PD=1.82U
* device instance $148 r0 *1 14.25,13.04 sky130_fd_pr__nfet_01v8
M$148 234 210 94 94 sky130_fd_pr__nfet_01v8 L=0.15U W=0.65U AS=0.169P
+ AD=0.08775P PS=1.82U PD=0.92U
* device instance $149 r0 *1 14.67,13.04 sky130_fd_pr__nfet_01v8
M$149 130 179 234 234 sky130_fd_pr__nfet_01v8 L=0.15U W=0.65U AS=0.08775P
+ AD=0.195P PS=0.92U PD=1.9U
* device instance $150 r0 *1 15.69,13.04 sky130_fd_pr__nfet_01v8
M$150 180 50 94 94 sky130_fd_pr__nfet_01v8 L=0.15U W=0.65U AS=0.169P
+ AD=0.08775P PS=1.82U PD=0.92U
* device instance $151 r0 *1 16.11,13.04 sky130_fd_pr__nfet_01v8
M$151 94 129 180 180 sky130_fd_pr__nfet_01v8 L=0.15U W=0.65U AS=0.08775P
+ AD=0.08775P PS=0.92U PD=0.92U
* device instance $152 r0 *1 16.53,13.04 sky130_fd_pr__nfet_01v8
M$152 242 129 94 94 sky130_fd_pr__nfet_01v8 L=0.15U W=0.65U AS=0.08775P
+ AD=0.08775P PS=0.92U PD=0.92U
* device instance $153 r0 *1 16.95,13.04 sky130_fd_pr__nfet_01v8
M$153 210 50 242 242 sky130_fd_pr__nfet_01v8 L=0.15U W=0.65U AS=0.08775P
+ AD=0.25025P PS=0.92U PD=1.42U
* device instance $154 r0 *1 17.87,13.04 sky130_fd_pr__nfet_01v8
M$154 94 180 210 210 sky130_fd_pr__nfet_01v8 L=0.15U W=0.65U AS=0.25025P
+ AD=0.208P PS=1.42U PD=1.94U
* device instance $155 r0 *1 19.33,13.155 sky130_fd_pr__nfet_01v8
M$155 94 31 182 182 sky130_fd_pr__nfet_01v8 L=0.15U W=0.42U AS=0.1092P
+ AD=0.0567P PS=1.36U PD=0.69U
* device instance $156 r0 *1 19.75,13.155 sky130_fd_pr__nfet_01v8
M$156 183 182 94 94 sky130_fd_pr__nfet_01v8 L=0.15U W=0.42U AS=0.0567P
+ AD=0.1092P PS=0.69U PD=1.36U
* device instance $157 r0 *1 20.69,13.155 sky130_fd_pr__nfet_01v8
M$157 243 67 185 185 sky130_fd_pr__nfet_01v8 L=0.15U W=0.42U AS=0.1092P
+ AD=0.0441P PS=1.36U PD=0.63U
* device instance $158 r0 *1 21.05,13.155 sky130_fd_pr__nfet_01v8
M$158 94 16 243 243 sky130_fd_pr__nfet_01v8 L=0.15U W=0.42U AS=0.0441P
+ AD=0.1092P PS=0.63U PD=1.36U
* device instance $159 r0 *1 21.99,13.155 sky130_fd_pr__nfet_01v8
M$159 94 16 184 184 sky130_fd_pr__nfet_01v8 L=0.15U W=0.42U AS=0.1092P
+ AD=0.0609P PS=1.36U PD=0.71U
* device instance $160 r0 *1 22.43,13.155 sky130_fd_pr__nfet_01v8
M$160 244 184 94 94 sky130_fd_pr__nfet_01v8 L=0.15U W=0.42U AS=0.0609P
+ AD=0.0756P PS=0.71U PD=0.78U
* device instance $161 r0 *1 22.94,13.155 sky130_fd_pr__nfet_01v8
M$161 185 189 244 244 sky130_fd_pr__nfet_01v8 L=0.15U W=0.42U AS=0.0756P
+ AD=0.1446P PS=0.78U PD=1.18U
* device instance $162 r0 *1 23.85,13.185 sky130_fd_pr__nfet_01v8
M$162 186 182 185 185 sky130_fd_pr__nfet_01v8 L=0.15U W=0.36U AS=0.1446P
+ AD=0.0522P PS=1.18U PD=0.65U
* device instance $163 r0 *1 24.29,13.185 sky130_fd_pr__nfet_01v8
M$163 186 183 246 246 sky130_fd_pr__nfet_01v8 L=0.15U W=0.36U AS=0.0759P
+ AD=0.0522P PS=0.8U PD=0.65U
* device instance $164 r0 *1 24.82,13.155 sky130_fd_pr__nfet_01v8
M$164 246 187 94 94 sky130_fd_pr__nfet_01v8 L=0.15U W=0.42U AS=0.12095P
+ AD=0.0759P PS=1.085U PD=0.8U
* device instance $165 r0 *1 25.415,13.045 sky130_fd_pr__nfet_01v8
M$165 187 186 94 94 sky130_fd_pr__nfet_01v8 L=0.15U W=0.64U AS=0.12095P
+ AD=0.1664P PS=1.085U PD=1.8U
* device instance $166 r0 *1 26.355,13.155 sky130_fd_pr__nfet_01v8
M$166 248 187 94 94 sky130_fd_pr__nfet_01v8 L=0.15U W=0.42U AS=0.1092P
+ AD=0.0678P PS=1.36U PD=0.755U
* device instance $167 r0 *1 26.84,13.185 sky130_fd_pr__nfet_01v8
M$167 188 183 248 248 sky130_fd_pr__nfet_01v8 L=0.15U W=0.36U AS=0.0678P
+ AD=0.0684P PS=0.755U PD=0.74U
* device instance $168 r0 *1 27.37,13.185 sky130_fd_pr__nfet_01v8
M$168 188 182 249 249 sky130_fd_pr__nfet_01v8 L=0.15U W=0.36U AS=0.066P
+ AD=0.0684P PS=0.745U PD=0.74U
* device instance $169 r0 *1 27.845,13.155 sky130_fd_pr__nfet_01v8
M$169 94 189 249 249 sky130_fd_pr__nfet_01v8 L=0.15U W=0.42U AS=0.066P
+ AD=0.1092P PS=0.745U PD=1.36U
* device instance $170 r0 *1 28.785,13.155 sky130_fd_pr__nfet_01v8
M$170 189 188 94 94 sky130_fd_pr__nfet_01v8 L=0.15U W=0.42U AS=0.10025P
+ AD=0.1092P PS=0.985U PD=1.36U
* device instance $171 r0 *1 29.27,13.04 sky130_fd_pr__nfet_01v8
M$171 190 188 94 94 sky130_fd_pr__nfet_01v8 L=0.15U W=0.65U AS=0.10025P
+ AD=0.182P PS=0.985U PD=1.86U
* device instance $172 r0 *1 30.85,13.04 sky130_fd_pr__nfet_01v8
M$172 252 92 94 94 sky130_fd_pr__nfet_01v8 L=0.15U W=0.65U AS=0.169P
+ AD=0.08775P PS=1.82U PD=0.92U
* device instance $173 r0 *1 31.27,13.04 sky130_fd_pr__nfet_01v8
M$173 53 71 252 252 sky130_fd_pr__nfet_01v8 L=0.15U W=0.65U AS=0.08775P
+ AD=0.169P PS=0.92U PD=1.82U
* device instance $174 r0 *1 32.625,13.155 sky130_fd_pr__nfet_01v8
M$174 94 190 69 69 sky130_fd_pr__nfet_01v8 L=0.15U W=0.42U AS=0.1092P
+ AD=0.1197P PS=1.36U PD=1.41U
* device instance $175 r0 *1 33.605,13.04 sky130_fd_pr__nfet_01v8
M$175 94 164 235 235 sky130_fd_pr__nfet_01v8 L=0.15U W=1.3U AS=0.299P AD=0.182P
+ PS=2.87U PD=1.86U
* device instance $176 r0 *1 34.035,13.04 sky130_fd_pr__nfet_01v8
M$176 235 69 94 94 sky130_fd_pr__nfet_01v8 L=0.15U W=1.3U AS=0.182P AD=0.21775P
+ PS=1.86U PD=1.97U
* device instance $179 r0 *1 35.435,13.04 sky130_fd_pr__nfet_01v8
M$179 72 192 235 235 sky130_fd_pr__nfet_01v8 L=0.15U W=1.3U AS=0.182P
+ AD=0.26325P PS=1.86U PD=2.76U
* device instance $181 r0 *1 40.95,13.04 sky130_fd_pr__nfet_01v8
M$181 94 119 193 193 sky130_fd_pr__nfet_01v8 L=0.15U W=0.65U AS=0.169P
+ AD=0.10725P PS=1.82U PD=0.98U
* device instance $182 r0 *1 41.43,13.04 sky130_fd_pr__nfet_01v8
M$182 255 232 94 94 sky130_fd_pr__nfet_01v8 L=0.15U W=0.65U AS=0.10725P
+ AD=0.06825P PS=0.98U PD=0.86U
* device instance $183 r0 *1 41.79,13.04 sky130_fd_pr__nfet_01v8
M$183 193 90 255 255 sky130_fd_pr__nfet_01v8 L=0.15U W=0.65U AS=0.06825P
+ AD=0.169P PS=0.86U PD=1.82U
* device instance $184 r0 *1 42.73,13.04 sky130_fd_pr__nfet_01v8
M$184 254 138 193 193 sky130_fd_pr__nfet_01v8 L=0.15U W=0.65U AS=0.169P
+ AD=0.10725P PS=1.82U PD=0.98U
* device instance $185 r0 *1 43.21,13.04 sky130_fd_pr__nfet_01v8
M$185 94 57 254 254 sky130_fd_pr__nfet_01v8 L=0.15U W=0.65U AS=0.10725P
+ AD=0.102375P PS=0.98U PD=0.965U
* device instance $186 r0 *1 43.675,13.04 sky130_fd_pr__nfet_01v8
M$186 195 193 94 94 sky130_fd_pr__nfet_01v8 L=0.15U W=0.65U AS=0.102375P
+ AD=0.169P PS=0.965U PD=1.82U
* device instance $187 r0 *1 46.93,13.155 sky130_fd_pr__nfet_01v8
M$187 94 329 196 196 sky130_fd_pr__nfet_01v8 L=0.15U W=0.42U AS=0.1092P
+ AD=0.0567P PS=1.36U PD=0.69U
* device instance $188 r0 *1 47.35,13.155 sky130_fd_pr__nfet_01v8
M$188 197 196 94 94 sky130_fd_pr__nfet_01v8 L=0.15U W=0.42U AS=0.0567P
+ AD=0.1092P PS=0.69U PD=1.36U
* device instance $189 r0 *1 48.29,13.155 sky130_fd_pr__nfet_01v8
M$189 253 120 199 199 sky130_fd_pr__nfet_01v8 L=0.15U W=0.42U AS=0.1092P
+ AD=0.0441P PS=1.36U PD=0.63U
* device instance $190 r0 *1 48.65,13.155 sky130_fd_pr__nfet_01v8
M$190 94 93 253 253 sky130_fd_pr__nfet_01v8 L=0.15U W=0.42U AS=0.0441P
+ AD=0.1092P PS=0.63U PD=1.36U
* device instance $191 r0 *1 49.59,13.155 sky130_fd_pr__nfet_01v8
M$191 94 93 198 198 sky130_fd_pr__nfet_01v8 L=0.15U W=0.42U AS=0.1092P
+ AD=0.0609P PS=1.36U PD=0.71U
* device instance $192 r0 *1 50.03,13.155 sky130_fd_pr__nfet_01v8
M$192 251 198 94 94 sky130_fd_pr__nfet_01v8 L=0.15U W=0.42U AS=0.0609P
+ AD=0.0756P PS=0.71U PD=0.78U
* device instance $193 r0 *1 50.54,13.155 sky130_fd_pr__nfet_01v8
M$193 199 203 251 251 sky130_fd_pr__nfet_01v8 L=0.15U W=0.42U AS=0.0756P
+ AD=0.1446P PS=0.78U PD=1.18U
* device instance $194 r0 *1 51.45,13.185 sky130_fd_pr__nfet_01v8
M$194 200 196 199 199 sky130_fd_pr__nfet_01v8 L=0.15U W=0.36U AS=0.1446P
+ AD=0.0522P PS=1.18U PD=0.65U
* device instance $195 r0 *1 51.89,13.185 sky130_fd_pr__nfet_01v8
M$195 200 197 250 250 sky130_fd_pr__nfet_01v8 L=0.15U W=0.36U AS=0.0759P
+ AD=0.0522P PS=0.8U PD=0.65U
* device instance $196 r0 *1 52.42,13.155 sky130_fd_pr__nfet_01v8
M$196 250 201 94 94 sky130_fd_pr__nfet_01v8 L=0.15U W=0.42U AS=0.12095P
+ AD=0.0759P PS=1.085U PD=0.8U
* device instance $197 r0 *1 53.015,13.045 sky130_fd_pr__nfet_01v8
M$197 201 200 94 94 sky130_fd_pr__nfet_01v8 L=0.15U W=0.64U AS=0.12095P
+ AD=0.1664P PS=1.085U PD=1.8U
* device instance $198 r0 *1 53.955,13.155 sky130_fd_pr__nfet_01v8
M$198 247 201 94 94 sky130_fd_pr__nfet_01v8 L=0.15U W=0.42U AS=0.1092P
+ AD=0.0678P PS=1.36U PD=0.755U
* device instance $199 r0 *1 54.44,13.185 sky130_fd_pr__nfet_01v8
M$199 202 197 247 247 sky130_fd_pr__nfet_01v8 L=0.15U W=0.36U AS=0.0678P
+ AD=0.0684P PS=0.755U PD=0.74U
* device instance $200 r0 *1 54.97,13.185 sky130_fd_pr__nfet_01v8
M$200 202 196 245 245 sky130_fd_pr__nfet_01v8 L=0.15U W=0.36U AS=0.066P
+ AD=0.0684P PS=0.745U PD=0.74U
* device instance $201 r0 *1 55.445,13.155 sky130_fd_pr__nfet_01v8
M$201 94 203 245 245 sky130_fd_pr__nfet_01v8 L=0.15U W=0.42U AS=0.066P
+ AD=0.1092P PS=0.745U PD=1.36U
* device instance $202 r0 *1 56.385,13.155 sky130_fd_pr__nfet_01v8
M$202 203 202 94 94 sky130_fd_pr__nfet_01v8 L=0.15U W=0.42U AS=0.10025P
+ AD=0.1092P PS=0.985U PD=1.36U
* device instance $203 r0 *1 56.87,13.04 sky130_fd_pr__nfet_01v8
M$203 232 202 94 94 sky130_fd_pr__nfet_01v8 L=0.15U W=0.65U AS=0.10025P
+ AD=0.182P PS=0.985U PD=1.86U
* device instance $204 r0 *1 61.69,13.04 sky130_fd_pr__nfet_01v8
M$204 204 212 94 94 sky130_fd_pr__nfet_01v8 L=0.15U W=0.65U AS=0.169P
+ AD=0.08775P PS=1.82U PD=0.92U
* device instance $205 r0 *1 62.11,13.04 sky130_fd_pr__nfet_01v8
M$205 94 213 204 204 sky130_fd_pr__nfet_01v8 L=0.15U W=0.65U AS=0.08775P
+ AD=0.08775P PS=0.92U PD=0.92U
* device instance $206 r0 *1 62.53,13.04 sky130_fd_pr__nfet_01v8
M$206 241 213 94 94 sky130_fd_pr__nfet_01v8 L=0.15U W=0.65U AS=0.08775P
+ AD=0.08775P PS=0.92U PD=0.92U
* device instance $207 r0 *1 62.95,13.04 sky130_fd_pr__nfet_01v8
M$207 1 212 241 241 sky130_fd_pr__nfet_01v8 L=0.15U W=0.65U AS=0.08775P
+ AD=0.25025P PS=0.92U PD=1.42U
* device instance $208 r0 *1 63.87,13.04 sky130_fd_pr__nfet_01v8
M$208 94 204 1 1 sky130_fd_pr__nfet_01v8 L=0.15U W=0.65U AS=0.25025P AD=0.208P
+ PS=1.42U PD=1.94U
* device instance $209 r0 *1 66.29,13.04 sky130_fd_pr__nfet_01v8
M$209 206 20 94 94 sky130_fd_pr__nfet_01v8 L=0.15U W=0.65U AS=0.169P
+ AD=0.08775P PS=1.82U PD=0.92U
* device instance $210 r0 *1 66.71,13.04 sky130_fd_pr__nfet_01v8
M$210 94 137 206 206 sky130_fd_pr__nfet_01v8 L=0.15U W=0.65U AS=0.08775P
+ AD=0.08775P PS=0.92U PD=0.92U
* device instance $211 r0 *1 67.13,13.04 sky130_fd_pr__nfet_01v8
M$211 240 137 94 94 sky130_fd_pr__nfet_01v8 L=0.15U W=0.65U AS=0.08775P
+ AD=0.08775P PS=0.92U PD=0.92U
* device instance $212 r0 *1 67.55,13.04 sky130_fd_pr__nfet_01v8
M$212 213 20 240 240 sky130_fd_pr__nfet_01v8 L=0.15U W=0.65U AS=0.08775P
+ AD=0.25025P PS=0.92U PD=1.42U
* device instance $213 r0 *1 68.47,13.04 sky130_fd_pr__nfet_01v8
M$213 94 206 213 213 sky130_fd_pr__nfet_01v8 L=0.15U W=0.65U AS=0.25025P
+ AD=0.208P PS=1.42U PD=1.94U
* device instance $214 r0 *1 69.47,12.925 sky130_fd_pr__nfet_01v8
M$214 94 137 214 214 sky130_fd_pr__nfet_01v8 L=0.15U W=0.42U AS=0.1092P
+ AD=0.10025P PS=1.36U PD=0.985U
* device instance $215 r0 *1 69.955,13.04 sky130_fd_pr__nfet_01v8
M$215 238 20 94 94 sky130_fd_pr__nfet_01v8 L=0.15U W=0.65U AS=0.10025P
+ AD=0.08775P PS=0.985U PD=0.92U
* device instance $216 r0 *1 70.375,13.04 sky130_fd_pr__nfet_01v8
M$216 208 214 238 238 sky130_fd_pr__nfet_01v8 L=0.15U W=0.65U AS=0.08775P
+ AD=0.169P PS=0.92U PD=1.82U
* device instance $217 r0 *1 12.665,14.045 sky130_fd_pr__nfet_01v8
M$217 94 50 256 256 sky130_fd_pr__nfet_01v8 L=0.15U W=0.42U AS=0.1092P
+ AD=0.10025P PS=1.36U PD=0.985U
* device instance $218 r0 *1 13.15,14.16 sky130_fd_pr__nfet_01v8
M$218 257 129 94 94 sky130_fd_pr__nfet_01v8 L=0.15U W=0.65U AS=0.10025P
+ AD=0.08775P PS=0.985U PD=0.92U
* device instance $219 r0 *1 13.57,14.16 sky130_fd_pr__nfet_01v8
M$219 94 256 257 257 sky130_fd_pr__nfet_01v8 L=0.15U W=0.65U AS=0.08775P
+ AD=0.169P PS=0.92U PD=1.82U
* device instance $220 r0 *1 13.82,18.48 sky130_fd_pr__nfet_01v8
M$220 94 294 293 293 sky130_fd_pr__nfet_01v8 L=0.15U W=0.65U AS=0.169P
+ AD=0.25675P PS=1.82U PD=1.44U
* device instance $221 r0 *1 14.76,18.48 sky130_fd_pr__nfet_01v8
M$221 294 257 94 94 sky130_fd_pr__nfet_01v8 L=0.15U W=0.65U AS=0.25675P
+ AD=0.089375P PS=1.44U PD=0.925U
* device instance $222 r0 *1 15.185,18.48 sky130_fd_pr__nfet_01v8
M$222 318 231 294 294 sky130_fd_pr__nfet_01v8 L=0.15U W=0.65U AS=0.089375P
+ AD=0.091P PS=0.925U PD=0.93U
* device instance $223 r0 *1 15.615,18.48 sky130_fd_pr__nfet_01v8
M$223 94 258 318 318 sky130_fd_pr__nfet_01v8 L=0.15U W=0.65U AS=0.091P
+ AD=0.17225P PS=0.93U PD=1.83U
* device instance $224 r0 *1 15.145,14.045 sky130_fd_pr__nfet_01v8
M$224 94 210 258 258 sky130_fd_pr__nfet_01v8 L=0.15U W=0.42U AS=0.1092P
+ AD=0.1197P PS=1.36U PD=1.41U
* device instance $225 r0 *1 28.63,14.16 sky130_fd_pr__nfet_01v8
M$225 282 190 259 259 sky130_fd_pr__nfet_01v8 L=0.15U W=0.65U AS=0.169P
+ AD=0.06825P PS=1.82U PD=0.86U
* device instance $226 r0 *1 28.99,14.16 sky130_fd_pr__nfet_01v8
M$226 94 164 282 282 sky130_fd_pr__nfet_01v8 L=0.15U W=0.65U AS=0.06825P
+ AD=0.08775P PS=0.86U PD=0.92U
* device instance $227 r0 *1 29.41,14.16 sky130_fd_pr__nfet_01v8
M$227 260 164 94 94 sky130_fd_pr__nfet_01v8 L=0.15U W=0.65U AS=0.08775P
+ AD=0.169P PS=0.92U PD=1.82U
* device instance $228 r0 *1 30.35,14.16 sky130_fd_pr__nfet_01v8
M$228 260 190 94 94 sky130_fd_pr__nfet_01v8 L=0.15U W=0.65U AS=0.169P
+ AD=0.08775P PS=1.82U PD=0.92U
* device instance $229 r0 *1 30.77,14.16 sky130_fd_pr__nfet_01v8
M$229 277 259 260 260 sky130_fd_pr__nfet_01v8 L=0.15U W=0.65U AS=0.08775P
+ AD=0.195P PS=0.92U PD=1.9U
* device instance $230 r0 *1 31.985,14.045 sky130_fd_pr__nfet_01v8
M$230 94 192 261 261 sky130_fd_pr__nfet_01v8 L=0.15U W=0.42U AS=0.1092P
+ AD=0.10025P PS=1.36U PD=0.985U
* device instance $231 r0 *1 32.47,14.16 sky130_fd_pr__nfet_01v8
M$231 89 276 94 94 sky130_fd_pr__nfet_01v8 L=0.15U W=0.65U AS=0.10025P
+ AD=0.08775P PS=0.985U PD=0.92U
* device instance $232 r0 *1 32.89,14.16 sky130_fd_pr__nfet_01v8
M$232 94 261 89 89 sky130_fd_pr__nfet_01v8 L=0.15U W=0.65U AS=0.08775P
+ AD=0.169P PS=0.92U PD=1.82U
* device instance $233 r0 *1 34.05,14.16 sky130_fd_pr__nfet_01v8
M$233 192 277 262 262 sky130_fd_pr__nfet_01v8 L=0.15U W=1.3U AS=0.25675P
+ AD=0.1755P PS=2.74U PD=1.84U
* device instance $235 r0 *1 34.89,14.16 sky130_fd_pr__nfet_01v8
M$235 264 263 262 262 sky130_fd_pr__nfet_01v8 L=0.15U W=1.3U AS=0.1755P
+ AD=0.25675P PS=1.84U PD=2.74U
* device instance $237 r0 *1 34.07,18.48 sky130_fd_pr__nfet_01v8
M$237 276 277 94 94 sky130_fd_pr__nfet_01v8 L=0.15U W=0.65U AS=0.17225P
+ AD=0.091P PS=1.83U PD=0.93U
* device instance $238 r0 *1 34.5,18.48 sky130_fd_pr__nfet_01v8
M$238 324 263 276 276 sky130_fd_pr__nfet_01v8 L=0.15U W=0.65U AS=0.091P
+ AD=0.095875P PS=0.93U PD=0.945U
* device instance $239 r0 *1 34.945,18.48 sky130_fd_pr__nfet_01v8
M$239 94 278 324 324 sky130_fd_pr__nfet_01v8 L=0.15U W=0.65U AS=0.095875P
+ AD=0.17225P PS=0.945U PD=1.83U
* device instance $240 r0 *1 35.89,18.48 sky130_fd_pr__nfet_01v8
M$240 280 69 94 94 sky130_fd_pr__nfet_01v8 L=0.15U W=0.65U AS=0.169P
+ AD=0.08775P PS=1.82U PD=0.92U
* device instance $241 r0 *1 36.31,18.48 sky130_fd_pr__nfet_01v8
M$241 94 164 280 280 sky130_fd_pr__nfet_01v8 L=0.15U W=0.65U AS=0.08775P
+ AD=0.169P PS=0.92U PD=1.82U
* device instance $242 r0 *1 36.25,14.16 sky130_fd_pr__nfet_01v8
M$242 264 278 94 94 sky130_fd_pr__nfet_01v8 L=0.15U W=1.3U AS=0.25675P
+ AD=0.28925P PS=2.74U PD=2.84U
* device instance $244 r0 *1 37.73,14.16 sky130_fd_pr__nfet_01v8
M$244 94 263 265 265 sky130_fd_pr__nfet_01v8 L=0.15U W=1.3U AS=0.25675P
+ AD=0.1755P PS=2.74U PD=1.84U
* device instance $246 r0 *1 38.57,14.16 sky130_fd_pr__nfet_01v8
M$246 266 279 265 265 sky130_fd_pr__nfet_01v8 L=0.15U W=1.3U AS=0.1755P
+ AD=0.25675P PS=1.84U PD=2.74U
* device instance $248 r0 *1 39.93,14.16 sky130_fd_pr__nfet_01v8
M$248 266 277 267 267 sky130_fd_pr__nfet_01v8 L=0.15U W=1.3U AS=0.25675P
+ AD=0.18525P PS=2.74U PD=1.87U
* device instance $250 r0 *1 40.8,14.16 sky130_fd_pr__nfet_01v8
M$250 94 280 267 267 sky130_fd_pr__nfet_01v8 L=0.15U W=1.3U AS=0.18525P
+ AD=0.25675P PS=1.87U PD=2.09U
* device instance $252 r0 *1 41.89,14.16 sky130_fd_pr__nfet_01v8
M$252 94 268 267 267 sky130_fd_pr__nfet_01v8 L=0.15U W=1.3U AS=0.25675P
+ AD=0.25675P PS=2.09U PD=2.74U
* device instance $254 r0 *1 45.325,14.045 sky130_fd_pr__nfet_01v8
M$254 94 135 269 269 sky130_fd_pr__nfet_01v8 L=0.15U W=0.42U AS=0.1092P
+ AD=0.10025P PS=1.36U PD=0.985U
* device instance $255 r0 *1 45.81,14.16 sky130_fd_pr__nfet_01v8
M$255 268 232 94 94 sky130_fd_pr__nfet_01v8 L=0.15U W=0.65U AS=0.10025P
+ AD=0.08775P PS=0.985U PD=0.92U
* device instance $256 r0 *1 46.23,14.16 sky130_fd_pr__nfet_01v8
M$256 94 269 268 268 sky130_fd_pr__nfet_01v8 L=0.15U W=0.65U AS=0.08775P
+ AD=0.169P PS=0.92U PD=1.82U
* device instance $257 r0 *1 47.39,14.16 sky130_fd_pr__nfet_01v8
M$257 55 281 94 94 sky130_fd_pr__nfet_01v8 L=0.15U W=0.65U AS=0.169P
+ AD=0.08775P PS=1.82U PD=0.92U
* device instance $258 r0 *1 47.81,14.16 sky130_fd_pr__nfet_01v8
M$258 94 268 55 55 sky130_fd_pr__nfet_01v8 L=0.15U W=0.65U AS=0.08775P
+ AD=0.169P PS=0.92U PD=1.82U
* device instance $259 r0 *1 50.385,14.045 sky130_fd_pr__nfet_01v8
M$259 94 232 270 270 sky130_fd_pr__nfet_01v8 L=0.15U W=0.42U AS=0.1092P
+ AD=0.10025P PS=1.36U PD=0.985U
* device instance $260 r0 *1 50.87,14.16 sky130_fd_pr__nfet_01v8
M$260 281 135 94 94 sky130_fd_pr__nfet_01v8 L=0.15U W=0.65U AS=0.10025P
+ AD=0.08775P PS=0.985U PD=0.92U
* device instance $261 r0 *1 51.29,14.16 sky130_fd_pr__nfet_01v8
M$261 94 270 281 281 sky130_fd_pr__nfet_01v8 L=0.15U W=0.65U AS=0.08775P
+ AD=0.169P PS=0.92U PD=1.82U
* device instance $262 r0 *1 53.625,18.595 sky130_fd_pr__nfet_01v8
M$262 304 303 94 94 sky130_fd_pr__nfet_01v8 L=0.15U W=0.42U AS=0.10025P
+ AD=0.1092P PS=0.985U PD=1.36U
* device instance $263 r0 *1 54.11,18.48 sky130_fd_pr__nfet_01v8
M$263 135 303 94 94 sky130_fd_pr__nfet_01v8 L=0.15U W=0.65U AS=0.10025P
+ AD=0.182P PS=0.985U PD=1.86U
* device instance $264 r0 *1 57.655,14.045 sky130_fd_pr__nfet_01v8
M$264 271 281 94 94 sky130_fd_pr__nfet_01v8 L=0.15U W=0.42U AS=0.1092P
+ AD=0.0567P PS=1.36U PD=0.69U
* device instance $265 r0 *1 58.075,14.045 sky130_fd_pr__nfet_01v8
M$265 94 267 271 271 sky130_fd_pr__nfet_01v8 L=0.15U W=0.42U AS=0.0567P
+ AD=0.10025P PS=0.69U PD=0.985U
* device instance $266 r0 *1 58.56,14.16 sky130_fd_pr__nfet_01v8
M$266 272 271 94 94 sky130_fd_pr__nfet_01v8 L=0.15U W=0.65U AS=0.10025P
+ AD=0.169P PS=0.985U PD=1.82U
* device instance $267 r0 *1 59.95,18.48 sky130_fd_pr__nfet_01v8
M$267 94 213 316 316 sky130_fd_pr__nfet_01v8 L=0.15U W=1.3U AS=0.25675P
+ AD=0.1755P PS=2.74U PD=1.84U
* device instance $269 r0 *1 60.79,18.48 sky130_fd_pr__nfet_01v8
M$269 94 267 316 316 sky130_fd_pr__nfet_01v8 L=0.15U W=1.3U AS=0.1755P
+ AD=0.1755P PS=1.84U PD=1.84U
* device instance $271 r0 *1 61.63,18.48 sky130_fd_pr__nfet_01v8
M$271 94 281 316 316 sky130_fd_pr__nfet_01v8 L=0.15U W=1.3U AS=0.3185P
+ AD=0.3185P PS=2.28U PD=2.28U
* device instance $273 r0 *1 62.91,18.48 sky130_fd_pr__nfet_01v8
M$273 317 208 316 316 sky130_fd_pr__nfet_01v8 L=0.15U W=1.3U AS=0.1755P
+ AD=0.26975P PS=1.84U PD=2.78U
* device instance $275 r0 *1 63.5,14.045 sky130_fd_pr__nfet_01v8
M$275 274 208 273 273 sky130_fd_pr__nfet_01v8 L=0.15U W=0.42U AS=0.1113P
+ AD=0.0588P PS=1.37U PD=0.7U
* device instance $276 r0 *1 63.93,14.045 sky130_fd_pr__nfet_01v8
M$276 94 272 274 274 sky130_fd_pr__nfet_01v8 L=0.15U W=0.42U AS=0.0588P
+ AD=0.0588P PS=0.7U PD=0.7U
* device instance $277 r0 *1 64.36,14.045 sky130_fd_pr__nfet_01v8
M$277 274 213 94 94 sky130_fd_pr__nfet_01v8 L=0.15U W=0.42U AS=0.0588P
+ AD=0.1113P PS=0.7U PD=1.37U
* device instance $278 r0 *1 64.31,18.48 sky130_fd_pr__nfet_01v8
M$278 317 312 305 305 sky130_fd_pr__nfet_01v8 L=0.15U W=1.3U AS=0.26975P
+ AD=0.25675P PS=2.78U PD=2.74U
* device instance $280 r0 *1 65.32,14.16 sky130_fd_pr__nfet_01v8
M$280 212 275 94 94 sky130_fd_pr__nfet_01v8 L=0.15U W=2.6U AS=0.43225P
+ AD=0.351P PS=4.58U PD=3.68U
* device instance $284 r0 *1 67,14.16 sky130_fd_pr__nfet_01v8
M$284 275 272 94 94 sky130_fd_pr__nfet_01v8 L=0.15U W=0.65U AS=0.08775P
+ AD=0.169P PS=0.92U PD=1.82U
* device instance $285 r0 *1 17.03,19.6 sky130_fd_pr__nfet_01v8
M$285 94 334 335 335 sky130_fd_pr__nfet_01v8 L=0.15U W=0.65U AS=0.169P
+ AD=0.08775P PS=1.82U PD=0.92U
* device instance $286 r0 *1 17.45,19.6 sky130_fd_pr__nfet_01v8
M$286 231 335 94 94 sky130_fd_pr__nfet_01v8 L=0.15U W=2.6U AS=0.351P AD=0.52P
+ PS=3.68U PD=4.2U
* device instance $290 r0 *1 19.65,19.6 sky130_fd_pr__nfet_01v8
M$290 325 334 94 94 sky130_fd_pr__nfet_01v8 L=0.15U W=2.6U AS=0.52P AD=0.351P
+ PS=4.2U PD=3.68U
* device instance $293 r0 *1 20.91,19.6 sky130_fd_pr__nfet_01v8
M$293 336 258 325 325 sky130_fd_pr__nfet_01v8 L=0.15U W=2.6U AS=0.351P
+ AD=0.351P PS=3.68U PD=3.68U
* device instance $298 r0 *1 23.01,19.6 sky130_fd_pr__nfet_01v8
M$298 336 337 94 94 sky130_fd_pr__nfet_01v8 L=0.15U W=2.6U AS=0.378625P
+ AD=0.47775P PS=3.765U PD=4.72U
* device instance $301 r0 *1 24.35,19.6 sky130_fd_pr__nfet_01v8
M$301 94 257 336 336 sky130_fd_pr__nfet_01v8 L=0.15U W=2.6U AS=0.352625P
+ AD=0.35425P PS=3.685U PD=3.69U
* device instance $306 r0 *1 27.155,19.485 sky130_fd_pr__nfet_01v8
M$306 326 311 94 94 sky130_fd_pr__nfet_01v8 L=0.15U W=1.68U AS=0.2877P
+ AD=0.2352P PS=3.47U PD=2.8U
* device instance $310 r0 *1 28.875,19.485 sky130_fd_pr__nfet_01v8
M$310 31 326 94 94 sky130_fd_pr__nfet_01v8 L=0.15U W=6.72U AS=0.93975P
+ AD=1.07465P PS=11.195U PD=11.925U
* device instance $326 r0 *1 36.25,19.6 sky130_fd_pr__nfet_01v8
M$326 278 327 94 94 sky130_fd_pr__nfet_01v8 L=0.15U W=2.6U AS=0.45695P
+ AD=0.351P PS=4.19U PD=3.68U
* device instance $330 r0 *1 37.93,19.6 sky130_fd_pr__nfet_01v8
M$330 327 279 94 94 sky130_fd_pr__nfet_01v8 L=0.15U W=0.65U AS=0.08775P
+ AD=0.169P PS=0.92U PD=1.82U
* device instance $331 r0 *1 44.17,18.595 sky130_fd_pr__nfet_01v8
M$331 94 329 297 297 sky130_fd_pr__nfet_01v8 L=0.15U W=0.42U AS=0.1092P
+ AD=0.0567P PS=1.36U PD=0.69U
* device instance $332 r0 *1 44.59,18.595 sky130_fd_pr__nfet_01v8
M$332 298 297 94 94 sky130_fd_pr__nfet_01v8 L=0.15U W=0.42U AS=0.0567P
+ AD=0.1092P PS=0.69U PD=1.36U
* device instance $333 r0 *1 45.53,18.595 sky130_fd_pr__nfet_01v8
M$333 323 195 299 299 sky130_fd_pr__nfet_01v8 L=0.15U W=0.42U AS=0.1092P
+ AD=0.0441P PS=1.36U PD=0.63U
* device instance $334 r0 *1 45.89,18.595 sky130_fd_pr__nfet_01v8
M$334 94 16 323 323 sky130_fd_pr__nfet_01v8 L=0.15U W=0.42U AS=0.0441P
+ AD=0.1092P PS=0.63U PD=1.36U
* device instance $335 r0 *1 46.475,19.485 sky130_fd_pr__nfet_01v8
M$335 328 311 94 94 sky130_fd_pr__nfet_01v8 L=0.15U W=1.68U AS=0.2877P
+ AD=0.2352P PS=3.47U PD=2.8U
* device instance $339 r0 *1 48.195,19.485 sky130_fd_pr__nfet_01v8
M$339 329 328 94 94 sky130_fd_pr__nfet_01v8 L=0.15U W=6.72U AS=0.93975P
+ AD=0.99225P PS=11.195U PD=11.865U
* device instance $355 r0 *1 46.83,18.595 sky130_fd_pr__nfet_01v8
M$355 94 16 300 300 sky130_fd_pr__nfet_01v8 L=0.15U W=0.42U AS=0.1092P
+ AD=0.0609P PS=1.36U PD=0.71U
* device instance $356 r0 *1 47.27,18.595 sky130_fd_pr__nfet_01v8
M$356 322 300 94 94 sky130_fd_pr__nfet_01v8 L=0.15U W=0.42U AS=0.0609P
+ AD=0.0756P PS=0.71U PD=0.78U
* device instance $357 r0 *1 47.78,18.595 sky130_fd_pr__nfet_01v8
M$357 299 304 322 322 sky130_fd_pr__nfet_01v8 L=0.15U W=0.42U AS=0.0756P
+ AD=0.1446P PS=0.78U PD=1.18U
* device instance $358 r0 *1 48.69,18.625 sky130_fd_pr__nfet_01v8
M$358 301 297 299 299 sky130_fd_pr__nfet_01v8 L=0.15U W=0.36U AS=0.1446P
+ AD=0.0522P PS=1.18U PD=0.65U
* device instance $359 r0 *1 49.13,18.625 sky130_fd_pr__nfet_01v8
M$359 301 298 321 321 sky130_fd_pr__nfet_01v8 L=0.15U W=0.36U AS=0.0759P
+ AD=0.0522P PS=0.8U PD=0.65U
* device instance $360 r0 *1 49.66,18.595 sky130_fd_pr__nfet_01v8
M$360 321 302 94 94 sky130_fd_pr__nfet_01v8 L=0.15U W=0.42U AS=0.12095P
+ AD=0.0759P PS=1.085U PD=0.8U
* device instance $361 r0 *1 50.255,18.485 sky130_fd_pr__nfet_01v8
M$361 302 301 94 94 sky130_fd_pr__nfet_01v8 L=0.15U W=0.64U AS=0.12095P
+ AD=0.1664P PS=1.085U PD=1.8U
* device instance $362 r0 *1 51.195,18.595 sky130_fd_pr__nfet_01v8
M$362 320 302 94 94 sky130_fd_pr__nfet_01v8 L=0.15U W=0.42U AS=0.1092P
+ AD=0.0678P PS=1.36U PD=0.755U
* device instance $363 r0 *1 51.68,18.625 sky130_fd_pr__nfet_01v8
M$363 303 298 320 320 sky130_fd_pr__nfet_01v8 L=0.15U W=0.36U AS=0.0678P
+ AD=0.0684P PS=0.755U PD=0.74U
* device instance $364 r0 *1 52.21,18.625 sky130_fd_pr__nfet_01v8
M$364 303 297 319 319 sky130_fd_pr__nfet_01v8 L=0.15U W=0.36U AS=0.066P
+ AD=0.0684P PS=0.745U PD=0.74U
* device instance $365 r0 *1 52.685,18.595 sky130_fd_pr__nfet_01v8
M$365 94 304 319 319 sky130_fd_pr__nfet_01v8 L=0.15U W=0.42U AS=0.066P
+ AD=0.1092P PS=0.745U PD=1.36U
* device instance $366 r0 *1 63.51,19.6 sky130_fd_pr__nfet_01v8
M$366 343 338 94 94 sky130_fd_pr__nfet_01v8 L=0.15U W=0.65U AS=0.169P
+ AD=0.08775P PS=1.82U PD=0.92U
* device instance $367 r0 *1 63.93,19.6 sky130_fd_pr__nfet_01v8
M$367 330 312 343 343 sky130_fd_pr__nfet_01v8 L=0.15U W=0.65U AS=0.08775P
+ AD=0.169P PS=0.92U PD=1.82U
* device instance $368 r0 *1 64.97,19.6 sky130_fd_pr__nfet_01v8
M$368 342 273 331 331 sky130_fd_pr__nfet_01v8 L=0.15U W=0.65U AS=0.169P
+ AD=0.06825P PS=1.82U PD=0.86U
* device instance $369 r0 *1 65.33,19.6 sky130_fd_pr__nfet_01v8
M$369 94 330 342 342 sky130_fd_pr__nfet_01v8 L=0.15U W=0.65U AS=0.06825P
+ AD=0.08775P PS=0.86U PD=0.92U
* device instance $370 r0 *1 65.75,19.6 sky130_fd_pr__nfet_01v8
M$370 332 330 94 94 sky130_fd_pr__nfet_01v8 L=0.15U W=0.65U AS=0.08775P
+ AD=0.169P PS=0.92U PD=1.82U
* device instance $371 r0 *1 66.69,19.6 sky130_fd_pr__nfet_01v8
M$371 332 273 94 94 sky130_fd_pr__nfet_01v8 L=0.15U W=0.65U AS=0.169P
+ AD=0.08775P PS=1.82U PD=0.92U
* device instance $372 r0 *1 67.11,19.6 sky130_fd_pr__nfet_01v8
M$372 346 331 332 332 sky130_fd_pr__nfet_01v8 L=0.15U W=0.65U AS=0.08775P
+ AD=0.195P PS=0.92U PD=1.9U
* device instance $373 r0 *1 68.325,19.485 sky130_fd_pr__nfet_01v8
M$373 94 339 340 340 sky130_fd_pr__nfet_01v8 L=0.15U W=0.42U AS=0.1092P
+ AD=0.10025P PS=1.36U PD=0.985U
* device instance $374 r0 *1 68.81,19.6 sky130_fd_pr__nfet_01v8
M$374 333 341 94 94 sky130_fd_pr__nfet_01v8 L=0.15U W=0.65U AS=0.10025P
+ AD=0.08775P PS=0.985U PD=0.92U
* device instance $375 r0 *1 69.23,19.6 sky130_fd_pr__nfet_01v8
M$375 94 340 333 333 sky130_fd_pr__nfet_01v8 L=0.15U W=0.65U AS=0.08775P
+ AD=0.169P PS=0.92U PD=1.82U
* device instance $376 r0 *1 6.98,24.035 sky130_fd_pr__nfet_01v8
M$376 409 380 382 382 sky130_fd_pr__nfet_01v8 L=0.15U W=0.42U AS=0.1113P
+ AD=0.0441P PS=1.37U PD=0.63U
* device instance $377 r0 *1 7.34,24.035 sky130_fd_pr__nfet_01v8
M$377 94 109 409 409 sky130_fd_pr__nfet_01v8 L=0.15U W=0.42U AS=0.0441P
+ AD=0.0966P PS=0.63U PD=0.88U
* device instance $378 r0 *1 7.95,24.035 sky130_fd_pr__nfet_01v8
M$378 351 382 94 94 sky130_fd_pr__nfet_01v8 L=0.15U W=0.42U AS=0.0966P
+ AD=0.1113P PS=0.88U PD=1.37U
* device instance $379 r0 *1 9.21,23.92 sky130_fd_pr__nfet_01v8
M$379 94 351 352 352 sky130_fd_pr__nfet_01v8 L=0.15U W=0.65U AS=0.169P
+ AD=0.10725P PS=1.82U PD=0.98U
* device instance $380 r0 *1 9.69,23.92 sky130_fd_pr__nfet_01v8
M$380 412 354 94 94 sky130_fd_pr__nfet_01v8 L=0.15U W=0.65U AS=0.10725P
+ AD=0.06825P PS=0.98U PD=0.86U
* device instance $381 r0 *1 10.05,23.92 sky130_fd_pr__nfet_01v8
M$381 352 90 412 412 sky130_fd_pr__nfet_01v8 L=0.15U W=0.65U AS=0.06825P
+ AD=0.169P PS=0.86U PD=1.82U
* device instance $382 r0 *1 10.99,23.92 sky130_fd_pr__nfet_01v8
M$382 414 87 352 352 sky130_fd_pr__nfet_01v8 L=0.15U W=0.65U AS=0.169P
+ AD=0.10725P PS=1.82U PD=0.98U
* device instance $383 r0 *1 11.47,23.92 sky130_fd_pr__nfet_01v8
M$383 94 381 414 414 sky130_fd_pr__nfet_01v8 L=0.15U W=0.65U AS=0.10725P
+ AD=0.102375P PS=0.98U PD=0.965U
* device instance $384 r0 *1 11.935,23.92 sky130_fd_pr__nfet_01v8
M$384 405 352 94 94 sky130_fd_pr__nfet_01v8 L=0.15U W=0.65U AS=0.102375P
+ AD=0.169P PS=0.965U PD=1.82U
* device instance $385 r0 *1 12.93,23.92 sky130_fd_pr__nfet_01v8
M$385 355 384 94 94 sky130_fd_pr__nfet_01v8 L=0.15U W=0.65U AS=0.169P
+ AD=0.08775P PS=1.82U PD=0.92U
* device instance $386 r0 *1 13.35,23.92 sky130_fd_pr__nfet_01v8
M$386 94 293 355 355 sky130_fd_pr__nfet_01v8 L=0.15U W=0.65U AS=0.08775P
+ AD=0.08775P PS=0.92U PD=0.92U
* device instance $387 r0 *1 13.77,23.92 sky130_fd_pr__nfet_01v8
M$387 417 293 94 94 sky130_fd_pr__nfet_01v8 L=0.15U W=0.65U AS=0.08775P
+ AD=0.08775P PS=0.92U PD=0.92U
* device instance $388 r0 *1 14.19,23.92 sky130_fd_pr__nfet_01v8
M$388 381 384 417 417 sky130_fd_pr__nfet_01v8 L=0.15U W=0.65U AS=0.08775P
+ AD=0.25025P PS=0.92U PD=1.42U
* device instance $389 r0 *1 15.11,23.92 sky130_fd_pr__nfet_01v8
M$389 94 355 381 381 sky130_fd_pr__nfet_01v8 L=0.15U W=0.65U AS=0.25025P
+ AD=0.208P PS=1.42U PD=1.94U
* device instance $390 r0 *1 17.49,24.005 sky130_fd_pr__nfet_01v8
M$390 385 599 94 94 sky130_fd_pr__nfet_01v8 L=0.15U W=0.42U AS=0.1092P
+ AD=0.0693P PS=1.36U PD=0.75U
* device instance $391 r0 *1 17.97,24.005 sky130_fd_pr__nfet_01v8
M$391 94 129 385 385 sky130_fd_pr__nfet_01v8 L=0.15U W=0.42U AS=0.0693P
+ AD=0.0567P PS=0.75U PD=0.69U
* device instance $392 r0 *1 18.39,24.005 sky130_fd_pr__nfet_01v8
M$392 385 354 94 94 sky130_fd_pr__nfet_01v8 L=0.15U W=0.42U AS=0.0567P
+ AD=0.0567P PS=0.69U PD=0.69U
* device instance $393 r0 *1 18.81,24.005 sky130_fd_pr__nfet_01v8
M$393 385 164 94 94 sky130_fd_pr__nfet_01v8 L=0.15U W=0.42U AS=0.101875P
+ AD=0.0567P PS=0.99U PD=0.69U
* device instance $394 r0 *1 19.3,23.92 sky130_fd_pr__nfet_01v8
M$394 406 385 94 94 sky130_fd_pr__nfet_01v8 L=0.15U W=0.65U AS=0.101875P
+ AD=0.1755P PS=0.99U PD=1.84U
* device instance $395 r0 *1 27.625,24.035 sky130_fd_pr__nfet_01v8
M$395 357 31 94 94 sky130_fd_pr__nfet_01v8 L=0.15U W=1.68U AS=0.315P AD=0.3423P
+ PS=3.6U PD=3.73U
* device instance $399 r0 *1 41.41,24.035 sky130_fd_pr__nfet_01v8
M$399 94 329 358 358 sky130_fd_pr__nfet_01v8 L=0.15U W=0.42U AS=0.1092P
+ AD=0.0567P PS=1.36U PD=0.69U
* device instance $400 r0 *1 41.83,24.035 sky130_fd_pr__nfet_01v8
M$400 359 358 94 94 sky130_fd_pr__nfet_01v8 L=0.15U W=0.42U AS=0.0567P
+ AD=0.1092P PS=0.69U PD=1.36U
* device instance $401 r0 *1 42.77,24.035 sky130_fd_pr__nfet_01v8
M$401 421 386 361 361 sky130_fd_pr__nfet_01v8 L=0.15U W=0.42U AS=0.1092P
+ AD=0.0441P PS=1.36U PD=0.63U
* device instance $402 r0 *1 43.13,24.035 sky130_fd_pr__nfet_01v8
M$402 94 93 421 421 sky130_fd_pr__nfet_01v8 L=0.15U W=0.42U AS=0.0441P
+ AD=0.1092P PS=0.63U PD=1.36U
* device instance $403 r0 *1 44.07,24.035 sky130_fd_pr__nfet_01v8
M$403 94 93 360 360 sky130_fd_pr__nfet_01v8 L=0.15U W=0.42U AS=0.1092P
+ AD=0.0609P PS=1.36U PD=0.71U
* device instance $404 r0 *1 44.51,24.035 sky130_fd_pr__nfet_01v8
M$404 423 360 94 94 sky130_fd_pr__nfet_01v8 L=0.15U W=0.42U AS=0.0609P
+ AD=0.0756P PS=0.71U PD=0.78U
* device instance $405 r0 *1 45.02,24.035 sky130_fd_pr__nfet_01v8
M$405 361 365 423 423 sky130_fd_pr__nfet_01v8 L=0.15U W=0.42U AS=0.0756P
+ AD=0.1446P PS=0.78U PD=1.18U
* device instance $406 r0 *1 45.93,24.065 sky130_fd_pr__nfet_01v8
M$406 362 358 361 361 sky130_fd_pr__nfet_01v8 L=0.15U W=0.36U AS=0.1446P
+ AD=0.0522P PS=1.18U PD=0.65U
* device instance $407 r0 *1 46.37,24.065 sky130_fd_pr__nfet_01v8
M$407 362 359 424 424 sky130_fd_pr__nfet_01v8 L=0.15U W=0.36U AS=0.0759P
+ AD=0.0522P PS=0.8U PD=0.65U
* device instance $408 r0 *1 46.9,24.035 sky130_fd_pr__nfet_01v8
M$408 424 363 94 94 sky130_fd_pr__nfet_01v8 L=0.15U W=0.42U AS=0.12095P
+ AD=0.0759P PS=1.085U PD=0.8U
* device instance $409 r0 *1 47.495,23.925 sky130_fd_pr__nfet_01v8
M$409 363 362 94 94 sky130_fd_pr__nfet_01v8 L=0.15U W=0.64U AS=0.12095P
+ AD=0.1664P PS=1.085U PD=1.8U
* device instance $410 r0 *1 48.435,24.035 sky130_fd_pr__nfet_01v8
M$410 422 363 94 94 sky130_fd_pr__nfet_01v8 L=0.15U W=0.42U AS=0.1092P
+ AD=0.0678P PS=1.36U PD=0.755U
* device instance $411 r0 *1 48.92,24.065 sky130_fd_pr__nfet_01v8
M$411 364 359 422 422 sky130_fd_pr__nfet_01v8 L=0.15U W=0.36U AS=0.0678P
+ AD=0.0684P PS=0.755U PD=0.74U
* device instance $412 r0 *1 49.45,24.065 sky130_fd_pr__nfet_01v8
M$412 364 358 420 420 sky130_fd_pr__nfet_01v8 L=0.15U W=0.36U AS=0.066P
+ AD=0.0684P PS=0.745U PD=0.74U
* device instance $413 r0 *1 49.925,24.035 sky130_fd_pr__nfet_01v8
M$413 94 365 420 420 sky130_fd_pr__nfet_01v8 L=0.15U W=0.42U AS=0.066P
+ AD=0.1092P PS=0.745U PD=1.36U
* device instance $414 r0 *1 50.865,24.035 sky130_fd_pr__nfet_01v8
M$414 365 364 94 94 sky130_fd_pr__nfet_01v8 L=0.15U W=0.42U AS=0.10025P
+ AD=0.1092P PS=0.985U PD=1.36U
* device instance $415 r0 *1 51.35,23.92 sky130_fd_pr__nfet_01v8
M$415 366 364 94 94 sky130_fd_pr__nfet_01v8 L=0.15U W=0.65U AS=0.10025P
+ AD=0.182P PS=0.985U PD=1.86U
* device instance $416 r0 *1 53.39,23.92 sky130_fd_pr__nfet_01v8
M$416 407 387 94 94 sky130_fd_pr__nfet_01v8 L=0.15U W=1.3U AS=0.26975P
+ AD=0.1755P PS=2.78U PD=1.84U
* device instance $418 r0 *1 54.23,23.92 sky130_fd_pr__nfet_01v8
M$418 407 341 94 94 sky130_fd_pr__nfet_01v8 L=0.15U W=1.3U AS=0.1755P
+ AD=0.26975P PS=1.84U PD=2.78U
* device instance $420 r0 *1 55.63,23.92 sky130_fd_pr__nfet_01v8
M$420 407 137 94 94 sky130_fd_pr__nfet_01v8 L=0.15U W=1.3U AS=0.26975P
+ AD=0.1755P PS=2.78U PD=1.84U
* device instance $422 r0 *1 56.47,23.92 sky130_fd_pr__nfet_01v8
M$422 407 232 94 94 sky130_fd_pr__nfet_01v8 L=0.15U W=1.3U AS=0.1755P
+ AD=0.25675P PS=1.84U PD=2.74U
* device instance $424 r0 *1 60.73,23.92 sky130_fd_pr__nfet_01v8
M$424 94 388 370 370 sky130_fd_pr__nfet_01v8 L=0.15U W=0.65U AS=0.169P
+ AD=0.10725P PS=1.82U PD=0.98U
* device instance $425 r0 *1 61.21,23.92 sky130_fd_pr__nfet_01v8
M$425 419 341 94 94 sky130_fd_pr__nfet_01v8 L=0.15U W=0.65U AS=0.10725P
+ AD=0.06825P PS=0.98U PD=0.86U
* device instance $426 r0 *1 61.57,23.92 sky130_fd_pr__nfet_01v8
M$426 370 90 419 419 sky130_fd_pr__nfet_01v8 L=0.15U W=0.65U AS=0.06825P
+ AD=0.169P PS=0.86U PD=1.82U
* device instance $427 r0 *1 62.51,23.92 sky130_fd_pr__nfet_01v8
M$427 418 138 370 370 sky130_fd_pr__nfet_01v8 L=0.15U W=0.65U AS=0.169P
+ AD=0.10725P PS=1.82U PD=0.98U
* device instance $428 r0 *1 62.99,23.92 sky130_fd_pr__nfet_01v8
M$428 94 346 418 418 sky130_fd_pr__nfet_01v8 L=0.15U W=0.65U AS=0.10725P
+ AD=0.102375P PS=0.98U PD=0.965U
* device instance $429 r0 *1 63.455,23.92 sky130_fd_pr__nfet_01v8
M$429 408 370 94 94 sky130_fd_pr__nfet_01v8 L=0.15U W=0.65U AS=0.102375P
+ AD=0.169P PS=0.965U PD=1.82U
* device instance $430 r0 *1 64.41,24.035 sky130_fd_pr__nfet_01v8
M$430 94 329 372 372 sky130_fd_pr__nfet_01v8 L=0.15U W=0.42U AS=0.1092P
+ AD=0.0567P PS=1.36U PD=0.69U
* device instance $431 r0 *1 64.83,24.035 sky130_fd_pr__nfet_01v8
M$431 373 372 94 94 sky130_fd_pr__nfet_01v8 L=0.15U W=0.42U AS=0.0567P
+ AD=0.1092P PS=0.69U PD=1.36U
* device instance $432 r0 *1 65.77,24.035 sky130_fd_pr__nfet_01v8
M$432 416 390 375 375 sky130_fd_pr__nfet_01v8 L=0.15U W=0.42U AS=0.1092P
+ AD=0.0441P PS=1.36U PD=0.63U
* device instance $433 r0 *1 66.13,24.035 sky130_fd_pr__nfet_01v8
M$433 94 1102 416 416 sky130_fd_pr__nfet_01v8 L=0.15U W=0.42U AS=0.0441P
+ AD=0.1092P PS=0.63U PD=1.36U
* device instance $434 r0 *1 67.07,24.035 sky130_fd_pr__nfet_01v8
M$434 94 1102 374 374 sky130_fd_pr__nfet_01v8 L=0.15U W=0.42U AS=0.1092P
+ AD=0.0609P PS=1.36U PD=0.71U
* device instance $435 r0 *1 67.51,24.035 sky130_fd_pr__nfet_01v8
M$435 415 374 94 94 sky130_fd_pr__nfet_01v8 L=0.15U W=0.42U AS=0.0609P
+ AD=0.0756P PS=0.71U PD=0.78U
* device instance $436 r0 *1 68.02,24.035 sky130_fd_pr__nfet_01v8
M$436 375 379 415 415 sky130_fd_pr__nfet_01v8 L=0.15U W=0.42U AS=0.0756P
+ AD=0.1446P PS=0.78U PD=1.18U
* device instance $437 r0 *1 68.93,24.065 sky130_fd_pr__nfet_01v8
M$437 376 372 375 375 sky130_fd_pr__nfet_01v8 L=0.15U W=0.36U AS=0.1446P
+ AD=0.0522P PS=1.18U PD=0.65U
* device instance $438 r0 *1 69.37,24.065 sky130_fd_pr__nfet_01v8
M$438 376 373 413 413 sky130_fd_pr__nfet_01v8 L=0.15U W=0.36U AS=0.0759P
+ AD=0.0522P PS=0.8U PD=0.65U
* device instance $439 r0 *1 69.9,24.035 sky130_fd_pr__nfet_01v8
M$439 413 377 94 94 sky130_fd_pr__nfet_01v8 L=0.15U W=0.42U AS=0.12095P
+ AD=0.0759P PS=1.085U PD=0.8U
* device instance $440 r0 *1 70.495,23.925 sky130_fd_pr__nfet_01v8
M$440 377 376 94 94 sky130_fd_pr__nfet_01v8 L=0.15U W=0.64U AS=0.12095P
+ AD=0.1664P PS=1.085U PD=1.8U
* device instance $441 r0 *1 71.435,24.035 sky130_fd_pr__nfet_01v8
M$441 411 377 94 94 sky130_fd_pr__nfet_01v8 L=0.15U W=0.42U AS=0.1092P
+ AD=0.0678P PS=1.36U PD=0.755U
* device instance $442 r0 *1 71.92,24.065 sky130_fd_pr__nfet_01v8
M$442 378 373 411 411 sky130_fd_pr__nfet_01v8 L=0.15U W=0.36U AS=0.0678P
+ AD=0.0684P PS=0.755U PD=0.74U
* device instance $443 r0 *1 72.45,24.065 sky130_fd_pr__nfet_01v8
M$443 378 372 410 410 sky130_fd_pr__nfet_01v8 L=0.15U W=0.36U AS=0.066P
+ AD=0.0684P PS=0.745U PD=0.74U
* device instance $444 r0 *1 72.925,24.035 sky130_fd_pr__nfet_01v8
M$444 94 379 410 410 sky130_fd_pr__nfet_01v8 L=0.15U W=0.42U AS=0.066P
+ AD=0.1092P PS=0.745U PD=1.36U
* device instance $445 r0 *1 73.865,24.035 sky130_fd_pr__nfet_01v8
M$445 379 378 94 94 sky130_fd_pr__nfet_01v8 L=0.15U W=0.42U AS=0.10025P
+ AD=0.1092P PS=0.985U PD=1.36U
* device instance $446 r0 *1 74.35,23.92 sky130_fd_pr__nfet_01v8
M$446 341 378 94 94 sky130_fd_pr__nfet_01v8 L=0.15U W=0.65U AS=0.10025P
+ AD=0.182P PS=0.985U PD=1.86U
* device instance $447 r0 *1 4.61,24.925 sky130_fd_pr__nfet_01v8
M$447 94 31 425 425 sky130_fd_pr__nfet_01v8 L=0.15U W=0.42U AS=0.1092P
+ AD=0.0567P PS=1.36U PD=0.69U
* device instance $448 r0 *1 5.03,24.925 sky130_fd_pr__nfet_01v8
M$448 426 425 94 94 sky130_fd_pr__nfet_01v8 L=0.15U W=0.42U AS=0.0567P
+ AD=0.1092P PS=0.69U PD=1.36U
* device instance $449 r0 *1 5.97,24.925 sky130_fd_pr__nfet_01v8
M$449 452 447 427 427 sky130_fd_pr__nfet_01v8 L=0.15U W=0.42U AS=0.1092P
+ AD=0.0441P PS=1.36U PD=0.63U
* device instance $450 r0 *1 6.33,24.925 sky130_fd_pr__nfet_01v8
M$450 94 93 452 452 sky130_fd_pr__nfet_01v8 L=0.15U W=0.42U AS=0.0441P
+ AD=0.1092P PS=0.63U PD=1.36U
* device instance $451 r0 *1 9.13,24.895 sky130_fd_pr__nfet_01v8
M$451 429 425 427 427 sky130_fd_pr__nfet_01v8 L=0.15U W=0.36U AS=0.1446P
+ AD=0.0522P PS=1.18U PD=0.65U
* device instance $452 r0 *1 9.57,24.895 sky130_fd_pr__nfet_01v8
M$452 456 426 429 429 sky130_fd_pr__nfet_01v8 L=0.15U W=0.36U AS=0.0522P
+ AD=0.0759P PS=0.65U PD=0.8U
* device instance $453 r0 *1 7.27,24.925 sky130_fd_pr__nfet_01v8
M$453 94 93 428 428 sky130_fd_pr__nfet_01v8 L=0.15U W=0.42U AS=0.1092P
+ AD=0.0609P PS=1.36U PD=0.71U
* device instance $454 r0 *1 7.71,24.925 sky130_fd_pr__nfet_01v8
M$454 454 428 94 94 sky130_fd_pr__nfet_01v8 L=0.15U W=0.42U AS=0.0609P
+ AD=0.0756P PS=0.71U PD=0.78U
* device instance $455 r0 *1 8.22,24.925 sky130_fd_pr__nfet_01v8
M$455 427 448 454 454 sky130_fd_pr__nfet_01v8 L=0.15U W=0.42U AS=0.0756P
+ AD=0.1446P PS=0.78U PD=1.18U
* device instance $456 r0 *1 10.1,24.925 sky130_fd_pr__nfet_01v8
M$456 94 430 456 456 sky130_fd_pr__nfet_01v8 L=0.15U W=0.42U AS=0.0759P
+ AD=0.12095P PS=0.8U PD=1.085U
* device instance $457 r0 *1 10.695,25.035 sky130_fd_pr__nfet_01v8
M$457 430 429 94 94 sky130_fd_pr__nfet_01v8 L=0.15U W=0.64U AS=0.12095P
+ AD=0.1664P PS=1.085U PD=1.8U
* device instance $458 r0 *1 12.12,24.895 sky130_fd_pr__nfet_01v8
M$458 431 426 457 457 sky130_fd_pr__nfet_01v8 L=0.15U W=0.36U AS=0.0678P
+ AD=0.0684P PS=0.755U PD=0.74U
* device instance $459 r0 *1 12.65,24.895 sky130_fd_pr__nfet_01v8
M$459 459 425 431 431 sky130_fd_pr__nfet_01v8 L=0.15U W=0.36U AS=0.0684P
+ AD=0.066P PS=0.74U PD=0.745U
* device instance $460 r0 *1 11.635,24.925 sky130_fd_pr__nfet_01v8
M$460 457 430 94 94 sky130_fd_pr__nfet_01v8 L=0.15U W=0.42U AS=0.1092P
+ AD=0.0678P PS=1.36U PD=0.755U
* device instance $461 r0 *1 13.125,24.925 sky130_fd_pr__nfet_01v8
M$461 94 448 459 459 sky130_fd_pr__nfet_01v8 L=0.15U W=0.42U AS=0.066P
+ AD=0.1092P PS=0.745U PD=1.36U
* device instance $462 r0 *1 14.065,24.925 sky130_fd_pr__nfet_01v8
M$462 94 431 448 448 sky130_fd_pr__nfet_01v8 L=0.15U W=0.42U AS=0.1092P
+ AD=0.10025P PS=1.36U PD=0.985U
* device instance $463 r0 *1 14.55,25.04 sky130_fd_pr__nfet_01v8
M$463 354 431 94 94 sky130_fd_pr__nfet_01v8 L=0.15U W=0.65U AS=0.10025P
+ AD=0.182P PS=0.985U PD=1.86U
* device instance $464 r0 *1 18.185,24.925 sky130_fd_pr__nfet_01v8
M$464 94 354 432 432 sky130_fd_pr__nfet_01v8 L=0.15U W=0.42U AS=0.1092P
+ AD=0.10025P PS=1.36U PD=0.985U
* device instance $465 r0 *1 18.67,25.04 sky130_fd_pr__nfet_01v8
M$465 433 449 94 94 sky130_fd_pr__nfet_01v8 L=0.15U W=0.65U AS=0.10025P
+ AD=0.08775P PS=0.985U PD=0.92U
* device instance $466 r0 *1 19.09,25.04 sky130_fd_pr__nfet_01v8
M$466 94 432 433 433 sky130_fd_pr__nfet_01v8 L=0.15U W=0.65U AS=0.08775P
+ AD=0.169P PS=0.92U PD=1.82U
* device instance $467 r0 *1 20.25,25.04 sky130_fd_pr__nfet_01v8
M$467 384 433 94 94 sky130_fd_pr__nfet_01v8 L=0.15U W=0.65U AS=0.169P
+ AD=0.08775P PS=1.82U PD=0.92U
* device instance $468 r0 *1 20.67,25.04 sky130_fd_pr__nfet_01v8
M$468 94 337 384 384 sky130_fd_pr__nfet_01v8 L=0.15U W=0.65U AS=0.08775P
+ AD=0.169P PS=0.92U PD=1.82U
* device instance $469 r0 *1 21.865,24.925 sky130_fd_pr__nfet_01v8
M$469 94 449 434 434 sky130_fd_pr__nfet_01v8 L=0.15U W=0.42U AS=0.1092P
+ AD=0.10025P PS=1.36U PD=0.985U
* device instance $470 r0 *1 22.35,25.04 sky130_fd_pr__nfet_01v8
M$470 337 354 94 94 sky130_fd_pr__nfet_01v8 L=0.15U W=0.65U AS=0.10025P
+ AD=0.08775P PS=0.985U PD=0.92U
* device instance $471 r0 *1 22.77,25.04 sky130_fd_pr__nfet_01v8
M$471 94 434 337 337 sky130_fd_pr__nfet_01v8 L=0.15U W=0.65U AS=0.08775P
+ AD=0.169P PS=0.92U PD=1.82U
* device instance $472 r0 *1 34.985,25.04 sky130_fd_pr__nfet_01v8
M$472 450 436 435 435 sky130_fd_pr__nfet_01v8 L=0.15U W=1.3U AS=0.2665P
+ AD=0.1755P PS=2.77U PD=1.84U
* device instance $474 r0 *1 35.825,25.04 sky130_fd_pr__nfet_01v8
M$474 94 437 435 435 sky130_fd_pr__nfet_01v8 L=0.15U W=1.3U AS=0.1755P
+ AD=0.26975P PS=1.84U PD=2.78U
* device instance $476 r0 *1 37.225,25.04 sky130_fd_pr__nfet_01v8
M$476 438 437 94 94 sky130_fd_pr__nfet_01v8 L=0.15U W=1.3U AS=0.26975P
+ AD=0.1755P PS=2.78U PD=1.84U
* device instance $478 r0 *1 38.065,25.04 sky130_fd_pr__nfet_01v8
M$478 438 436 94 94 sky130_fd_pr__nfet_01v8 L=0.15U W=1.3U AS=0.186875P
+ AD=0.268125P PS=1.875U PD=2.775U
* device instance $480 r0 *1 39.46,25.04 sky130_fd_pr__nfet_01v8
M$480 438 450 439 439 sky130_fd_pr__nfet_01v8 L=0.15U W=1.3U AS=0.25675P
+ AD=0.25675P PS=2.74U PD=2.74U
* device instance $482 r0 *1 46.47,25.04 sky130_fd_pr__nfet_01v8
M$482 94 329 440 440 sky130_fd_pr__nfet_01v8 L=0.15U W=1.95U AS=0.3445P
+ AD=0.26325P PS=3.66U PD=2.76U
* device instance $485 r0 *1 47.73,25.04 sky130_fd_pr__nfet_01v8
M$485 441 440 94 94 sky130_fd_pr__nfet_01v8 L=0.15U W=3.9U AS=0.5265P
+ AD=0.5265P PS=5.52U PD=5.52U
* device instance $491 r0 *1 50.25,25.04 sky130_fd_pr__nfet_01v8
M$491 442 441 94 94 sky130_fd_pr__nfet_01v8 L=0.15U W=10.4U AS=1.404P
+ AD=1.48525P PS=14.72U PD=15.62U
* device instance $507 r0 *1 61.26,24.925 sky130_fd_pr__nfet_01v8
M$507 460 462 443 443 sky130_fd_pr__nfet_01v8 L=0.15U W=0.42U AS=0.1113P
+ AD=0.0441P PS=1.37U PD=0.63U
* device instance $508 r0 *1 61.62,24.925 sky130_fd_pr__nfet_01v8
M$508 94 109 460 460 sky130_fd_pr__nfet_01v8 L=0.15U W=0.42U AS=0.0441P
+ AD=0.0966P PS=0.63U PD=0.88U
* device instance $509 r0 *1 62.23,24.925 sky130_fd_pr__nfet_01v8
M$509 388 443 94 94 sky130_fd_pr__nfet_01v8 L=0.15U W=0.42U AS=0.0966P
+ AD=0.1113P PS=0.88U PD=1.37U
* device instance $510 r0 *1 64.365,24.925 sky130_fd_pr__nfet_01v8
M$510 94 333 312 312 sky130_fd_pr__nfet_01v8 L=0.15U W=0.42U AS=0.1092P
+ AD=0.1197P PS=1.36U PD=1.41U
* device instance $511 r0 *1 65.33,25.155 sky130_fd_pr__nfet_01v8
M$511 451 339 94 94 sky130_fd_pr__nfet_01v8 L=0.15U W=0.42U AS=0.10025P
+ AD=0.1092P PS=0.985U PD=1.36U
* device instance $512 r0 *1 65.815,25.04 sky130_fd_pr__nfet_01v8
M$512 458 341 94 94 sky130_fd_pr__nfet_01v8 L=0.15U W=0.65U AS=0.10025P
+ AD=0.08775P PS=0.985U PD=0.92U
* device instance $513 r0 *1 66.235,25.04 sky130_fd_pr__nfet_01v8
M$513 338 451 458 458 sky130_fd_pr__nfet_01v8 L=0.15U W=0.65U AS=0.08775P
+ AD=0.169P PS=0.92U PD=1.82U
* device instance $514 r0 *1 68.175,24.925 sky130_fd_pr__nfet_01v8
M$514 455 71 94 94 sky130_fd_pr__nfet_01v8 L=0.15U W=0.42U AS=0.11285P
+ AD=0.0693P PS=1.045U PD=0.75U
* device instance $515 r0 *1 68.655,24.925 sky130_fd_pr__nfet_01v8
M$515 444 445 455 455 sky130_fd_pr__nfet_01v8 L=0.15U W=0.42U AS=0.0693P
+ AD=0.09975P PS=0.75U PD=0.895U
* device instance $516 r0 *1 69.28,24.925 sky130_fd_pr__nfet_01v8
M$516 453 339 444 444 sky130_fd_pr__nfet_01v8 L=0.15U W=0.42U AS=0.09975P
+ AD=0.0693P PS=0.895U PD=0.75U
* device instance $517 r0 *1 69.76,24.925 sky130_fd_pr__nfet_01v8
M$517 94 446 453 453 sky130_fd_pr__nfet_01v8 L=0.15U W=0.42U AS=0.0693P
+ AD=0.1449P PS=0.75U PD=1.11U
* device instance $518 r0 *1 70.6,24.925 sky130_fd_pr__nfet_01v8
M$518 446 71 94 94 sky130_fd_pr__nfet_01v8 L=0.15U W=0.42U AS=0.1449P
+ AD=0.1092P PS=1.11U PD=1.36U
* device instance $519 r0 *1 67.63,25.04 sky130_fd_pr__nfet_01v8
M$519 94 444 390 390 sky130_fd_pr__nfet_01v8 L=0.15U W=0.65U AS=0.169P
+ AD=0.11285P PS=1.82U PD=1.045U
* device instance $520 r0 *1 5.07,29.36 sky130_fd_pr__nfet_01v8
M$520 94 474 447 447 sky130_fd_pr__nfet_01v8 L=0.15U W=0.65U AS=0.169P
+ AD=0.11285P PS=1.82U PD=1.045U
* device instance $521 r0 *1 5.615,29.475 sky130_fd_pr__nfet_01v8
M$521 518 71 94 94 sky130_fd_pr__nfet_01v8 L=0.15U W=0.42U AS=0.11285P
+ AD=0.0693P PS=1.045U PD=0.75U
* device instance $522 r0 *1 6.095,29.475 sky130_fd_pr__nfet_01v8
M$522 474 461 518 518 sky130_fd_pr__nfet_01v8 L=0.15U W=0.42U AS=0.0693P
+ AD=0.09975P PS=0.75U PD=0.895U
* device instance $523 r0 *1 6.72,29.475 sky130_fd_pr__nfet_01v8
M$523 519 449 474 474 sky130_fd_pr__nfet_01v8 L=0.15U W=0.42U AS=0.09975P
+ AD=0.0693P PS=0.895U PD=0.75U
* device instance $524 r0 *1 7.2,29.475 sky130_fd_pr__nfet_01v8
M$524 94 514 519 519 sky130_fd_pr__nfet_01v8 L=0.15U W=0.42U AS=0.0693P
+ AD=0.1449P PS=0.75U PD=1.11U
* device instance $525 r0 *1 8.04,29.475 sky130_fd_pr__nfet_01v8
M$525 514 71 94 94 sky130_fd_pr__nfet_01v8 L=0.15U W=0.42U AS=0.1449P
+ AD=0.1092P PS=1.11U PD=1.36U
* device instance $526 r0 *1 9.21,29.475 sky130_fd_pr__nfet_01v8
M$526 94 31 475 475 sky130_fd_pr__nfet_01v8 L=0.15U W=0.42U AS=0.1092P
+ AD=0.0567P PS=1.36U PD=0.69U
* device instance $527 r0 *1 9.63,29.475 sky130_fd_pr__nfet_01v8
M$527 476 475 94 94 sky130_fd_pr__nfet_01v8 L=0.15U W=0.42U AS=0.0567P
+ AD=0.1092P PS=0.69U PD=1.36U
* device instance $528 r0 *1 10.57,29.475 sky130_fd_pr__nfet_01v8
M$528 521 405 478 478 sky130_fd_pr__nfet_01v8 L=0.15U W=0.42U AS=0.1092P
+ AD=0.0441P PS=1.36U PD=0.63U
* device instance $529 r0 *1 10.93,29.475 sky130_fd_pr__nfet_01v8
M$529 94 16 521 521 sky130_fd_pr__nfet_01v8 L=0.15U W=0.42U AS=0.0441P
+ AD=0.1092P PS=0.63U PD=1.36U
* device instance $530 r0 *1 11.87,29.475 sky130_fd_pr__nfet_01v8
M$530 94 16 477 477 sky130_fd_pr__nfet_01v8 L=0.15U W=0.42U AS=0.1092P
+ AD=0.0609P PS=1.36U PD=0.71U
* device instance $531 r0 *1 12.31,29.475 sky130_fd_pr__nfet_01v8
M$531 523 477 94 94 sky130_fd_pr__nfet_01v8 L=0.15U W=0.42U AS=0.0609P
+ AD=0.0756P PS=0.71U PD=0.78U
* device instance $532 r0 *1 12.82,29.475 sky130_fd_pr__nfet_01v8
M$532 478 482 523 523 sky130_fd_pr__nfet_01v8 L=0.15U W=0.42U AS=0.0756P
+ AD=0.1446P PS=0.78U PD=1.18U
* device instance $533 r0 *1 13.73,29.505 sky130_fd_pr__nfet_01v8
M$533 479 475 478 478 sky130_fd_pr__nfet_01v8 L=0.15U W=0.36U AS=0.1446P
+ AD=0.0522P PS=1.18U PD=0.65U
* device instance $534 r0 *1 14.17,29.505 sky130_fd_pr__nfet_01v8
M$534 479 476 524 524 sky130_fd_pr__nfet_01v8 L=0.15U W=0.36U AS=0.0759P
+ AD=0.0522P PS=0.8U PD=0.65U
* device instance $535 r0 *1 14.7,29.475 sky130_fd_pr__nfet_01v8
M$535 524 480 94 94 sky130_fd_pr__nfet_01v8 L=0.15U W=0.42U AS=0.12095P
+ AD=0.0759P PS=1.085U PD=0.8U
* device instance $536 r0 *1 15.295,29.365 sky130_fd_pr__nfet_01v8
M$536 480 479 94 94 sky130_fd_pr__nfet_01v8 L=0.15U W=0.64U AS=0.12095P
+ AD=0.1664P PS=1.085U PD=1.8U
* device instance $537 r0 *1 16.235,29.475 sky130_fd_pr__nfet_01v8
M$537 527 480 94 94 sky130_fd_pr__nfet_01v8 L=0.15U W=0.42U AS=0.1092P
+ AD=0.0678P PS=1.36U PD=0.755U
* device instance $538 r0 *1 16.72,29.505 sky130_fd_pr__nfet_01v8
M$538 481 476 527 527 sky130_fd_pr__nfet_01v8 L=0.15U W=0.36U AS=0.0678P
+ AD=0.0684P PS=0.755U PD=0.74U
* device instance $539 r0 *1 17.25,29.505 sky130_fd_pr__nfet_01v8
M$539 481 475 529 529 sky130_fd_pr__nfet_01v8 L=0.15U W=0.36U AS=0.066P
+ AD=0.0684P PS=0.745U PD=0.74U
* device instance $540 r0 *1 17.725,29.475 sky130_fd_pr__nfet_01v8
M$540 94 482 529 529 sky130_fd_pr__nfet_01v8 L=0.15U W=0.42U AS=0.066P
+ AD=0.1092P PS=0.745U PD=1.36U
* device instance $541 r0 *1 18.665,29.475 sky130_fd_pr__nfet_01v8
M$541 482 481 94 94 sky130_fd_pr__nfet_01v8 L=0.15U W=0.42U AS=0.10025P
+ AD=0.1092P PS=0.985U PD=1.36U
* device instance $542 r0 *1 19.15,29.36 sky130_fd_pr__nfet_01v8
M$542 449 481 94 94 sky130_fd_pr__nfet_01v8 L=0.15U W=0.65U AS=0.10025P
+ AD=0.182P PS=0.985U PD=1.86U
* device instance $543 r0 *1 26.26,30.365 sky130_fd_pr__nfet_01v8
M$543 94 433 533 533 sky130_fd_pr__nfet_01v8 L=0.15U W=0.42U AS=0.1113P
+ AD=0.0588P PS=1.37U PD=0.7U
* device instance $544 r0 *1 26.69,30.365 sky130_fd_pr__nfet_01v8
M$544 533 336 94 94 sky130_fd_pr__nfet_01v8 L=0.15U W=0.42U AS=0.0588P
+ AD=0.0588P PS=0.7U PD=0.7U
* device instance $545 r0 *1 27.12,30.365 sky130_fd_pr__nfet_01v8
M$545 543 495 533 533 sky130_fd_pr__nfet_01v8 L=0.15U W=0.42U AS=0.0588P
+ AD=0.1113P PS=0.7U PD=1.37U
* device instance $546 r0 *1 30.91,29.36 sky130_fd_pr__nfet_01v8
M$546 515 336 94 94 sky130_fd_pr__nfet_01v8 L=0.15U W=2.6U AS=0.44525P
+ AD=0.351P PS=4.62U PD=3.68U
* device instance $550 r0 *1 32.59,29.36 sky130_fd_pr__nfet_01v8
M$550 515 433 94 94 sky130_fd_pr__nfet_01v8 L=0.15U W=2.6U AS=0.351P AD=0.3575P
+ PS=3.68U PD=3.7U
* device instance $554 r0 *1 34.29,29.36 sky130_fd_pr__nfet_01v8
M$554 515 495 94 94 sky130_fd_pr__nfet_01v8 L=0.15U W=2.6U AS=0.3575P
+ AD=0.44525P PS=3.7U PD=4.62U
* device instance $558 r0 *1 31.77,30.48 sky130_fd_pr__nfet_01v8
M$558 539 544 94 94 sky130_fd_pr__nfet_01v8 L=0.15U W=0.65U AS=0.169P
+ AD=0.08775P PS=1.82U PD=0.92U
* device instance $559 r0 *1 32.19,30.48 sky130_fd_pr__nfet_01v8
M$559 437 496 539 539 sky130_fd_pr__nfet_01v8 L=0.15U W=0.65U AS=0.08775P
+ AD=0.169P PS=0.92U PD=1.82U
* device instance $560 r0 *1 35.91,30.48 sky130_fd_pr__nfet_01v8
M$560 540 263 94 94 sky130_fd_pr__nfet_01v8 L=0.15U W=0.65U AS=0.169P
+ AD=0.08775P PS=1.82U PD=0.92U
* device instance $561 r0 *1 36.33,30.48 sky130_fd_pr__nfet_01v8
M$561 436 484 540 540 sky130_fd_pr__nfet_01v8 L=0.15U W=0.65U AS=0.08775P
+ AD=0.169P PS=0.92U PD=1.82U
* device instance $562 r0 *1 36.53,29.36 sky130_fd_pr__nfet_01v8
M$562 515 496 517 517 sky130_fd_pr__nfet_01v8 L=0.15U W=2.6U AS=0.44525P
+ AD=0.351P PS=4.62U PD=3.68U
* device instance $566 r0 *1 38.21,29.36 sky130_fd_pr__nfet_01v8
M$566 279 484 517 517 sky130_fd_pr__nfet_01v8 L=0.15U W=2.6U AS=0.351P
+ AD=0.44525P PS=3.68U PD=4.62U
* device instance $570 r0 *1 38.19,30.48 sky130_fd_pr__nfet_01v8
M$570 94 165 535 535 sky130_fd_pr__nfet_01v8 L=0.15U W=0.65U AS=0.169P
+ AD=0.10725P PS=1.82U PD=0.98U
* device instance $571 r0 *1 38.67,30.48 sky130_fd_pr__nfet_01v8
M$571 541 366 94 94 sky130_fd_pr__nfet_01v8 L=0.15U W=0.65U AS=0.10725P
+ AD=0.06825P PS=0.98U PD=0.86U
* device instance $572 r0 *1 39.03,30.48 sky130_fd_pr__nfet_01v8
M$572 535 90 541 541 sky130_fd_pr__nfet_01v8 L=0.15U W=0.65U AS=0.06825P
+ AD=0.169P PS=0.86U PD=1.82U
* device instance $573 r0 *1 39.97,30.48 sky130_fd_pr__nfet_01v8
M$573 542 138 535 535 sky130_fd_pr__nfet_01v8 L=0.15U W=0.65U AS=0.169P
+ AD=0.10725P PS=1.82U PD=0.98U
* device instance $574 r0 *1 40.45,30.48 sky130_fd_pr__nfet_01v8
M$574 94 439 542 542 sky130_fd_pr__nfet_01v8 L=0.15U W=0.65U AS=0.10725P
+ AD=0.102375P PS=0.98U PD=0.965U
* device instance $575 r0 *1 40.915,30.48 sky130_fd_pr__nfet_01v8
M$575 547 535 94 94 sky130_fd_pr__nfet_01v8 L=0.15U W=0.65U AS=0.102375P
+ AD=0.169P PS=0.965U PD=1.82U
* device instance $576 r0 *1 41.87,29.245 sky130_fd_pr__nfet_01v8
M$576 94 497 498 498 sky130_fd_pr__nfet_01v8 L=0.15U W=0.42U AS=0.1092P
+ AD=0.10025P PS=1.36U PD=0.985U
* device instance $577 r0 *1 42.355,29.36 sky130_fd_pr__nfet_01v8
M$577 532 366 94 94 sky130_fd_pr__nfet_01v8 L=0.15U W=0.65U AS=0.10025P
+ AD=0.08775P PS=0.985U PD=0.92U
* device instance $578 r0 *1 42.775,29.36 sky130_fd_pr__nfet_01v8
M$578 263 498 532 532 sky130_fd_pr__nfet_01v8 L=0.15U W=0.65U AS=0.08775P
+ AD=0.169P PS=0.92U PD=1.82U
* device instance $579 r0 *1 42.285,30.365 sky130_fd_pr__nfet_01v8
M$579 94 536 484 484 sky130_fd_pr__nfet_01v8 L=0.15U W=0.42U AS=0.1092P
+ AD=0.1197P PS=1.36U PD=1.41U
* device instance $580 r0 *1 44.17,29.36 sky130_fd_pr__nfet_01v8
M$580 94 485 386 386 sky130_fd_pr__nfet_01v8 L=0.15U W=0.65U AS=0.169P
+ AD=0.11285P PS=1.82U PD=1.045U
* device instance $581 r0 *1 44.715,29.475 sky130_fd_pr__nfet_01v8
M$581 531 71 94 94 sky130_fd_pr__nfet_01v8 L=0.15U W=0.42U AS=0.11285P
+ AD=0.0693P PS=1.045U PD=0.75U
* device instance $582 r0 *1 45.195,29.475 sky130_fd_pr__nfet_01v8
M$582 485 499 531 531 sky130_fd_pr__nfet_01v8 L=0.15U W=0.42U AS=0.0693P
+ AD=0.09975P PS=0.75U PD=0.895U
* device instance $583 r0 *1 45.82,29.475 sky130_fd_pr__nfet_01v8
M$583 530 497 485 485 sky130_fd_pr__nfet_01v8 L=0.15U W=0.42U AS=0.09975P
+ AD=0.0693P PS=0.895U PD=0.75U
* device instance $584 r0 *1 46.3,29.475 sky130_fd_pr__nfet_01v8
M$584 94 516 530 530 sky130_fd_pr__nfet_01v8 L=0.15U W=0.42U AS=0.0693P
+ AD=0.1449P PS=0.75U PD=1.11U
* device instance $585 r0 *1 47.14,29.475 sky130_fd_pr__nfet_01v8
M$585 516 71 94 94 sky130_fd_pr__nfet_01v8 L=0.15U W=0.42U AS=0.1449P
+ AD=0.1092P PS=1.11U PD=1.36U
* device instance $586 r0 *1 44.865,30.365 sky130_fd_pr__nfet_01v8
M$586 94 497 537 537 sky130_fd_pr__nfet_01v8 L=0.15U W=0.42U AS=0.1092P
+ AD=0.10025P PS=1.36U PD=0.985U
* device instance $587 r0 *1 45.35,30.48 sky130_fd_pr__nfet_01v8
M$587 536 366 94 94 sky130_fd_pr__nfet_01v8 L=0.15U W=0.65U AS=0.10025P
+ AD=0.08775P PS=0.985U PD=0.92U
* device instance $588 r0 *1 45.77,30.48 sky130_fd_pr__nfet_01v8
M$588 94 537 536 536 sky130_fd_pr__nfet_01v8 L=0.15U W=0.65U AS=0.08775P
+ AD=0.349375P PS=0.92U PD=1.725U
* device instance $589 r0 *1 46.995,30.48 sky130_fd_pr__nfet_01v8
M$589 538 997 94 94 sky130_fd_pr__nfet_01v8 L=0.15U W=1.3U AS=0.437125P
+ AD=0.1755P PS=2.645U PD=1.84U
* device instance $591 r0 *1 47.835,30.48 sky130_fd_pr__nfet_01v8
M$591 138 538 94 94 sky130_fd_pr__nfet_01v8 L=0.15U W=3.9U AS=0.5265P
+ AD=0.60775P PS=5.52U PD=6.42U
* device instance $597 r0 *1 60.73,29.475 sky130_fd_pr__nfet_01v8
M$597 94 329 486 486 sky130_fd_pr__nfet_01v8 L=0.15U W=0.42U AS=0.1092P
+ AD=0.0567P PS=1.36U PD=0.69U
* device instance $598 r0 *1 61.15,29.475 sky130_fd_pr__nfet_01v8
M$598 487 486 94 94 sky130_fd_pr__nfet_01v8 L=0.15U W=0.42U AS=0.0567P
+ AD=0.1092P PS=0.69U PD=1.36U
* device instance $599 r0 *1 62.09,29.475 sky130_fd_pr__nfet_01v8
M$599 528 408 489 489 sky130_fd_pr__nfet_01v8 L=0.15U W=0.42U AS=0.1092P
+ AD=0.0441P PS=1.36U PD=0.63U
* device instance $600 r0 *1 62.45,29.475 sky130_fd_pr__nfet_01v8
M$600 94 16 528 528 sky130_fd_pr__nfet_01v8 L=0.15U W=0.42U AS=0.0441P
+ AD=0.1092P PS=0.63U PD=1.36U
* device instance $601 r0 *1 63.39,29.475 sky130_fd_pr__nfet_01v8
M$601 94 16 488 488 sky130_fd_pr__nfet_01v8 L=0.15U W=0.42U AS=0.1092P
+ AD=0.0609P PS=1.36U PD=0.71U
* device instance $602 r0 *1 63.83,29.475 sky130_fd_pr__nfet_01v8
M$602 526 488 94 94 sky130_fd_pr__nfet_01v8 L=0.15U W=0.42U AS=0.0609P
+ AD=0.0756P PS=0.71U PD=0.78U
* device instance $603 r0 *1 64.34,29.475 sky130_fd_pr__nfet_01v8
M$603 489 493 526 526 sky130_fd_pr__nfet_01v8 L=0.15U W=0.42U AS=0.0756P
+ AD=0.1446P PS=0.78U PD=1.18U
* device instance $604 r0 *1 65.25,29.505 sky130_fd_pr__nfet_01v8
M$604 490 486 489 489 sky130_fd_pr__nfet_01v8 L=0.15U W=0.36U AS=0.1446P
+ AD=0.0522P PS=1.18U PD=0.65U
* device instance $605 r0 *1 65.69,29.505 sky130_fd_pr__nfet_01v8
M$605 490 487 525 525 sky130_fd_pr__nfet_01v8 L=0.15U W=0.36U AS=0.0759P
+ AD=0.0522P PS=0.8U PD=0.65U
* device instance $606 r0 *1 66.22,29.475 sky130_fd_pr__nfet_01v8
M$606 525 491 94 94 sky130_fd_pr__nfet_01v8 L=0.15U W=0.42U AS=0.12095P
+ AD=0.0759P PS=1.085U PD=0.8U
* device instance $607 r0 *1 66.815,29.365 sky130_fd_pr__nfet_01v8
M$607 491 490 94 94 sky130_fd_pr__nfet_01v8 L=0.15U W=0.64U AS=0.12095P
+ AD=0.1664P PS=1.085U PD=1.8U
* device instance $608 r0 *1 67.755,29.475 sky130_fd_pr__nfet_01v8
M$608 522 491 94 94 sky130_fd_pr__nfet_01v8 L=0.15U W=0.42U AS=0.1092P
+ AD=0.0678P PS=1.36U PD=0.755U
* device instance $609 r0 *1 68.24,29.505 sky130_fd_pr__nfet_01v8
M$609 492 487 522 522 sky130_fd_pr__nfet_01v8 L=0.15U W=0.36U AS=0.0678P
+ AD=0.0684P PS=0.755U PD=0.74U
* device instance $610 r0 *1 68.77,29.505 sky130_fd_pr__nfet_01v8
M$610 492 486 520 520 sky130_fd_pr__nfet_01v8 L=0.15U W=0.36U AS=0.066P
+ AD=0.0684P PS=0.745U PD=0.74U
* device instance $611 r0 *1 69.245,29.475 sky130_fd_pr__nfet_01v8
M$611 94 493 520 520 sky130_fd_pr__nfet_01v8 L=0.15U W=0.42U AS=0.066P
+ AD=0.1092P PS=0.745U PD=1.36U
* device instance $612 r0 *1 70.185,29.475 sky130_fd_pr__nfet_01v8
M$612 493 492 94 94 sky130_fd_pr__nfet_01v8 L=0.15U W=0.42U AS=0.10025P
+ AD=0.1092P PS=0.985U PD=1.36U
* device instance $613 r0 *1 70.67,29.36 sky130_fd_pr__nfet_01v8
M$613 339 492 94 94 sky130_fd_pr__nfet_01v8 L=0.15U W=0.65U AS=0.10025P
+ AD=0.182P PS=0.985U PD=1.86U
* device instance $614 r0 *1 13.765,34.915 sky130_fd_pr__nfet_01v8
M$614 94 552 553 553 sky130_fd_pr__nfet_01v8 L=0.15U W=0.42U AS=0.1092P
+ AD=0.1197P PS=1.36U PD=1.41U
* device instance $615 r0 *1 27.155,34.8 sky130_fd_pr__nfet_01v8
M$615 580 544 555 555 sky130_fd_pr__nfet_01v8 L=0.15U W=0.65U AS=0.17225P
+ AD=0.06825P PS=1.83U PD=0.86U
* device instance $616 r0 *1 27.515,34.8 sky130_fd_pr__nfet_01v8
M$616 94 543 580 580 sky130_fd_pr__nfet_01v8 L=0.15U W=0.65U AS=0.06825P
+ AD=0.138125P PS=0.86U PD=1.075U
* device instance $617 r0 *1 28.09,34.8 sky130_fd_pr__nfet_01v8
M$617 554 555 94 94 sky130_fd_pr__nfet_01v8 L=0.15U W=2.6U AS=0.411125P
+ AD=0.45825P PS=3.865U PD=4.66U
* device instance $621 r0 *1 28.08,30.395 sky130_fd_pr__nfet_01v8
M$621 94 336 534 534 sky130_fd_pr__nfet_01v8 L=0.15U W=0.42U AS=0.1092P
+ AD=0.0567P PS=1.36U PD=0.69U
* device instance $622 r0 *1 28.5,30.395 sky130_fd_pr__nfet_01v8
M$622 534 433 94 94 sky130_fd_pr__nfet_01v8 L=0.15U W=0.42U AS=0.0567P
+ AD=0.0567P PS=0.69U PD=0.69U
* device instance $623 r0 *1 28.92,30.395 sky130_fd_pr__nfet_01v8
M$623 534 495 94 94 sky130_fd_pr__nfet_01v8 L=0.15U W=0.42U AS=0.101875P
+ AD=0.0567P PS=0.99U PD=0.69U
* device instance $624 r0 *1 29.41,30.48 sky130_fd_pr__nfet_01v8
M$624 544 534 94 94 sky130_fd_pr__nfet_01v8 L=0.15U W=0.65U AS=0.101875P
+ AD=0.182P PS=0.99U PD=1.86U
* device instance $625 r0 *1 40.49,34.915 sky130_fd_pr__nfet_01v8
M$625 94 329 556 556 sky130_fd_pr__nfet_01v8 L=0.15U W=0.42U AS=0.1092P
+ AD=0.0567P PS=1.36U PD=0.69U
* device instance $626 r0 *1 40.91,34.915 sky130_fd_pr__nfet_01v8
M$626 557 556 94 94 sky130_fd_pr__nfet_01v8 L=0.15U W=0.42U AS=0.0567P
+ AD=0.1092P PS=0.69U PD=1.36U
* device instance $627 r0 *1 41.85,34.915 sky130_fd_pr__nfet_01v8
M$627 584 547 558 558 sky130_fd_pr__nfet_01v8 L=0.15U W=0.42U AS=0.1092P
+ AD=0.0441P PS=1.36U PD=0.63U
* device instance $628 r0 *1 42.21,34.915 sky130_fd_pr__nfet_01v8
M$628 94 16 584 584 sky130_fd_pr__nfet_01v8 L=0.15U W=0.42U AS=0.0441P
+ AD=0.1092P PS=0.63U PD=1.36U
* device instance $629 r0 *1 43.15,34.915 sky130_fd_pr__nfet_01v8
M$629 94 16 559 559 sky130_fd_pr__nfet_01v8 L=0.15U W=0.42U AS=0.1092P
+ AD=0.0609P PS=1.36U PD=0.71U
* device instance $630 r0 *1 43.59,34.915 sky130_fd_pr__nfet_01v8
M$630 585 559 94 94 sky130_fd_pr__nfet_01v8 L=0.15U W=0.42U AS=0.0609P
+ AD=0.0756P PS=0.71U PD=0.78U
* device instance $631 r0 *1 44.1,34.915 sky130_fd_pr__nfet_01v8
M$631 558 563 585 585 sky130_fd_pr__nfet_01v8 L=0.15U W=0.42U AS=0.0756P
+ AD=0.1446P PS=0.78U PD=1.18U
* device instance $632 r0 *1 45.01,34.945 sky130_fd_pr__nfet_01v8
M$632 560 556 558 558 sky130_fd_pr__nfet_01v8 L=0.15U W=0.36U AS=0.1446P
+ AD=0.0522P PS=1.18U PD=0.65U
* device instance $633 r0 *1 45.45,34.945 sky130_fd_pr__nfet_01v8
M$633 560 557 583 583 sky130_fd_pr__nfet_01v8 L=0.15U W=0.36U AS=0.0759P
+ AD=0.0522P PS=0.8U PD=0.65U
* device instance $634 r0 *1 45.98,34.915 sky130_fd_pr__nfet_01v8
M$634 583 561 94 94 sky130_fd_pr__nfet_01v8 L=0.15U W=0.42U AS=0.12095P
+ AD=0.0759P PS=1.085U PD=0.8U
* device instance $635 r0 *1 46.575,34.805 sky130_fd_pr__nfet_01v8
M$635 561 560 94 94 sky130_fd_pr__nfet_01v8 L=0.15U W=0.64U AS=0.12095P
+ AD=0.1664P PS=1.085U PD=1.8U
* device instance $636 r0 *1 47.515,34.915 sky130_fd_pr__nfet_01v8
M$636 582 561 94 94 sky130_fd_pr__nfet_01v8 L=0.15U W=0.42U AS=0.1092P
+ AD=0.0678P PS=1.36U PD=0.755U
* device instance $637 r0 *1 48,34.945 sky130_fd_pr__nfet_01v8
M$637 562 557 582 582 sky130_fd_pr__nfet_01v8 L=0.15U W=0.36U AS=0.0678P
+ AD=0.0684P PS=0.755U PD=0.74U
* device instance $638 r0 *1 48.53,34.945 sky130_fd_pr__nfet_01v8
M$638 562 556 581 581 sky130_fd_pr__nfet_01v8 L=0.15U W=0.36U AS=0.066P
+ AD=0.0684P PS=0.745U PD=0.74U
* device instance $639 r0 *1 49.005,34.915 sky130_fd_pr__nfet_01v8
M$639 94 563 581 581 sky130_fd_pr__nfet_01v8 L=0.15U W=0.42U AS=0.066P
+ AD=0.1092P PS=0.745U PD=1.36U
* device instance $640 r0 *1 49.945,34.915 sky130_fd_pr__nfet_01v8
M$640 563 562 94 94 sky130_fd_pr__nfet_01v8 L=0.15U W=0.42U AS=0.10025P
+ AD=0.1092P PS=0.985U PD=1.36U
* device instance $641 r0 *1 50.43,34.8 sky130_fd_pr__nfet_01v8
M$641 497 562 94 94 sky130_fd_pr__nfet_01v8 L=0.15U W=0.65U AS=0.10025P
+ AD=0.182P PS=0.985U PD=1.86U
* device instance $642 r0 *1 59.81,34.8 sky130_fd_pr__nfet_01v8
M$642 94 305 564 564 sky130_fd_pr__nfet_01v8 L=0.15U W=0.65U AS=0.169P
+ AD=0.08775P PS=1.82U PD=0.92U
* device instance $643 r0 *1 60.23,34.8 sky130_fd_pr__nfet_01v8
M$643 577 564 94 94 sky130_fd_pr__nfet_01v8 L=0.15U W=2.6U AS=0.351P
+ AD=0.43225P PS=3.68U PD=4.58U
* device instance $647 r0 *1 62.57,34.8 sky130_fd_pr__nfet_01v8
M$647 94 572 565 565 sky130_fd_pr__nfet_01v8 L=0.15U W=0.65U AS=0.169P
+ AD=0.10725P PS=1.82U PD=0.98U
* device instance $648 r0 *1 63.05,34.8 sky130_fd_pr__nfet_01v8
M$648 579 573 94 94 sky130_fd_pr__nfet_01v8 L=0.15U W=0.65U AS=0.10725P
+ AD=0.06825P PS=0.98U PD=0.86U
* device instance $649 r0 *1 63.41,34.8 sky130_fd_pr__nfet_01v8
M$649 565 90 579 579 sky130_fd_pr__nfet_01v8 L=0.15U W=0.65U AS=0.06825P
+ AD=0.169P PS=0.86U PD=1.82U
* device instance $650 r0 *1 64.35,34.8 sky130_fd_pr__nfet_01v8
M$650 578 87 565 565 sky130_fd_pr__nfet_01v8 L=0.15U W=0.65U AS=0.169P
+ AD=0.10725P PS=1.82U PD=0.98U
* device instance $651 r0 *1 64.83,34.8 sky130_fd_pr__nfet_01v8
M$651 94 574 578 578 sky130_fd_pr__nfet_01v8 L=0.15U W=0.65U AS=0.10725P
+ AD=0.102375P PS=0.98U PD=0.965U
* device instance $652 r0 *1 65.295,34.8 sky130_fd_pr__nfet_01v8
M$652 568 565 94 94 sky130_fd_pr__nfet_01v8 L=0.15U W=0.65U AS=0.102375P
+ AD=0.169P PS=0.965U PD=1.82U
* device instance $653 r0 *1 8.75,35.92 sky130_fd_pr__nfet_01v8
M$653 94 598 586 586 sky130_fd_pr__nfet_01v8 L=0.15U W=0.65U AS=0.169P
+ AD=0.10725P PS=1.82U PD=0.98U
* device instance $654 r0 *1 9.23,35.92 sky130_fd_pr__nfet_01v8
M$654 603 599 94 94 sky130_fd_pr__nfet_01v8 L=0.15U W=0.65U AS=0.10725P
+ AD=0.06825P PS=0.98U PD=0.86U
* device instance $655 r0 *1 9.59,35.92 sky130_fd_pr__nfet_01v8
M$655 586 90 603 603 sky130_fd_pr__nfet_01v8 L=0.15U W=0.65U AS=0.06825P
+ AD=0.169P PS=0.86U PD=1.82U
* device instance $656 r0 *1 10.53,35.92 sky130_fd_pr__nfet_01v8
M$656 604 87 586 586 sky130_fd_pr__nfet_01v8 L=0.15U W=0.65U AS=0.169P
+ AD=0.10725P PS=1.82U PD=0.98U
* device instance $657 r0 *1 11.01,35.92 sky130_fd_pr__nfet_01v8
M$657 94 600 604 604 sky130_fd_pr__nfet_01v8 L=0.15U W=0.65U AS=0.10725P
+ AD=0.102375P PS=0.98U PD=0.965U
* device instance $658 r0 *1 11.475,35.92 sky130_fd_pr__nfet_01v8
M$658 587 586 94 94 sky130_fd_pr__nfet_01v8 L=0.15U W=0.65U AS=0.102375P
+ AD=0.169P PS=0.965U PD=1.82U
* device instance $659 r0 *1 12.53,35.805 sky130_fd_pr__nfet_01v8
M$659 607 553 588 588 sky130_fd_pr__nfet_01v8 L=0.15U W=0.42U AS=0.1092P
+ AD=0.0441P PS=1.36U PD=0.63U
* device instance $660 r0 *1 12.89,35.805 sky130_fd_pr__nfet_01v8
M$660 94 589 607 607 sky130_fd_pr__nfet_01v8 L=0.15U W=0.42U AS=0.0441P
+ AD=0.0567P PS=0.63U PD=0.69U
* device instance $661 r0 *1 13.31,35.805 sky130_fd_pr__nfet_01v8
M$661 608 589 94 94 sky130_fd_pr__nfet_01v8 L=0.15U W=0.42U AS=0.0567P
+ AD=0.0441P PS=0.69U PD=0.63U
* device instance $662 r0 *1 13.67,35.805 sky130_fd_pr__nfet_01v8
M$662 588 590 608 608 sky130_fd_pr__nfet_01v8 L=0.15U W=0.42U AS=0.0441P
+ AD=0.0567P PS=0.63U PD=0.69U
* device instance $663 r0 *1 14.09,35.805 sky130_fd_pr__nfet_01v8
M$663 611 590 588 588 sky130_fd_pr__nfet_01v8 L=0.15U W=0.42U AS=0.0567P
+ AD=0.0441P PS=0.69U PD=0.63U
* device instance $664 r0 *1 14.45,35.805 sky130_fd_pr__nfet_01v8
M$664 94 553 611 611 sky130_fd_pr__nfet_01v8 L=0.15U W=0.42U AS=0.0441P
+ AD=0.162225P PS=0.63U PD=1.25U
* device instance $665 r0 *1 15.2,35.92 sky130_fd_pr__nfet_01v8
M$665 334 588 94 94 sky130_fd_pr__nfet_01v8 L=0.15U W=1.3U AS=0.249975P
+ AD=0.26325P PS=2.17U PD=2.76U
* device instance $667 r0 *1 31.705,35.805 sky130_fd_pr__nfet_01v8
M$667 94 601 495 495 sky130_fd_pr__nfet_01v8 L=0.15U W=0.42U AS=0.1092P
+ AD=0.1197P PS=1.36U PD=1.41U
* device instance $668 r0 *1 34.05,36.035 sky130_fd_pr__nfet_01v8
M$668 591 629 94 94 sky130_fd_pr__nfet_01v8 L=0.15U W=0.42U AS=0.10025P
+ AD=0.1092P PS=0.985U PD=1.36U
* device instance $669 r0 *1 34.535,35.92 sky130_fd_pr__nfet_01v8
M$669 610 602 94 94 sky130_fd_pr__nfet_01v8 L=0.15U W=0.65U AS=0.10025P
+ AD=0.08775P PS=0.985U PD=0.92U
* device instance $670 r0 *1 34.955,35.92 sky130_fd_pr__nfet_01v8
M$670 496 591 610 610 sky130_fd_pr__nfet_01v8 L=0.15U W=0.65U AS=0.08775P
+ AD=0.169P PS=0.92U PD=1.82U
* device instance $671 r0 *1 59.42,35.805 sky130_fd_pr__nfet_01v8
M$671 609 614 592 592 sky130_fd_pr__nfet_01v8 L=0.15U W=0.42U AS=0.1113P
+ AD=0.0441P PS=1.37U PD=0.63U
* device instance $672 r0 *1 59.78,35.805 sky130_fd_pr__nfet_01v8
M$672 94 109 609 609 sky130_fd_pr__nfet_01v8 L=0.15U W=0.42U AS=0.0441P
+ AD=0.0966P PS=0.63U PD=0.88U
* device instance $673 r0 *1 60.39,35.805 sky130_fd_pr__nfet_01v8
M$673 572 592 94 94 sky130_fd_pr__nfet_01v8 L=0.15U W=0.42U AS=0.0966P
+ AD=0.1113P PS=0.88U PD=1.37U
* device instance $674 r0 *1 61.67,35.92 sky130_fd_pr__nfet_01v8
M$674 606 577 94 94 sky130_fd_pr__nfet_01v8 L=0.15U W=0.65U AS=0.169P
+ AD=0.08775P PS=1.82U PD=0.92U
* device instance $675 r0 *1 62.09,35.92 sky130_fd_pr__nfet_01v8
M$675 593 338 606 606 sky130_fd_pr__nfet_01v8 L=0.15U W=0.65U AS=0.08775P
+ AD=0.169P PS=0.92U PD=1.82U
* device instance $676 r0 *1 63.13,35.92 sky130_fd_pr__nfet_01v8
M$676 605 593 594 594 sky130_fd_pr__nfet_01v8 L=0.15U W=0.65U AS=0.169P
+ AD=0.06825P PS=1.82U PD=0.86U
* device instance $677 r0 *1 63.49,35.92 sky130_fd_pr__nfet_01v8
M$677 94 641 605 605 sky130_fd_pr__nfet_01v8 L=0.15U W=0.65U AS=0.06825P
+ AD=0.08775P PS=0.86U PD=0.92U
* device instance $678 r0 *1 63.91,35.92 sky130_fd_pr__nfet_01v8
M$678 595 641 94 94 sky130_fd_pr__nfet_01v8 L=0.15U W=0.65U AS=0.08775P
+ AD=0.169P PS=0.92U PD=1.82U
* device instance $679 r0 *1 64.85,35.92 sky130_fd_pr__nfet_01v8
M$679 595 593 94 94 sky130_fd_pr__nfet_01v8 L=0.15U W=0.65U AS=0.169P
+ AD=0.08775P PS=1.82U PD=0.92U
* device instance $680 r0 *1 65.27,35.92 sky130_fd_pr__nfet_01v8
M$680 574 594 595 595 sky130_fd_pr__nfet_01v8 L=0.15U W=0.65U AS=0.08775P
+ AD=0.195P PS=0.92U PD=1.9U
* device instance $681 r0 *1 66.485,35.805 sky130_fd_pr__nfet_01v8
M$681 94 644 596 596 sky130_fd_pr__nfet_01v8 L=0.15U W=0.42U AS=0.1092P
+ AD=0.10025P PS=1.36U PD=0.985U
* device instance $682 r0 *1 66.97,35.92 sky130_fd_pr__nfet_01v8
M$682 597 573 94 94 sky130_fd_pr__nfet_01v8 L=0.15U W=0.65U AS=0.10025P
+ AD=0.08775P PS=0.985U PD=0.92U
* device instance $683 r0 *1 67.39,35.92 sky130_fd_pr__nfet_01v8
M$683 94 596 597 597 sky130_fd_pr__nfet_01v8 L=0.15U W=0.65U AS=0.08775P
+ AD=0.169P PS=0.92U PD=1.82U
* device instance $684 r0 *1 6.91,40.24 sky130_fd_pr__nfet_01v8
M$684 94 622 663 663 sky130_fd_pr__nfet_01v8 L=0.15U W=0.65U AS=0.169P
+ AD=0.11285P PS=1.82U PD=1.045U
* device instance $685 r0 *1 7.455,40.355 sky130_fd_pr__nfet_01v8
M$685 665 71 94 94 sky130_fd_pr__nfet_01v8 L=0.15U W=0.42U AS=0.11285P
+ AD=0.0693P PS=1.045U PD=0.75U
* device instance $686 r0 *1 7.935,40.355 sky130_fd_pr__nfet_01v8
M$686 622 620 665 665 sky130_fd_pr__nfet_01v8 L=0.15U W=0.42U AS=0.0693P
+ AD=0.09975P PS=0.75U PD=0.895U
* device instance $687 r0 *1 8.56,40.355 sky130_fd_pr__nfet_01v8
M$687 666 590 622 622 sky130_fd_pr__nfet_01v8 L=0.15U W=0.42U AS=0.09975P
+ AD=0.0693P PS=0.895U PD=0.75U
* device instance $688 r0 *1 9.04,40.355 sky130_fd_pr__nfet_01v8
M$688 94 650 666 666 sky130_fd_pr__nfet_01v8 L=0.15U W=0.42U AS=0.0693P
+ AD=0.1449P PS=0.75U PD=1.11U
* device instance $689 r0 *1 9.88,40.355 sky130_fd_pr__nfet_01v8
M$689 650 71 94 94 sky130_fd_pr__nfet_01v8 L=0.15U W=0.42U AS=0.1449P
+ AD=0.1092P PS=1.11U PD=1.36U
* device instance $690 r0 *1 11.15,40.24 sky130_fd_pr__nfet_01v8
M$690 667 638 623 623 sky130_fd_pr__nfet_01v8 L=0.15U W=0.65U AS=0.169P
+ AD=0.06825P PS=1.82U PD=0.86U
* device instance $691 r0 *1 11.51,40.24 sky130_fd_pr__nfet_01v8
M$691 94 624 667 667 sky130_fd_pr__nfet_01v8 L=0.15U W=0.65U AS=0.06825P
+ AD=0.08775P PS=0.86U PD=0.92U
* device instance $692 r0 *1 11.93,40.24 sky130_fd_pr__nfet_01v8
M$692 651 624 94 94 sky130_fd_pr__nfet_01v8 L=0.15U W=0.65U AS=0.08775P
+ AD=0.169P PS=0.92U PD=1.82U
* device instance $693 r0 *1 12.87,40.24 sky130_fd_pr__nfet_01v8
M$693 651 638 94 94 sky130_fd_pr__nfet_01v8 L=0.15U W=0.65U AS=0.169P
+ AD=0.08775P PS=1.82U PD=0.92U
* device instance $694 r0 *1 13.29,40.24 sky130_fd_pr__nfet_01v8
M$694 600 623 651 651 sky130_fd_pr__nfet_01v8 L=0.15U W=0.65U AS=0.08775P
+ AD=0.195P PS=0.92U PD=1.9U
* device instance $695 r0 *1 14.31,40.24 sky130_fd_pr__nfet_01v8
M$695 625 590 94 94 sky130_fd_pr__nfet_01v8 L=0.15U W=0.65U AS=0.169P
+ AD=0.08775P PS=1.82U PD=0.92U
* device instance $696 r0 *1 14.73,40.24 sky130_fd_pr__nfet_01v8
M$696 94 599 625 625 sky130_fd_pr__nfet_01v8 L=0.15U W=0.65U AS=0.08775P
+ AD=0.08775P PS=0.92U PD=0.92U
* device instance $697 r0 *1 15.15,40.24 sky130_fd_pr__nfet_01v8
M$697 669 599 94 94 sky130_fd_pr__nfet_01v8 L=0.15U W=0.65U AS=0.08775P
+ AD=0.08775P PS=0.92U PD=0.92U
* device instance $698 r0 *1 15.57,40.24 sky130_fd_pr__nfet_01v8
M$698 638 590 669 669 sky130_fd_pr__nfet_01v8 L=0.15U W=0.65U AS=0.08775P
+ AD=0.25025P PS=0.92U PD=1.42U
* device instance $699 r0 *1 16.49,40.24 sky130_fd_pr__nfet_01v8
M$699 94 625 638 638 sky130_fd_pr__nfet_01v8 L=0.15U W=0.65U AS=0.25025P
+ AD=0.208P PS=1.42U PD=1.94U
* device instance $700 r0 *1 25.77,40.24 sky130_fd_pr__nfet_01v8
M$700 94 652 627 627 sky130_fd_pr__nfet_01v8 L=0.15U W=0.65U AS=0.169P
+ AD=0.10725P PS=1.82U PD=0.98U
* device instance $701 r0 *1 26.25,40.24 sky130_fd_pr__nfet_01v8
M$701 671 629 94 94 sky130_fd_pr__nfet_01v8 L=0.15U W=0.65U AS=0.10725P
+ AD=0.06825P PS=0.98U PD=0.86U
* device instance $702 r0 *1 26.61,40.24 sky130_fd_pr__nfet_01v8
M$702 627 90 671 671 sky130_fd_pr__nfet_01v8 L=0.15U W=0.65U AS=0.06825P
+ AD=0.169P PS=0.86U PD=1.82U
* device instance $703 r0 *1 27.55,40.24 sky130_fd_pr__nfet_01v8
M$703 672 138 627 627 sky130_fd_pr__nfet_01v8 L=0.15U W=0.65U AS=0.169P
+ AD=0.10725P PS=1.82U PD=0.98U
* device instance $704 r0 *1 28.03,40.24 sky130_fd_pr__nfet_01v8
M$704 94 554 672 672 sky130_fd_pr__nfet_01v8 L=0.15U W=0.65U AS=0.10725P
+ AD=0.102375P PS=0.98U PD=0.965U
* device instance $705 r0 *1 28.495,40.24 sky130_fd_pr__nfet_01v8
M$705 640 627 94 94 sky130_fd_pr__nfet_01v8 L=0.15U W=0.65U AS=0.102375P
+ AD=0.169P PS=0.965U PD=1.82U
* device instance $706 r0 *1 30.93,40.24 sky130_fd_pr__nfet_01v8
M$706 673 602 630 630 sky130_fd_pr__nfet_01v8 L=0.15U W=0.65U AS=0.169P
+ AD=0.06825P PS=1.82U PD=0.86U
* device instance $707 r0 *1 31.29,40.24 sky130_fd_pr__nfet_01v8
M$707 94 629 673 673 sky130_fd_pr__nfet_01v8 L=0.15U W=0.65U AS=0.06825P
+ AD=0.08775P PS=0.86U PD=0.92U
* device instance $708 r0 *1 31.71,40.24 sky130_fd_pr__nfet_01v8
M$708 653 629 94 94 sky130_fd_pr__nfet_01v8 L=0.15U W=0.65U AS=0.08775P
+ AD=0.169P PS=0.92U PD=1.82U
* device instance $709 r0 *1 32.65,40.24 sky130_fd_pr__nfet_01v8
M$709 653 602 94 94 sky130_fd_pr__nfet_01v8 L=0.15U W=0.65U AS=0.169P
+ AD=0.08775P PS=1.82U PD=0.92U
* device instance $710 r0 *1 33.07,40.24 sky130_fd_pr__nfet_01v8
M$710 601 630 653 653 sky130_fd_pr__nfet_01v8 L=0.15U W=0.65U AS=0.08775P
+ AD=0.195P PS=0.92U PD=1.9U
* device instance $711 r0 *1 55.67,40.24 sky130_fd_pr__nfet_01v8
M$711 675 577 94 94 sky130_fd_pr__nfet_01v8 L=0.15U W=0.65U AS=0.169P
+ AD=0.06825P PS=1.82U PD=0.86U
* device instance $712 r0 *1 56.03,40.24 sky130_fd_pr__nfet_01v8
M$712 674 338 675 675 sky130_fd_pr__nfet_01v8 L=0.15U W=0.65U AS=0.06825P
+ AD=0.118625P PS=0.86U PD=1.015U
* device instance $713 r0 *1 56.545,40.24 sky130_fd_pr__nfet_01v8
M$713 633 641 674 674 sky130_fd_pr__nfet_01v8 L=0.15U W=0.65U AS=0.118625P
+ AD=0.105625P PS=1.015U PD=0.975U
* device instance $714 r0 *1 57.02,40.24 sky130_fd_pr__nfet_01v8
M$714 94 597 633 633 sky130_fd_pr__nfet_01v8 L=0.15U W=0.65U AS=0.105625P
+ AD=0.1755P PS=0.975U PD=1.84U
* device instance $715 r0 *1 59.35,40.24 sky130_fd_pr__nfet_01v8
M$715 677 338 94 94 sky130_fd_pr__nfet_01v8 L=0.15U W=0.65U AS=0.169P
+ AD=0.089375P PS=1.82U PD=0.925U
* device instance $716 r0 *1 59.775,40.24 sky130_fd_pr__nfet_01v8
M$716 678 305 677 677 sky130_fd_pr__nfet_01v8 L=0.15U W=0.65U AS=0.089375P
+ AD=0.091P PS=0.925U PD=0.93U
* device instance $717 r0 *1 60.205,40.24 sky130_fd_pr__nfet_01v8
M$717 643 641 678 678 sky130_fd_pr__nfet_01v8 L=0.15U W=0.65U AS=0.091P
+ AD=0.115375P PS=0.93U PD=1.005U
* device instance $718 r0 *1 60.71,40.24 sky130_fd_pr__nfet_01v8
M$718 94 597 643 643 sky130_fd_pr__nfet_01v8 L=0.15U W=0.65U AS=0.115375P
+ AD=0.112125P PS=1.005U PD=0.995U
* device instance $719 r0 *1 61.205,40.24 sky130_fd_pr__nfet_01v8
M$719 643 655 94 94 sky130_fd_pr__nfet_01v8 L=0.15U W=0.65U AS=0.112125P
+ AD=0.169P PS=0.995U PD=1.82U
* device instance $720 r0 *1 64.51,40.24 sky130_fd_pr__nfet_01v8
M$720 676 644 634 634 sky130_fd_pr__nfet_01v8 L=0.15U W=0.65U AS=0.169P
+ AD=0.06825P PS=1.82U PD=0.86U
* device instance $721 r0 *1 64.87,40.24 sky130_fd_pr__nfet_01v8
M$721 94 573 676 676 sky130_fd_pr__nfet_01v8 L=0.15U W=0.65U AS=0.06825P
+ AD=0.08775P PS=0.86U PD=0.92U
* device instance $722 r0 *1 65.29,40.24 sky130_fd_pr__nfet_01v8
M$722 656 573 94 94 sky130_fd_pr__nfet_01v8 L=0.15U W=0.65U AS=0.08775P
+ AD=0.169P PS=0.92U PD=1.82U
* device instance $723 r0 *1 66.23,40.24 sky130_fd_pr__nfet_01v8
M$723 656 644 94 94 sky130_fd_pr__nfet_01v8 L=0.15U W=0.65U AS=0.169P
+ AD=0.08775P PS=1.82U PD=0.92U
* device instance $724 r0 *1 66.65,40.24 sky130_fd_pr__nfet_01v8
M$724 641 634 656 656 sky130_fd_pr__nfet_01v8 L=0.15U W=0.65U AS=0.08775P
+ AD=0.195P PS=0.92U PD=1.9U
* device instance $725 r0 *1 68.09,40.24 sky130_fd_pr__nfet_01v8
M$725 94 636 635 635 sky130_fd_pr__nfet_01v8 L=0.15U W=0.65U AS=0.169P
+ AD=0.11285P PS=1.82U PD=1.045U
* device instance $726 r0 *1 68.635,40.355 sky130_fd_pr__nfet_01v8
M$726 670 71 94 94 sky130_fd_pr__nfet_01v8 L=0.15U W=0.42U AS=0.11285P
+ AD=0.0693P PS=1.045U PD=0.75U
* device instance $727 r0 *1 69.115,40.355 sky130_fd_pr__nfet_01v8
M$727 636 645 670 670 sky130_fd_pr__nfet_01v8 L=0.15U W=0.42U AS=0.0693P
+ AD=0.09975P PS=0.75U PD=0.895U
* device instance $728 r0 *1 69.74,40.355 sky130_fd_pr__nfet_01v8
M$728 668 644 636 636 sky130_fd_pr__nfet_01v8 L=0.15U W=0.42U AS=0.09975P
+ AD=0.0693P PS=0.895U PD=0.75U
* device instance $729 r0 *1 70.22,40.355 sky130_fd_pr__nfet_01v8
M$729 94 657 668 668 sky130_fd_pr__nfet_01v8 L=0.15U W=0.42U AS=0.0693P
+ AD=0.1449P PS=0.75U PD=1.11U
* device instance $730 r0 *1 71.06,40.355 sky130_fd_pr__nfet_01v8
M$730 657 71 94 94 sky130_fd_pr__nfet_01v8 L=0.15U W=0.42U AS=0.1449P
+ AD=0.1092P PS=1.11U PD=1.36U
* device instance $731 r0 *1 2.77,41.245 sky130_fd_pr__nfet_01v8
M$731 94 936 679 679 sky130_fd_pr__nfet_01v8 L=0.15U W=0.42U AS=0.1092P
+ AD=0.0567P PS=1.36U PD=0.69U
* device instance $732 r0 *1 3.19,41.245 sky130_fd_pr__nfet_01v8
M$732 680 679 94 94 sky130_fd_pr__nfet_01v8 L=0.15U W=0.42U AS=0.0567P
+ AD=0.1092P PS=0.69U PD=1.36U
* device instance $733 r0 *1 4.13,41.245 sky130_fd_pr__nfet_01v8
M$733 713 663 681 681 sky130_fd_pr__nfet_01v8 L=0.15U W=0.42U AS=0.1092P
+ AD=0.0441P PS=1.36U PD=0.63U
* device instance $734 r0 *1 4.49,41.245 sky130_fd_pr__nfet_01v8
M$734 94 93 713 713 sky130_fd_pr__nfet_01v8 L=0.15U W=0.42U AS=0.0441P
+ AD=0.1092P PS=0.63U PD=1.36U
* device instance $735 r0 *1 4.68,40.355 sky130_fd_pr__nfet_01v8
M$735 664 637 621 621 sky130_fd_pr__nfet_01v8 L=0.15U W=0.42U AS=0.1113P
+ AD=0.0441P PS=1.37U PD=0.63U
* device instance $736 r0 *1 5.04,40.355 sky130_fd_pr__nfet_01v8
M$736 94 109 664 664 sky130_fd_pr__nfet_01v8 L=0.15U W=0.42U AS=0.0441P
+ AD=0.0966P PS=0.63U PD=0.88U
* device instance $737 r0 *1 5.65,40.355 sky130_fd_pr__nfet_01v8
M$737 598 621 94 94 sky130_fd_pr__nfet_01v8 L=0.15U W=0.42U AS=0.0966P
+ AD=0.1113P PS=0.88U PD=1.37U
* device instance $738 r0 *1 7.29,41.215 sky130_fd_pr__nfet_01v8
M$738 683 679 681 681 sky130_fd_pr__nfet_01v8 L=0.15U W=0.36U AS=0.1446P
+ AD=0.0522P PS=1.18U PD=0.65U
* device instance $739 r0 *1 7.73,41.215 sky130_fd_pr__nfet_01v8
M$739 716 680 683 683 sky130_fd_pr__nfet_01v8 L=0.15U W=0.36U AS=0.0522P
+ AD=0.0759P PS=0.65U PD=0.8U
* device instance $740 r0 *1 5.43,41.245 sky130_fd_pr__nfet_01v8
M$740 94 93 682 682 sky130_fd_pr__nfet_01v8 L=0.15U W=0.42U AS=0.1092P
+ AD=0.0609P PS=1.36U PD=0.71U
* device instance $741 r0 *1 5.87,41.245 sky130_fd_pr__nfet_01v8
M$741 714 682 94 94 sky130_fd_pr__nfet_01v8 L=0.15U W=0.42U AS=0.0609P
+ AD=0.0756P PS=0.71U PD=0.78U
* device instance $742 r0 *1 6.38,41.245 sky130_fd_pr__nfet_01v8
M$742 681 705 714 714 sky130_fd_pr__nfet_01v8 L=0.15U W=0.42U AS=0.0756P
+ AD=0.1446P PS=0.78U PD=1.18U
* device instance $743 r0 *1 8.26,41.245 sky130_fd_pr__nfet_01v8
M$743 94 684 716 716 sky130_fd_pr__nfet_01v8 L=0.15U W=0.42U AS=0.0759P
+ AD=0.12095P PS=0.8U PD=1.085U
* device instance $744 r0 *1 8.855,41.355 sky130_fd_pr__nfet_01v8
M$744 684 683 94 94 sky130_fd_pr__nfet_01v8 L=0.15U W=0.64U AS=0.12095P
+ AD=0.1664P PS=1.085U PD=1.8U
* device instance $745 r0 *1 10.28,41.215 sky130_fd_pr__nfet_01v8
M$745 685 680 718 718 sky130_fd_pr__nfet_01v8 L=0.15U W=0.36U AS=0.0678P
+ AD=0.0684P PS=0.755U PD=0.74U
* device instance $746 r0 *1 10.81,41.215 sky130_fd_pr__nfet_01v8
M$746 720 679 685 685 sky130_fd_pr__nfet_01v8 L=0.15U W=0.36U AS=0.0684P
+ AD=0.066P PS=0.74U PD=0.745U
* device instance $747 r0 *1 9.795,41.245 sky130_fd_pr__nfet_01v8
M$747 718 684 94 94 sky130_fd_pr__nfet_01v8 L=0.15U W=0.42U AS=0.1092P
+ AD=0.0678P PS=1.36U PD=0.755U
* device instance $748 r0 *1 11.285,41.245 sky130_fd_pr__nfet_01v8
M$748 94 705 720 720 sky130_fd_pr__nfet_01v8 L=0.15U W=0.42U AS=0.066P
+ AD=0.1092P PS=0.745U PD=1.36U
* device instance $749 r0 *1 12.225,41.245 sky130_fd_pr__nfet_01v8
M$749 94 685 705 705 sky130_fd_pr__nfet_01v8 L=0.15U W=0.42U AS=0.1092P
+ AD=0.10025P PS=1.36U PD=0.985U
* device instance $750 r0 *1 12.71,41.36 sky130_fd_pr__nfet_01v8
M$750 552 685 94 94 sky130_fd_pr__nfet_01v8 L=0.15U W=0.65U AS=0.10025P
+ AD=0.182P PS=0.985U PD=1.86U
* device instance $751 r0 *1 13.81,41.36 sky130_fd_pr__nfet_01v8
M$751 94 552 706 706 sky130_fd_pr__nfet_01v8 L=0.15U W=0.65U AS=0.169P
+ AD=0.08775P PS=1.82U PD=0.92U
* device instance $752 r0 *1 14.23,41.36 sky130_fd_pr__nfet_01v8
M$752 599 706 94 94 sky130_fd_pr__nfet_01v8 L=0.15U W=2.6U AS=0.351P
+ AD=0.43225P PS=3.68U PD=4.58U
* device instance $756 r0 *1 17.03,41.36 sky130_fd_pr__nfet_01v8
M$756 94 589 707 707 sky130_fd_pr__nfet_01v8 L=0.15U W=0.65U AS=0.169P
+ AD=0.08775P PS=1.82U PD=0.92U
* device instance $757 r0 *1 17.45,41.36 sky130_fd_pr__nfet_01v8
M$757 624 707 94 94 sky130_fd_pr__nfet_01v8 L=0.15U W=2.6U AS=0.351P
+ AD=0.43225P PS=3.68U PD=4.58U
* device instance $761 r0 *1 19.71,41.245 sky130_fd_pr__nfet_01v8
M$761 723 732 686 686 sky130_fd_pr__nfet_01v8 L=0.15U W=0.42U AS=0.1113P
+ AD=0.0441P PS=1.37U PD=0.63U
* device instance $762 r0 *1 20.07,41.245 sky130_fd_pr__nfet_01v8
M$762 94 109 723 723 sky130_fd_pr__nfet_01v8 L=0.15U W=0.42U AS=0.0441P
+ AD=0.0966P PS=0.63U PD=0.88U
* device instance $763 r0 *1 20.68,41.245 sky130_fd_pr__nfet_01v8
M$763 652 686 94 94 sky130_fd_pr__nfet_01v8 L=0.15U W=0.42U AS=0.0966P
+ AD=0.1113P PS=0.88U PD=1.37U
* device instance $764 r0 *1 26.23,41.245 sky130_fd_pr__nfet_01v8
M$764 94 936 687 687 sky130_fd_pr__nfet_01v8 L=0.15U W=0.42U AS=0.1092P
+ AD=0.0567P PS=1.36U PD=0.69U
* device instance $765 r0 *1 26.65,41.245 sky130_fd_pr__nfet_01v8
M$765 688 687 94 94 sky130_fd_pr__nfet_01v8 L=0.15U W=0.42U AS=0.0567P
+ AD=0.1092P PS=0.69U PD=1.36U
* device instance $766 r0 *1 27.59,41.245 sky130_fd_pr__nfet_01v8
M$766 724 708 689 689 sky130_fd_pr__nfet_01v8 L=0.15U W=0.42U AS=0.1092P
+ AD=0.0441P PS=1.36U PD=0.63U
* device instance $767 r0 *1 27.95,41.245 sky130_fd_pr__nfet_01v8
M$767 94 93 724 724 sky130_fd_pr__nfet_01v8 L=0.15U W=0.42U AS=0.0441P
+ AD=0.1092P PS=0.63U PD=1.36U
* device instance $768 r0 *1 30.75,41.215 sky130_fd_pr__nfet_01v8
M$768 691 687 689 689 sky130_fd_pr__nfet_01v8 L=0.15U W=0.36U AS=0.1446P
+ AD=0.0522P PS=1.18U PD=0.65U
* device instance $769 r0 *1 31.19,41.215 sky130_fd_pr__nfet_01v8
M$769 729 688 691 691 sky130_fd_pr__nfet_01v8 L=0.15U W=0.36U AS=0.0522P
+ AD=0.0759P PS=0.65U PD=0.8U
* device instance $770 r0 *1 28.89,41.245 sky130_fd_pr__nfet_01v8
M$770 94 93 690 690 sky130_fd_pr__nfet_01v8 L=0.15U W=0.42U AS=0.1092P
+ AD=0.0609P PS=1.36U PD=0.71U
* device instance $771 r0 *1 29.33,41.245 sky130_fd_pr__nfet_01v8
M$771 728 690 94 94 sky130_fd_pr__nfet_01v8 L=0.15U W=0.42U AS=0.0609P
+ AD=0.0756P PS=0.71U PD=0.78U
* device instance $772 r0 *1 29.84,41.245 sky130_fd_pr__nfet_01v8
M$772 689 709 728 728 sky130_fd_pr__nfet_01v8 L=0.15U W=0.42U AS=0.0756P
+ AD=0.1446P PS=0.78U PD=1.18U
* device instance $773 r0 *1 31.72,41.245 sky130_fd_pr__nfet_01v8
M$773 94 692 729 729 sky130_fd_pr__nfet_01v8 L=0.15U W=0.42U AS=0.0759P
+ AD=0.12095P PS=0.8U PD=1.085U
* device instance $774 r0 *1 32.315,41.355 sky130_fd_pr__nfet_01v8
M$774 692 691 94 94 sky130_fd_pr__nfet_01v8 L=0.15U W=0.64U AS=0.12095P
+ AD=0.1664P PS=1.085U PD=1.8U
* device instance $775 r0 *1 33.74,41.215 sky130_fd_pr__nfet_01v8
M$775 693 688 730 730 sky130_fd_pr__nfet_01v8 L=0.15U W=0.36U AS=0.0678P
+ AD=0.0684P PS=0.755U PD=0.74U
* device instance $776 r0 *1 34.27,41.215 sky130_fd_pr__nfet_01v8
M$776 731 687 693 693 sky130_fd_pr__nfet_01v8 L=0.15U W=0.36U AS=0.0684P
+ AD=0.066P PS=0.74U PD=0.745U
* device instance $777 r0 *1 33.255,41.245 sky130_fd_pr__nfet_01v8
M$777 730 692 94 94 sky130_fd_pr__nfet_01v8 L=0.15U W=0.42U AS=0.1092P
+ AD=0.0678P PS=1.36U PD=0.755U
* device instance $778 r0 *1 34.745,41.245 sky130_fd_pr__nfet_01v8
M$778 94 709 731 731 sky130_fd_pr__nfet_01v8 L=0.15U W=0.42U AS=0.066P
+ AD=0.1092P PS=0.745U PD=1.36U
* device instance $779 r0 *1 35.435,40.355 sky130_fd_pr__nfet_01v8
M$779 631 654 94 94 sky130_fd_pr__nfet_01v8 L=0.15U W=1.68U AS=0.2877P
+ AD=0.2352P PS=3.47U PD=2.8U
* device instance $783 r0 *1 37.155,40.355 sky130_fd_pr__nfet_01v8
M$783 311 631 94 94 sky130_fd_pr__nfet_01v8 L=0.15U W=6.72U AS=0.93975P
+ AD=0.99225P PS=11.195U PD=11.865U
* device instance $799 r0 *1 35.685,41.245 sky130_fd_pr__nfet_01v8
M$799 94 693 709 709 sky130_fd_pr__nfet_01v8 L=0.15U W=0.42U AS=0.1092P
+ AD=0.10025P PS=1.36U PD=0.985U
* device instance $800 r0 *1 36.17,41.36 sky130_fd_pr__nfet_01v8
M$800 629 693 94 94 sky130_fd_pr__nfet_01v8 L=0.15U W=0.65U AS=0.10025P
+ AD=0.182P PS=0.985U PD=1.86U
* device instance $801 r0 *1 44.63,41.36 sky130_fd_pr__nfet_01v8
M$801 733 629 94 94 sky130_fd_pr__nfet_01v8 L=0.15U W=0.65U AS=0.169P
+ AD=0.118625P PS=1.82U PD=1.015U
* device instance $802 r0 *1 45.145,41.36 sky130_fd_pr__nfet_01v8
M$802 94 366 733 733 sky130_fd_pr__nfet_01v8 L=0.15U W=0.65U AS=0.118625P
+ AD=0.089375P PS=1.015U PD=0.925U
* device instance $803 r0 *1 45.57,41.36 sky130_fd_pr__nfet_01v8
M$803 733 710 94 94 sky130_fd_pr__nfet_01v8 L=0.15U W=0.65U AS=0.089375P
+ AD=0.08775P PS=0.925U PD=0.92U
* device instance $804 r0 *1 45.99,41.36 sky130_fd_pr__nfet_01v8
M$804 94 694 733 733 sky130_fd_pr__nfet_01v8 L=0.15U W=0.65U AS=0.08775P
+ AD=0.169P PS=0.92U PD=1.82U
* device instance $805 r0 *1 49.23,41.36 sky130_fd_pr__nfet_01v8
M$805 727 733 94 94 sky130_fd_pr__nfet_01v8 L=0.15U W=0.65U AS=0.169P
+ AD=0.08775P PS=1.82U PD=0.92U
* device instance $806 r0 *1 49.65,41.36 sky130_fd_pr__nfet_01v8
M$806 726 695 727 727 sky130_fd_pr__nfet_01v8 L=0.15U W=0.65U AS=0.08775P
+ AD=0.10725P PS=0.92U PD=0.98U
* device instance $807 r0 *1 50.13,41.36 sky130_fd_pr__nfet_01v8
M$807 893 407 726 726 sky130_fd_pr__nfet_01v8 L=0.15U W=0.65U AS=0.10725P
+ AD=0.169P PS=0.98U PD=1.82U
* device instance $808 r0 *1 57.61,41.36 sky130_fd_pr__nfet_01v8
M$808 725 711 696 696 sky130_fd_pr__nfet_01v8 L=0.15U W=0.65U AS=0.169P
+ AD=0.06825P PS=1.82U PD=0.86U
* device instance $809 r0 *1 57.97,41.36 sky130_fd_pr__nfet_01v8
M$809 94 633 725 725 sky130_fd_pr__nfet_01v8 L=0.15U W=0.65U AS=0.06825P
+ AD=0.08775P PS=0.86U PD=0.92U
* device instance $810 r0 *1 58.39,41.36 sky130_fd_pr__nfet_01v8
M$810 697 633 94 94 sky130_fd_pr__nfet_01v8 L=0.15U W=0.65U AS=0.08775P
+ AD=0.169P PS=0.92U PD=1.82U
* device instance $811 r0 *1 59.33,41.36 sky130_fd_pr__nfet_01v8
M$811 697 711 94 94 sky130_fd_pr__nfet_01v8 L=0.15U W=0.65U AS=0.169P
+ AD=0.08775P PS=1.82U PD=0.92U
* device instance $812 r0 *1 59.75,41.36 sky130_fd_pr__nfet_01v8
M$812 734 696 697 697 sky130_fd_pr__nfet_01v8 L=0.15U W=0.65U AS=0.08775P
+ AD=0.195P PS=0.92U PD=1.9U
* device instance $813 r0 *1 60.73,41.245 sky130_fd_pr__nfet_01v8
M$813 94 996 698 698 sky130_fd_pr__nfet_01v8 L=0.15U W=0.42U AS=0.1092P
+ AD=0.0567P PS=1.36U PD=0.69U
* device instance $814 r0 *1 61.15,41.245 sky130_fd_pr__nfet_01v8
M$814 699 698 94 94 sky130_fd_pr__nfet_01v8 L=0.15U W=0.42U AS=0.0567P
+ AD=0.1092P PS=0.69U PD=1.36U
* device instance $815 r0 *1 62.09,41.245 sky130_fd_pr__nfet_01v8
M$815 722 568 700 700 sky130_fd_pr__nfet_01v8 L=0.15U W=0.42U AS=0.1092P
+ AD=0.0441P PS=1.36U PD=0.63U
* device instance $816 r0 *1 62.45,41.245 sky130_fd_pr__nfet_01v8
M$816 94 16 722 722 sky130_fd_pr__nfet_01v8 L=0.15U W=0.42U AS=0.0441P
+ AD=0.1092P PS=0.63U PD=1.36U
* device instance $817 r0 *1 65.25,41.215 sky130_fd_pr__nfet_01v8
M$817 702 698 700 700 sky130_fd_pr__nfet_01v8 L=0.15U W=0.36U AS=0.1446P
+ AD=0.0522P PS=1.18U PD=0.65U
* device instance $818 r0 *1 65.69,41.215 sky130_fd_pr__nfet_01v8
M$818 719 699 702 702 sky130_fd_pr__nfet_01v8 L=0.15U W=0.36U AS=0.0522P
+ AD=0.0759P PS=0.65U PD=0.8U
* device instance $819 r0 *1 63.39,41.245 sky130_fd_pr__nfet_01v8
M$819 94 16 701 701 sky130_fd_pr__nfet_01v8 L=0.15U W=0.42U AS=0.1092P
+ AD=0.0609P PS=1.36U PD=0.71U
* device instance $820 r0 *1 63.83,41.245 sky130_fd_pr__nfet_01v8
M$820 721 701 94 94 sky130_fd_pr__nfet_01v8 L=0.15U W=0.42U AS=0.0609P
+ AD=0.0756P PS=0.71U PD=0.78U
* device instance $821 r0 *1 64.34,41.245 sky130_fd_pr__nfet_01v8
M$821 700 712 721 721 sky130_fd_pr__nfet_01v8 L=0.15U W=0.42U AS=0.0756P
+ AD=0.1446P PS=0.78U PD=1.18U
* device instance $822 r0 *1 66.22,41.245 sky130_fd_pr__nfet_01v8
M$822 94 703 719 719 sky130_fd_pr__nfet_01v8 L=0.15U W=0.42U AS=0.0759P
+ AD=0.12095P PS=0.8U PD=1.085U
* device instance $823 r0 *1 66.815,41.355 sky130_fd_pr__nfet_01v8
M$823 703 702 94 94 sky130_fd_pr__nfet_01v8 L=0.15U W=0.64U AS=0.12095P
+ AD=0.1664P PS=1.085U PD=1.8U
* device instance $824 r0 *1 68.24,41.215 sky130_fd_pr__nfet_01v8
M$824 704 699 717 717 sky130_fd_pr__nfet_01v8 L=0.15U W=0.36U AS=0.0678P
+ AD=0.0684P PS=0.755U PD=0.74U
* device instance $825 r0 *1 68.77,41.215 sky130_fd_pr__nfet_01v8
M$825 715 698 704 704 sky130_fd_pr__nfet_01v8 L=0.15U W=0.36U AS=0.0684P
+ AD=0.066P PS=0.74U PD=0.745U
* device instance $826 r0 *1 67.755,41.245 sky130_fd_pr__nfet_01v8
M$826 717 703 94 94 sky130_fd_pr__nfet_01v8 L=0.15U W=0.42U AS=0.1092P
+ AD=0.0678P PS=1.36U PD=0.755U
* device instance $827 r0 *1 69.245,41.245 sky130_fd_pr__nfet_01v8
M$827 94 712 715 715 sky130_fd_pr__nfet_01v8 L=0.15U W=0.42U AS=0.066P
+ AD=0.1092P PS=0.745U PD=1.36U
* device instance $828 r0 *1 70.185,41.245 sky130_fd_pr__nfet_01v8
M$828 94 704 712 712 sky130_fd_pr__nfet_01v8 L=0.15U W=0.42U AS=0.1092P
+ AD=0.10025P PS=1.36U PD=0.985U
* device instance $829 r0 *1 70.67,41.36 sky130_fd_pr__nfet_01v8
M$829 644 704 94 94 sky130_fd_pr__nfet_01v8 L=0.15U W=0.65U AS=0.10025P
+ AD=0.182P PS=0.985U PD=1.86U
* device instance $830 r0 *1 7.83,46.8 sky130_fd_pr__nfet_01v8
M$830 94 862 831 831 sky130_fd_pr__nfet_01v8 L=0.15U W=0.65U AS=0.169P
+ AD=0.10725P PS=1.82U PD=0.98U
* device instance $831 r0 *1 8.31,46.8 sky130_fd_pr__nfet_01v8
M$831 868 863 94 94 sky130_fd_pr__nfet_01v8 L=0.15U W=0.65U AS=0.10725P
+ AD=0.06825P PS=0.98U PD=0.86U
* device instance $832 r0 *1 8.67,46.8 sky130_fd_pr__nfet_01v8
M$832 831 90 868 868 sky130_fd_pr__nfet_01v8 L=0.15U W=0.65U AS=0.06825P
+ AD=0.169P PS=0.86U PD=1.82U
* device instance $833 r0 *1 9.21,45.795 sky130_fd_pr__nfet_01v8
M$833 94 936 754 754 sky130_fd_pr__nfet_01v8 L=0.15U W=0.42U AS=0.1092P
+ AD=0.0567P PS=1.36U PD=0.69U
* device instance $834 r0 *1 9.63,45.795 sky130_fd_pr__nfet_01v8
M$834 755 754 94 94 sky130_fd_pr__nfet_01v8 L=0.15U W=0.42U AS=0.0567P
+ AD=0.1092P PS=0.69U PD=1.36U
* device instance $835 r0 *1 9.61,46.8 sky130_fd_pr__nfet_01v8
M$835 869 87 831 831 sky130_fd_pr__nfet_01v8 L=0.15U W=0.65U AS=0.169P
+ AD=0.10725P PS=1.82U PD=0.98U
* device instance $836 r0 *1 10.09,46.8 sky130_fd_pr__nfet_01v8
M$836 94 864 869 869 sky130_fd_pr__nfet_01v8 L=0.15U W=0.65U AS=0.10725P
+ AD=0.102375P PS=0.98U PD=0.965U
* device instance $837 r0 *1 10.555,46.8 sky130_fd_pr__nfet_01v8
M$837 872 831 94 94 sky130_fd_pr__nfet_01v8 L=0.15U W=0.65U AS=0.102375P
+ AD=0.169P PS=0.965U PD=1.82U
* device instance $838 r0 *1 10.57,45.795 sky130_fd_pr__nfet_01v8
M$838 813 587 756 756 sky130_fd_pr__nfet_01v8 L=0.15U W=0.42U AS=0.1092P
+ AD=0.0441P PS=1.36U PD=0.63U
* device instance $839 r0 *1 10.93,45.795 sky130_fd_pr__nfet_01v8
M$839 94 16 813 813 sky130_fd_pr__nfet_01v8 L=0.15U W=0.42U AS=0.0441P
+ AD=0.1092P PS=0.63U PD=1.36U
* device instance $840 r0 *1 11.51,46.8 sky130_fd_pr__nfet_01v8
M$840 94 865 832 832 sky130_fd_pr__nfet_01v8 L=0.15U W=0.65U AS=0.169P
+ AD=0.169P PS=1.82U PD=1.82U
* device instance $841 r0 *1 11.87,45.795 sky130_fd_pr__nfet_01v8
M$841 94 16 757 757 sky130_fd_pr__nfet_01v8 L=0.15U W=0.42U AS=0.1092P
+ AD=0.0609P PS=1.36U PD=0.71U
* device instance $842 r0 *1 12.31,45.795 sky130_fd_pr__nfet_01v8
M$842 815 757 94 94 sky130_fd_pr__nfet_01v8 L=0.15U W=0.42U AS=0.0609P
+ AD=0.0756P PS=0.71U PD=0.78U
* device instance $843 r0 *1 12.82,45.795 sky130_fd_pr__nfet_01v8
M$843 756 761 815 815 sky130_fd_pr__nfet_01v8 L=0.15U W=0.42U AS=0.0756P
+ AD=0.1446P PS=0.78U PD=1.18U
* device instance $844 r0 *1 13.73,45.825 sky130_fd_pr__nfet_01v8
M$844 758 754 756 756 sky130_fd_pr__nfet_01v8 L=0.15U W=0.36U AS=0.1446P
+ AD=0.0522P PS=1.18U PD=0.65U
* device instance $845 r0 *1 14.17,45.825 sky130_fd_pr__nfet_01v8
M$845 758 755 817 817 sky130_fd_pr__nfet_01v8 L=0.15U W=0.36U AS=0.0759P
+ AD=0.0522P PS=0.8U PD=0.65U
* device instance $846 r0 *1 14.7,45.795 sky130_fd_pr__nfet_01v8
M$846 817 759 94 94 sky130_fd_pr__nfet_01v8 L=0.15U W=0.42U AS=0.12095P
+ AD=0.0759P PS=1.085U PD=0.8U
* device instance $847 r0 *1 15.295,45.685 sky130_fd_pr__nfet_01v8
M$847 759 758 94 94 sky130_fd_pr__nfet_01v8 L=0.15U W=0.64U AS=0.12095P
+ AD=0.1664P PS=1.085U PD=1.8U
* device instance $848 r0 *1 12.45,46.8 sky130_fd_pr__nfet_01v8
M$848 589 832 833 833 sky130_fd_pr__nfet_01v8 L=0.15U W=2.6U AS=0.43225P
+ AD=0.355875P PS=4.58U PD=3.695U
* device instance $852 r0 *1 14.145,46.8 sky130_fd_pr__nfet_01v8
M$852 94 834 833 833 sky130_fd_pr__nfet_01v8 L=0.15U W=2.6U AS=0.355875P
+ AD=0.51675P PS=3.695U PD=4.84U
* device instance $856 r0 *1 16.235,45.795 sky130_fd_pr__nfet_01v8
M$856 821 759 94 94 sky130_fd_pr__nfet_01v8 L=0.15U W=0.42U AS=0.1092P
+ AD=0.0678P PS=1.36U PD=0.755U
* device instance $857 r0 *1 16.72,45.825 sky130_fd_pr__nfet_01v8
M$857 760 755 821 821 sky130_fd_pr__nfet_01v8 L=0.15U W=0.36U AS=0.0678P
+ AD=0.0684P PS=0.755U PD=0.74U
* device instance $858 r0 *1 17.25,45.825 sky130_fd_pr__nfet_01v8
M$858 760 754 819 819 sky130_fd_pr__nfet_01v8 L=0.15U W=0.36U AS=0.066P
+ AD=0.0684P PS=0.745U PD=0.74U
* device instance $859 r0 *1 17.725,45.795 sky130_fd_pr__nfet_01v8
M$859 94 761 819 819 sky130_fd_pr__nfet_01v8 L=0.15U W=0.42U AS=0.066P
+ AD=0.1092P PS=0.745U PD=1.36U
* device instance $860 r0 *1 18.665,45.795 sky130_fd_pr__nfet_01v8
M$860 761 760 94 94 sky130_fd_pr__nfet_01v8 L=0.15U W=0.42U AS=0.10025P
+ AD=0.1092P PS=0.985U PD=1.36U
* device instance $861 r0 *1 19.15,45.68 sky130_fd_pr__nfet_01v8
M$861 590 760 94 94 sky130_fd_pr__nfet_01v8 L=0.15U W=0.65U AS=0.10025P
+ AD=0.182P PS=0.985U PD=1.86U
* device instance $862 r0 *1 25.77,46.685 sky130_fd_pr__nfet_01v8
M$862 94 936 835 835 sky130_fd_pr__nfet_01v8 L=0.15U W=0.42U AS=0.1092P
+ AD=0.0567P PS=1.36U PD=0.69U
* device instance $863 r0 *1 26.19,46.685 sky130_fd_pr__nfet_01v8
M$863 836 835 94 94 sky130_fd_pr__nfet_01v8 L=0.15U W=0.42U AS=0.0567P
+ AD=0.1092P PS=0.69U PD=1.36U
* device instance $864 r0 *1 26.23,45.68 sky130_fd_pr__nfet_01v8
M$864 94 762 708 708 sky130_fd_pr__nfet_01v8 L=0.15U W=0.65U AS=0.169P
+ AD=0.11285P PS=1.82U PD=1.045U
* device instance $865 r0 *1 26.775,45.795 sky130_fd_pr__nfet_01v8
M$865 822 71 94 94 sky130_fd_pr__nfet_01v8 L=0.15U W=0.42U AS=0.11285P
+ AD=0.0693P PS=1.045U PD=0.75U
* device instance $866 r0 *1 27.255,45.795 sky130_fd_pr__nfet_01v8
M$866 762 782 822 822 sky130_fd_pr__nfet_01v8 L=0.15U W=0.42U AS=0.0693P
+ AD=0.09975P PS=0.75U PD=0.895U
* device instance $867 r0 *1 27.88,45.795 sky130_fd_pr__nfet_01v8
M$867 823 602 762 762 sky130_fd_pr__nfet_01v8 L=0.15U W=0.42U AS=0.09975P
+ AD=0.0693P PS=0.895U PD=0.75U
* device instance $868 r0 *1 28.36,45.795 sky130_fd_pr__nfet_01v8
M$868 94 810 823 823 sky130_fd_pr__nfet_01v8 L=0.15U W=0.42U AS=0.0693P
+ AD=0.1449P PS=0.75U PD=1.11U
* device instance $869 r0 *1 29.2,45.795 sky130_fd_pr__nfet_01v8
M$869 810 71 94 94 sky130_fd_pr__nfet_01v8 L=0.15U W=0.42U AS=0.1449P
+ AD=0.1092P PS=1.11U PD=1.36U
* device instance $870 r0 *1 27.13,46.685 sky130_fd_pr__nfet_01v8
M$870 852 640 837 837 sky130_fd_pr__nfet_01v8 L=0.15U W=0.42U AS=0.1092P
+ AD=0.0441P PS=1.36U PD=0.63U
* device instance $871 r0 *1 27.49,46.685 sky130_fd_pr__nfet_01v8
M$871 94 16 852 852 sky130_fd_pr__nfet_01v8 L=0.15U W=0.42U AS=0.0441P
+ AD=0.1092P PS=0.63U PD=1.36U
* device instance $872 r0 *1 30.29,46.655 sky130_fd_pr__nfet_01v8
M$872 839 835 837 837 sky130_fd_pr__nfet_01v8 L=0.15U W=0.36U AS=0.1446P
+ AD=0.0522P PS=1.18U PD=0.65U
* device instance $873 r0 *1 30.73,46.655 sky130_fd_pr__nfet_01v8
M$873 854 836 839 839 sky130_fd_pr__nfet_01v8 L=0.15U W=0.36U AS=0.0522P
+ AD=0.0759P PS=0.65U PD=0.8U
* device instance $874 r0 *1 28.43,46.685 sky130_fd_pr__nfet_01v8
M$874 94 16 838 838 sky130_fd_pr__nfet_01v8 L=0.15U W=0.42U AS=0.1092P
+ AD=0.0609P PS=1.36U PD=0.71U
* device instance $875 r0 *1 28.87,46.685 sky130_fd_pr__nfet_01v8
M$875 853 838 94 94 sky130_fd_pr__nfet_01v8 L=0.15U W=0.42U AS=0.0609P
+ AD=0.0756P PS=0.71U PD=0.78U
* device instance $876 r0 *1 29.38,46.685 sky130_fd_pr__nfet_01v8
M$876 837 866 853 853 sky130_fd_pr__nfet_01v8 L=0.15U W=0.42U AS=0.0756P
+ AD=0.1446P PS=0.78U PD=1.18U
* device instance $877 r0 *1 31.26,46.685 sky130_fd_pr__nfet_01v8
M$877 94 840 854 854 sky130_fd_pr__nfet_01v8 L=0.15U W=0.42U AS=0.0759P
+ AD=0.12095P PS=0.8U PD=1.085U
* device instance $878 r0 *1 31.855,46.795 sky130_fd_pr__nfet_01v8
M$878 840 839 94 94 sky130_fd_pr__nfet_01v8 L=0.15U W=0.64U AS=0.12095P
+ AD=0.1664P PS=1.085U PD=1.8U
* device instance $879 r0 *1 33.28,46.655 sky130_fd_pr__nfet_01v8
M$879 841 836 855 855 sky130_fd_pr__nfet_01v8 L=0.15U W=0.36U AS=0.0678P
+ AD=0.0684P PS=0.755U PD=0.74U
* device instance $880 r0 *1 33.81,46.655 sky130_fd_pr__nfet_01v8
M$880 856 835 841 841 sky130_fd_pr__nfet_01v8 L=0.15U W=0.36U AS=0.0684P
+ AD=0.066P PS=0.74U PD=0.745U
* device instance $881 r0 *1 32.795,46.685 sky130_fd_pr__nfet_01v8
M$881 855 840 94 94 sky130_fd_pr__nfet_01v8 L=0.15U W=0.42U AS=0.1092P
+ AD=0.0678P PS=1.36U PD=0.755U
* device instance $882 r0 *1 34.285,46.685 sky130_fd_pr__nfet_01v8
M$882 94 866 856 856 sky130_fd_pr__nfet_01v8 L=0.15U W=0.42U AS=0.066P
+ AD=0.1092P PS=0.745U PD=1.36U
* device instance $883 r0 *1 33.59,45.795 sky130_fd_pr__nfet_01v8
M$883 94 936 763 763 sky130_fd_pr__nfet_01v8 L=0.15U W=0.42U AS=0.1092P
+ AD=0.0567P PS=1.36U PD=0.69U
* device instance $884 r0 *1 34.01,45.795 sky130_fd_pr__nfet_01v8
M$884 764 763 94 94 sky130_fd_pr__nfet_01v8 L=0.15U W=0.42U AS=0.0567P
+ AD=0.1092P PS=0.69U PD=1.36U
* device instance $885 r0 *1 34.95,45.795 sky130_fd_pr__nfet_01v8
M$885 824 783 765 765 sky130_fd_pr__nfet_01v8 L=0.15U W=0.42U AS=0.1092P
+ AD=0.0441P PS=1.36U PD=0.63U
* device instance $886 r0 *1 35.31,45.795 sky130_fd_pr__nfet_01v8
M$886 94 93 824 824 sky130_fd_pr__nfet_01v8 L=0.15U W=0.42U AS=0.0441P
+ AD=0.1092P PS=0.63U PD=1.36U
* device instance $887 r0 *1 35.225,46.685 sky130_fd_pr__nfet_01v8
M$887 94 841 866 866 sky130_fd_pr__nfet_01v8 L=0.15U W=0.42U AS=0.1092P
+ AD=0.10025P PS=1.36U PD=0.985U
* device instance $888 r0 *1 35.71,46.8 sky130_fd_pr__nfet_01v8
M$888 602 841 94 94 sky130_fd_pr__nfet_01v8 L=0.15U W=0.65U AS=0.10025P
+ AD=0.182P PS=0.985U PD=1.86U
* device instance $889 r0 *1 36.25,45.795 sky130_fd_pr__nfet_01v8
M$889 94 93 766 766 sky130_fd_pr__nfet_01v8 L=0.15U W=0.42U AS=0.1092P
+ AD=0.0609P PS=1.36U PD=0.71U
* device instance $890 r0 *1 36.69,45.795 sky130_fd_pr__nfet_01v8
M$890 825 766 94 94 sky130_fd_pr__nfet_01v8 L=0.15U W=0.42U AS=0.0609P
+ AD=0.0756P PS=0.71U PD=0.78U
* device instance $891 r0 *1 37.2,45.795 sky130_fd_pr__nfet_01v8
M$891 765 770 825 825 sky130_fd_pr__nfet_01v8 L=0.15U W=0.42U AS=0.0756P
+ AD=0.1446P PS=0.78U PD=1.18U
* device instance $892 r0 *1 38.11,45.825 sky130_fd_pr__nfet_01v8
M$892 767 763 765 765 sky130_fd_pr__nfet_01v8 L=0.15U W=0.36U AS=0.1446P
+ AD=0.0522P PS=1.18U PD=0.65U
* device instance $893 r0 *1 38.55,45.825 sky130_fd_pr__nfet_01v8
M$893 767 764 826 826 sky130_fd_pr__nfet_01v8 L=0.15U W=0.36U AS=0.0759P
+ AD=0.0522P PS=0.8U PD=0.65U
* device instance $894 r0 *1 39.08,45.795 sky130_fd_pr__nfet_01v8
M$894 826 768 94 94 sky130_fd_pr__nfet_01v8 L=0.15U W=0.42U AS=0.12095P
+ AD=0.0759P PS=1.085U PD=0.8U
* device instance $895 r0 *1 39.675,45.685 sky130_fd_pr__nfet_01v8
M$895 768 767 94 94 sky130_fd_pr__nfet_01v8 L=0.15U W=0.64U AS=0.12095P
+ AD=0.1664P PS=1.085U PD=1.8U
* device instance $896 r0 *1 40.615,45.795 sky130_fd_pr__nfet_01v8
M$896 827 768 94 94 sky130_fd_pr__nfet_01v8 L=0.15U W=0.42U AS=0.1092P
+ AD=0.0678P PS=1.36U PD=0.755U
* device instance $897 r0 *1 41.1,45.825 sky130_fd_pr__nfet_01v8
M$897 769 764 827 827 sky130_fd_pr__nfet_01v8 L=0.15U W=0.36U AS=0.0678P
+ AD=0.0684P PS=0.755U PD=0.74U
* device instance $898 r0 *1 41.63,45.825 sky130_fd_pr__nfet_01v8
M$898 769 763 828 828 sky130_fd_pr__nfet_01v8 L=0.15U W=0.36U AS=0.066P
+ AD=0.0684P PS=0.745U PD=0.74U
* device instance $899 r0 *1 42.105,45.795 sky130_fd_pr__nfet_01v8
M$899 94 770 828 828 sky130_fd_pr__nfet_01v8 L=0.15U W=0.42U AS=0.066P
+ AD=0.1092P PS=0.745U PD=1.36U
* device instance $900 r0 *1 40.98,46.685 sky130_fd_pr__nfet_01v8
M$900 94 773 842 842 sky130_fd_pr__nfet_01v8 L=0.15U W=0.42U AS=0.1113P
+ AD=0.0588P PS=1.37U PD=0.7U
* device instance $901 r0 *1 41.41,46.685 sky130_fd_pr__nfet_01v8
M$901 842 71 94 94 sky130_fd_pr__nfet_01v8 L=0.15U W=0.42U AS=0.0588P
+ AD=0.0588P PS=0.7U PD=0.7U
* device instance $902 r0 *1 41.84,46.685 sky130_fd_pr__nfet_01v8
M$902 783 1242 842 842 sky130_fd_pr__nfet_01v8 L=0.15U W=0.42U AS=0.0588P
+ AD=0.1113P PS=0.7U PD=1.37U
* device instance $903 r0 *1 43.045,45.795 sky130_fd_pr__nfet_01v8
M$903 770 769 94 94 sky130_fd_pr__nfet_01v8 L=0.15U W=0.42U AS=0.10025P
+ AD=0.1092P PS=0.985U PD=1.36U
* device instance $904 r0 *1 43.53,45.68 sky130_fd_pr__nfet_01v8
M$904 710 769 94 94 sky130_fd_pr__nfet_01v8 L=0.15U W=0.65U AS=0.10025P
+ AD=0.182P PS=0.985U PD=1.86U
* device instance $905 r0 *1 44.63,45.68 sky130_fd_pr__nfet_01v8
M$905 94 784 771 771 sky130_fd_pr__nfet_01v8 L=0.15U W=0.65U AS=0.169P
+ AD=0.10725P PS=1.82U PD=0.98U
* device instance $906 r0 *1 45.11,45.68 sky130_fd_pr__nfet_01v8
M$906 830 710 94 94 sky130_fd_pr__nfet_01v8 L=0.15U W=0.65U AS=0.10725P
+ AD=0.06825P PS=0.98U PD=0.86U
* device instance $907 r0 *1 45.47,45.68 sky130_fd_pr__nfet_01v8
M$907 771 90 830 830 sky130_fd_pr__nfet_01v8 L=0.15U W=0.65U AS=0.06825P
+ AD=0.169P PS=0.86U PD=1.82U
* device instance $908 r0 *1 44.63,46.685 sky130_fd_pr__nfet_01v8
M$908 94 996 843 843 sky130_fd_pr__nfet_01v8 L=0.15U W=0.42U AS=0.1092P
+ AD=0.0567P PS=1.36U PD=0.69U
* device instance $909 r0 *1 45.05,46.685 sky130_fd_pr__nfet_01v8
M$909 844 843 94 94 sky130_fd_pr__nfet_01v8 L=0.15U W=0.42U AS=0.0567P
+ AD=0.1092P PS=0.69U PD=1.36U
* device instance $910 r0 *1 45.99,46.685 sky130_fd_pr__nfet_01v8
M$910 859 811 845 845 sky130_fd_pr__nfet_01v8 L=0.15U W=0.42U AS=0.1092P
+ AD=0.0441P PS=1.36U PD=0.63U
* device instance $911 r0 *1 46.35,46.685 sky130_fd_pr__nfet_01v8
M$911 94 16 859 859 sky130_fd_pr__nfet_01v8 L=0.15U W=0.42U AS=0.0441P
+ AD=0.1092P PS=0.63U PD=1.36U
* device instance $912 r0 *1 46.41,45.68 sky130_fd_pr__nfet_01v8
M$912 829 138 771 771 sky130_fd_pr__nfet_01v8 L=0.15U W=0.65U AS=0.169P
+ AD=0.10725P PS=1.82U PD=0.98U
* device instance $913 r0 *1 46.89,45.68 sky130_fd_pr__nfet_01v8
M$913 94 734 829 829 sky130_fd_pr__nfet_01v8 L=0.15U W=0.65U AS=0.10725P
+ AD=0.102375P PS=0.98U PD=0.965U
* device instance $914 r0 *1 47.355,45.68 sky130_fd_pr__nfet_01v8
M$914 811 771 94 94 sky130_fd_pr__nfet_01v8 L=0.15U W=0.65U AS=0.102375P
+ AD=0.169P PS=0.965U PD=1.82U
* device instance $915 r0 *1 49.15,46.655 sky130_fd_pr__nfet_01v8
M$915 847 843 845 845 sky130_fd_pr__nfet_01v8 L=0.15U W=0.36U AS=0.1446P
+ AD=0.0522P PS=1.18U PD=0.65U
* device instance $916 r0 *1 49.59,46.655 sky130_fd_pr__nfet_01v8
M$916 861 844 847 847 sky130_fd_pr__nfet_01v8 L=0.15U W=0.36U AS=0.0522P
+ AD=0.0759P PS=0.65U PD=0.8U
* device instance $917 r0 *1 47.29,46.685 sky130_fd_pr__nfet_01v8
M$917 94 16 846 846 sky130_fd_pr__nfet_01v8 L=0.15U W=0.42U AS=0.1092P
+ AD=0.0609P PS=1.36U PD=0.71U
* device instance $918 r0 *1 47.73,46.685 sky130_fd_pr__nfet_01v8
M$918 860 846 94 94 sky130_fd_pr__nfet_01v8 L=0.15U W=0.42U AS=0.0609P
+ AD=0.0756P PS=0.71U PD=0.78U
* device instance $919 r0 *1 48.24,46.685 sky130_fd_pr__nfet_01v8
M$919 845 867 860 860 sky130_fd_pr__nfet_01v8 L=0.15U W=0.42U AS=0.0756P
+ AD=0.1446P PS=0.78U PD=1.18U
* device instance $920 r0 *1 50.12,46.685 sky130_fd_pr__nfet_01v8
M$920 94 848 861 861 sky130_fd_pr__nfet_01v8 L=0.15U W=0.42U AS=0.0759P
+ AD=0.12095P PS=0.8U PD=1.085U
* device instance $921 r0 *1 50.715,46.795 sky130_fd_pr__nfet_01v8
M$921 848 847 94 94 sky130_fd_pr__nfet_01v8 L=0.15U W=0.64U AS=0.12095P
+ AD=0.1664P PS=1.085U PD=1.8U
* device instance $922 r0 *1 48.725,45.795 sky130_fd_pr__nfet_01v8
M$922 94 786 773 773 sky130_fd_pr__nfet_01v8 L=0.15U W=0.42U AS=0.1092P
+ AD=0.1197P PS=1.36U PD=1.41U
* device instance $923 r0 *1 49.69,45.68 sky130_fd_pr__nfet_01v8
M$923 655 773 94 94 sky130_fd_pr__nfet_01v8 L=0.15U W=0.65U AS=0.169P
+ AD=0.08775P PS=1.82U PD=0.92U
* device instance $924 r0 *1 50.11,45.68 sky130_fd_pr__nfet_01v8
M$924 94 710 655 655 sky130_fd_pr__nfet_01v8 L=0.15U W=0.65U AS=0.08775P
+ AD=0.169P PS=0.92U PD=1.82U
* device instance $925 r0 *1 51.305,45.795 sky130_fd_pr__nfet_01v8
M$925 787 710 94 94 sky130_fd_pr__nfet_01v8 L=0.15U W=0.42U AS=0.10025P
+ AD=0.1092P PS=0.985U PD=1.36U
* device instance $926 r0 *1 51.79,45.68 sky130_fd_pr__nfet_01v8
M$926 788 786 94 94 sky130_fd_pr__nfet_01v8 L=0.15U W=0.65U AS=0.10025P
+ AD=0.08775P PS=0.985U PD=0.92U
* device instance $927 r0 *1 52.21,45.68 sky130_fd_pr__nfet_01v8
M$927 94 787 788 788 sky130_fd_pr__nfet_01v8 L=0.15U W=0.65U AS=0.08775P
+ AD=0.169P PS=0.92U PD=1.82U
* device instance $928 r0 *1 52.14,46.655 sky130_fd_pr__nfet_01v8
M$928 849 844 858 858 sky130_fd_pr__nfet_01v8 L=0.15U W=0.36U AS=0.0678P
+ AD=0.0684P PS=0.755U PD=0.74U
* device instance $929 r0 *1 52.67,46.655 sky130_fd_pr__nfet_01v8
M$929 857 843 849 849 sky130_fd_pr__nfet_01v8 L=0.15U W=0.36U AS=0.0684P
+ AD=0.066P PS=0.74U PD=0.745U
* device instance $930 r0 *1 51.655,46.685 sky130_fd_pr__nfet_01v8
M$930 858 848 94 94 sky130_fd_pr__nfet_01v8 L=0.15U W=0.42U AS=0.1092P
+ AD=0.0678P PS=1.36U PD=0.755U
* device instance $931 r0 *1 53.145,46.685 sky130_fd_pr__nfet_01v8
M$931 94 867 857 857 sky130_fd_pr__nfet_01v8 L=0.15U W=0.42U AS=0.066P
+ AD=0.1092P PS=0.745U PD=1.36U
* device instance $932 r0 *1 54.085,46.685 sky130_fd_pr__nfet_01v8
M$932 94 849 867 867 sky130_fd_pr__nfet_01v8 L=0.15U W=0.42U AS=0.1092P
+ AD=0.10025P PS=1.36U PD=0.985U
* device instance $933 r0 *1 54.57,46.8 sky130_fd_pr__nfet_01v8
M$933 786 849 94 94 sky130_fd_pr__nfet_01v8 L=0.15U W=0.65U AS=0.10025P
+ AD=0.182P PS=0.985U PD=1.86U
* device instance $934 r0 *1 56.59,45.68 sky130_fd_pr__nfet_01v8
M$934 711 788 94 94 sky130_fd_pr__nfet_01v8 L=0.15U W=0.65U AS=0.169P
+ AD=0.08775P PS=1.82U PD=0.92U
* device instance $935 r0 *1 57.01,45.68 sky130_fd_pr__nfet_01v8
M$935 94 655 711 711 sky130_fd_pr__nfet_01v8 L=0.15U W=0.65U AS=0.08775P
+ AD=0.169P PS=0.92U PD=1.82U
* device instance $936 r0 *1 61.19,45.68 sky130_fd_pr__nfet_01v8
M$936 695 573 94 94 sky130_fd_pr__nfet_01v8 L=0.15U W=0.65U AS=0.169P
+ AD=0.08775P PS=1.82U PD=0.92U
* device instance $937 r0 *1 61.61,45.68 sky130_fd_pr__nfet_01v8
M$937 94 918 695 695 sky130_fd_pr__nfet_01v8 L=0.15U W=0.65U AS=0.08775P
+ AD=0.169P PS=0.92U PD=1.82U
* device instance $938 r0 *1 61.65,46.8 sky130_fd_pr__nfet_01v8
M$938 94 643 850 850 sky130_fd_pr__nfet_01v8 L=0.15U W=0.65U AS=0.169P
+ AD=0.08775P PS=1.82U PD=0.92U
* device instance $939 r0 *1 62.07,46.8 sky130_fd_pr__nfet_01v8
M$939 851 850 94 94 sky130_fd_pr__nfet_01v8 L=0.15U W=2.6U AS=0.351P
+ AD=0.43225P PS=3.68U PD=4.58U
* device instance $943 r0 *1 64.87,45.795 sky130_fd_pr__nfet_01v8
M$943 94 996 774 774 sky130_fd_pr__nfet_01v8 L=0.15U W=0.42U AS=0.1092P
+ AD=0.0567P PS=1.36U PD=0.69U
* device instance $944 r0 *1 65.29,45.795 sky130_fd_pr__nfet_01v8
M$944 775 774 94 94 sky130_fd_pr__nfet_01v8 L=0.15U W=0.42U AS=0.0567P
+ AD=0.1092P PS=0.69U PD=1.36U
* device instance $945 r0 *1 66.23,45.795 sky130_fd_pr__nfet_01v8
M$945 820 635 776 776 sky130_fd_pr__nfet_01v8 L=0.15U W=0.42U AS=0.1092P
+ AD=0.0441P PS=1.36U PD=0.63U
* device instance $946 r0 *1 66.59,45.795 sky130_fd_pr__nfet_01v8
M$946 94 1102 820 820 sky130_fd_pr__nfet_01v8 L=0.15U W=0.42U AS=0.0441P
+ AD=0.1092P PS=0.63U PD=1.36U
* device instance $947 r0 *1 67.53,45.795 sky130_fd_pr__nfet_01v8
M$947 94 1102 777 777 sky130_fd_pr__nfet_01v8 L=0.15U W=0.42U AS=0.1092P
+ AD=0.0609P PS=1.36U PD=0.71U
* device instance $948 r0 *1 67.97,45.795 sky130_fd_pr__nfet_01v8
M$948 818 777 94 94 sky130_fd_pr__nfet_01v8 L=0.15U W=0.42U AS=0.0609P
+ AD=0.0756P PS=0.71U PD=0.78U
* device instance $949 r0 *1 68.48,45.795 sky130_fd_pr__nfet_01v8
M$949 776 781 818 818 sky130_fd_pr__nfet_01v8 L=0.15U W=0.42U AS=0.0756P
+ AD=0.1446P PS=0.78U PD=1.18U
* device instance $950 r0 *1 69.39,45.825 sky130_fd_pr__nfet_01v8
M$950 778 774 776 776 sky130_fd_pr__nfet_01v8 L=0.15U W=0.36U AS=0.1446P
+ AD=0.0522P PS=1.18U PD=0.65U
* device instance $951 r0 *1 69.83,45.825 sky130_fd_pr__nfet_01v8
M$951 778 775 816 816 sky130_fd_pr__nfet_01v8 L=0.15U W=0.36U AS=0.0759P
+ AD=0.0522P PS=0.8U PD=0.65U
* device instance $952 r0 *1 70.36,45.795 sky130_fd_pr__nfet_01v8
M$952 816 779 94 94 sky130_fd_pr__nfet_01v8 L=0.15U W=0.42U AS=0.12095P
+ AD=0.0759P PS=1.085U PD=0.8U
* device instance $953 r0 *1 70.955,45.685 sky130_fd_pr__nfet_01v8
M$953 779 778 94 94 sky130_fd_pr__nfet_01v8 L=0.15U W=0.64U AS=0.12095P
+ AD=0.1664P PS=1.085U PD=1.8U
* device instance $954 r0 *1 71.895,45.795 sky130_fd_pr__nfet_01v8
M$954 814 779 94 94 sky130_fd_pr__nfet_01v8 L=0.15U W=0.42U AS=0.1092P
+ AD=0.0678P PS=1.36U PD=0.755U
* device instance $955 r0 *1 72.38,45.825 sky130_fd_pr__nfet_01v8
M$955 780 775 814 814 sky130_fd_pr__nfet_01v8 L=0.15U W=0.36U AS=0.0678P
+ AD=0.0684P PS=0.755U PD=0.74U
* device instance $956 r0 *1 72.91,45.825 sky130_fd_pr__nfet_01v8
M$956 780 774 812 812 sky130_fd_pr__nfet_01v8 L=0.15U W=0.36U AS=0.066P
+ AD=0.0684P PS=0.745U PD=0.74U
* device instance $957 r0 *1 73.385,45.795 sky130_fd_pr__nfet_01v8
M$957 94 781 812 812 sky130_fd_pr__nfet_01v8 L=0.15U W=0.42U AS=0.066P
+ AD=0.1092P PS=0.745U PD=1.36U
* device instance $958 r0 *1 74.325,45.795 sky130_fd_pr__nfet_01v8
M$958 781 780 94 94 sky130_fd_pr__nfet_01v8 L=0.15U W=0.42U AS=0.10025P
+ AD=0.1092P PS=0.985U PD=1.36U
* device instance $959 r0 *1 74.81,45.68 sky130_fd_pr__nfet_01v8
M$959 573 780 94 94 sky130_fd_pr__nfet_01v8 L=0.15U W=0.65U AS=0.10025P
+ AD=0.182P PS=0.985U PD=1.86U
* device instance $960 r0 *1 2.77,52.125 sky130_fd_pr__nfet_01v8
M$960 94 936 929 929 sky130_fd_pr__nfet_01v8 L=0.15U W=0.42U AS=0.1092P
+ AD=0.0567P PS=1.36U PD=0.69U
* device instance $961 r0 *1 3.19,52.125 sky130_fd_pr__nfet_01v8
M$961 930 929 94 94 sky130_fd_pr__nfet_01v8 L=0.15U W=0.42U AS=0.0567P
+ AD=0.1092P PS=0.69U PD=1.36U
* device instance $962 r0 *1 4.13,52.125 sky130_fd_pr__nfet_01v8
M$962 949 885 931 931 sky130_fd_pr__nfet_01v8 L=0.15U W=0.42U AS=0.1092P
+ AD=0.0441P PS=1.36U PD=0.63U
* device instance $963 r0 *1 4.49,52.125 sky130_fd_pr__nfet_01v8
M$963 94 93 949 949 sky130_fd_pr__nfet_01v8 L=0.15U W=0.42U AS=0.0441P
+ AD=0.1092P PS=0.63U PD=1.36U
* device instance $964 r0 *1 4.68,51.235 sky130_fd_pr__nfet_01v8
M$964 919 906 884 884 sky130_fd_pr__nfet_01v8 L=0.15U W=0.42U AS=0.1113P
+ AD=0.0441P PS=1.37U PD=0.63U
* device instance $965 r0 *1 5.04,51.235 sky130_fd_pr__nfet_01v8
M$965 94 109 919 919 sky130_fd_pr__nfet_01v8 L=0.15U W=0.42U AS=0.0441P
+ AD=0.0966P PS=0.63U PD=0.88U
* device instance $966 r0 *1 5.65,51.235 sky130_fd_pr__nfet_01v8
M$966 862 884 94 94 sky130_fd_pr__nfet_01v8 L=0.15U W=0.42U AS=0.0966P
+ AD=0.1113P PS=0.88U PD=1.37U
* device instance $967 r0 *1 7.29,52.095 sky130_fd_pr__nfet_01v8
M$967 932 929 931 931 sky130_fd_pr__nfet_01v8 L=0.15U W=0.36U AS=0.1446P
+ AD=0.0522P PS=1.18U PD=0.65U
* device instance $968 r0 *1 7.73,52.095 sky130_fd_pr__nfet_01v8
M$968 952 930 932 932 sky130_fd_pr__nfet_01v8 L=0.15U W=0.36U AS=0.0522P
+ AD=0.0759P PS=0.65U PD=0.8U
* device instance $969 r0 *1 5.43,52.125 sky130_fd_pr__nfet_01v8
M$969 94 93 943 943 sky130_fd_pr__nfet_01v8 L=0.15U W=0.42U AS=0.1092P
+ AD=0.0609P PS=1.36U PD=0.71U
* device instance $970 r0 *1 5.87,52.125 sky130_fd_pr__nfet_01v8
M$970 950 943 94 94 sky130_fd_pr__nfet_01v8 L=0.15U W=0.42U AS=0.0609P
+ AD=0.0756P PS=0.71U PD=0.78U
* device instance $971 r0 *1 6.38,52.125 sky130_fd_pr__nfet_01v8
M$971 931 944 950 950 sky130_fd_pr__nfet_01v8 L=0.15U W=0.42U AS=0.0756P
+ AD=0.1446P PS=0.78U PD=1.18U
* device instance $972 r0 *1 8.26,52.125 sky130_fd_pr__nfet_01v8
M$972 94 933 952 952 sky130_fd_pr__nfet_01v8 L=0.15U W=0.42U AS=0.0759P
+ AD=0.12095P PS=0.8U PD=1.085U
* device instance $973 r0 *1 8.855,52.235 sky130_fd_pr__nfet_01v8
M$973 933 932 94 94 sky130_fd_pr__nfet_01v8 L=0.15U W=0.64U AS=0.12095P
+ AD=0.1664P PS=1.085U PD=1.8U
* device instance $974 r0 *1 6.91,51.12 sky130_fd_pr__nfet_01v8
M$974 94 886 885 885 sky130_fd_pr__nfet_01v8 L=0.15U W=0.65U AS=0.169P
+ AD=0.11285P PS=1.82U PD=1.045U
* device instance $975 r0 *1 7.455,51.235 sky130_fd_pr__nfet_01v8
M$975 920 71 94 94 sky130_fd_pr__nfet_01v8 L=0.15U W=0.42U AS=0.11285P
+ AD=0.0693P PS=1.045U PD=0.75U
* device instance $976 r0 *1 7.935,51.235 sky130_fd_pr__nfet_01v8
M$976 886 914 920 920 sky130_fd_pr__nfet_01v8 L=0.15U W=0.42U AS=0.0693P
+ AD=0.09975P PS=0.75U PD=0.895U
* device instance $977 r0 *1 8.56,51.235 sky130_fd_pr__nfet_01v8
M$977 921 915 886 886 sky130_fd_pr__nfet_01v8 L=0.15U W=0.42U AS=0.09975P
+ AD=0.0693P PS=0.895U PD=0.75U
* device instance $978 r0 *1 9.04,51.235 sky130_fd_pr__nfet_01v8
M$978 94 916 921 921 sky130_fd_pr__nfet_01v8 L=0.15U W=0.42U AS=0.0693P
+ AD=0.1449P PS=0.75U PD=1.11U
* device instance $979 r0 *1 9.88,51.235 sky130_fd_pr__nfet_01v8
M$979 916 71 94 94 sky130_fd_pr__nfet_01v8 L=0.15U W=0.42U AS=0.1449P
+ AD=0.1092P PS=1.11U PD=1.36U
* device instance $980 r0 *1 10.28,52.095 sky130_fd_pr__nfet_01v8
M$980 934 930 953 953 sky130_fd_pr__nfet_01v8 L=0.15U W=0.36U AS=0.0678P
+ AD=0.0684P PS=0.755U PD=0.74U
* device instance $981 r0 *1 10.81,52.095 sky130_fd_pr__nfet_01v8
M$981 955 929 934 934 sky130_fd_pr__nfet_01v8 L=0.15U W=0.36U AS=0.0684P
+ AD=0.066P PS=0.74U PD=0.745U
* device instance $982 r0 *1 9.795,52.125 sky130_fd_pr__nfet_01v8
M$982 953 933 94 94 sky130_fd_pr__nfet_01v8 L=0.15U W=0.42U AS=0.1092P
+ AD=0.0678P PS=1.36U PD=0.755U
* device instance $983 r0 *1 11.285,52.125 sky130_fd_pr__nfet_01v8
M$983 94 944 955 955 sky130_fd_pr__nfet_01v8 L=0.15U W=0.42U AS=0.066P
+ AD=0.1092P PS=0.745U PD=1.36U
* device instance $984 r0 *1 11.09,51.12 sky130_fd_pr__nfet_01v8
M$984 887 863 94 94 sky130_fd_pr__nfet_01v8 L=0.15U W=0.65U AS=0.169P
+ AD=0.08775P PS=1.82U PD=0.92U
* device instance $985 r0 *1 11.51,51.12 sky130_fd_pr__nfet_01v8
M$985 94 915 887 887 sky130_fd_pr__nfet_01v8 L=0.15U W=0.65U AS=0.08775P
+ AD=0.08775P PS=0.92U PD=0.92U
* device instance $986 r0 *1 11.93,51.12 sky130_fd_pr__nfet_01v8
M$986 922 915 94 94 sky130_fd_pr__nfet_01v8 L=0.15U W=0.65U AS=0.08775P
+ AD=0.08775P PS=0.92U PD=0.92U
* device instance $987 r0 *1 12.35,51.12 sky130_fd_pr__nfet_01v8
M$987 864 863 922 922 sky130_fd_pr__nfet_01v8 L=0.15U W=0.65U AS=0.08775P
+ AD=0.25025P PS=0.92U PD=1.42U
* device instance $988 r0 *1 13.27,51.12 sky130_fd_pr__nfet_01v8
M$988 94 887 864 864 sky130_fd_pr__nfet_01v8 L=0.15U W=0.65U AS=0.25025P
+ AD=0.208P PS=1.42U PD=1.94U
* device instance $989 r0 *1 12.225,52.125 sky130_fd_pr__nfet_01v8
M$989 94 934 944 944 sky130_fd_pr__nfet_01v8 L=0.15U W=0.42U AS=0.1092P
+ AD=0.10025P PS=1.36U PD=0.985U
* device instance $990 r0 *1 12.71,52.24 sky130_fd_pr__nfet_01v8
M$990 834 934 94 94 sky130_fd_pr__nfet_01v8 L=0.15U W=0.65U AS=0.10025P
+ AD=0.182P PS=0.985U PD=1.86U
* device instance $991 r0 *1 13.81,52.24 sky130_fd_pr__nfet_01v8
M$991 94 865 945 945 sky130_fd_pr__nfet_01v8 L=0.15U W=0.65U AS=0.169P
+ AD=0.08775P PS=1.82U PD=0.92U
* device instance $992 r0 *1 14.23,52.24 sky130_fd_pr__nfet_01v8
M$992 915 945 94 94 sky130_fd_pr__nfet_01v8 L=0.15U W=2.6U AS=0.351P
+ AD=0.43225P PS=3.68U PD=4.58U
* device instance $996 r0 *1 19.64,52.125 sky130_fd_pr__nfet_01v8
M$996 936 935 94 94 sky130_fd_pr__nfet_01v8 L=0.15U W=6.72U AS=1.103975P
+ AD=0.93975P PS=11.925U PD=11.195U
* device instance $1012 r0 *1 26.515,52.125 sky130_fd_pr__nfet_01v8
M$1012 935 311 94 94 sky130_fd_pr__nfet_01v8 L=0.15U W=1.68U AS=0.2352P
+ AD=0.2877P PS=2.8U PD=3.47U
* device instance $1016 r0 *1 17.03,52.24 sky130_fd_pr__nfet_01v8
M$1016 94 834 946 946 sky130_fd_pr__nfet_01v8 L=0.15U W=0.65U AS=0.169P
+ AD=0.08775P PS=1.82U PD=0.92U
* device instance $1017 r0 *1 17.45,52.24 sky130_fd_pr__nfet_01v8
M$1017 863 946 94 94 sky130_fd_pr__nfet_01v8 L=0.15U W=2.6U AS=0.351P
+ AD=0.486275P PS=3.68U PD=4.19U
* device instance $1021 r0 *1 21.19,51.12 sky130_fd_pr__nfet_01v8
M$1021 917 863 94 94 sky130_fd_pr__nfet_01v8 L=0.15U W=2.6U AS=0.44525P
+ AD=0.351P PS=4.62U PD=3.68U
* device instance $1025 r0 *1 22.87,51.12 sky130_fd_pr__nfet_01v8
M$1025 917 890 94 94 sky130_fd_pr__nfet_01v8 L=0.15U W=2.6U AS=0.351P AD=0.52P
+ PS=3.68U PD=4.2U
* device instance $1029 r0 *1 25.07,51.12 sky130_fd_pr__nfet_01v8
M$1029 917 893 94 94 sky130_fd_pr__nfet_01v8 L=0.15U W=2.6U AS=0.52P AD=0.351P
+ PS=4.2U PD=3.68U
* device instance $1033 r0 *1 26.75,51.12 sky130_fd_pr__nfet_01v8
M$1033 917 406 94 94 sky130_fd_pr__nfet_01v8 L=0.15U W=2.6U AS=0.351P
+ AD=0.43225P PS=3.68U PD=4.58U
* device instance $1037 r0 *1 43.32,51.235 sky130_fd_pr__nfet_01v8
M$1037 926 907 894 894 sky130_fd_pr__nfet_01v8 L=0.15U W=0.42U AS=0.1113P
+ AD=0.0441P PS=1.37U PD=0.63U
* device instance $1038 r0 *1 43.68,51.235 sky130_fd_pr__nfet_01v8
M$1038 94 109 926 926 sky130_fd_pr__nfet_01v8 L=0.15U W=0.42U AS=0.0441P
+ AD=0.0966P PS=0.63U PD=0.88U
* device instance $1039 r0 *1 44.29,51.235 sky130_fd_pr__nfet_01v8
M$1039 784 894 94 94 sky130_fd_pr__nfet_01v8 L=0.15U W=0.42U AS=0.0966P
+ AD=0.1113P PS=0.88U PD=1.37U
* device instance $1040 r0 *1 56.13,52.24 sky130_fd_pr__nfet_01v8
M$1040 94 947 937 937 sky130_fd_pr__nfet_01v8 L=0.15U W=0.65U AS=0.169P
+ AD=0.08775P PS=1.82U PD=0.92U
* device instance $1041 r0 *1 56.55,52.24 sky130_fd_pr__nfet_01v8
M$1041 937 788 94 94 sky130_fd_pr__nfet_01v8 L=0.15U W=0.65U AS=0.08775P
+ AD=0.08775P PS=0.92U PD=0.92U
* device instance $1042 r0 *1 56.97,52.24 sky130_fd_pr__nfet_01v8
M$1042 94 978 937 937 sky130_fd_pr__nfet_01v8 L=0.15U W=0.65U AS=0.08775P
+ AD=0.26P PS=0.92U PD=1.45U
* device instance $1043 r0 *1 57.92,52.24 sky130_fd_pr__nfet_01v8
M$1043 938 937 94 94 sky130_fd_pr__nfet_01v8 L=0.15U W=2.6U AS=0.52325P
+ AD=0.5655P PS=4.21U PD=4.34U
* device instance $1047 r0 *1 60.26,52.24 sky130_fd_pr__nfet_01v8
M$1047 947 939 94 94 sky130_fd_pr__nfet_01v8 L=0.15U W=2.6U AS=0.5655P
+ AD=0.351P PS=4.34U PD=3.68U
* device instance $1051 r0 *1 61.94,52.24 sky130_fd_pr__nfet_01v8
M$1051 939 851 94 94 sky130_fd_pr__nfet_01v8 L=0.15U W=0.65U AS=0.08775P
+ AD=0.169P PS=0.92U PD=1.82U
* device instance $1052 r0 *1 64.87,51.235 sky130_fd_pr__nfet_01v8
M$1052 94 996 895 895 sky130_fd_pr__nfet_01v8 L=0.15U W=0.42U AS=0.1092P
+ AD=0.0567P PS=1.36U PD=0.69U
* device instance $1053 r0 *1 65.29,51.235 sky130_fd_pr__nfet_01v8
M$1053 896 895 94 94 sky130_fd_pr__nfet_01v8 L=0.15U W=0.42U AS=0.0567P
+ AD=0.1092P PS=0.69U PD=1.36U
* device instance $1054 r0 *1 66.23,51.235 sky130_fd_pr__nfet_01v8
M$1054 928 908 897 897 sky130_fd_pr__nfet_01v8 L=0.15U W=0.42U AS=0.1092P
+ AD=0.0441P PS=1.36U PD=0.63U
* device instance $1055 r0 *1 66.59,51.235 sky130_fd_pr__nfet_01v8
M$1055 94 1102 928 928 sky130_fd_pr__nfet_01v8 L=0.15U W=0.42U AS=0.0441P
+ AD=0.1092P PS=0.63U PD=1.36U
* device instance $1056 r0 *1 67.53,51.235 sky130_fd_pr__nfet_01v8
M$1056 94 1102 898 898 sky130_fd_pr__nfet_01v8 L=0.15U W=0.42U AS=0.1092P
+ AD=0.0609P PS=1.36U PD=0.71U
* device instance $1057 r0 *1 67.97,51.235 sky130_fd_pr__nfet_01v8
M$1057 927 898 94 94 sky130_fd_pr__nfet_01v8 L=0.15U W=0.42U AS=0.0609P
+ AD=0.0756P PS=0.71U PD=0.78U
* device instance $1058 r0 *1 68.48,51.235 sky130_fd_pr__nfet_01v8
M$1058 897 902 927 927 sky130_fd_pr__nfet_01v8 L=0.15U W=0.42U AS=0.0756P
+ AD=0.1446P PS=0.78U PD=1.18U
* device instance $1059 r0 *1 69.39,51.265 sky130_fd_pr__nfet_01v8
M$1059 899 895 897 897 sky130_fd_pr__nfet_01v8 L=0.15U W=0.36U AS=0.1446P
+ AD=0.0522P PS=1.18U PD=0.65U
* device instance $1060 r0 *1 69.83,51.265 sky130_fd_pr__nfet_01v8
M$1060 899 896 925 925 sky130_fd_pr__nfet_01v8 L=0.15U W=0.36U AS=0.0759P
+ AD=0.0522P PS=0.8U PD=0.65U
* device instance $1061 r0 *1 70.36,51.235 sky130_fd_pr__nfet_01v8
M$1061 925 900 94 94 sky130_fd_pr__nfet_01v8 L=0.15U W=0.42U AS=0.12095P
+ AD=0.0759P PS=1.085U PD=0.8U
* device instance $1062 r0 *1 70.955,51.125 sky130_fd_pr__nfet_01v8
M$1062 900 899 94 94 sky130_fd_pr__nfet_01v8 L=0.15U W=0.64U AS=0.12095P
+ AD=0.1664P PS=1.085U PD=1.8U
* device instance $1063 r0 *1 68.175,52.125 sky130_fd_pr__nfet_01v8
M$1063 954 71 94 94 sky130_fd_pr__nfet_01v8 L=0.15U W=0.42U AS=0.11285P
+ AD=0.0693P PS=1.045U PD=0.75U
* device instance $1064 r0 *1 68.655,52.125 sky130_fd_pr__nfet_01v8
M$1064 940 941 954 954 sky130_fd_pr__nfet_01v8 L=0.15U W=0.42U AS=0.0693P
+ AD=0.09975P PS=0.75U PD=0.895U
* device instance $1065 r0 *1 69.28,52.125 sky130_fd_pr__nfet_01v8
M$1065 951 948 940 940 sky130_fd_pr__nfet_01v8 L=0.15U W=0.42U AS=0.09975P
+ AD=0.0693P PS=0.895U PD=0.75U
* device instance $1066 r0 *1 69.76,52.125 sky130_fd_pr__nfet_01v8
M$1066 94 942 951 951 sky130_fd_pr__nfet_01v8 L=0.15U W=0.42U AS=0.0693P
+ AD=0.1449P PS=0.75U PD=1.11U
* device instance $1067 r0 *1 70.6,52.125 sky130_fd_pr__nfet_01v8
M$1067 942 71 94 94 sky130_fd_pr__nfet_01v8 L=0.15U W=0.42U AS=0.1449P
+ AD=0.1092P PS=1.11U PD=1.36U
* device instance $1068 r0 *1 67.63,52.24 sky130_fd_pr__nfet_01v8
M$1068 94 940 908 908 sky130_fd_pr__nfet_01v8 L=0.15U W=0.65U AS=0.169P
+ AD=0.11285P PS=1.82U PD=1.045U
* device instance $1069 r0 *1 71.895,51.235 sky130_fd_pr__nfet_01v8
M$1069 924 900 94 94 sky130_fd_pr__nfet_01v8 L=0.15U W=0.42U AS=0.1092P
+ AD=0.0678P PS=1.36U PD=0.755U
* device instance $1070 r0 *1 72.38,51.265 sky130_fd_pr__nfet_01v8
M$1070 901 896 924 924 sky130_fd_pr__nfet_01v8 L=0.15U W=0.36U AS=0.0678P
+ AD=0.0684P PS=0.755U PD=0.74U
* device instance $1071 r0 *1 72.91,51.265 sky130_fd_pr__nfet_01v8
M$1071 901 895 923 923 sky130_fd_pr__nfet_01v8 L=0.15U W=0.36U AS=0.066P
+ AD=0.0684P PS=0.745U PD=0.74U
* device instance $1072 r0 *1 73.385,51.235 sky130_fd_pr__nfet_01v8
M$1072 94 902 923 923 sky130_fd_pr__nfet_01v8 L=0.15U W=0.42U AS=0.066P
+ AD=0.1092P PS=0.745U PD=1.36U
* device instance $1073 r0 *1 74.325,51.235 sky130_fd_pr__nfet_01v8
M$1073 902 901 94 94 sky130_fd_pr__nfet_01v8 L=0.15U W=0.42U AS=0.10025P
+ AD=0.1092P PS=0.985U PD=1.36U
* device instance $1074 r0 *1 74.81,51.12 sky130_fd_pr__nfet_01v8
M$1074 918 901 94 94 sky130_fd_pr__nfet_01v8 L=0.15U W=0.65U AS=0.10025P
+ AD=0.182P PS=0.985U PD=1.86U
* device instance $1075 r0 *1 9.21,56.675 sky130_fd_pr__nfet_01v8
M$1075 94 936 965 965 sky130_fd_pr__nfet_01v8 L=0.15U W=0.42U AS=0.1092P
+ AD=0.0567P PS=1.36U PD=0.69U
* device instance $1076 r0 *1 9.63,56.675 sky130_fd_pr__nfet_01v8
M$1076 966 965 94 94 sky130_fd_pr__nfet_01v8 L=0.15U W=0.42U AS=0.0567P
+ AD=0.1092P PS=0.69U PD=1.36U
* device instance $1077 r0 *1 10.57,56.675 sky130_fd_pr__nfet_01v8
M$1077 1000 872 967 967 sky130_fd_pr__nfet_01v8 L=0.15U W=0.42U AS=0.1092P
+ AD=0.0441P PS=1.36U PD=0.63U
* device instance $1078 r0 *1 10.93,56.675 sky130_fd_pr__nfet_01v8
M$1078 94 16 1000 1000 sky130_fd_pr__nfet_01v8 L=0.15U W=0.42U AS=0.0441P
+ AD=0.1092P PS=0.63U PD=1.36U
* device instance $1079 r0 *1 11.87,56.675 sky130_fd_pr__nfet_01v8
M$1079 94 16 968 968 sky130_fd_pr__nfet_01v8 L=0.15U W=0.42U AS=0.1092P
+ AD=0.0609P PS=1.36U PD=0.71U
* device instance $1080 r0 *1 12.31,56.675 sky130_fd_pr__nfet_01v8
M$1080 1001 968 94 94 sky130_fd_pr__nfet_01v8 L=0.15U W=0.42U AS=0.0609P
+ AD=0.0756P PS=0.71U PD=0.78U
* device instance $1081 r0 *1 12.82,56.675 sky130_fd_pr__nfet_01v8
M$1081 967 972 1001 1001 sky130_fd_pr__nfet_01v8 L=0.15U W=0.42U AS=0.0756P
+ AD=0.1446P PS=0.78U PD=1.18U
* device instance $1082 r0 *1 13.73,56.705 sky130_fd_pr__nfet_01v8
M$1082 969 965 967 967 sky130_fd_pr__nfet_01v8 L=0.15U W=0.36U AS=0.1446P
+ AD=0.0522P PS=1.18U PD=0.65U
* device instance $1083 r0 *1 14.17,56.705 sky130_fd_pr__nfet_01v8
M$1083 969 966 1002 1002 sky130_fd_pr__nfet_01v8 L=0.15U W=0.36U AS=0.0759P
+ AD=0.0522P PS=0.8U PD=0.65U
* device instance $1084 r0 *1 14.7,56.675 sky130_fd_pr__nfet_01v8
M$1084 1002 970 94 94 sky130_fd_pr__nfet_01v8 L=0.15U W=0.42U AS=0.12095P
+ AD=0.0759P PS=1.085U PD=0.8U
* device instance $1085 r0 *1 15.295,56.565 sky130_fd_pr__nfet_01v8
M$1085 970 969 94 94 sky130_fd_pr__nfet_01v8 L=0.15U W=0.64U AS=0.12095P
+ AD=0.1664P PS=1.085U PD=1.8U
* device instance $1086 r0 *1 16.235,56.675 sky130_fd_pr__nfet_01v8
M$1086 1005 970 94 94 sky130_fd_pr__nfet_01v8 L=0.15U W=0.42U AS=0.1092P
+ AD=0.0678P PS=1.36U PD=0.755U
* device instance $1087 r0 *1 16.72,56.705 sky130_fd_pr__nfet_01v8
M$1087 971 966 1005 1005 sky130_fd_pr__nfet_01v8 L=0.15U W=0.36U AS=0.0678P
+ AD=0.0684P PS=0.755U PD=0.74U
* device instance $1088 r0 *1 17.25,56.705 sky130_fd_pr__nfet_01v8
M$1088 971 965 1006 1006 sky130_fd_pr__nfet_01v8 L=0.15U W=0.36U AS=0.066P
+ AD=0.0684P PS=0.745U PD=0.74U
* device instance $1089 r0 *1 17.725,56.675 sky130_fd_pr__nfet_01v8
M$1089 94 972 1006 1006 sky130_fd_pr__nfet_01v8 L=0.15U W=0.42U AS=0.066P
+ AD=0.1092P PS=0.745U PD=1.36U
* device instance $1090 r0 *1 18.665,56.675 sky130_fd_pr__nfet_01v8
M$1090 972 971 94 94 sky130_fd_pr__nfet_01v8 L=0.15U W=0.42U AS=0.10025P
+ AD=0.1092P PS=0.985U PD=1.36U
* device instance $1091 r0 *1 19.15,56.56 sky130_fd_pr__nfet_01v8
M$1091 865 971 94 94 sky130_fd_pr__nfet_01v8 L=0.15U W=0.65U AS=0.10025P
+ AD=0.182P PS=0.985U PD=1.86U
* device instance $1092 r0 *1 28.305,56.675 sky130_fd_pr__nfet_01v8
M$1092 983 890 94 94 sky130_fd_pr__nfet_01v8 L=0.15U W=0.42U AS=0.10025P
+ AD=0.1092P PS=0.985U PD=1.36U
* device instance $1093 r0 *1 28.79,56.56 sky130_fd_pr__nfet_01v8
M$1093 994 995 94 94 sky130_fd_pr__nfet_01v8 L=0.15U W=0.65U AS=0.10025P
+ AD=0.08775P PS=0.985U PD=0.92U
* device instance $1094 r0 *1 29.21,56.56 sky130_fd_pr__nfet_01v8
M$1094 94 983 994 994 sky130_fd_pr__nfet_01v8 L=0.15U W=0.65U AS=0.08775P
+ AD=0.169P PS=0.92U PD=1.82U
* device instance $1095 r0 *1 30.85,56.56 sky130_fd_pr__nfet_01v8
M$1095 997 984 94 94 sky130_fd_pr__nfet_01v8 L=0.15U W=2.6U AS=0.44525P
+ AD=0.351P PS=4.62U PD=3.68U
* device instance $1099 r0 *1 32.53,56.56 sky130_fd_pr__nfet_01v8
M$1099 997 109 94 94 sky130_fd_pr__nfet_01v8 L=0.15U W=2.6U AS=0.351P
+ AD=0.43225P PS=3.68U PD=4.58U
* device instance $1102 r0 *1 33.79,56.56 sky130_fd_pr__nfet_01v8
M$1102 94 994 997 997 sky130_fd_pr__nfet_01v8 L=0.15U W=2.6U AS=0.351P
+ AD=0.351P PS=3.68U PD=3.68U
* device instance $1107 r0 *1 43.26,56.675 sky130_fd_pr__nfet_01v8
M$1107 975 996 94 94 sky130_fd_pr__nfet_01v8 L=0.15U W=0.84U AS=0.1701P
+ AD=0.168P PS=2.07U PD=2.06U
* device instance $1109 r0 *1 44.635,56.675 sky130_fd_pr__nfet_01v8
M$1109 976 311 94 94 sky130_fd_pr__nfet_01v8 L=0.15U W=1.68U AS=0.2877P
+ AD=0.2352P PS=3.47U PD=2.8U
* device instance $1113 r0 *1 46.355,56.675 sky130_fd_pr__nfet_01v8
M$1113 996 976 94 94 sky130_fd_pr__nfet_01v8 L=0.15U W=6.72U AS=0.93975P
+ AD=0.99225P PS=11.195U PD=11.865U
* device instance $1129 r0 *1 59.38,56.675 sky130_fd_pr__nfet_01v8
M$1129 94 788 998 998 sky130_fd_pr__nfet_01v8 L=0.15U W=0.42U AS=0.1113P
+ AD=0.0588P PS=1.37U PD=0.7U
* device instance $1130 r0 *1 59.81,56.675 sky130_fd_pr__nfet_01v8
M$1130 998 947 94 94 sky130_fd_pr__nfet_01v8 L=0.15U W=0.42U AS=0.0588P
+ AD=0.0588P PS=0.7U PD=0.7U
* device instance $1131 r0 *1 60.24,56.675 sky130_fd_pr__nfet_01v8
M$1131 977 978 998 998 sky130_fd_pr__nfet_01v8 L=0.15U W=0.42U AS=0.0588P
+ AD=0.1113P PS=0.7U PD=1.37U
* device instance $1132 r0 *1 62.115,56.56 sky130_fd_pr__nfet_01v8
M$1132 1007 938 979 979 sky130_fd_pr__nfet_01v8 L=0.15U W=0.65U AS=0.17225P
+ AD=0.06825P PS=1.83U PD=0.86U
* device instance $1133 r0 *1 62.475,56.56 sky130_fd_pr__nfet_01v8
M$1133 94 977 1007 1007 sky130_fd_pr__nfet_01v8 L=0.15U W=0.65U AS=0.06825P
+ AD=0.138125P PS=0.86U PD=1.075U
* device instance $1134 r0 *1 63.05,56.56 sky130_fd_pr__nfet_01v8
M$1134 980 979 94 94 sky130_fd_pr__nfet_01v8 L=0.15U W=2.6U AS=0.411125P
+ AD=0.45825P PS=3.865U PD=4.66U
* device instance $1138 r0 *1 65.745,56.675 sky130_fd_pr__nfet_01v8
M$1138 94 981 978 978 sky130_fd_pr__nfet_01v8 L=0.15U W=0.42U AS=0.1092P
+ AD=0.1197P PS=1.36U PD=1.41U
* device instance $1139 r0 *1 66.71,56.445 sky130_fd_pr__nfet_01v8
M$1139 94 918 985 985 sky130_fd_pr__nfet_01v8 L=0.15U W=0.42U AS=0.1092P
+ AD=0.10025P PS=1.36U PD=0.985U
* device instance $1140 r0 *1 67.195,56.56 sky130_fd_pr__nfet_01v8
M$1140 1004 948 94 94 sky130_fd_pr__nfet_01v8 L=0.15U W=0.65U AS=0.10025P
+ AD=0.08775P PS=0.985U PD=0.92U
* device instance $1141 r0 *1 67.615,56.56 sky130_fd_pr__nfet_01v8
M$1141 1020 985 1004 1004 sky130_fd_pr__nfet_01v8 L=0.15U W=0.65U AS=0.08775P
+ AD=0.169P PS=0.92U PD=1.82U
* device instance $1142 r0 *1 69.11,56.56 sky130_fd_pr__nfet_01v8
M$1142 1003 948 982 982 sky130_fd_pr__nfet_01v8 L=0.15U W=0.65U AS=0.169P
+ AD=0.06825P PS=1.82U PD=0.86U
* device instance $1143 r0 *1 69.47,56.56 sky130_fd_pr__nfet_01v8
M$1143 94 918 1003 1003 sky130_fd_pr__nfet_01v8 L=0.15U W=0.65U AS=0.06825P
+ AD=0.08775P PS=0.86U PD=0.92U
* device instance $1144 r0 *1 69.89,56.56 sky130_fd_pr__nfet_01v8
M$1144 999 918 94 94 sky130_fd_pr__nfet_01v8 L=0.15U W=0.65U AS=0.08775P
+ AD=0.169P PS=0.92U PD=1.82U
* device instance $1145 r0 *1 70.83,56.56 sky130_fd_pr__nfet_01v8
M$1145 999 948 94 94 sky130_fd_pr__nfet_01v8 L=0.15U W=0.65U AS=0.169P
+ AD=0.08775P PS=1.82U PD=0.92U
* device instance $1146 r0 *1 71.25,56.56 sky130_fd_pr__nfet_01v8
M$1146 981 982 999 999 sky130_fd_pr__nfet_01v8 L=0.15U W=0.65U AS=0.08775P
+ AD=0.195P PS=0.92U PD=1.9U
* device instance $1147 r0 *1 15.665,62 sky130_fd_pr__nfet_01v8
M$1147 94 1061 1045 1045 sky130_fd_pr__nfet_01v8 L=0.15U W=0.65U AS=0.169P
+ AD=0.105625P PS=1.82U PD=0.975U
* device instance $1148 r0 *1 16.14,62 sky130_fd_pr__nfet_01v8
M$1148 71 1045 94 94 sky130_fd_pr__nfet_01v8 L=0.15U W=2.6U AS=0.37375P
+ AD=0.453375P PS=3.75U PD=4.645U
* device instance $1152 r0 *1 20.73,62 sky130_fd_pr__nfet_01v8
M$1152 1062 1100 94 94 sky130_fd_pr__nfet_01v8 L=0.15U W=2.6U AS=0.44525P
+ AD=0.351P PS=4.62U PD=3.68U
* device instance $1156 r0 *1 22.41,62 sky130_fd_pr__nfet_01v8
M$1156 1062 1008 94 94 sky130_fd_pr__nfet_01v8 L=0.15U W=2.6U AS=0.351P
+ AD=0.59475P PS=3.68U PD=4.43U
* device instance $1160 r0 *1 24.84,62 sky130_fd_pr__nfet_01v8
M$1160 93 1047 94 94 sky130_fd_pr__nfet_01v8 L=0.15U W=5.2U AS=0.94575P
+ AD=0.702P PS=8.11U PD=7.36U
* device instance $1168 r0 *1 28.2,62 sky130_fd_pr__nfet_01v8
M$1168 1047 1062 94 94 sky130_fd_pr__nfet_01v8 L=0.15U W=1.95U AS=0.26325P
+ AD=0.3445P PS=2.76U PD=3.66U
* device instance $1171 r0 *1 24.87,57.68 sky130_fd_pr__nfet_01v8
M$1171 1008 71 94 94 sky130_fd_pr__nfet_01v8 L=0.15U W=1.3U AS=0.2665P
+ AD=0.1755P PS=2.77U PD=1.84U
* device instance $1173 r0 *1 25.71,57.68 sky130_fd_pr__nfet_01v8
M$1173 1008 994 94 94 sky130_fd_pr__nfet_01v8 L=0.15U W=1.3U AS=0.1755P
+ AD=0.25675P PS=1.84U PD=2.74U
* device instance $1175 r0 *1 27.09,57.68 sky130_fd_pr__nfet_01v8
M$1175 1008 1024 94 94 sky130_fd_pr__nfet_01v8 L=0.15U W=1.3U AS=0.25675P
+ AD=0.25675P PS=2.74U PD=2.74U
* device instance $1177 r0 *1 28.65,57.68 sky130_fd_pr__nfet_01v8
M$1177 94 109 1009 1009 sky130_fd_pr__nfet_01v8 L=0.15U W=0.65U AS=0.19825P
+ AD=0.08775P PS=1.91U PD=0.92U
* device instance $1178 r0 *1 29.07,57.68 sky130_fd_pr__nfet_01v8
M$1178 90 1010 94 94 sky130_fd_pr__nfet_01v8 L=0.15U W=2.6U AS=0.351P
+ AD=0.43225P PS=3.68U PD=4.58U
* device instance $1182 r0 *1 31.27,57.68 sky130_fd_pr__nfet_01v8
M$1182 1010 1009 1011 1011 sky130_fd_pr__nfet_01v8 L=0.15U W=1.3U AS=0.25675P
+ AD=0.1755P PS=2.74U PD=1.84U
* device instance $1184 r0 *1 32.11,57.68 sky130_fd_pr__nfet_01v8
M$1184 94 1024 1011 1011 sky130_fd_pr__nfet_01v8 L=0.15U W=1.3U AS=0.1755P
+ AD=0.1755P PS=1.84U PD=1.84U
* device instance $1186 r0 *1 32.95,57.68 sky130_fd_pr__nfet_01v8
M$1186 94 994 1011 1011 sky130_fd_pr__nfet_01v8 L=0.15U W=1.3U AS=0.1755P
+ AD=0.26975P PS=1.84U PD=2.78U
* device instance $1188 r0 *1 32.21,62 sky130_fd_pr__nfet_01v8
M$1188 1048 994 94 94 sky130_fd_pr__nfet_01v8 L=0.15U W=0.65U AS=0.169P
+ AD=0.08775P PS=1.82U PD=0.92U
* device instance $1189 r0 *1 32.63,62 sky130_fd_pr__nfet_01v8
M$1189 94 1063 1048 1048 sky130_fd_pr__nfet_01v8 L=0.15U W=0.65U AS=0.08775P
+ AD=0.169P PS=0.92U PD=1.82U
* device instance $1190 r0 *1 33.825,62.115 sky130_fd_pr__nfet_01v8
M$1190 1064 995 94 94 sky130_fd_pr__nfet_01v8 L=0.15U W=0.42U AS=0.10025P
+ AD=0.1092P PS=0.985U PD=1.36U
* device instance $1191 r0 *1 34.31,62 sky130_fd_pr__nfet_01v8
M$1191 1063 890 94 94 sky130_fd_pr__nfet_01v8 L=0.15U W=0.65U AS=0.10025P
+ AD=0.08775P PS=0.985U PD=0.92U
* device instance $1192 r0 *1 34.73,62 sky130_fd_pr__nfet_01v8
M$1192 94 1064 1063 1063 sky130_fd_pr__nfet_01v8 L=0.15U W=0.65U AS=0.08775P
+ AD=0.169P PS=0.92U PD=1.82U
* device instance $1193 r0 *1 34.97,57.68 sky130_fd_pr__nfet_01v8
M$1193 94 984 1012 1012 sky130_fd_pr__nfet_01v8 L=0.15U W=0.65U AS=0.169P
+ AD=0.08775P PS=1.82U PD=0.92U
* device instance $1194 r0 *1 35.39,57.68 sky130_fd_pr__nfet_01v8
M$1194 1024 1012 94 94 sky130_fd_pr__nfet_01v8 L=0.15U W=2.6U AS=0.351P
+ AD=0.4615P PS=3.68U PD=4.02U
* device instance $1198 r0 *1 37.41,57.68 sky130_fd_pr__nfet_01v8
M$1198 1013 997 94 94 sky130_fd_pr__nfet_01v8 L=0.15U W=1.3U AS=0.286P
+ AD=0.1755P PS=2.18U PD=1.84U
* device instance $1200 r0 *1 38.25,57.68 sky130_fd_pr__nfet_01v8
M$1200 87 1013 94 94 sky130_fd_pr__nfet_01v8 L=0.15U W=3.9U AS=0.5265P
+ AD=0.60775P PS=5.52U PD=6.42U
* device instance $1206 r0 *1 40.03,62 sky130_fd_pr__nfet_01v8
M$1206 94 1068 1082 1082 sky130_fd_pr__nfet_01v8 L=0.15U W=1.3U AS=0.25675P
+ AD=0.1755P PS=2.74U PD=1.84U
* device instance $1208 r0 *1 40.87,62 sky130_fd_pr__nfet_01v8
M$1208 1084 1034 1082 1082 sky130_fd_pr__nfet_01v8 L=0.15U W=1.3U AS=0.1755P
+ AD=0.25675P PS=1.84U PD=2.74U
* device instance $1210 r0 *1 42.23,62 sky130_fd_pr__nfet_01v8
M$1210 1084 1081 1065 1065 sky130_fd_pr__nfet_01v8 L=0.15U W=1.3U AS=0.25675P
+ AD=0.18525P PS=2.74U PD=1.87U
* device instance $1212 r0 *1 43.1,62 sky130_fd_pr__nfet_01v8
M$1212 94 1063 1065 1065 sky130_fd_pr__nfet_01v8 L=0.15U W=1.3U AS=0.18525P
+ AD=0.25675P PS=1.87U PD=2.09U
* device instance $1214 r0 *1 44.19,62 sky130_fd_pr__nfet_01v8
M$1214 94 1066 1065 1065 sky130_fd_pr__nfet_01v8 L=0.15U W=1.3U AS=0.25675P
+ AD=0.25675P PS=2.09U PD=2.74U
* device instance $1216 r0 *1 42.33,57.68 sky130_fd_pr__nfet_01v8
M$1216 1014 1025 94 94 sky130_fd_pr__nfet_01v8 L=0.15U W=0.65U AS=0.169P
+ AD=0.08775P PS=1.82U PD=0.92U
* device instance $1217 r0 *1 42.75,57.68 sky130_fd_pr__nfet_01v8
M$1217 94 1015 1014 1014 sky130_fd_pr__nfet_01v8 L=0.15U W=0.65U AS=0.08775P
+ AD=0.169P PS=0.92U PD=1.82U
* device instance $1218 r0 *1 45.57,62 sky130_fd_pr__nfet_01v8
M$1218 1015 1081 94 94 sky130_fd_pr__nfet_01v8 L=0.15U W=0.65U AS=0.17225P
+ AD=0.091P PS=1.83U PD=0.93U
* device instance $1219 r0 *1 46,62 sky130_fd_pr__nfet_01v8
M$1219 1095 1068 1015 1015 sky130_fd_pr__nfet_01v8 L=0.15U W=0.65U AS=0.091P
+ AD=0.095875P PS=0.93U PD=0.945U
* device instance $1220 r0 *1 46.445,62 sky130_fd_pr__nfet_01v8
M$1220 94 1069 1095 1095 sky130_fd_pr__nfet_01v8 L=0.15U W=0.65U AS=0.095875P
+ AD=0.17225P PS=0.945U PD=1.83U
* device instance $1221 r0 *1 46.01,57.68 sky130_fd_pr__nfet_01v8
M$1221 94 997 1016 1016 sky130_fd_pr__nfet_01v8 L=0.15U W=0.65U AS=0.169P
+ AD=0.08775P PS=1.82U PD=0.92U
* device instance $1222 r0 *1 46.43,57.68 sky130_fd_pr__nfet_01v8
M$1222 1017 1016 94 94 sky130_fd_pr__nfet_01v8 L=0.15U W=2.6U AS=0.351P
+ AD=0.54275P PS=3.68U PD=4.27U
* device instance $1226 r0 *1 48.7,57.68 sky130_fd_pr__nfet_01v8
M$1226 1018 851 94 94 sky130_fd_pr__nfet_01v8 L=0.15U W=2.6U AS=0.54275P
+ AD=0.351P PS=4.27U PD=3.68U
* device instance $1230 r0 *1 50.38,57.68 sky130_fd_pr__nfet_01v8
M$1230 1018 788 94 94 sky130_fd_pr__nfet_01v8 L=0.15U W=2.6U AS=0.351P
+ AD=0.3575P PS=3.68U PD=3.7U
* device instance $1234 r0 *1 52.08,57.68 sky130_fd_pr__nfet_01v8
M$1234 1018 978 94 94 sky130_fd_pr__nfet_01v8 L=0.15U W=2.6U AS=0.3575P
+ AD=0.44525P PS=3.7U PD=4.62U
* device instance $1238 r0 *1 49.69,62 sky130_fd_pr__nfet_01v8
M$1238 94 1068 1083 1083 sky130_fd_pr__nfet_01v8 L=0.15U W=1.3U AS=0.25675P
+ AD=0.1755P PS=2.74U PD=1.84U
* device instance $1240 r0 *1 50.53,62 sky130_fd_pr__nfet_01v8
M$1240 1085 1069 1083 1083 sky130_fd_pr__nfet_01v8 L=0.15U W=1.3U AS=0.1755P
+ AD=0.25675P PS=1.84U PD=2.74U
* device instance $1242 r0 *1 51.89,62 sky130_fd_pr__nfet_01v8
M$1242 1085 1081 1070 1070 sky130_fd_pr__nfet_01v8 L=0.15U W=1.3U AS=0.2665P
+ AD=0.2145P PS=2.77U PD=1.96U
* device instance $1244 r0 *1 52.85,62 sky130_fd_pr__nfet_01v8
M$1244 94 1066 1070 1070 sky130_fd_pr__nfet_01v8 L=0.15U W=1.3U AS=0.23075P
+ AD=0.28275P PS=2.01U PD=2.82U
* device instance $1246 r0 *1 54.32,57.68 sky130_fd_pr__nfet_01v8
M$1246 1018 1020 1019 1019 sky130_fd_pr__nfet_01v8 L=0.15U W=2.6U AS=0.44525P
+ AD=0.351P PS=4.62U PD=3.68U
* device instance $1250 r0 *1 56,57.68 sky130_fd_pr__nfet_01v8
M$1250 1034 1021 1019 1019 sky130_fd_pr__nfet_01v8 L=0.15U W=2.6U AS=0.351P
+ AD=0.44525P PS=3.68U PD=4.62U
* device instance $1254 r0 *1 60.27,57.68 sky130_fd_pr__nfet_01v8
M$1254 94 1026 1022 1022 sky130_fd_pr__nfet_01v8 L=0.15U W=0.65U AS=0.169P
+ AD=0.10725P PS=1.82U PD=0.98U
* device instance $1255 r0 *1 60.75,57.68 sky130_fd_pr__nfet_01v8
M$1255 1029 918 94 94 sky130_fd_pr__nfet_01v8 L=0.15U W=0.65U AS=0.10725P
+ AD=0.06825P PS=0.98U PD=0.86U
* device instance $1256 r0 *1 61.11,57.68 sky130_fd_pr__nfet_01v8
M$1256 1022 90 1029 1029 sky130_fd_pr__nfet_01v8 L=0.15U W=0.65U AS=0.06825P
+ AD=0.169P PS=0.86U PD=1.82U
* device instance $1257 r0 *1 62.05,57.68 sky130_fd_pr__nfet_01v8
M$1257 1028 1017 1022 1022 sky130_fd_pr__nfet_01v8 L=0.15U W=0.65U AS=0.169P
+ AD=0.10725P PS=1.82U PD=0.98U
* device instance $1258 r0 *1 62.53,57.68 sky130_fd_pr__nfet_01v8
M$1258 94 980 1028 1028 sky130_fd_pr__nfet_01v8 L=0.15U W=0.65U AS=0.10725P
+ AD=0.102375P PS=0.98U PD=0.965U
* device instance $1259 r0 *1 62.995,57.68 sky130_fd_pr__nfet_01v8
M$1259 1037 1022 94 94 sky130_fd_pr__nfet_01v8 L=0.15U W=0.65U AS=0.102375P
+ AD=0.169P PS=0.965U PD=1.82U
* device instance $1260 r0 *1 63.97,57.68 sky130_fd_pr__nfet_01v8
M$1260 1027 938 94 94 sky130_fd_pr__nfet_01v8 L=0.15U W=0.65U AS=0.169P
+ AD=0.08775P PS=1.82U PD=0.92U
* device instance $1261 r0 *1 64.39,57.68 sky130_fd_pr__nfet_01v8
M$1261 1023 1020 1027 1027 sky130_fd_pr__nfet_01v8 L=0.15U W=0.65U AS=0.08775P
+ AD=0.169P PS=0.92U PD=1.82U
* device instance $1262 r0 *1 72.945,62.115 sky130_fd_pr__nfet_01v8
M$1262 1060 1059 94 94 sky130_fd_pr__nfet_01v8 L=0.15U W=0.42U AS=0.10025P
+ AD=0.1092P PS=0.985U PD=1.36U
* device instance $1263 r0 *1 73.43,62 sky130_fd_pr__nfet_01v8
M$1263 948 1059 94 94 sky130_fd_pr__nfet_01v8 L=0.15U W=0.65U AS=0.10025P
+ AD=0.182P PS=0.985U PD=1.86U
* device instance $1264 r0 *1 8.245,63.005 sky130_fd_pr__nfet_01v8
M$1264 94 1117 1199 1199 sky130_fd_pr__nfet_01v8 L=0.15U W=0.42U AS=0.1092P
+ AD=0.1197P PS=1.36U PD=1.41U
* device instance $1265 r0 *1 9.21,63.12 sky130_fd_pr__nfet_01v8
M$1265 1097 1118 1096 1096 sky130_fd_pr__nfet_01v8 L=0.15U W=0.65U AS=0.169P
+ AD=0.092625P PS=1.82U PD=0.935U
* device instance $1266 r0 *1 9.645,63.12 sky130_fd_pr__nfet_01v8
M$1266 1096 1117 1097 1097 sky130_fd_pr__nfet_01v8 L=0.15U W=0.65U AS=0.092625P
+ AD=0.115375P PS=0.935U PD=1.005U
* device instance $1267 r0 *1 10.15,63.12 sky130_fd_pr__nfet_01v8
M$1267 94 1098 1096 1096 sky130_fd_pr__nfet_01v8 L=0.15U W=0.65U AS=0.115375P
+ AD=0.08775P PS=1.005U PD=0.92U
* device instance $1268 r0 *1 10.57,63.12 sky130_fd_pr__nfet_01v8
M$1268 1096 917 94 94 sky130_fd_pr__nfet_01v8 L=0.15U W=0.65U AS=0.08775P
+ AD=0.169P PS=0.92U PD=1.82U
* device instance $1269 r0 *1 9.67,62.115 sky130_fd_pr__nfet_01v8
M$1269 94 936 1040 1040 sky130_fd_pr__nfet_01v8 L=0.15U W=0.42U AS=0.1092P
+ AD=0.0567P PS=1.36U PD=0.69U
* device instance $1270 r0 *1 10.09,62.115 sky130_fd_pr__nfet_01v8
M$1270 1041 1040 94 94 sky130_fd_pr__nfet_01v8 L=0.15U W=0.42U AS=0.0567P
+ AD=0.1092P PS=0.69U PD=1.36U
* device instance $1271 r0 *1 11.03,62.115 sky130_fd_pr__nfet_01v8
M$1271 1042 1080 94 94 sky130_fd_pr__nfet_01v8 L=0.15U W=0.42U AS=0.1092P
+ AD=0.066P PS=1.36U PD=0.745U
* device instance $1272 r0 *1 11.505,62.145 sky130_fd_pr__nfet_01v8
M$1272 1043 1040 1042 1042 sky130_fd_pr__nfet_01v8 L=0.15U W=0.36U AS=0.066P
+ AD=0.0594P PS=0.745U PD=0.69U
* device instance $1273 r0 *1 11.985,62.145 sky130_fd_pr__nfet_01v8
M$1273 1043 1041 1088 1088 sky130_fd_pr__nfet_01v8 L=0.15U W=0.36U AS=0.0687P
+ AD=0.0594P PS=0.76U PD=0.69U
* device instance $1274 r0 *1 12.475,62.115 sky130_fd_pr__nfet_01v8
M$1274 1088 1044 94 94 sky130_fd_pr__nfet_01v8 L=0.15U W=0.42U AS=0.1493P
+ AD=0.0687P PS=1.22U PD=0.76U
* device instance $1275 r0 *1 13.205,62.005 sky130_fd_pr__nfet_01v8
M$1275 1044 1043 94 94 sky130_fd_pr__nfet_01v8 L=0.15U W=0.64U AS=0.1493P
+ AD=0.0989P PS=1.22U PD=0.995U
* device instance $1276 r0 *1 13.71,62.145 sky130_fd_pr__nfet_01v8
M$1276 1061 1041 1044 1044 sky130_fd_pr__nfet_01v8 L=0.15U W=0.36U AS=0.0989P
+ AD=0.0657P PS=0.995U PD=0.725U
* device instance $1277 r0 *1 14.225,62.145 sky130_fd_pr__nfet_01v8
M$1277 1061 1040 1090 1090 sky130_fd_pr__nfet_01v8 L=0.15U W=0.36U AS=0.066P
+ AD=0.0657P PS=0.745U PD=0.725U
* device instance $1278 r0 *1 14.7,62.115 sky130_fd_pr__nfet_01v8
M$1278 94 1045 1090 1090 sky130_fd_pr__nfet_01v8 L=0.15U W=0.42U AS=0.066P
+ AD=0.1197P PS=0.745U PD=1.41U
* device instance $1279 r0 *1 11.53,63.12 sky130_fd_pr__nfet_01v8
M$1279 1125 1119 94 94 sky130_fd_pr__nfet_01v8 L=0.15U W=0.65U AS=0.169P
+ AD=0.08775P PS=1.82U PD=0.92U
* device instance $1280 r0 *1 11.95,63.12 sky130_fd_pr__nfet_01v8
M$1280 109 1099 1125 1125 sky130_fd_pr__nfet_01v8 L=0.15U W=0.65U AS=0.08775P
+ AD=0.169P PS=0.92U PD=1.82U
* device instance $1281 r0 *1 13.305,63.005 sky130_fd_pr__nfet_01v8
M$1281 94 71 1099 1099 sky130_fd_pr__nfet_01v8 L=0.15U W=0.42U AS=0.1092P
+ AD=0.1197P PS=1.36U PD=1.41U
* device instance $1282 r0 *1 17.05,63.12 sky130_fd_pr__nfet_01v8
M$1282 1100 1119 94 94 sky130_fd_pr__nfet_01v8 L=0.15U W=2.6U AS=0.44525P
+ AD=0.351P PS=4.62U PD=3.68U
* device instance $1286 r0 *1 18.73,63.12 sky130_fd_pr__nfet_01v8
M$1286 1100 71 94 94 sky130_fd_pr__nfet_01v8 L=0.15U W=2.6U AS=0.351P
+ AD=0.43225P PS=3.68U PD=4.58U
* device instance $1290 r0 *1 22.255,63.12 sky130_fd_pr__nfet_01v8
M$1290 16 1100 94 94 sky130_fd_pr__nfet_01v8 L=0.15U W=5.2U AS=0.78325P
+ AD=0.78325P PS=8.26U PD=8.26U
* device instance $1298 r0 *1 26.49,63.12 sky130_fd_pr__nfet_01v8
M$1298 1101 1062 94 94 sky130_fd_pr__nfet_01v8 L=0.15U W=1.3U AS=0.25675P
+ AD=0.1755P PS=2.74U PD=1.84U
* device instance $1300 r0 *1 27.33,63.12 sky130_fd_pr__nfet_01v8
M$1300 1102 1101 94 94 sky130_fd_pr__nfet_01v8 L=0.15U W=3.9U AS=0.5265P
+ AD=0.60775P PS=5.52U PD=6.42U
* device instance $1306 r0 *1 30.37,63.005 sky130_fd_pr__nfet_01v8
M$1306 94 936 1103 1103 sky130_fd_pr__nfet_01v8 L=0.15U W=0.42U AS=0.1092P
+ AD=0.0567P PS=1.36U PD=0.69U
* device instance $1307 r0 *1 30.79,63.005 sky130_fd_pr__nfet_01v8
M$1307 1104 1103 94 94 sky130_fd_pr__nfet_01v8 L=0.15U W=0.42U AS=0.0567P
+ AD=0.1092P PS=0.69U PD=1.36U
* device instance $1308 r0 *1 31.73,63.005 sky130_fd_pr__nfet_01v8
M$1308 1131 1133 1105 1105 sky130_fd_pr__nfet_01v8 L=0.15U W=0.42U AS=0.1092P
+ AD=0.0441P PS=1.36U PD=0.63U
* device instance $1309 r0 *1 32.09,63.005 sky130_fd_pr__nfet_01v8
M$1309 94 16 1131 1131 sky130_fd_pr__nfet_01v8 L=0.15U W=0.42U AS=0.0441P
+ AD=0.1092P PS=0.63U PD=1.36U
* device instance $1310 r0 *1 34.89,62.975 sky130_fd_pr__nfet_01v8
M$1310 1107 1103 1105 1105 sky130_fd_pr__nfet_01v8 L=0.15U W=0.36U AS=0.1446P
+ AD=0.0522P PS=1.18U PD=0.65U
* device instance $1311 r0 *1 35.33,62.975 sky130_fd_pr__nfet_01v8
M$1311 1129 1104 1107 1107 sky130_fd_pr__nfet_01v8 L=0.15U W=0.36U AS=0.0522P
+ AD=0.0759P PS=0.65U PD=0.8U
* device instance $1312 r0 *1 33.03,63.005 sky130_fd_pr__nfet_01v8
M$1312 94 16 1106 1106 sky130_fd_pr__nfet_01v8 L=0.15U W=0.42U AS=0.1092P
+ AD=0.0609P PS=1.36U PD=0.71U
* device instance $1313 r0 *1 33.47,63.005 sky130_fd_pr__nfet_01v8
M$1313 1130 1106 94 94 sky130_fd_pr__nfet_01v8 L=0.15U W=0.42U AS=0.0609P
+ AD=0.0756P PS=0.71U PD=0.78U
* device instance $1314 r0 *1 33.98,63.005 sky130_fd_pr__nfet_01v8
M$1314 1105 1120 1130 1130 sky130_fd_pr__nfet_01v8 L=0.15U W=0.42U AS=0.0756P
+ AD=0.1446P PS=0.78U PD=1.18U
* device instance $1315 r0 *1 35.86,63.005 sky130_fd_pr__nfet_01v8
M$1315 94 1108 1129 1129 sky130_fd_pr__nfet_01v8 L=0.15U W=0.42U AS=0.0759P
+ AD=0.12095P PS=0.8U PD=1.085U
* device instance $1316 r0 *1 36.455,63.115 sky130_fd_pr__nfet_01v8
M$1316 1108 1107 94 94 sky130_fd_pr__nfet_01v8 L=0.15U W=0.64U AS=0.12095P
+ AD=0.1664P PS=1.085U PD=1.8U
* device instance $1317 r0 *1 37.88,62.975 sky130_fd_pr__nfet_01v8
M$1317 1109 1104 1128 1128 sky130_fd_pr__nfet_01v8 L=0.15U W=0.36U AS=0.0678P
+ AD=0.0684P PS=0.755U PD=0.74U
* device instance $1318 r0 *1 38.41,62.975 sky130_fd_pr__nfet_01v8
M$1318 1127 1103 1109 1109 sky130_fd_pr__nfet_01v8 L=0.15U W=0.36U AS=0.0684P
+ AD=0.066P PS=0.74U PD=0.745U
* device instance $1319 r0 *1 37.395,63.005 sky130_fd_pr__nfet_01v8
M$1319 1128 1108 94 94 sky130_fd_pr__nfet_01v8 L=0.15U W=0.42U AS=0.1092P
+ AD=0.0678P PS=1.36U PD=0.755U
* device instance $1320 r0 *1 38.885,63.005 sky130_fd_pr__nfet_01v8
M$1320 94 1120 1127 1127 sky130_fd_pr__nfet_01v8 L=0.15U W=0.42U AS=0.066P
+ AD=0.1092P PS=0.745U PD=1.36U
* device instance $1321 r0 *1 39.825,63.005 sky130_fd_pr__nfet_01v8
M$1321 94 1109 1120 1120 sky130_fd_pr__nfet_01v8 L=0.15U W=0.42U AS=0.1092P
+ AD=0.10025P PS=1.36U PD=0.985U
* device instance $1322 r0 *1 40.31,63.12 sky130_fd_pr__nfet_01v8
M$1322 995 1109 94 94 sky130_fd_pr__nfet_01v8 L=0.15U W=0.65U AS=0.10025P
+ AD=0.182P PS=0.985U PD=1.86U
* device instance $1323 r0 *1 41.41,63.12 sky130_fd_pr__nfet_01v8
M$1323 94 1065 1110 1110 sky130_fd_pr__nfet_01v8 L=0.15U W=0.65U AS=0.169P
+ AD=0.08775P PS=1.82U PD=0.92U
* device instance $1324 r0 *1 41.83,63.12 sky130_fd_pr__nfet_01v8
M$1324 984 1110 94 94 sky130_fd_pr__nfet_01v8 L=0.15U W=2.6U AS=0.351P
+ AD=0.43225P PS=3.68U PD=4.58U
* device instance $1328 r0 *1 45.59,63.12 sky130_fd_pr__nfet_01v8
M$1328 1112 1111 1081 1081 sky130_fd_pr__nfet_01v8 L=0.15U W=0.65U AS=0.195P
+ AD=0.08775P PS=1.9U PD=0.92U
* device instance $1329 r0 *1 46.01,63.12 sky130_fd_pr__nfet_01v8
M$1329 94 694 1112 1112 sky130_fd_pr__nfet_01v8 L=0.15U W=0.65U AS=0.08775P
+ AD=0.169P PS=0.92U PD=1.82U
* device instance $1330 r0 *1 46.95,63.12 sky130_fd_pr__nfet_01v8
M$1330 94 1121 1112 1112 sky130_fd_pr__nfet_01v8 L=0.15U W=0.65U AS=0.169P
+ AD=0.08775P PS=1.82U PD=0.92U
* device instance $1331 r0 *1 47.37,63.12 sky130_fd_pr__nfet_01v8
M$1331 1126 1121 94 94 sky130_fd_pr__nfet_01v8 L=0.15U W=0.65U AS=0.08775P
+ AD=0.06825P PS=0.92U PD=0.86U
* device instance $1332 r0 *1 47.73,63.12 sky130_fd_pr__nfet_01v8
M$1332 1111 694 1126 1126 sky130_fd_pr__nfet_01v8 L=0.15U W=0.65U AS=0.06825P
+ AD=0.169P PS=0.86U PD=1.82U
* device instance $1333 r0 *1 47.39,62.115 sky130_fd_pr__nfet_01v8
M$1333 1094 1081 1067 1067 sky130_fd_pr__nfet_01v8 L=0.15U W=0.42U AS=0.1092P
+ AD=0.0441P PS=1.36U PD=0.63U
* device instance $1334 r0 *1 47.75,62.115 sky130_fd_pr__nfet_01v8
M$1334 1093 1068 1094 1094 sky130_fd_pr__nfet_01v8 L=0.15U W=0.42U AS=0.0441P
+ AD=0.0441P PS=0.63U PD=0.63U
* device instance $1335 r0 *1 48.11,62.115 sky130_fd_pr__nfet_01v8
M$1335 1093 1069 94 94 sky130_fd_pr__nfet_01v8 L=0.15U W=0.42U AS=0.13165P
+ AD=0.0441P PS=1.14U PD=0.63U
* device instance $1336 r0 *1 48.75,62 sky130_fd_pr__nfet_01v8
M$1336 1025 1067 94 94 sky130_fd_pr__nfet_01v8 L=0.15U W=0.65U AS=0.13165P
+ AD=0.169P PS=1.14U PD=1.82U
* device instance $1337 r0 *1 48.76,63.12 sky130_fd_pr__nfet_01v8
M$1337 1069 1113 94 94 sky130_fd_pr__nfet_01v8 L=0.15U W=2.6U AS=0.43225P
+ AD=0.351P PS=4.58U PD=3.68U
* device instance $1341 r0 *1 50.44,63.12 sky130_fd_pr__nfet_01v8
M$1341 1113 1034 94 94 sky130_fd_pr__nfet_01v8 L=0.15U W=0.65U AS=0.08775P
+ AD=0.169P PS=0.92U PD=1.82U
* device instance $1342 r0 *1 51.765,63.005 sky130_fd_pr__nfet_01v8
M$1342 94 1121 1114 1114 sky130_fd_pr__nfet_01v8 L=0.15U W=0.42U AS=0.1092P
+ AD=0.10025P PS=1.36U PD=0.985U
* device instance $1343 r0 *1 52.25,63.12 sky130_fd_pr__nfet_01v8
M$1343 1066 694 94 94 sky130_fd_pr__nfet_01v8 L=0.15U W=0.65U AS=0.10025P
+ AD=0.08775P PS=0.985U PD=0.92U
* device instance $1344 r0 *1 52.67,63.12 sky130_fd_pr__nfet_01v8
M$1344 94 1114 1066 1066 sky130_fd_pr__nfet_01v8 L=0.15U W=0.65U AS=0.08775P
+ AD=0.169P PS=0.92U PD=1.82U
* device instance $1345 r0 *1 63.49,62.115 sky130_fd_pr__nfet_01v8
M$1345 94 996 1053 1053 sky130_fd_pr__nfet_01v8 L=0.15U W=0.42U AS=0.1092P
+ AD=0.0567P PS=1.36U PD=0.69U
* device instance $1346 r0 *1 63.91,62.115 sky130_fd_pr__nfet_01v8
M$1346 1054 1053 94 94 sky130_fd_pr__nfet_01v8 L=0.15U W=0.42U AS=0.0567P
+ AD=0.1092P PS=0.69U PD=1.36U
* device instance $1347 r0 *1 64.85,62.115 sky130_fd_pr__nfet_01v8
M$1347 1092 1037 1055 1055 sky130_fd_pr__nfet_01v8 L=0.15U W=0.42U AS=0.1092P
+ AD=0.0441P PS=1.36U PD=0.63U
* device instance $1348 r0 *1 65.21,62.115 sky130_fd_pr__nfet_01v8
M$1348 94 16 1092 1092 sky130_fd_pr__nfet_01v8 L=0.15U W=0.42U AS=0.0441P
+ AD=0.1092P PS=0.63U PD=1.36U
* device instance $1349 r0 *1 64.41,63.235 sky130_fd_pr__nfet_01v8
M$1349 1115 1122 94 94 sky130_fd_pr__nfet_01v8 L=0.15U W=0.42U AS=0.10025P
+ AD=0.1092P PS=0.985U PD=1.36U
* device instance $1350 r0 *1 64.895,63.12 sky130_fd_pr__nfet_01v8
M$1350 1124 1123 94 94 sky130_fd_pr__nfet_01v8 L=0.15U W=0.65U AS=0.10025P
+ AD=0.08775P PS=0.985U PD=0.92U
* device instance $1351 r0 *1 65.315,63.12 sky130_fd_pr__nfet_01v8
M$1351 1068 1115 1124 1124 sky130_fd_pr__nfet_01v8 L=0.15U W=0.65U AS=0.08775P
+ AD=0.169P PS=0.92U PD=1.82U
* device instance $1352 r0 *1 66.15,62.115 sky130_fd_pr__nfet_01v8
M$1352 94 16 1056 1056 sky130_fd_pr__nfet_01v8 L=0.15U W=0.42U AS=0.1092P
+ AD=0.0609P PS=1.36U PD=0.71U
* device instance $1353 r0 *1 66.59,62.115 sky130_fd_pr__nfet_01v8
M$1353 1091 1056 94 94 sky130_fd_pr__nfet_01v8 L=0.15U W=0.42U AS=0.0609P
+ AD=0.0756P PS=0.71U PD=0.78U
* device instance $1354 r0 *1 67.1,62.115 sky130_fd_pr__nfet_01v8
M$1354 1055 1060 1091 1091 sky130_fd_pr__nfet_01v8 L=0.15U W=0.42U AS=0.0756P
+ AD=0.1446P PS=0.78U PD=1.18U
* device instance $1355 r0 *1 68.01,62.145 sky130_fd_pr__nfet_01v8
M$1355 1057 1053 1055 1055 sky130_fd_pr__nfet_01v8 L=0.15U W=0.36U AS=0.1446P
+ AD=0.0522P PS=1.18U PD=0.65U
* device instance $1356 r0 *1 68.45,62.145 sky130_fd_pr__nfet_01v8
M$1356 1057 1054 1089 1089 sky130_fd_pr__nfet_01v8 L=0.15U W=0.36U AS=0.0759P
+ AD=0.0522P PS=0.8U PD=0.65U
* device instance $1357 r0 *1 68.98,62.115 sky130_fd_pr__nfet_01v8
M$1357 1089 1058 94 94 sky130_fd_pr__nfet_01v8 L=0.15U W=0.42U AS=0.12095P
+ AD=0.0759P PS=1.085U PD=0.8U
* device instance $1358 r0 *1 69.575,62.005 sky130_fd_pr__nfet_01v8
M$1358 1058 1057 94 94 sky130_fd_pr__nfet_01v8 L=0.15U W=0.64U AS=0.12095P
+ AD=0.1664P PS=1.085U PD=1.8U
* device instance $1359 r0 *1 66.655,63.12 sky130_fd_pr__nfet_01v8
M$1359 387 1116 94 94 sky130_fd_pr__nfet_01v8 L=0.15U W=2.6U AS=0.43225P
+ AD=0.351P PS=4.58U PD=3.68U
* device instance $1363 r0 *1 68.335,63.12 sky130_fd_pr__nfet_01v8
M$1363 1116 1123 94 94 sky130_fd_pr__nfet_01v8 L=0.15U W=0.65U AS=0.08775P
+ AD=0.169P PS=0.92U PD=1.82U
* device instance $1364 r0 *1 70.515,62.115 sky130_fd_pr__nfet_01v8
M$1364 1087 1058 94 94 sky130_fd_pr__nfet_01v8 L=0.15U W=0.42U AS=0.1092P
+ AD=0.0678P PS=1.36U PD=0.755U
* device instance $1365 r0 *1 71,62.145 sky130_fd_pr__nfet_01v8
M$1365 1059 1054 1087 1087 sky130_fd_pr__nfet_01v8 L=0.15U W=0.36U AS=0.0678P
+ AD=0.0684P PS=0.755U PD=0.74U
* device instance $1366 r0 *1 71.53,62.145 sky130_fd_pr__nfet_01v8
M$1366 1059 1053 1086 1086 sky130_fd_pr__nfet_01v8 L=0.15U W=0.36U AS=0.066P
+ AD=0.0684P PS=0.745U PD=0.74U
* device instance $1367 r0 *1 72.005,62.115 sky130_fd_pr__nfet_01v8
M$1367 94 1060 1086 1086 sky130_fd_pr__nfet_01v8 L=0.15U W=0.42U AS=0.066P
+ AD=0.1092P PS=0.745U PD=1.36U
* device instance $1368 r0 *1 5.09,67.44 sky130_fd_pr__nfet_01v8
M$1368 1204 1143 94 94 sky130_fd_pr__nfet_01v8 L=0.15U W=0.65U AS=0.169P
+ AD=0.08775P PS=1.82U PD=0.92U
* device instance $1369 r0 *1 5.51,67.44 sky130_fd_pr__nfet_01v8
M$1369 1118 71 1204 1204 sky130_fd_pr__nfet_01v8 L=0.15U W=0.65U AS=0.08775P
+ AD=0.169P PS=0.92U PD=1.82U
* device instance $1370 r0 *1 8.78,67.555 sky130_fd_pr__nfet_01v8
M$1370 94 1099 1202 1202 sky130_fd_pr__nfet_01v8 L=0.15U W=0.42U AS=0.1113P
+ AD=0.0588P PS=1.37U PD=0.7U
* device instance $1371 r0 *1 9.21,67.555 sky130_fd_pr__nfet_01v8
M$1371 1202 1143 94 94 sky130_fd_pr__nfet_01v8 L=0.15U W=0.42U AS=0.0588P
+ AD=0.0588P PS=0.7U PD=0.7U
* device instance $1372 r0 *1 9.64,67.555 sky130_fd_pr__nfet_01v8
M$1372 1080 1144 1202 1202 sky130_fd_pr__nfet_01v8 L=0.15U W=0.42U AS=0.0588P
+ AD=0.1113P PS=0.7U PD=1.37U
* device instance $1373 r0 *1 10.61,67.44 sky130_fd_pr__nfet_01v8
M$1373 1208 1199 94 94 sky130_fd_pr__nfet_01v8 L=0.15U W=0.65U AS=0.169P
+ AD=0.08775P PS=1.82U PD=0.92U
* device instance $1374 r0 *1 11.03,67.44 sky130_fd_pr__nfet_01v8
M$1374 1098 1119 1208 1208 sky130_fd_pr__nfet_01v8 L=0.15U W=0.65U AS=0.08775P
+ AD=0.169P PS=0.92U PD=1.82U
* device instance $1375 r0 *1 12.04,67.44 sky130_fd_pr__nfet_01v8
M$1375 94 1177 1145 1145 sky130_fd_pr__nfet_01v8 L=0.15U W=0.65U AS=0.2145P
+ AD=0.167375P PS=1.96U PD=1.165U
* device instance $1376 r0 *1 12.705,67.44 sky130_fd_pr__nfet_01v8
M$1376 1210 917 94 94 sky130_fd_pr__nfet_01v8 L=0.15U W=0.65U AS=0.167375P
+ AD=0.0975P PS=1.165U PD=0.95U
* device instance $1377 r0 *1 13.155,67.44 sky130_fd_pr__nfet_01v8
M$1377 1211 1199 1210 1210 sky130_fd_pr__nfet_01v8 L=0.15U W=0.65U AS=0.0975P
+ AD=0.14625P PS=0.95U PD=1.1U
* device instance $1378 r0 *1 13.755,67.44 sky130_fd_pr__nfet_01v8
M$1378 1177 1119 1211 1211 sky130_fd_pr__nfet_01v8 L=0.15U W=0.65U AS=0.14625P
+ AD=0.143P PS=1.1U PD=1.09U
* device instance $1379 r0 *1 14.345,67.44 sky130_fd_pr__nfet_01v8
M$1379 1212 1144 1177 1177 sky130_fd_pr__nfet_01v8 L=0.15U W=0.65U AS=0.143P
+ AD=0.06825P PS=1.09U PD=0.86U
* device instance $1380 r0 *1 14.705,67.44 sky130_fd_pr__nfet_01v8
M$1380 94 1147 1212 1212 sky130_fd_pr__nfet_01v8 L=0.15U W=0.65U AS=0.06825P
+ AD=0.17225P PS=0.86U PD=1.83U
* device instance $1381 r0 *1 15.83,67.415 sky130_fd_pr__nfet_01v8
M$1381 1214 1147 1178 1178 sky130_fd_pr__nfet_01v8 L=0.15U W=0.42U AS=0.1176P
+ AD=0.0567P PS=1.4U PD=0.69U
* device instance $1382 r0 *1 16.25,67.415 sky130_fd_pr__nfet_01v8
M$1382 1214 1100 94 94 sky130_fd_pr__nfet_01v8 L=0.15U W=0.42U AS=0.1118P
+ AD=0.0567P PS=1.04U PD=0.69U
* device instance $1383 r0 *1 16.79,67.44 sky130_fd_pr__nfet_01v8
M$1383 1148 1178 94 94 sky130_fd_pr__nfet_01v8 L=0.15U W=0.65U AS=0.1118P
+ AD=0.182P PS=1.04U PD=1.86U
* device instance $1384 r0 *1 24.46,67.555 sky130_fd_pr__nfet_01v8
M$1384 1216 1179 1149 1149 sky130_fd_pr__nfet_01v8 L=0.15U W=0.42U AS=0.1113P
+ AD=0.0441P PS=1.37U PD=0.63U
* device instance $1385 r0 *1 24.82,67.555 sky130_fd_pr__nfet_01v8
M$1385 94 109 1216 1216 sky130_fd_pr__nfet_01v8 L=0.15U W=0.42U AS=0.0441P
+ AD=0.0966P PS=0.63U PD=0.88U
* device instance $1386 r0 *1 25.43,67.555 sky130_fd_pr__nfet_01v8
M$1386 1150 1149 94 94 sky130_fd_pr__nfet_01v8 L=0.15U W=0.42U AS=0.0966P
+ AD=0.1113P PS=0.88U PD=1.37U
* device instance $1387 r0 *1 26.69,67.44 sky130_fd_pr__nfet_01v8
M$1387 94 1150 1151 1151 sky130_fd_pr__nfet_01v8 L=0.15U W=0.65U AS=0.169P
+ AD=0.10725P PS=1.82U PD=0.98U
* device instance $1388 r0 *1 27.17,67.44 sky130_fd_pr__nfet_01v8
M$1388 1218 890 94 94 sky130_fd_pr__nfet_01v8 L=0.15U W=0.65U AS=0.10725P
+ AD=0.06825P PS=0.98U PD=0.86U
* device instance $1389 r0 *1 27.53,67.44 sky130_fd_pr__nfet_01v8
M$1389 1151 90 1218 1218 sky130_fd_pr__nfet_01v8 L=0.15U W=0.65U AS=0.06825P
+ AD=0.169P PS=0.86U PD=1.82U
* device instance $1390 r0 *1 28.47,67.44 sky130_fd_pr__nfet_01v8
M$1390 1219 1181 1151 1151 sky130_fd_pr__nfet_01v8 L=0.15U W=0.65U AS=0.169P
+ AD=0.10725P PS=1.82U PD=0.98U
* device instance $1391 r0 *1 28.95,67.44 sky130_fd_pr__nfet_01v8
M$1391 94 997 1219 1219 sky130_fd_pr__nfet_01v8 L=0.15U W=0.65U AS=0.10725P
+ AD=0.102375P PS=0.98U PD=0.965U
* device instance $1392 r0 *1 29.415,67.44 sky130_fd_pr__nfet_01v8
M$1392 1133 1151 94 94 sky130_fd_pr__nfet_01v8 L=0.15U W=0.65U AS=0.102375P
+ AD=0.169P PS=0.965U PD=1.82U
* device instance $1393 r0 *1 32.31,67.44 sky130_fd_pr__nfet_01v8
M$1393 1222 1070 1153 1153 sky130_fd_pr__nfet_01v8 L=0.15U W=0.65U AS=0.169P
+ AD=0.06825P PS=1.82U PD=0.86U
* device instance $1394 r0 *1 32.67,67.44 sky130_fd_pr__nfet_01v8
M$1394 94 1048 1222 1222 sky130_fd_pr__nfet_01v8 L=0.15U W=0.65U AS=0.06825P
+ AD=0.08775P PS=0.86U PD=0.92U
* device instance $1395 r0 *1 33.09,67.44 sky130_fd_pr__nfet_01v8
M$1395 1203 1048 94 94 sky130_fd_pr__nfet_01v8 L=0.15U W=0.65U AS=0.08775P
+ AD=0.169P PS=0.92U PD=1.82U
* device instance $1396 r0 *1 34.03,67.44 sky130_fd_pr__nfet_01v8
M$1396 1203 1070 94 94 sky130_fd_pr__nfet_01v8 L=0.15U W=0.65U AS=0.169P
+ AD=0.08775P PS=1.82U PD=0.92U
* device instance $1397 r0 *1 34.45,67.44 sky130_fd_pr__nfet_01v8
M$1397 1181 1153 1203 1203 sky130_fd_pr__nfet_01v8 L=0.15U W=0.65U AS=0.08775P
+ AD=0.195P PS=0.92U PD=1.9U
* device instance $1398 r0 *1 36.81,67.44 sky130_fd_pr__nfet_01v8
M$1398 94 1200 1154 1154 sky130_fd_pr__nfet_01v8 L=0.15U W=0.65U AS=0.169P
+ AD=0.10725P PS=1.82U PD=0.98U
* device instance $1399 r0 *1 37.29,67.44 sky130_fd_pr__nfet_01v8
M$1399 1225 694 94 94 sky130_fd_pr__nfet_01v8 L=0.15U W=0.65U AS=0.10725P
+ AD=0.06825P PS=0.98U PD=0.86U
* device instance $1400 r0 *1 37.65,67.44 sky130_fd_pr__nfet_01v8
M$1400 1154 90 1225 1225 sky130_fd_pr__nfet_01v8 L=0.15U W=0.65U AS=0.06825P
+ AD=0.169P PS=0.86U PD=1.82U
* device instance $1401 r0 *1 38.59,67.44 sky130_fd_pr__nfet_01v8
M$1401 1226 1286 1154 1154 sky130_fd_pr__nfet_01v8 L=0.15U W=0.65U AS=0.169P
+ AD=0.10725P PS=1.82U PD=0.98U
* device instance $1402 r0 *1 39.07,67.44 sky130_fd_pr__nfet_01v8
M$1402 94 1014 1226 1226 sky130_fd_pr__nfet_01v8 L=0.15U W=0.65U AS=0.10725P
+ AD=0.102375P PS=0.98U PD=0.965U
* device instance $1403 r0 *1 39.535,67.44 sky130_fd_pr__nfet_01v8
M$1403 1156 1154 94 94 sky130_fd_pr__nfet_01v8 L=0.15U W=0.65U AS=0.102375P
+ AD=0.169P PS=0.965U PD=1.82U
* device instance $1404 r0 *1 40.49,67.555 sky130_fd_pr__nfet_01v8
M$1404 94 996 1157 1157 sky130_fd_pr__nfet_01v8 L=0.15U W=0.42U AS=0.1092P
+ AD=0.0567P PS=1.36U PD=0.69U
* device instance $1405 r0 *1 40.91,67.555 sky130_fd_pr__nfet_01v8
M$1405 1158 1157 94 94 sky130_fd_pr__nfet_01v8 L=0.15U W=0.42U AS=0.0567P
+ AD=0.1092P PS=0.69U PD=1.36U
* device instance $1406 r0 *1 41.85,67.555 sky130_fd_pr__nfet_01v8
M$1406 1227 1183 1160 1160 sky130_fd_pr__nfet_01v8 L=0.15U W=0.42U AS=0.1092P
+ AD=0.0441P PS=1.36U PD=0.63U
* device instance $1407 r0 *1 42.21,67.555 sky130_fd_pr__nfet_01v8
M$1407 94 1102 1227 1227 sky130_fd_pr__nfet_01v8 L=0.15U W=0.42U AS=0.0441P
+ AD=0.1092P PS=0.63U PD=1.36U
* device instance $1408 r0 *1 43.15,67.555 sky130_fd_pr__nfet_01v8
M$1408 94 1102 1159 1159 sky130_fd_pr__nfet_01v8 L=0.15U W=0.42U AS=0.1092P
+ AD=0.0609P PS=1.36U PD=0.71U
* device instance $1409 r0 *1 43.59,67.555 sky130_fd_pr__nfet_01v8
M$1409 1224 1159 94 94 sky130_fd_pr__nfet_01v8 L=0.15U W=0.42U AS=0.0609P
+ AD=0.0756P PS=0.71U PD=0.78U
* device instance $1410 r0 *1 44.1,67.555 sky130_fd_pr__nfet_01v8
M$1410 1160 1164 1224 1224 sky130_fd_pr__nfet_01v8 L=0.15U W=0.42U AS=0.0756P
+ AD=0.1446P PS=0.78U PD=1.18U
* device instance $1411 r0 *1 45.01,67.585 sky130_fd_pr__nfet_01v8
M$1411 1161 1157 1160 1160 sky130_fd_pr__nfet_01v8 L=0.15U W=0.36U AS=0.1446P
+ AD=0.0522P PS=1.18U PD=0.65U
* device instance $1412 r0 *1 45.45,67.585 sky130_fd_pr__nfet_01v8
M$1412 1161 1158 1223 1223 sky130_fd_pr__nfet_01v8 L=0.15U W=0.36U AS=0.0759P
+ AD=0.0522P PS=0.8U PD=0.65U
* device instance $1413 r0 *1 45.98,67.555 sky130_fd_pr__nfet_01v8
M$1413 1223 1162 94 94 sky130_fd_pr__nfet_01v8 L=0.15U W=0.42U AS=0.12095P
+ AD=0.0759P PS=1.085U PD=0.8U
* device instance $1414 r0 *1 46.575,67.445 sky130_fd_pr__nfet_01v8
M$1414 1162 1161 94 94 sky130_fd_pr__nfet_01v8 L=0.15U W=0.64U AS=0.12095P
+ AD=0.1664P PS=1.085U PD=1.8U
* device instance $1415 r0 *1 47.515,67.555 sky130_fd_pr__nfet_01v8
M$1415 1221 1162 94 94 sky130_fd_pr__nfet_01v8 L=0.15U W=0.42U AS=0.1092P
+ AD=0.0678P PS=1.36U PD=0.755U
* device instance $1416 r0 *1 48,67.585 sky130_fd_pr__nfet_01v8
M$1416 1163 1158 1221 1221 sky130_fd_pr__nfet_01v8 L=0.15U W=0.36U AS=0.0678P
+ AD=0.0684P PS=0.755U PD=0.74U
* device instance $1417 r0 *1 48.53,67.585 sky130_fd_pr__nfet_01v8
M$1417 1163 1157 1220 1220 sky130_fd_pr__nfet_01v8 L=0.15U W=0.36U AS=0.066P
+ AD=0.0684P PS=0.745U PD=0.74U
* device instance $1418 r0 *1 49.005,67.555 sky130_fd_pr__nfet_01v8
M$1418 94 1164 1220 1220 sky130_fd_pr__nfet_01v8 L=0.15U W=0.42U AS=0.066P
+ AD=0.1092P PS=0.745U PD=1.36U
* device instance $1419 r0 *1 49.945,67.555 sky130_fd_pr__nfet_01v8
M$1419 1164 1163 94 94 sky130_fd_pr__nfet_01v8 L=0.15U W=0.42U AS=0.10025P
+ AD=0.1092P PS=0.985U PD=1.36U
* device instance $1420 r0 *1 50.43,67.44 sky130_fd_pr__nfet_01v8
M$1420 694 1163 94 94 sky130_fd_pr__nfet_01v8 L=0.15U W=0.65U AS=0.10025P
+ AD=0.182P PS=0.985U PD=1.86U
* device instance $1421 r0 *1 60.34,67.555 sky130_fd_pr__nfet_01v8
M$1421 1217 1021 1165 1165 sky130_fd_pr__nfet_01v8 L=0.15U W=0.42U AS=0.1113P
+ AD=0.0441P PS=1.37U PD=0.63U
* device instance $1422 r0 *1 60.7,67.555 sky130_fd_pr__nfet_01v8
M$1422 94 1068 1217 1217 sky130_fd_pr__nfet_01v8 L=0.15U W=0.42U AS=0.0441P
+ AD=0.0966P PS=0.63U PD=0.88U
* device instance $1423 r0 *1 61.31,67.555 sky130_fd_pr__nfet_01v8
M$1423 1166 1165 94 94 sky130_fd_pr__nfet_01v8 L=0.15U W=0.42U AS=0.0966P
+ AD=0.1113P PS=0.88U PD=1.37U
* device instance $1424 r0 *1 62.61,67.44 sky130_fd_pr__nfet_01v8
M$1424 1167 1023 94 94 sky130_fd_pr__nfet_01v8 L=0.15U W=0.65U AS=0.169P
+ AD=0.08775P PS=1.82U PD=0.92U
* device instance $1425 r0 *1 63.03,67.44 sky130_fd_pr__nfet_01v8
M$1425 94 1166 1167 1167 sky130_fd_pr__nfet_01v8 L=0.15U W=0.65U AS=0.08775P
+ AD=0.08775P PS=0.92U PD=0.92U
* device instance $1426 r0 *1 63.45,67.44 sky130_fd_pr__nfet_01v8
M$1426 1215 1166 94 94 sky130_fd_pr__nfet_01v8 L=0.15U W=0.65U AS=0.08775P
+ AD=0.08775P PS=0.92U PD=0.92U
* device instance $1427 r0 *1 63.87,67.44 sky130_fd_pr__nfet_01v8
M$1427 1184 1023 1215 1215 sky130_fd_pr__nfet_01v8 L=0.15U W=0.65U AS=0.08775P
+ AD=0.25025P PS=0.92U PD=1.42U
* device instance $1428 r0 *1 64.79,67.44 sky130_fd_pr__nfet_01v8
M$1428 94 1167 1184 1184 sky130_fd_pr__nfet_01v8 L=0.15U W=0.65U AS=0.25025P
+ AD=0.208P PS=1.42U PD=1.94U
* device instance $1429 r0 *1 65.79,67.555 sky130_fd_pr__nfet_01v8
M$1429 94 996 1169 1169 sky130_fd_pr__nfet_01v8 L=0.15U W=0.42U AS=0.1092P
+ AD=0.0567P PS=1.36U PD=0.69U
* device instance $1430 r0 *1 66.21,67.555 sky130_fd_pr__nfet_01v8
M$1430 1170 1169 94 94 sky130_fd_pr__nfet_01v8 L=0.15U W=0.42U AS=0.0567P
+ AD=0.1092P PS=0.69U PD=1.36U
* device instance $1431 r0 *1 67.15,67.555 sky130_fd_pr__nfet_01v8
M$1431 1213 1201 1172 1172 sky130_fd_pr__nfet_01v8 L=0.15U W=0.42U AS=0.1092P
+ AD=0.0441P PS=1.36U PD=0.63U
* device instance $1432 r0 *1 67.51,67.555 sky130_fd_pr__nfet_01v8
M$1432 94 1102 1213 1213 sky130_fd_pr__nfet_01v8 L=0.15U W=0.42U AS=0.0441P
+ AD=0.1092P PS=0.63U PD=1.36U
* device instance $1433 r0 *1 68.45,67.555 sky130_fd_pr__nfet_01v8
M$1433 94 1102 1171 1171 sky130_fd_pr__nfet_01v8 L=0.15U W=0.42U AS=0.1092P
+ AD=0.0609P PS=1.36U PD=0.71U
* device instance $1434 r0 *1 68.89,67.555 sky130_fd_pr__nfet_01v8
M$1434 1209 1171 94 94 sky130_fd_pr__nfet_01v8 L=0.15U W=0.42U AS=0.0609P
+ AD=0.0756P PS=0.71U PD=0.78U
* device instance $1435 r0 *1 69.4,67.555 sky130_fd_pr__nfet_01v8
M$1435 1172 1176 1209 1209 sky130_fd_pr__nfet_01v8 L=0.15U W=0.42U AS=0.0756P
+ AD=0.1446P PS=0.78U PD=1.18U
* device instance $1436 r0 *1 70.31,67.585 sky130_fd_pr__nfet_01v8
M$1436 1173 1169 1172 1172 sky130_fd_pr__nfet_01v8 L=0.15U W=0.36U AS=0.1446P
+ AD=0.0522P PS=1.18U PD=0.65U
* device instance $1437 r0 *1 70.75,67.585 sky130_fd_pr__nfet_01v8
M$1437 1173 1170 1207 1207 sky130_fd_pr__nfet_01v8 L=0.15U W=0.36U AS=0.0759P
+ AD=0.0522P PS=0.8U PD=0.65U
* device instance $1438 r0 *1 71.28,67.555 sky130_fd_pr__nfet_01v8
M$1438 1207 1174 94 94 sky130_fd_pr__nfet_01v8 L=0.15U W=0.42U AS=0.12095P
+ AD=0.0759P PS=1.085U PD=0.8U
* device instance $1439 r0 *1 71.875,67.445 sky130_fd_pr__nfet_01v8
M$1439 1174 1173 94 94 sky130_fd_pr__nfet_01v8 L=0.15U W=0.64U AS=0.12095P
+ AD=0.1664P PS=1.085U PD=1.8U
* device instance $1440 r0 *1 72.815,67.555 sky130_fd_pr__nfet_01v8
M$1440 1206 1174 94 94 sky130_fd_pr__nfet_01v8 L=0.15U W=0.42U AS=0.1092P
+ AD=0.0678P PS=1.36U PD=0.755U
* device instance $1441 r0 *1 73.3,67.585 sky130_fd_pr__nfet_01v8
M$1441 1175 1170 1206 1206 sky130_fd_pr__nfet_01v8 L=0.15U W=0.36U AS=0.0678P
+ AD=0.0684P PS=0.755U PD=0.74U
* device instance $1442 r0 *1 73.83,67.585 sky130_fd_pr__nfet_01v8
M$1442 1175 1169 1205 1205 sky130_fd_pr__nfet_01v8 L=0.15U W=0.36U AS=0.066P
+ AD=0.0684P PS=0.745U PD=0.74U
* device instance $1443 r0 *1 74.305,67.555 sky130_fd_pr__nfet_01v8
M$1443 94 1176 1205 1205 sky130_fd_pr__nfet_01v8 L=0.15U W=0.42U AS=0.066P
+ AD=0.1092P PS=0.745U PD=1.36U
* device instance $1444 r0 *1 75.245,67.555 sky130_fd_pr__nfet_01v8
M$1444 1176 1175 94 94 sky130_fd_pr__nfet_01v8 L=0.15U W=0.42U AS=0.10025P
+ AD=0.1092P PS=0.985U PD=1.36U
* device instance $1445 r0 *1 75.73,67.44 sky130_fd_pr__nfet_01v8
M$1445 1123 1175 94 94 sky130_fd_pr__nfet_01v8 L=0.15U W=0.65U AS=0.10025P
+ AD=0.182P PS=0.985U PD=1.86U
* device instance $1446 r0 *1 5.555,68.56 sky130_fd_pr__nfet_01v8
M$1446 1263 1198 94 94 sky130_fd_pr__nfet_01v8 L=0.15U W=0.65U AS=0.18525P
+ AD=0.089375P PS=1.87U PD=0.925U
* device instance $1447 r0 *1 5.98,68.56 sky130_fd_pr__nfet_01v8
M$1447 1144 1148 1263 1263 sky130_fd_pr__nfet_01v8 L=0.15U W=0.65U AS=0.089375P
+ AD=0.091P PS=0.925U PD=0.93U
* device instance $1448 r0 *1 6.41,68.56 sky130_fd_pr__nfet_01v8
M$1448 1266 1148 1144 1144 sky130_fd_pr__nfet_01v8 L=0.15U W=0.65U AS=0.091P
+ AD=0.06825P PS=0.93U PD=0.86U
* device instance $1449 r0 *1 6.77,68.56 sky130_fd_pr__nfet_01v8
M$1449 94 1198 1266 1266 sky130_fd_pr__nfet_01v8 L=0.15U W=0.65U AS=0.06825P
+ AD=0.10725P PS=0.86U PD=0.98U
* device instance $1450 r0 *1 7.25,68.56 sky130_fd_pr__nfet_01v8
M$1450 1144 1117 94 94 sky130_fd_pr__nfet_01v8 L=0.15U W=1.3U AS=0.195P
+ AD=0.34775P PS=1.9U PD=3.02U
* device instance $1452 r0 *1 8.75,68.445 sky130_fd_pr__nfet_01v8
M$1452 94 936 1228 1228 sky130_fd_pr__nfet_01v8 L=0.15U W=0.42U AS=0.1092P
+ AD=0.0567P PS=1.36U PD=0.69U
* device instance $1453 r0 *1 9.17,68.445 sky130_fd_pr__nfet_01v8
M$1453 1229 1228 94 94 sky130_fd_pr__nfet_01v8 L=0.15U W=0.42U AS=0.0567P
+ AD=0.1092P PS=0.69U PD=1.36U
* device instance $1454 r0 *1 10.67,68.415 sky130_fd_pr__nfet_01v8
M$1454 1231 1228 1230 1230 sky130_fd_pr__nfet_01v8 L=0.15U W=0.36U AS=0.0813P
+ AD=0.0621P PS=0.83U PD=0.705U
* device instance $1455 r0 *1 11.165,68.415 sky130_fd_pr__nfet_01v8
M$1455 1268 1229 1231 1231 sky130_fd_pr__nfet_01v8 L=0.15U W=0.36U AS=0.0621P
+ AD=0.0696P PS=0.705U PD=0.765U
* device instance $1456 r0 *1 12.76,68.415 sky130_fd_pr__nfet_01v8
M$1456 1233 1229 1232 1232 sky130_fd_pr__nfet_01v8 L=0.15U W=0.36U AS=0.0989P
+ AD=0.0684P PS=0.995U PD=0.74U
* device instance $1457 r0 *1 13.29,68.415 sky130_fd_pr__nfet_01v8
M$1457 1270 1228 1233 1233 sky130_fd_pr__nfet_01v8 L=0.15U W=0.36U AS=0.0684P
+ AD=0.066P PS=0.74U PD=0.745U
* device instance $1458 r0 *1 10.11,68.445 sky130_fd_pr__nfet_01v8
M$1458 1230 1145 94 94 sky130_fd_pr__nfet_01v8 L=0.15U W=0.42U AS=0.1092P
+ AD=0.0813P PS=1.36U PD=0.83U
* device instance $1459 r0 *1 11.66,68.445 sky130_fd_pr__nfet_01v8
M$1459 94 1232 1268 1268 sky130_fd_pr__nfet_01v8 L=0.15U W=0.42U AS=0.0696P
+ AD=0.12095P PS=0.765U PD=1.085U
* device instance $1460 r0 *1 13.765,68.445 sky130_fd_pr__nfet_01v8
M$1460 94 1234 1270 1270 sky130_fd_pr__nfet_01v8 L=0.15U W=0.42U AS=0.066P
+ AD=0.1092P PS=0.745U PD=1.36U
* device instance $1461 r0 *1 12.255,68.555 sky130_fd_pr__nfet_01v8
M$1461 1232 1231 94 94 sky130_fd_pr__nfet_01v8 L=0.15U W=0.64U AS=0.12095P
+ AD=0.0989P PS=1.085U PD=0.995U
* device instance $1462 r0 *1 14.71,68.56 sky130_fd_pr__nfet_01v8
M$1462 94 1233 1234 1234 sky130_fd_pr__nfet_01v8 L=0.15U W=0.65U AS=0.169P
+ AD=0.08775P PS=1.82U PD=0.92U
* device instance $1463 r0 *1 15.13,68.56 sky130_fd_pr__nfet_01v8
M$1463 1147 1234 94 94 sky130_fd_pr__nfet_01v8 L=0.15U W=0.65U AS=0.08775P
+ AD=0.169P PS=0.92U PD=1.82U
* device instance $1464 r0 *1 22.09,68.445 sky130_fd_pr__nfet_01v8
M$1464 94 936 1235 1235 sky130_fd_pr__nfet_01v8 L=0.15U W=0.42U AS=0.1092P
+ AD=0.0567P PS=1.36U PD=0.69U
* device instance $1465 r0 *1 22.51,68.445 sky130_fd_pr__nfet_01v8
M$1465 1236 1235 94 94 sky130_fd_pr__nfet_01v8 L=0.15U W=0.42U AS=0.0567P
+ AD=0.1092P PS=0.69U PD=1.36U
* device instance $1466 r0 *1 23.45,68.445 sky130_fd_pr__nfet_01v8
M$1466 1273 1255 1237 1237 sky130_fd_pr__nfet_01v8 L=0.15U W=0.42U AS=0.1092P
+ AD=0.0441P PS=1.36U PD=0.63U
* device instance $1467 r0 *1 23.81,68.445 sky130_fd_pr__nfet_01v8
M$1467 94 1102 1273 1273 sky130_fd_pr__nfet_01v8 L=0.15U W=0.42U AS=0.0441P
+ AD=0.1092P PS=0.63U PD=1.36U
* device instance $1468 r0 *1 26.61,68.415 sky130_fd_pr__nfet_01v8
M$1468 1239 1235 1237 1237 sky130_fd_pr__nfet_01v8 L=0.15U W=0.36U AS=0.1446P
+ AD=0.0522P PS=1.18U PD=0.65U
* device instance $1469 r0 *1 27.05,68.415 sky130_fd_pr__nfet_01v8
M$1469 1276 1236 1239 1239 sky130_fd_pr__nfet_01v8 L=0.15U W=0.36U AS=0.0522P
+ AD=0.0759P PS=0.65U PD=0.8U
* device instance $1470 r0 *1 24.75,68.445 sky130_fd_pr__nfet_01v8
M$1470 94 1102 1238 1238 sky130_fd_pr__nfet_01v8 L=0.15U W=0.42U AS=0.1092P
+ AD=0.0609P PS=1.36U PD=0.71U
* device instance $1471 r0 *1 25.19,68.445 sky130_fd_pr__nfet_01v8
M$1471 1274 1238 94 94 sky130_fd_pr__nfet_01v8 L=0.15U W=0.42U AS=0.0609P
+ AD=0.0756P PS=0.71U PD=0.78U
* device instance $1472 r0 *1 25.7,68.445 sky130_fd_pr__nfet_01v8
M$1472 1237 1256 1274 1274 sky130_fd_pr__nfet_01v8 L=0.15U W=0.42U AS=0.0756P
+ AD=0.1446P PS=0.78U PD=1.18U
* device instance $1473 r0 *1 27.58,68.445 sky130_fd_pr__nfet_01v8
M$1473 94 1240 1276 1276 sky130_fd_pr__nfet_01v8 L=0.15U W=0.42U AS=0.0759P
+ AD=0.12095P PS=0.8U PD=1.085U
* device instance $1474 r0 *1 28.175,68.555 sky130_fd_pr__nfet_01v8
M$1474 1240 1239 94 94 sky130_fd_pr__nfet_01v8 L=0.15U W=0.64U AS=0.12095P
+ AD=0.1664P PS=1.085U PD=1.8U
* device instance $1475 r0 *1 29.6,68.415 sky130_fd_pr__nfet_01v8
M$1475 1241 1236 1279 1279 sky130_fd_pr__nfet_01v8 L=0.15U W=0.36U AS=0.0678P
+ AD=0.0684P PS=0.755U PD=0.74U
* device instance $1476 r0 *1 30.13,68.415 sky130_fd_pr__nfet_01v8
M$1476 1280 1235 1241 1241 sky130_fd_pr__nfet_01v8 L=0.15U W=0.36U AS=0.0684P
+ AD=0.066P PS=0.74U PD=0.745U
* device instance $1477 r0 *1 29.115,68.445 sky130_fd_pr__nfet_01v8
M$1477 1279 1240 94 94 sky130_fd_pr__nfet_01v8 L=0.15U W=0.42U AS=0.1092P
+ AD=0.0678P PS=1.36U PD=0.755U
* device instance $1478 r0 *1 30.605,68.445 sky130_fd_pr__nfet_01v8
M$1478 94 1256 1280 1280 sky130_fd_pr__nfet_01v8 L=0.15U W=0.42U AS=0.066P
+ AD=0.1092P PS=0.745U PD=1.36U
* device instance $1479 r0 *1 31.545,68.445 sky130_fd_pr__nfet_01v8
M$1479 94 1241 1256 1256 sky130_fd_pr__nfet_01v8 L=0.15U W=0.42U AS=0.1092P
+ AD=0.10025P PS=1.36U PD=0.985U
* device instance $1480 r0 *1 32.03,68.56 sky130_fd_pr__nfet_01v8
M$1480 890 1241 94 94 sky130_fd_pr__nfet_01v8 L=0.15U W=0.65U AS=0.10025P
+ AD=0.182P PS=0.985U PD=1.86U
* device instance $1481 r0 *1 33.13,68.56 sky130_fd_pr__nfet_01v8
M$1481 94 997 1257 1257 sky130_fd_pr__nfet_01v8 L=0.15U W=0.65U AS=0.169P
+ AD=0.08775P PS=1.82U PD=0.92U
* device instance $1482 r0 *1 33.55,68.56 sky130_fd_pr__nfet_01v8
M$1482 1286 1257 94 94 sky130_fd_pr__nfet_01v8 L=0.15U W=2.6U AS=0.351P
+ AD=0.43225P PS=3.68U PD=4.58U
* device instance $1486 r0 *1 35.91,68.56 sky130_fd_pr__nfet_01v8
M$1486 1283 1258 94 94 sky130_fd_pr__nfet_01v8 L=0.15U W=0.65U AS=0.169P
+ AD=0.08775P PS=1.82U PD=0.92U
* device instance $1487 r0 *1 36.33,68.56 sky130_fd_pr__nfet_01v8
M$1487 1242 71 1283 1283 sky130_fd_pr__nfet_01v8 L=0.15U W=0.65U AS=0.08775P
+ AD=0.169P PS=0.92U PD=1.82U
* device instance $1488 r0 *1 41.94,68.445 sky130_fd_pr__nfet_01v8
M$1488 1284 1287 1243 1243 sky130_fd_pr__nfet_01v8 L=0.15U W=0.42U AS=0.1113P
+ AD=0.0441P PS=1.37U PD=0.63U
* device instance $1489 r0 *1 42.3,68.445 sky130_fd_pr__nfet_01v8
M$1489 94 109 1284 1284 sky130_fd_pr__nfet_01v8 L=0.15U W=0.42U AS=0.0441P
+ AD=0.0966P PS=0.63U PD=0.88U
* device instance $1490 r0 *1 42.91,68.445 sky130_fd_pr__nfet_01v8
M$1490 1200 1243 94 94 sky130_fd_pr__nfet_01v8 L=0.15U W=0.42U AS=0.0966P
+ AD=0.1113P PS=0.88U PD=1.37U
* device instance $1491 r0 *1 44.63,68.445 sky130_fd_pr__nfet_01v8
M$1491 94 996 1244 1244 sky130_fd_pr__nfet_01v8 L=0.15U W=0.42U AS=0.1092P
+ AD=0.0567P PS=1.36U PD=0.69U
* device instance $1492 r0 *1 45.05,68.445 sky130_fd_pr__nfet_01v8
M$1492 1245 1244 94 94 sky130_fd_pr__nfet_01v8 L=0.15U W=0.42U AS=0.0567P
+ AD=0.1092P PS=0.69U PD=1.36U
* device instance $1493 r0 *1 45.99,68.445 sky130_fd_pr__nfet_01v8
M$1493 1282 1156 1246 1246 sky130_fd_pr__nfet_01v8 L=0.15U W=0.42U AS=0.1092P
+ AD=0.0441P PS=1.36U PD=0.63U
* device instance $1494 r0 *1 46.35,68.445 sky130_fd_pr__nfet_01v8
M$1494 94 16 1282 1282 sky130_fd_pr__nfet_01v8 L=0.15U W=0.42U AS=0.0441P
+ AD=0.1092P PS=0.63U PD=1.36U
* device instance $1495 r0 *1 49.15,68.415 sky130_fd_pr__nfet_01v8
M$1495 1248 1244 1246 1246 sky130_fd_pr__nfet_01v8 L=0.15U W=0.36U AS=0.1446P
+ AD=0.0522P PS=1.18U PD=0.65U
* device instance $1496 r0 *1 49.59,68.415 sky130_fd_pr__nfet_01v8
M$1496 1278 1245 1248 1248 sky130_fd_pr__nfet_01v8 L=0.15U W=0.36U AS=0.0522P
+ AD=0.0759P PS=0.65U PD=0.8U
* device instance $1497 r0 *1 47.29,68.445 sky130_fd_pr__nfet_01v8
M$1497 94 16 1247 1247 sky130_fd_pr__nfet_01v8 L=0.15U W=0.42U AS=0.1092P
+ AD=0.0609P PS=1.36U PD=0.71U
* device instance $1498 r0 *1 47.73,68.445 sky130_fd_pr__nfet_01v8
M$1498 1281 1247 94 94 sky130_fd_pr__nfet_01v8 L=0.15U W=0.42U AS=0.0609P
+ AD=0.0756P PS=0.71U PD=0.78U
* device instance $1499 r0 *1 48.24,68.445 sky130_fd_pr__nfet_01v8
M$1499 1246 1259 1281 1281 sky130_fd_pr__nfet_01v8 L=0.15U W=0.42U AS=0.0756P
+ AD=0.1446P PS=0.78U PD=1.18U
* device instance $1500 r0 *1 50.12,68.445 sky130_fd_pr__nfet_01v8
M$1500 94 1249 1278 1278 sky130_fd_pr__nfet_01v8 L=0.15U W=0.42U AS=0.0759P
+ AD=0.12095P PS=0.8U PD=1.085U
* device instance $1501 r0 *1 50.715,68.555 sky130_fd_pr__nfet_01v8
M$1501 1249 1248 94 94 sky130_fd_pr__nfet_01v8 L=0.15U W=0.64U AS=0.12095P
+ AD=0.1664P PS=1.085U PD=1.8U
* device instance $1502 r0 *1 52.14,68.415 sky130_fd_pr__nfet_01v8
M$1502 1250 1245 1277 1277 sky130_fd_pr__nfet_01v8 L=0.15U W=0.36U AS=0.0678P
+ AD=0.0684P PS=0.755U PD=0.74U
* device instance $1503 r0 *1 52.67,68.415 sky130_fd_pr__nfet_01v8
M$1503 1275 1244 1250 1250 sky130_fd_pr__nfet_01v8 L=0.15U W=0.36U AS=0.0684P
+ AD=0.066P PS=0.74U PD=0.745U
* device instance $1504 r0 *1 51.655,68.445 sky130_fd_pr__nfet_01v8
M$1504 1277 1249 94 94 sky130_fd_pr__nfet_01v8 L=0.15U W=0.42U AS=0.1092P
+ AD=0.0678P PS=1.36U PD=0.755U
* device instance $1505 r0 *1 53.145,68.445 sky130_fd_pr__nfet_01v8
M$1505 94 1259 1275 1275 sky130_fd_pr__nfet_01v8 L=0.15U W=0.42U AS=0.066P
+ AD=0.1092P PS=0.745U PD=1.36U
* device instance $1506 r0 *1 54.085,68.445 sky130_fd_pr__nfet_01v8
M$1506 94 1250 1259 1259 sky130_fd_pr__nfet_01v8 L=0.15U W=0.42U AS=0.1092P
+ AD=0.10025P PS=1.36U PD=0.985U
* device instance $1507 r0 *1 54.57,68.56 sky130_fd_pr__nfet_01v8
M$1507 1121 1250 94 94 sky130_fd_pr__nfet_01v8 L=0.15U W=0.65U AS=0.10025P
+ AD=0.182P PS=0.985U PD=1.86U
* device instance $1508 r0 *1 57.12,68.445 sky130_fd_pr__nfet_01v8
M$1508 1272 1288 1251 1251 sky130_fd_pr__nfet_01v8 L=0.15U W=0.42U AS=0.1113P
+ AD=0.0441P PS=1.37U PD=0.63U
* device instance $1509 r0 *1 57.48,68.445 sky130_fd_pr__nfet_01v8
M$1509 94 109 1272 1272 sky130_fd_pr__nfet_01v8 L=0.15U W=0.42U AS=0.0441P
+ AD=0.0966P PS=0.63U PD=0.88U
* device instance $1510 r0 *1 58.09,68.445 sky130_fd_pr__nfet_01v8
M$1510 1026 1251 94 94 sky130_fd_pr__nfet_01v8 L=0.15U W=0.42U AS=0.0966P
+ AD=0.1113P PS=0.88U PD=1.37U
* device instance $1511 r0 *1 60.27,68.56 sky130_fd_pr__nfet_01v8
M$1511 94 1260 1252 1252 sky130_fd_pr__nfet_01v8 L=0.15U W=0.65U AS=0.169P
+ AD=0.10725P PS=1.82U PD=0.98U
* device instance $1512 r0 *1 60.75,68.56 sky130_fd_pr__nfet_01v8
M$1512 1271 1261 94 94 sky130_fd_pr__nfet_01v8 L=0.15U W=0.65U AS=0.10725P
+ AD=0.06825P PS=0.98U PD=0.86U
* device instance $1513 r0 *1 61.11,68.56 sky130_fd_pr__nfet_01v8
M$1513 1252 90 1271 1271 sky130_fd_pr__nfet_01v8 L=0.15U W=0.65U AS=0.06825P
+ AD=0.169P PS=0.86U PD=1.82U
* device instance $1514 r0 *1 62.05,68.56 sky130_fd_pr__nfet_01v8
M$1514 1269 1017 1252 1252 sky130_fd_pr__nfet_01v8 L=0.15U W=0.65U AS=0.169P
+ AD=0.10725P PS=1.82U PD=0.98U
* device instance $1515 r0 *1 62.53,68.56 sky130_fd_pr__nfet_01v8
M$1515 94 1184 1269 1269 sky130_fd_pr__nfet_01v8 L=0.15U W=0.65U AS=0.10725P
+ AD=0.102375P PS=0.98U PD=0.965U
* device instance $1516 r0 *1 62.995,68.56 sky130_fd_pr__nfet_01v8
M$1516 1290 1252 94 94 sky130_fd_pr__nfet_01v8 L=0.15U W=0.65U AS=0.102375P
+ AD=0.169P PS=0.965U PD=1.82U
* device instance $1517 r0 *1 63.95,68.675 sky130_fd_pr__nfet_01v8
M$1517 1262 1123 94 94 sky130_fd_pr__nfet_01v8 L=0.15U W=0.42U AS=0.10025P
+ AD=0.1092P PS=0.985U PD=1.36U
* device instance $1518 r0 *1 64.435,68.56 sky130_fd_pr__nfet_01v8
M$1518 1267 1122 94 94 sky130_fd_pr__nfet_01v8 L=0.15U W=0.65U AS=0.10025P
+ AD=0.08775P PS=0.985U PD=0.92U
* device instance $1519 r0 *1 64.855,68.56 sky130_fd_pr__nfet_01v8
M$1519 1021 1262 1267 1267 sky130_fd_pr__nfet_01v8 L=0.15U W=0.65U AS=0.08775P
+ AD=0.169P PS=0.92U PD=1.82U
* device instance $1520 r0 *1 68.175,68.445 sky130_fd_pr__nfet_01v8
M$1520 1265 71 94 94 sky130_fd_pr__nfet_01v8 L=0.15U W=0.42U AS=0.11285P
+ AD=0.0693P PS=1.045U PD=0.75U
* device instance $1521 r0 *1 68.655,68.445 sky130_fd_pr__nfet_01v8
M$1521 1253 1291 1265 1265 sky130_fd_pr__nfet_01v8 L=0.15U W=0.42U AS=0.0693P
+ AD=0.09975P PS=0.75U PD=0.895U
* device instance $1522 r0 *1 69.28,68.445 sky130_fd_pr__nfet_01v8
M$1522 1264 1122 1253 1253 sky130_fd_pr__nfet_01v8 L=0.15U W=0.42U AS=0.09975P
+ AD=0.0693P PS=0.895U PD=0.75U
* device instance $1523 r0 *1 69.76,68.445 sky130_fd_pr__nfet_01v8
M$1523 94 1254 1264 1264 sky130_fd_pr__nfet_01v8 L=0.15U W=0.42U AS=0.0693P
+ AD=0.1449P PS=0.75U PD=1.11U
* device instance $1524 r0 *1 70.6,68.445 sky130_fd_pr__nfet_01v8
M$1524 1254 71 94 94 sky130_fd_pr__nfet_01v8 L=0.15U W=0.42U AS=0.1449P
+ AD=0.1092P PS=1.11U PD=1.36U
* device instance $1525 r0 *1 67.63,68.56 sky130_fd_pr__nfet_01v8
M$1525 94 1253 1201 1201 sky130_fd_pr__nfet_01v8 L=0.15U W=0.65U AS=0.169P
+ AD=0.11285P PS=1.82U PD=1.045U
* device instance $1526 r0 *1 8.29,72.995 sky130_fd_pr__nfet_01v8
M$1526 94 936 1307 1307 sky130_fd_pr__nfet_01v8 L=0.15U W=0.42U AS=0.1092P
+ AD=0.0567P PS=1.36U PD=0.69U
* device instance $1527 r0 *1 8.71,72.995 sky130_fd_pr__nfet_01v8
M$1527 1308 1307 94 94 sky130_fd_pr__nfet_01v8 L=0.15U W=0.42U AS=0.0567P
+ AD=0.1092P PS=0.69U PD=1.36U
* device instance $1528 r0 *1 9.65,72.995 sky130_fd_pr__nfet_01v8
M$1528 1309 1097 94 94 sky130_fd_pr__nfet_01v8 L=0.15U W=0.42U AS=0.1092P
+ AD=0.0813P PS=1.36U PD=0.83U
* device instance $1529 r0 *1 10.21,73.025 sky130_fd_pr__nfet_01v8
M$1529 1310 1307 1309 1309 sky130_fd_pr__nfet_01v8 L=0.15U W=0.36U AS=0.0813P
+ AD=0.0621P PS=0.83U PD=0.705U
* device instance $1530 r0 *1 10.705,73.025 sky130_fd_pr__nfet_01v8
M$1530 1310 1308 1341 1341 sky130_fd_pr__nfet_01v8 L=0.15U W=0.36U AS=0.0696P
+ AD=0.0621P PS=0.765U PD=0.705U
* device instance $1531 r0 *1 11.2,72.995 sky130_fd_pr__nfet_01v8
M$1531 1341 1311 94 94 sky130_fd_pr__nfet_01v8 L=0.15U W=0.42U AS=0.12095P
+ AD=0.0696P PS=1.085U PD=0.765U
* device instance $1532 r0 *1 11.795,72.885 sky130_fd_pr__nfet_01v8
M$1532 1311 1310 94 94 sky130_fd_pr__nfet_01v8 L=0.15U W=0.64U AS=0.12095P
+ AD=0.0989P PS=1.085U PD=0.995U
* device instance $1533 r0 *1 12.3,73.025 sky130_fd_pr__nfet_01v8
M$1533 1312 1308 1311 1311 sky130_fd_pr__nfet_01v8 L=0.15U W=0.36U AS=0.0989P
+ AD=0.0684P PS=0.995U PD=0.74U
* device instance $1534 r0 *1 12.83,73.025 sky130_fd_pr__nfet_01v8
M$1534 1312 1307 1342 1342 sky130_fd_pr__nfet_01v8 L=0.15U W=0.36U AS=0.066P
+ AD=0.0684P PS=0.745U PD=0.74U
* device instance $1535 r0 *1 13.305,72.995 sky130_fd_pr__nfet_01v8
M$1535 94 1313 1342 1342 sky130_fd_pr__nfet_01v8 L=0.15U W=0.42U AS=0.066P
+ AD=0.1092P PS=0.745U PD=1.36U
* device instance $1536 r0 *1 14.25,72.88 sky130_fd_pr__nfet_01v8
M$1536 94 1312 1313 1313 sky130_fd_pr__nfet_01v8 L=0.15U W=0.65U AS=0.169P
+ AD=0.08775P PS=1.82U PD=0.92U
* device instance $1537 r0 *1 14.67,72.88 sky130_fd_pr__nfet_01v8
M$1537 1119 1313 94 94 sky130_fd_pr__nfet_01v8 L=0.15U W=0.65U AS=0.08775P
+ AD=0.169P PS=0.92U PD=1.82U
* device instance $1538 r0 *1 26.23,72.88 sky130_fd_pr__nfet_01v8
M$1538 94 1314 1255 1255 sky130_fd_pr__nfet_01v8 L=0.15U W=0.65U AS=0.169P
+ AD=0.11285P PS=1.82U PD=1.045U
* device instance $1539 r0 *1 26.775,72.995 sky130_fd_pr__nfet_01v8
M$1539 1347 71 94 94 sky130_fd_pr__nfet_01v8 L=0.15U W=0.42U AS=0.11285P
+ AD=0.0693P PS=1.045U PD=0.75U
* device instance $1540 r0 *1 27.255,72.995 sky130_fd_pr__nfet_01v8
M$1540 1314 1330 1347 1347 sky130_fd_pr__nfet_01v8 L=0.15U W=0.42U AS=0.0693P
+ AD=0.09975P PS=0.75U PD=0.895U
* device instance $1541 r0 *1 27.88,72.995 sky130_fd_pr__nfet_01v8
M$1541 1348 995 1314 1314 sky130_fd_pr__nfet_01v8 L=0.15U W=0.42U AS=0.09975P
+ AD=0.0693P PS=0.895U PD=0.75U
* device instance $1542 r0 *1 28.36,72.995 sky130_fd_pr__nfet_01v8
M$1542 94 1339 1348 1348 sky130_fd_pr__nfet_01v8 L=0.15U W=0.42U AS=0.0693P
+ AD=0.1449P PS=0.75U PD=1.11U
* device instance $1543 r0 *1 29.2,72.995 sky130_fd_pr__nfet_01v8
M$1543 1339 71 94 94 sky130_fd_pr__nfet_01v8 L=0.15U W=0.42U AS=0.1449P
+ AD=0.1092P PS=1.11U PD=1.36U
* device instance $1544 r0 *1 44.63,72.88 sky130_fd_pr__nfet_01v8
M$1544 94 1315 1183 1183 sky130_fd_pr__nfet_01v8 L=0.15U W=0.65U AS=0.169P
+ AD=0.11285P PS=1.82U PD=1.045U
* device instance $1545 r0 *1 45.175,72.995 sky130_fd_pr__nfet_01v8
M$1545 1351 71 94 94 sky130_fd_pr__nfet_01v8 L=0.15U W=0.42U AS=0.11285P
+ AD=0.0693P PS=1.045U PD=0.75U
* device instance $1546 r0 *1 45.655,72.995 sky130_fd_pr__nfet_01v8
M$1546 1315 1331 1351 1351 sky130_fd_pr__nfet_01v8 L=0.15U W=0.42U AS=0.0693P
+ AD=0.09975P PS=0.75U PD=0.895U
* device instance $1547 r0 *1 46.28,72.995 sky130_fd_pr__nfet_01v8
M$1547 1352 1121 1315 1315 sky130_fd_pr__nfet_01v8 L=0.15U W=0.42U AS=0.09975P
+ AD=0.0693P PS=0.895U PD=0.75U
* device instance $1548 r0 *1 46.76,72.995 sky130_fd_pr__nfet_01v8
M$1548 94 1340 1352 1352 sky130_fd_pr__nfet_01v8 L=0.15U W=0.42U AS=0.0693P
+ AD=0.1449P PS=0.75U PD=1.11U
* device instance $1549 r0 *1 47.6,72.995 sky130_fd_pr__nfet_01v8
M$1549 1340 71 94 94 sky130_fd_pr__nfet_01v8 L=0.15U W=0.42U AS=0.1449P
+ AD=0.1092P PS=1.11U PD=1.36U
* device instance $1550 r0 *1 58.5,72.995 sky130_fd_pr__nfet_01v8
M$1550 1350 1332 1316 1316 sky130_fd_pr__nfet_01v8 L=0.15U W=0.42U AS=0.1113P
+ AD=0.0441P PS=1.37U PD=0.63U
* device instance $1551 r0 *1 58.86,72.995 sky130_fd_pr__nfet_01v8
M$1551 94 109 1350 1350 sky130_fd_pr__nfet_01v8 L=0.15U W=0.42U AS=0.0441P
+ AD=0.0966P PS=0.63U PD=0.88U
* device instance $1552 r0 *1 59.47,72.995 sky130_fd_pr__nfet_01v8
M$1552 1260 1316 94 94 sky130_fd_pr__nfet_01v8 L=0.15U W=0.42U AS=0.0966P
+ AD=0.1113P PS=0.88U PD=1.37U
* device instance $1553 r0 *1 60.73,72.995 sky130_fd_pr__nfet_01v8
M$1553 94 996 1317 1317 sky130_fd_pr__nfet_01v8 L=0.15U W=0.42U AS=0.1092P
+ AD=0.0567P PS=1.36U PD=0.69U
* device instance $1554 r0 *1 61.15,72.995 sky130_fd_pr__nfet_01v8
M$1554 1318 1317 94 94 sky130_fd_pr__nfet_01v8 L=0.15U W=0.42U AS=0.0567P
+ AD=0.1092P PS=0.69U PD=1.36U
* device instance $1555 r0 *1 62.09,72.995 sky130_fd_pr__nfet_01v8
M$1555 1349 1290 1319 1319 sky130_fd_pr__nfet_01v8 L=0.15U W=0.42U AS=0.1092P
+ AD=0.0441P PS=1.36U PD=0.63U
* device instance $1556 r0 *1 62.45,72.995 sky130_fd_pr__nfet_01v8
M$1556 94 16 1349 1349 sky130_fd_pr__nfet_01v8 L=0.15U W=0.42U AS=0.0441P
+ AD=0.1092P PS=0.63U PD=1.36U
* device instance $1557 r0 *1 63.39,72.995 sky130_fd_pr__nfet_01v8
M$1557 94 16 1320 1320 sky130_fd_pr__nfet_01v8 L=0.15U W=0.42U AS=0.1092P
+ AD=0.0609P PS=1.36U PD=0.71U
* device instance $1558 r0 *1 63.83,72.995 sky130_fd_pr__nfet_01v8
M$1558 1346 1320 94 94 sky130_fd_pr__nfet_01v8 L=0.15U W=0.42U AS=0.0609P
+ AD=0.0756P PS=0.71U PD=0.78U
* device instance $1559 r0 *1 64.34,72.995 sky130_fd_pr__nfet_01v8
M$1559 1319 1324 1346 1346 sky130_fd_pr__nfet_01v8 L=0.15U W=0.42U AS=0.0756P
+ AD=0.1446P PS=0.78U PD=1.18U
* device instance $1560 r0 *1 65.25,73.025 sky130_fd_pr__nfet_01v8
M$1560 1321 1317 1319 1319 sky130_fd_pr__nfet_01v8 L=0.15U W=0.36U AS=0.1446P
+ AD=0.0522P PS=1.18U PD=0.65U
* device instance $1561 r0 *1 65.69,73.025 sky130_fd_pr__nfet_01v8
M$1561 1321 1318 1345 1345 sky130_fd_pr__nfet_01v8 L=0.15U W=0.36U AS=0.0759P
+ AD=0.0522P PS=0.8U PD=0.65U
* device instance $1562 r0 *1 66.22,72.995 sky130_fd_pr__nfet_01v8
M$1562 1345 1322 94 94 sky130_fd_pr__nfet_01v8 L=0.15U W=0.42U AS=0.12095P
+ AD=0.0759P PS=1.085U PD=0.8U
* device instance $1563 r0 *1 66.815,72.885 sky130_fd_pr__nfet_01v8
M$1563 1322 1321 94 94 sky130_fd_pr__nfet_01v8 L=0.15U W=0.64U AS=0.12095P
+ AD=0.1664P PS=1.085U PD=1.8U
* device instance $1564 r0 *1 65.79,74 sky130_fd_pr__nfet_01v8
M$1564 94 1123 1353 1353 sky130_fd_pr__nfet_01v8 L=0.15U W=0.65U AS=0.169P
+ AD=0.08775P PS=1.82U PD=0.92U
* device instance $1565 r0 *1 66.21,74 sky130_fd_pr__nfet_01v8
M$1565 1261 1353 94 94 sky130_fd_pr__nfet_01v8 L=0.15U W=2.6U AS=0.351P
+ AD=0.43225P PS=3.68U PD=4.58U
* device instance $1569 r0 *1 67.755,72.995 sky130_fd_pr__nfet_01v8
M$1569 1344 1322 94 94 sky130_fd_pr__nfet_01v8 L=0.15U W=0.42U AS=0.1092P
+ AD=0.0678P PS=1.36U PD=0.755U
* device instance $1570 r0 *1 68.24,73.025 sky130_fd_pr__nfet_01v8
M$1570 1323 1318 1344 1344 sky130_fd_pr__nfet_01v8 L=0.15U W=0.36U AS=0.0678P
+ AD=0.0684P PS=0.755U PD=0.74U
* device instance $1571 r0 *1 68.77,73.025 sky130_fd_pr__nfet_01v8
M$1571 1323 1317 1343 1343 sky130_fd_pr__nfet_01v8 L=0.15U W=0.36U AS=0.066P
+ AD=0.0684P PS=0.745U PD=0.74U
* device instance $1572 r0 *1 69.245,72.995 sky130_fd_pr__nfet_01v8
M$1572 94 1324 1343 1343 sky130_fd_pr__nfet_01v8 L=0.15U W=0.42U AS=0.066P
+ AD=0.1092P PS=0.745U PD=1.36U
* device instance $1573 r0 *1 70.185,72.995 sky130_fd_pr__nfet_01v8
M$1573 1324 1323 94 94 sky130_fd_pr__nfet_01v8 L=0.15U W=0.42U AS=0.10025P
+ AD=0.1092P PS=0.985U PD=1.36U
* device instance $1574 r0 *1 70.67,72.88 sky130_fd_pr__nfet_01v8
M$1574 1122 1323 94 94 sky130_fd_pr__nfet_01v8 L=0.15U W=0.65U AS=0.10025P
+ AD=0.182P PS=0.985U PD=1.86U
* device instance $1575 r0 *1 14.525,4.885 sky130_fd_pr__pfet_01v8
M$1575 11 12 168 168 sky130_fd_pr__pfet_01v8 L=0.15U W=0.64U AS=0.154P
+ AD=0.1728P PS=1.335U PD=1.82U
* device instance $1576 r0 *1 15.01,4.705 sky130_fd_pr__pfet_01v8
M$1576 129 12 168 168 sky130_fd_pr__pfet_01v8 L=0.15U W=1U AS=0.154P AD=0.28P
+ PS=1.335U PD=2.56U
* device instance $1577 r0 *1 70.185,4.885 sky130_fd_pr__pfet_01v8
M$1577 18 19 168 168 sky130_fd_pr__pfet_01v8 L=0.15U W=0.64U AS=0.154P
+ AD=0.1728P PS=1.335U PD=1.82U
* device instance $1578 r0 *1 70.67,4.705 sky130_fd_pr__pfet_01v8
M$1578 20 19 168 168 sky130_fd_pr__pfet_01v8 L=0.15U W=1U AS=0.154P AD=0.28P
+ PS=1.335U PD=2.56U
* device instance $1579 r0 *1 5.07,4.855 sky130_fd_pr__pfet_01v8
M$1579 168 31 8 8 sky130_fd_pr__pfet_01v8 L=0.15U W=0.64U AS=0.1664P AD=0.0864P
+ PS=1.8U PD=0.91U
* device instance $1580 r0 *1 5.49,4.855 sky130_fd_pr__pfet_01v8
M$1580 9 8 168 168 sky130_fd_pr__pfet_01v8 L=0.15U W=0.64U AS=0.0864P
+ AD=0.1664P PS=0.91U PD=1.8U
* device instance $1581 r0 *1 6.43,4.885 sky130_fd_pr__pfet_01v8
M$1581 33 32 2 2 sky130_fd_pr__pfet_01v8 L=0.15U W=0.64U AS=0.1664P AD=0.0672P
+ PS=1.8U PD=0.85U
* device instance $1582 r0 *1 6.79,4.885 sky130_fd_pr__pfet_01v8
M$1582 168 10 33 33 sky130_fd_pr__pfet_01v8 L=0.15U W=0.64U AS=0.0672P
+ AD=0.1664P PS=0.85U PD=1.8U
* device instance $1583 r0 *1 7.73,4.885 sky130_fd_pr__pfet_01v8
M$1583 168 93 10 10 sky130_fd_pr__pfet_01v8 L=0.15U W=0.64U AS=0.1664P
+ AD=0.0928P PS=1.8U PD=0.93U
* device instance $1584 r0 *1 8.17,4.885 sky130_fd_pr__pfet_01v8
M$1584 34 93 168 168 sky130_fd_pr__pfet_01v8 L=0.15U W=0.64U AS=0.0928P
+ AD=0.1152P PS=0.93U PD=1U
* device instance $1585 r0 *1 8.68,4.885 sky130_fd_pr__pfet_01v8
M$1585 2 11 34 34 sky130_fd_pr__pfet_01v8 L=0.15U W=0.64U AS=0.1152P
+ AD=0.15985P PS=1U PD=1.265U
* device instance $1586 r0 *1 9.455,4.995 sky130_fd_pr__pfet_01v8
M$1586 3 9 2 2 sky130_fd_pr__pfet_01v8 L=0.15U W=0.42U AS=0.15985P AD=0.06405P
+ PS=1.265U PD=0.725U
* device instance $1587 r0 *1 9.91,4.995 sky130_fd_pr__pfet_01v8
M$1587 36 8 3 3 sky130_fd_pr__pfet_01v8 L=0.15U W=0.42U AS=0.06405P AD=0.07665P
+ PS=0.725U PD=0.785U
* device instance $1588 r0 *1 10.425,4.995 sky130_fd_pr__pfet_01v8
M$1588 36 4 168 168 sky130_fd_pr__pfet_01v8 L=0.15U W=0.42U AS=0.178875P
+ AD=0.07665P PS=1.26U PD=0.785U
* device instance $1589 r0 *1 11.085,4.83 sky130_fd_pr__pfet_01v8
M$1589 4 3 168 168 sky130_fd_pr__pfet_01v8 L=0.15U W=0.75U AS=0.178875P
+ AD=0.195P PS=1.26U PD=2.02U
* device instance $1590 r0 *1 60.73,4.855 sky130_fd_pr__pfet_01v8
M$1590 168 329 13 13 sky130_fd_pr__pfet_01v8 L=0.15U W=0.64U AS=0.1664P
+ AD=0.0864P PS=1.8U PD=0.91U
* device instance $1591 r0 *1 61.15,4.855 sky130_fd_pr__pfet_01v8
M$1591 15 13 168 168 sky130_fd_pr__pfet_01v8 L=0.15U W=0.64U AS=0.0864P
+ AD=0.1664P PS=0.91U PD=1.8U
* device instance $1592 r0 *1 62.09,4.885 sky130_fd_pr__pfet_01v8
M$1592 42 14 5 5 sky130_fd_pr__pfet_01v8 L=0.15U W=0.64U AS=0.1664P AD=0.0672P
+ PS=1.8U PD=0.85U
* device instance $1593 r0 *1 62.45,4.885 sky130_fd_pr__pfet_01v8
M$1593 168 17 42 42 sky130_fd_pr__pfet_01v8 L=0.15U W=0.64U AS=0.0672P
+ AD=0.1664P PS=0.85U PD=1.8U
* device instance $1594 r0 *1 63.39,4.885 sky130_fd_pr__pfet_01v8
M$1594 168 16 17 17 sky130_fd_pr__pfet_01v8 L=0.15U W=0.64U AS=0.1664P
+ AD=0.0928P PS=1.8U PD=0.93U
* device instance $1595 r0 *1 63.83,4.885 sky130_fd_pr__pfet_01v8
M$1595 41 16 168 168 sky130_fd_pr__pfet_01v8 L=0.15U W=0.64U AS=0.0928P
+ AD=0.1152P PS=0.93U PD=1U
* device instance $1596 r0 *1 64.34,4.885 sky130_fd_pr__pfet_01v8
M$1596 5 18 41 41 sky130_fd_pr__pfet_01v8 L=0.15U W=0.64U AS=0.1152P
+ AD=0.15985P PS=1U PD=1.265U
* device instance $1597 r0 *1 65.115,4.995 sky130_fd_pr__pfet_01v8
M$1597 6 15 5 5 sky130_fd_pr__pfet_01v8 L=0.15U W=0.42U AS=0.15985P AD=0.06405P
+ PS=1.265U PD=0.725U
* device instance $1598 r0 *1 65.57,4.995 sky130_fd_pr__pfet_01v8
M$1598 39 13 6 6 sky130_fd_pr__pfet_01v8 L=0.15U W=0.42U AS=0.06405P
+ AD=0.07665P PS=0.725U PD=0.785U
* device instance $1599 r0 *1 66.085,4.995 sky130_fd_pr__pfet_01v8
M$1599 39 7 168 168 sky130_fd_pr__pfet_01v8 L=0.15U W=0.42U AS=0.178875P
+ AD=0.07665P PS=1.26U PD=0.785U
* device instance $1600 r0 *1 66.745,4.83 sky130_fd_pr__pfet_01v8
M$1600 7 6 168 168 sky130_fd_pr__pfet_01v8 L=0.15U W=0.75U AS=0.178875P
+ AD=0.195P PS=1.26U PD=2.02U
* device instance $1601 r0 *1 6.89,5.995 sky130_fd_pr__pfet_01v8
M$1601 75 65 45 45 sky130_fd_pr__pfet_01v8 L=0.15U W=0.64U AS=0.1664P
+ AD=0.0672P PS=1.8U PD=0.85U
* device instance $1602 r0 *1 7.25,5.995 sky130_fd_pr__pfet_01v8
M$1602 168 46 75 75 sky130_fd_pr__pfet_01v8 L=0.15U W=0.64U AS=0.0672P
+ AD=0.1664P PS=0.85U PD=1.8U
* device instance $1603 r0 *1 9.915,5.885 sky130_fd_pr__pfet_01v8
M$1603 47 44 45 45 sky130_fd_pr__pfet_01v8 L=0.15U W=0.42U AS=0.15985P
+ AD=0.06405P PS=1.265U PD=0.725U
* device instance $1604 r0 *1 10.37,5.885 sky130_fd_pr__pfet_01v8
M$1604 78 43 47 47 sky130_fd_pr__pfet_01v8 L=0.15U W=0.42U AS=0.06405P
+ AD=0.07665P PS=0.725U PD=0.785U
* device instance $1605 r0 *1 10.885,5.885 sky130_fd_pr__pfet_01v8
M$1605 168 48 78 78 sky130_fd_pr__pfet_01v8 L=0.15U W=0.42U AS=0.07665P
+ AD=0.178875P PS=0.785U PD=1.26U
* device instance $1606 r0 *1 8.19,5.995 sky130_fd_pr__pfet_01v8
M$1606 168 16 46 46 sky130_fd_pr__pfet_01v8 L=0.15U W=0.64U AS=0.1664P
+ AD=0.0928P PS=1.8U PD=0.93U
* device instance $1607 r0 *1 8.63,5.995 sky130_fd_pr__pfet_01v8
M$1607 76 16 168 168 sky130_fd_pr__pfet_01v8 L=0.15U W=0.64U AS=0.0928P
+ AD=0.1152P PS=0.93U PD=1U
* device instance $1608 r0 *1 9.14,5.995 sky130_fd_pr__pfet_01v8
M$1608 45 49 76 76 sky130_fd_pr__pfet_01v8 L=0.15U W=0.64U AS=0.1152P
+ AD=0.15985P PS=1U PD=1.265U
* device instance $1609 r0 *1 11.545,6.05 sky130_fd_pr__pfet_01v8
M$1609 48 47 168 168 sky130_fd_pr__pfet_01v8 L=0.15U W=0.75U AS=0.178875P
+ AD=0.195P PS=1.26U PD=2.02U
* device instance $1610 r0 *1 12.025,4.995 sky130_fd_pr__pfet_01v8
M$1610 38 4 168 168 sky130_fd_pr__pfet_01v8 L=0.15U W=0.42U AS=0.1092P
+ AD=0.06405P PS=1.36U PD=0.725U
* device instance $1611 r0 *1 12.48,4.995 sky130_fd_pr__pfet_01v8
M$1611 12 8 38 38 sky130_fd_pr__pfet_01v8 L=0.15U W=0.42U AS=0.06405P
+ AD=0.0567P PS=0.725U PD=0.69U
* device instance $1612 r0 *1 12.9,4.995 sky130_fd_pr__pfet_01v8
M$1612 40 9 12 12 sky130_fd_pr__pfet_01v8 L=0.15U W=0.42U AS=0.0567P AD=0.0882P
+ PS=0.69U PD=0.84U
* device instance $1613 r0 *1 13.47,4.995 sky130_fd_pr__pfet_01v8
M$1613 168 11 40 40 sky130_fd_pr__pfet_01v8 L=0.15U W=0.42U AS=0.0882P
+ AD=0.1113P PS=0.84U PD=1.37U
* device instance $1614 r0 *1 12.485,5.885 sky130_fd_pr__pfet_01v8
M$1614 80 48 168 168 sky130_fd_pr__pfet_01v8 L=0.15U W=0.42U AS=0.1092P
+ AD=0.06405P PS=1.36U PD=0.725U
* device instance $1615 r0 *1 12.94,5.885 sky130_fd_pr__pfet_01v8
M$1615 66 43 80 80 sky130_fd_pr__pfet_01v8 L=0.15U W=0.42U AS=0.06405P
+ AD=0.0567P PS=0.725U PD=0.69U
* device instance $1616 r0 *1 13.36,5.885 sky130_fd_pr__pfet_01v8
M$1616 81 44 66 66 sky130_fd_pr__pfet_01v8 L=0.15U W=0.42U AS=0.0567P
+ AD=0.0882P PS=0.69U PD=0.84U
* device instance $1617 r0 *1 13.93,5.885 sky130_fd_pr__pfet_01v8
M$1617 168 49 81 81 sky130_fd_pr__pfet_01v8 L=0.15U W=0.42U AS=0.0882P
+ AD=0.1113P PS=0.84U PD=1.37U
* device instance $1618 r0 *1 14.985,5.995 sky130_fd_pr__pfet_01v8
M$1618 168 66 49 49 sky130_fd_pr__pfet_01v8 L=0.15U W=0.64U AS=0.1728P
+ AD=0.154P PS=1.82U PD=1.335U
* device instance $1619 r0 *1 15.47,6.175 sky130_fd_pr__pfet_01v8
M$1619 50 66 168 168 sky130_fd_pr__pfet_01v8 L=0.15U W=1U AS=0.154P AD=0.28P
+ PS=1.335U PD=2.56U
* device instance $1620 r0 *1 23.47,6.175 sky130_fd_pr__pfet_01v8
M$1620 52 88 51 51 sky130_fd_pr__pfet_01v8 L=0.15U W=1U AS=0.26P AD=0.135P
+ PS=2.52U PD=1.27U
* device instance $1621 r0 *1 23.89,6.175 sky130_fd_pr__pfet_01v8
M$1621 68 164 52 52 sky130_fd_pr__pfet_01v8 L=0.15U W=1U AS=0.135P AD=0.135P
+ PS=1.27U PD=1.27U
* device instance $1622 r0 *1 24.31,6.175 sky130_fd_pr__pfet_01v8
M$1622 52 90 68 68 sky130_fd_pr__pfet_01v8 L=0.15U W=1U AS=0.135P AD=0.26P
+ PS=1.27U PD=2.52U
* device instance $1623 r0 *1 25.25,6.175 sky130_fd_pr__pfet_01v8
M$1623 68 87 168 168 sky130_fd_pr__pfet_01v8 L=0.15U W=1U AS=0.26P AD=0.165P
+ PS=2.52U PD=1.33U
* device instance $1624 r0 *1 25.73,6.175 sky130_fd_pr__pfet_01v8
M$1624 168 89 68 68 sky130_fd_pr__pfet_01v8 L=0.15U W=1U AS=0.165P AD=0.1575P
+ PS=1.33U PD=1.315U
* device instance $1625 r0 *1 26.195,6.175 sky130_fd_pr__pfet_01v8
M$1625 67 51 168 168 sky130_fd_pr__pfet_01v8 L=0.15U W=1U AS=0.1575P AD=0.26P
+ PS=1.315U PD=2.52U
* device instance $1626 r0 *1 27.665,5.995 sky130_fd_pr__pfet_01v8
M$1626 84 69 168 168 sky130_fd_pr__pfet_01v8 L=0.15U W=0.64U AS=0.1696P
+ AD=0.0768P PS=1.81U PD=0.88U
* device instance $1627 r0 *1 28.055,5.995 sky130_fd_pr__pfet_01v8
M$1627 70 71 84 84 sky130_fd_pr__pfet_01v8 L=0.15U W=0.64U AS=0.0768P
+ AD=0.0896P PS=0.88U PD=0.92U
* device instance $1628 r0 *1 28.485,5.995 sky130_fd_pr__pfet_01v8
M$1628 168 53 70 70 sky130_fd_pr__pfet_01v8 L=0.15U W=0.64U AS=0.0896P
+ AD=0.1824P PS=0.92U PD=1.85U
* device instance $1629 r0 *1 44.67,6.175 sky130_fd_pr__pfet_01v8
M$1629 86 72 54 54 sky130_fd_pr__pfet_01v8 L=0.15U W=1U AS=0.26P AD=0.135P
+ PS=2.52U PD=1.27U
* device instance $1630 r0 *1 45.09,6.175 sky130_fd_pr__pfet_01v8
M$1630 168 55 86 86 sky130_fd_pr__pfet_01v8 L=0.15U W=1U AS=0.135P AD=0.135P
+ PS=1.27U PD=1.27U
* device instance $1631 r0 *1 45.51,6.175 sky130_fd_pr__pfet_01v8
M$1631 56 55 168 168 sky130_fd_pr__pfet_01v8 L=0.15U W=1U AS=0.135P AD=0.135P
+ PS=1.27U PD=1.27U
* device instance $1632 r0 *1 45.93,6.175 sky130_fd_pr__pfet_01v8
M$1632 168 72 56 56 sky130_fd_pr__pfet_01v8 L=0.15U W=1U AS=0.135P AD=0.26P
+ PS=1.27U PD=2.52U
* device instance $1633 r0 *1 46.87,6.175 sky130_fd_pr__pfet_01v8
M$1633 57 54 56 56 sky130_fd_pr__pfet_01v8 L=0.15U W=1U AS=0.26P AD=0.3P
+ PS=2.52U PD=2.6U
* device instance $1634 r0 *1 66.23,5.995 sky130_fd_pr__pfet_01v8
M$1634 85 73 60 60 sky130_fd_pr__pfet_01v8 L=0.15U W=0.64U AS=0.1664P
+ AD=0.0672P PS=1.8U PD=0.85U
* device instance $1635 r0 *1 66.59,5.995 sky130_fd_pr__pfet_01v8
M$1635 168 61 85 85 sky130_fd_pr__pfet_01v8 L=0.15U W=0.64U AS=0.0672P
+ AD=0.1664P PS=0.85U PD=1.8U
* device instance $1636 r0 *1 69.255,5.885 sky130_fd_pr__pfet_01v8
M$1636 62 59 60 60 sky130_fd_pr__pfet_01v8 L=0.15U W=0.42U AS=0.15985P
+ AD=0.06405P PS=1.265U PD=0.725U
* device instance $1637 r0 *1 69.71,5.885 sky130_fd_pr__pfet_01v8
M$1637 82 58 62 62 sky130_fd_pr__pfet_01v8 L=0.15U W=0.42U AS=0.06405P
+ AD=0.07665P PS=0.725U PD=0.785U
* device instance $1638 r0 *1 70.225,5.885 sky130_fd_pr__pfet_01v8
M$1638 168 63 82 82 sky130_fd_pr__pfet_01v8 L=0.15U W=0.42U AS=0.07665P
+ AD=0.178875P PS=0.785U PD=1.26U
* device instance $1639 r0 *1 67.53,5.995 sky130_fd_pr__pfet_01v8
M$1639 168 93 61 61 sky130_fd_pr__pfet_01v8 L=0.15U W=0.64U AS=0.1664P
+ AD=0.0928P PS=1.8U PD=0.93U
* device instance $1640 r0 *1 67.97,5.995 sky130_fd_pr__pfet_01v8
M$1640 83 93 168 168 sky130_fd_pr__pfet_01v8 L=0.15U W=0.64U AS=0.0928P
+ AD=0.1152P PS=0.93U PD=1U
* device instance $1641 r0 *1 68.48,5.995 sky130_fd_pr__pfet_01v8
M$1641 60 64 83 83 sky130_fd_pr__pfet_01v8 L=0.15U W=0.64U AS=0.1152P
+ AD=0.15985P PS=1U PD=1.265U
* device instance $1642 r0 *1 70.885,6.05 sky130_fd_pr__pfet_01v8
M$1642 63 62 168 168 sky130_fd_pr__pfet_01v8 L=0.15U W=0.75U AS=0.178875P
+ AD=0.195P PS=1.26U PD=2.02U
* device instance $1643 r0 *1 67.685,4.995 sky130_fd_pr__pfet_01v8
M$1643 37 7 168 168 sky130_fd_pr__pfet_01v8 L=0.15U W=0.42U AS=0.1092P
+ AD=0.06405P PS=1.36U PD=0.725U
* device instance $1644 r0 *1 68.14,4.995 sky130_fd_pr__pfet_01v8
M$1644 19 13 37 37 sky130_fd_pr__pfet_01v8 L=0.15U W=0.42U AS=0.06405P
+ AD=0.0567P PS=0.725U PD=0.69U
* device instance $1645 r0 *1 68.56,4.995 sky130_fd_pr__pfet_01v8
M$1645 35 15 19 19 sky130_fd_pr__pfet_01v8 L=0.15U W=0.42U AS=0.0567P
+ AD=0.0882P PS=0.69U PD=0.84U
* device instance $1646 r0 *1 69.13,4.995 sky130_fd_pr__pfet_01v8
M$1646 168 18 35 35 sky130_fd_pr__pfet_01v8 L=0.15U W=0.42U AS=0.0882P
+ AD=0.1113P PS=0.84U PD=1.37U
* device instance $1647 r0 *1 71.825,5.885 sky130_fd_pr__pfet_01v8
M$1647 79 63 168 168 sky130_fd_pr__pfet_01v8 L=0.15U W=0.42U AS=0.1092P
+ AD=0.06405P PS=1.36U PD=0.725U
* device instance $1648 r0 *1 72.28,5.885 sky130_fd_pr__pfet_01v8
M$1648 74 58 79 79 sky130_fd_pr__pfet_01v8 L=0.15U W=0.42U AS=0.06405P
+ AD=0.0567P PS=0.725U PD=0.69U
* device instance $1649 r0 *1 72.7,5.885 sky130_fd_pr__pfet_01v8
M$1649 77 59 74 74 sky130_fd_pr__pfet_01v8 L=0.15U W=0.42U AS=0.0567P
+ AD=0.0882P PS=0.69U PD=0.84U
* device instance $1650 r0 *1 73.27,5.885 sky130_fd_pr__pfet_01v8
M$1650 168 64 77 77 sky130_fd_pr__pfet_01v8 L=0.15U W=0.42U AS=0.0882P
+ AD=0.1113P PS=0.84U PD=1.37U
* device instance $1651 r0 *1 74.325,5.995 sky130_fd_pr__pfet_01v8
M$1651 168 74 64 64 sky130_fd_pr__pfet_01v8 L=0.15U W=0.64U AS=0.1728P
+ AD=0.154P PS=1.82U PD=1.335U
* device instance $1652 r0 *1 74.81,6.175 sky130_fd_pr__pfet_01v8
M$1652 137 74 168 168 sky130_fd_pr__pfet_01v8 L=0.15U W=1U AS=0.154P AD=0.28P
+ PS=1.335U PD=2.56U
* device instance $1653 r0 *1 5.53,6.025 sky130_fd_pr__pfet_01v8
M$1653 168 31 43 43 sky130_fd_pr__pfet_01v8 L=0.15U W=0.64U AS=0.1664P
+ AD=0.0864P PS=1.8U PD=0.91U
* device instance $1654 r0 *1 5.95,6.025 sky130_fd_pr__pfet_01v8
M$1654 44 43 168 168 sky130_fd_pr__pfet_01v8 L=0.15U W=0.64U AS=0.0864P
+ AD=0.1664P PS=0.91U PD=1.8U
* device instance $1655 r0 *1 9.21,10.145 sky130_fd_pr__pfet_01v8
M$1655 162 110 111 111 sky130_fd_pr__pfet_01v8 L=0.15U W=1U AS=0.26P AD=0.135P
+ PS=2.52U PD=1.27U
* device instance $1656 r0 *1 9.63,10.145 sky130_fd_pr__pfet_01v8
M$1656 163 129 162 162 sky130_fd_pr__pfet_01v8 L=0.15U W=1U AS=0.135P AD=0.135P
+ PS=1.27U PD=1.27U
* device instance $1657 r0 *1 10.05,10.145 sky130_fd_pr__pfet_01v8
M$1657 162 90 163 163 sky130_fd_pr__pfet_01v8 L=0.15U W=1U AS=0.135P AD=0.26P
+ PS=1.27U PD=2.52U
* device instance $1658 r0 *1 10.99,10.145 sky130_fd_pr__pfet_01v8
M$1658 163 87 168 168 sky130_fd_pr__pfet_01v8 L=0.15U W=1U AS=0.26P AD=0.165P
+ PS=2.52U PD=1.33U
* device instance $1659 r0 *1 11.47,10.145 sky130_fd_pr__pfet_01v8
M$1659 168 130 163 163 sky130_fd_pr__pfet_01v8 L=0.15U W=1U AS=0.165P
+ AD=0.1575P PS=1.33U PD=1.315U
* device instance $1660 r0 *1 11.935,10.145 sky130_fd_pr__pfet_01v8
M$1660 65 111 168 168 sky130_fd_pr__pfet_01v8 L=0.15U W=1U AS=0.1575P AD=0.26P
+ PS=1.315U PD=2.52U
* device instance $1661 r0 *1 25.31,10.295 sky130_fd_pr__pfet_01v8
M$1661 168 31 131 131 sky130_fd_pr__pfet_01v8 L=0.15U W=0.64U AS=0.1664P
+ AD=0.0864P PS=1.8U PD=0.91U
* device instance $1662 r0 *1 25.73,10.295 sky130_fd_pr__pfet_01v8
M$1662 132 131 168 168 sky130_fd_pr__pfet_01v8 L=0.15U W=0.64U AS=0.0864P
+ AD=0.1664P PS=0.91U PD=1.8U
* device instance $1663 r0 *1 26.67,10.325 sky130_fd_pr__pfet_01v8
M$1663 173 70 113 113 sky130_fd_pr__pfet_01v8 L=0.15U W=0.64U AS=0.1664P
+ AD=0.0672P PS=1.8U PD=0.85U
* device instance $1664 r0 *1 27.03,10.325 sky130_fd_pr__pfet_01v8
M$1664 168 133 173 173 sky130_fd_pr__pfet_01v8 L=0.15U W=0.64U AS=0.0672P
+ AD=0.1664P PS=0.85U PD=1.8U
* device instance $1665 r0 *1 27.97,10.325 sky130_fd_pr__pfet_01v8
M$1665 168 93 133 133 sky130_fd_pr__pfet_01v8 L=0.15U W=0.64U AS=0.1664P
+ AD=0.0928P PS=1.8U PD=0.93U
* device instance $1666 r0 *1 28.41,10.325 sky130_fd_pr__pfet_01v8
M$1666 174 93 168 168 sky130_fd_pr__pfet_01v8 L=0.15U W=0.64U AS=0.0928P
+ AD=0.1152P PS=0.93U PD=1U
* device instance $1667 r0 *1 28.92,10.325 sky130_fd_pr__pfet_01v8
M$1667 113 134 174 174 sky130_fd_pr__pfet_01v8 L=0.15U W=0.64U AS=0.1152P
+ AD=0.15985P PS=1U PD=1.265U
* device instance $1668 r0 *1 29.695,10.435 sky130_fd_pr__pfet_01v8
M$1668 114 132 113 113 sky130_fd_pr__pfet_01v8 L=0.15U W=0.42U AS=0.15985P
+ AD=0.06405P PS=1.265U PD=0.725U
* device instance $1669 r0 *1 30.15,10.435 sky130_fd_pr__pfet_01v8
M$1669 175 131 114 114 sky130_fd_pr__pfet_01v8 L=0.15U W=0.42U AS=0.06405P
+ AD=0.07665P PS=0.725U PD=0.785U
* device instance $1670 r0 *1 30.665,10.435 sky130_fd_pr__pfet_01v8
M$1670 175 115 168 168 sky130_fd_pr__pfet_01v8 L=0.15U W=0.42U AS=0.178875P
+ AD=0.07665P PS=1.26U PD=0.785U
* device instance $1671 r0 *1 31.325,10.27 sky130_fd_pr__pfet_01v8
M$1671 115 114 168 168 sky130_fd_pr__pfet_01v8 L=0.15U W=0.75U AS=0.178875P
+ AD=0.195P PS=1.26U PD=2.02U
* device instance $1672 r0 *1 34.765,10.325 sky130_fd_pr__pfet_01v8
M$1672 134 116 168 168 sky130_fd_pr__pfet_01v8 L=0.15U W=0.64U AS=0.154P
+ AD=0.1728P PS=1.335U PD=1.82U
* device instance $1673 r0 *1 35.25,10.145 sky130_fd_pr__pfet_01v8
M$1673 164 116 168 168 sky130_fd_pr__pfet_01v8 L=0.15U W=1U AS=0.154P AD=0.28P
+ PS=1.335U PD=2.56U
* device instance $1674 r0 *1 47.475,10.24 sky130_fd_pr__pfet_01v8
M$1674 172 71 168 168 sky130_fd_pr__pfet_01v8 L=0.15U W=0.42U AS=0.15835P
+ AD=0.07665P PS=1.395U PD=0.785U
* device instance $1675 r0 *1 47.99,10.24 sky130_fd_pr__pfet_01v8
M$1675 121 135 172 172 sky130_fd_pr__pfet_01v8 L=0.15U W=0.42U AS=0.07665P
+ AD=0.1932P PS=0.785U PD=1.34U
* device instance $1676 r0 *1 49.06,10.24 sky130_fd_pr__pfet_01v8
M$1676 171 136 121 121 sky130_fd_pr__pfet_01v8 L=0.15U W=0.42U AS=0.1932P
+ AD=0.0441P PS=1.34U PD=0.63U
* device instance $1677 r0 *1 49.42,10.24 sky130_fd_pr__pfet_01v8
M$1677 168 122 171 171 sky130_fd_pr__pfet_01v8 L=0.15U W=0.42U AS=0.0441P
+ AD=0.0693P PS=0.63U PD=0.75U
* device instance $1678 r0 *1 49.9,10.24 sky130_fd_pr__pfet_01v8
M$1678 122 71 168 168 sky130_fd_pr__pfet_01v8 L=0.15U W=0.42U AS=0.0693P
+ AD=0.1176P PS=0.75U PD=1.4U
* device instance $1679 r0 *1 46.93,10.145 sky130_fd_pr__pfet_01v8
M$1679 168 121 120 120 sky130_fd_pr__pfet_01v8 L=0.15U W=1U AS=0.26P
+ AD=0.15835P PS=2.52U PD=1.395U
* device instance $1680 r0 *1 59.81,10.145 sky130_fd_pr__pfet_01v8
M$1680 166 124 125 125 sky130_fd_pr__pfet_01v8 L=0.15U W=1U AS=0.26P AD=0.135P
+ PS=2.52U PD=1.27U
* device instance $1681 r0 *1 60.23,10.145 sky130_fd_pr__pfet_01v8
M$1681 167 137 166 166 sky130_fd_pr__pfet_01v8 L=0.15U W=1U AS=0.135P AD=0.135P
+ PS=1.27U PD=1.27U
* device instance $1682 r0 *1 60.65,10.145 sky130_fd_pr__pfet_01v8
M$1682 166 90 167 167 sky130_fd_pr__pfet_01v8 L=0.15U W=1U AS=0.135P AD=0.26P
+ PS=1.27U PD=2.52U
* device instance $1683 r0 *1 61.59,10.145 sky130_fd_pr__pfet_01v8
M$1683 167 138 168 168 sky130_fd_pr__pfet_01v8 L=0.15U W=1U AS=0.26P AD=0.165P
+ PS=2.52U PD=1.33U
* device instance $1684 r0 *1 62.07,10.145 sky130_fd_pr__pfet_01v8
M$1684 168 1 167 167 sky130_fd_pr__pfet_01v8 L=0.15U W=1U AS=0.165P AD=0.1575P
+ PS=1.33U PD=1.315U
* device instance $1685 r0 *1 62.535,10.145 sky130_fd_pr__pfet_01v8
M$1685 14 125 168 168 sky130_fd_pr__pfet_01v8 L=0.15U W=1U AS=0.1575P AD=0.26P
+ PS=1.315U PD=2.52U
* device instance $1686 r0 *1 64.87,6.025 sky130_fd_pr__pfet_01v8
M$1686 168 329 58 58 sky130_fd_pr__pfet_01v8 L=0.15U W=0.64U AS=0.1664P
+ AD=0.0864P PS=1.8U PD=0.91U
* device instance $1687 r0 *1 65.29,6.025 sky130_fd_pr__pfet_01v8
M$1687 59 58 168 168 sky130_fd_pr__pfet_01v8 L=0.15U W=0.64U AS=0.0864P
+ AD=0.1664P PS=0.91U PD=1.8U
* device instance $1688 r0 *1 68.175,10.24 sky130_fd_pr__pfet_01v8
M$1688 170 71 168 168 sky130_fd_pr__pfet_01v8 L=0.15U W=0.42U AS=0.15835P
+ AD=0.07665P PS=1.395U PD=0.785U
* device instance $1689 r0 *1 68.69,10.24 sky130_fd_pr__pfet_01v8
M$1689 126 20 170 170 sky130_fd_pr__pfet_01v8 L=0.15U W=0.42U AS=0.07665P
+ AD=0.1932P PS=0.785U PD=1.34U
* device instance $1690 r0 *1 69.76,10.24 sky130_fd_pr__pfet_01v8
M$1690 169 127 126 126 sky130_fd_pr__pfet_01v8 L=0.15U W=0.42U AS=0.1932P
+ AD=0.0441P PS=1.34U PD=0.63U
* device instance $1691 r0 *1 70.12,10.24 sky130_fd_pr__pfet_01v8
M$1691 168 128 169 169 sky130_fd_pr__pfet_01v8 L=0.15U W=0.42U AS=0.0441P
+ AD=0.0693P PS=0.63U PD=0.75U
* device instance $1692 r0 *1 70.6,10.24 sky130_fd_pr__pfet_01v8
M$1692 128 71 168 168 sky130_fd_pr__pfet_01v8 L=0.15U W=0.42U AS=0.0693P
+ AD=0.1176P PS=0.75U PD=1.4U
* device instance $1693 r0 *1 67.63,10.145 sky130_fd_pr__pfet_01v8
M$1693 168 126 73 73 sky130_fd_pr__pfet_01v8 L=0.15U W=1U AS=0.26P AD=0.15835P
+ PS=2.52U PD=1.395U
* device instance $1694 r0 *1 6.98,10.435 sky130_fd_pr__pfet_01v8
M$1694 108 157 168 168 sky130_fd_pr__pfet_01v8 L=0.15U W=0.42U AS=0.1113P
+ AD=0.0609P PS=1.37U PD=0.71U
* device instance $1695 r0 *1 7.42,10.435 sky130_fd_pr__pfet_01v8
M$1695 108 109 168 168 sky130_fd_pr__pfet_01v8 L=0.15U W=0.42U AS=0.1841P
+ AD=0.0609P PS=1.26U PD=0.71U
* device instance $1696 r0 *1 8.19,10.325 sky130_fd_pr__pfet_01v8
M$1696 110 108 168 168 sky130_fd_pr__pfet_01v8 L=0.15U W=0.64U AS=0.1841P
+ AD=0.1696P PS=1.26U PD=1.81U
* device instance $1697 r0 *1 8.375,11.52 sky130_fd_pr__pfet_01v8
M$1697 215 71 168 168 sky130_fd_pr__pfet_01v8 L=0.15U W=0.42U AS=0.15835P
+ AD=0.07665P PS=1.395U PD=0.785U
* device instance $1698 r0 *1 8.89,11.52 sky130_fd_pr__pfet_01v8
M$1698 178 50 215 215 sky130_fd_pr__pfet_01v8 L=0.15U W=0.42U AS=0.07665P
+ AD=0.1932P PS=0.785U PD=1.34U
* device instance $1699 r0 *1 9.96,11.52 sky130_fd_pr__pfet_01v8
M$1699 216 209 178 178 sky130_fd_pr__pfet_01v8 L=0.15U W=0.42U AS=0.1932P
+ AD=0.0441P PS=1.34U PD=0.63U
* device instance $1700 r0 *1 10.32,11.52 sky130_fd_pr__pfet_01v8
M$1700 168 233 216 216 sky130_fd_pr__pfet_01v8 L=0.15U W=0.42U AS=0.0441P
+ AD=0.0693P PS=0.63U PD=0.75U
* device instance $1701 r0 *1 10.8,11.52 sky130_fd_pr__pfet_01v8
M$1701 233 71 168 168 sky130_fd_pr__pfet_01v8 L=0.15U W=0.42U AS=0.0693P
+ AD=0.1176P PS=0.75U PD=1.4U
* device instance $1702 r0 *1 7.83,11.615 sky130_fd_pr__pfet_01v8
M$1702 168 178 32 32 sky130_fd_pr__pfet_01v8 L=0.15U W=1U AS=0.26P AD=0.15835P
+ PS=2.52U PD=1.395U
* device instance $1703 r0 *1 12.47,11.615 sky130_fd_pr__pfet_01v8
M$1703 179 210 168 168 sky130_fd_pr__pfet_01v8 L=0.15U W=1U AS=0.3P AD=0.135P
+ PS=2.6U PD=1.27U
* device instance $1704 r0 *1 12.89,11.615 sky130_fd_pr__pfet_01v8
M$1704 168 231 179 179 sky130_fd_pr__pfet_01v8 L=0.15U W=1U AS=0.135P AD=0.365P
+ PS=1.27U PD=1.73U
* device instance $1705 r0 *1 13.77,11.615 sky130_fd_pr__pfet_01v8
M$1705 217 231 168 168 sky130_fd_pr__pfet_01v8 L=0.15U W=1U AS=0.365P AD=0.105P
+ PS=1.73U PD=1.21U
* device instance $1706 r0 *1 14.13,11.615 sky130_fd_pr__pfet_01v8
M$1706 130 210 217 217 sky130_fd_pr__pfet_01v8 L=0.15U W=1U AS=0.105P AD=0.165P
+ PS=1.21U PD=1.33U
* device instance $1707 r0 *1 14.61,11.615 sky130_fd_pr__pfet_01v8
M$1707 168 179 130 130 sky130_fd_pr__pfet_01v8 L=0.15U W=1U AS=0.165P AD=0.36P
+ PS=1.33U PD=2.72U
* device instance $1708 r0 *1 15.69,11.615 sky130_fd_pr__pfet_01v8
M$1708 218 50 180 180 sky130_fd_pr__pfet_01v8 L=0.15U W=1U AS=0.26P AD=0.135P
+ PS=2.52U PD=1.27U
* device instance $1709 r0 *1 16.11,11.615 sky130_fd_pr__pfet_01v8
M$1709 168 129 218 218 sky130_fd_pr__pfet_01v8 L=0.15U W=1U AS=0.135P AD=0.135P
+ PS=1.27U PD=1.27U
* device instance $1710 r0 *1 16.53,11.615 sky130_fd_pr__pfet_01v8
M$1710 181 129 168 168 sky130_fd_pr__pfet_01v8 L=0.15U W=1U AS=0.135P AD=0.135P
+ PS=1.27U PD=1.27U
* device instance $1711 r0 *1 16.95,11.615 sky130_fd_pr__pfet_01v8
M$1711 168 50 181 181 sky130_fd_pr__pfet_01v8 L=0.15U W=1U AS=0.135P AD=0.26P
+ PS=1.27U PD=2.52U
* device instance $1712 r0 *1 17.89,11.615 sky130_fd_pr__pfet_01v8
M$1712 210 180 181 181 sky130_fd_pr__pfet_01v8 L=0.15U W=1U AS=0.26P AD=0.3P
+ PS=2.52U PD=2.6U
* device instance $1713 r0 *1 20.69,11.435 sky130_fd_pr__pfet_01v8
M$1713 219 67 185 185 sky130_fd_pr__pfet_01v8 L=0.15U W=0.64U AS=0.1664P
+ AD=0.0672P PS=1.8U PD=0.85U
* device instance $1714 r0 *1 21.05,11.435 sky130_fd_pr__pfet_01v8
M$1714 168 184 219 219 sky130_fd_pr__pfet_01v8 L=0.15U W=0.64U AS=0.0672P
+ AD=0.1664P PS=0.85U PD=1.8U
* device instance $1715 r0 *1 23.715,11.325 sky130_fd_pr__pfet_01v8
M$1715 186 183 185 185 sky130_fd_pr__pfet_01v8 L=0.15U W=0.42U AS=0.15985P
+ AD=0.06405P PS=1.265U PD=0.725U
* device instance $1716 r0 *1 24.17,11.325 sky130_fd_pr__pfet_01v8
M$1716 222 182 186 186 sky130_fd_pr__pfet_01v8 L=0.15U W=0.42U AS=0.06405P
+ AD=0.07665P PS=0.725U PD=0.785U
* device instance $1717 r0 *1 24.685,11.325 sky130_fd_pr__pfet_01v8
M$1717 168 187 222 222 sky130_fd_pr__pfet_01v8 L=0.15U W=0.42U AS=0.07665P
+ AD=0.178875P PS=0.785U PD=1.26U
* device instance $1718 r0 *1 21.99,11.435 sky130_fd_pr__pfet_01v8
M$1718 168 16 184 184 sky130_fd_pr__pfet_01v8 L=0.15U W=0.64U AS=0.1664P
+ AD=0.0928P PS=1.8U PD=0.93U
* device instance $1719 r0 *1 22.43,11.435 sky130_fd_pr__pfet_01v8
M$1719 221 16 168 168 sky130_fd_pr__pfet_01v8 L=0.15U W=0.64U AS=0.0928P
+ AD=0.1152P PS=0.93U PD=1U
* device instance $1720 r0 *1 22.94,11.435 sky130_fd_pr__pfet_01v8
M$1720 185 189 221 221 sky130_fd_pr__pfet_01v8 L=0.15U W=0.64U AS=0.1152P
+ AD=0.15985P PS=1U PD=1.265U
* device instance $1721 r0 *1 25.345,11.49 sky130_fd_pr__pfet_01v8
M$1721 187 186 168 168 sky130_fd_pr__pfet_01v8 L=0.15U W=0.75U AS=0.178875P
+ AD=0.195P PS=1.26U PD=2.02U
* device instance $1722 r0 *1 23.08,10.435 sky130_fd_pr__pfet_01v8
M$1722 112 158 168 168 sky130_fd_pr__pfet_01v8 L=0.15U W=0.42U AS=0.1113P
+ AD=0.0609P PS=1.37U PD=0.71U
* device instance $1723 r0 *1 23.52,10.435 sky130_fd_pr__pfet_01v8
M$1723 112 109 168 168 sky130_fd_pr__pfet_01v8 L=0.15U W=0.42U AS=0.1841P
+ AD=0.0609P PS=1.26U PD=0.71U
* device instance $1724 r0 *1 24.29,10.325 sky130_fd_pr__pfet_01v8
M$1724 88 112 168 168 sky130_fd_pr__pfet_01v8 L=0.15U W=0.64U AS=0.1841P
+ AD=0.1696P PS=1.26U PD=1.81U
* device instance $1725 r0 *1 26.285,11.325 sky130_fd_pr__pfet_01v8
M$1725 223 187 168 168 sky130_fd_pr__pfet_01v8 L=0.15U W=0.42U AS=0.1092P
+ AD=0.06405P PS=1.36U PD=0.725U
* device instance $1726 r0 *1 26.74,11.325 sky130_fd_pr__pfet_01v8
M$1726 188 182 223 223 sky130_fd_pr__pfet_01v8 L=0.15U W=0.42U AS=0.06405P
+ AD=0.0567P PS=0.725U PD=0.69U
* device instance $1727 r0 *1 27.16,11.325 sky130_fd_pr__pfet_01v8
M$1727 224 183 188 188 sky130_fd_pr__pfet_01v8 L=0.15U W=0.42U AS=0.0567P
+ AD=0.0882P PS=0.69U PD=0.84U
* device instance $1728 r0 *1 27.73,11.325 sky130_fd_pr__pfet_01v8
M$1728 168 189 224 224 sky130_fd_pr__pfet_01v8 L=0.15U W=0.42U AS=0.0882P
+ AD=0.1113P PS=0.84U PD=1.37U
* device instance $1729 r0 *1 28.785,11.435 sky130_fd_pr__pfet_01v8
M$1729 168 188 189 189 sky130_fd_pr__pfet_01v8 L=0.15U W=0.64U AS=0.1728P
+ AD=0.154P PS=1.82U PD=1.335U
* device instance $1730 r0 *1 29.27,11.615 sky130_fd_pr__pfet_01v8
M$1730 190 188 168 168 sky130_fd_pr__pfet_01v8 L=0.15U W=1U AS=0.154P AD=0.28P
+ PS=1.335U PD=2.56U
* device instance $1731 r0 *1 30.85,11.615 sky130_fd_pr__pfet_01v8
M$1731 53 92 168 168 sky130_fd_pr__pfet_01v8 L=0.15U W=1U AS=0.26P AD=0.135P
+ PS=2.52U PD=1.27U
* device instance $1732 r0 *1 31.27,11.615 sky130_fd_pr__pfet_01v8
M$1732 168 71 53 53 sky130_fd_pr__pfet_01v8 L=0.15U W=1U AS=0.135P AD=0.26P
+ PS=1.27U PD=2.52U
* device instance $1733 r0 *1 32.21,11.535 sky130_fd_pr__pfet_01v8
M$1733 69 190 168 168 sky130_fd_pr__pfet_01v8 L=0.15U W=1.68U AS=0.3318P
+ AD=0.3486P PS=3.31U PD=3.35U
* device instance $1735 r0 *1 32.265,10.435 sky130_fd_pr__pfet_01v8
M$1735 176 115 168 168 sky130_fd_pr__pfet_01v8 L=0.15U W=0.42U AS=0.1092P
+ AD=0.06405P PS=1.36U PD=0.725U
* device instance $1736 r0 *1 32.72,10.435 sky130_fd_pr__pfet_01v8
M$1736 116 131 176 176 sky130_fd_pr__pfet_01v8 L=0.15U W=0.42U AS=0.06405P
+ AD=0.0567P PS=0.725U PD=0.69U
* device instance $1737 r0 *1 33.14,10.435 sky130_fd_pr__pfet_01v8
M$1737 177 132 116 116 sky130_fd_pr__pfet_01v8 L=0.15U W=0.42U AS=0.0567P
+ AD=0.0882P PS=0.69U PD=0.84U
* device instance $1738 r0 *1 33.71,10.435 sky130_fd_pr__pfet_01v8
M$1738 168 134 177 177 sky130_fd_pr__pfet_01v8 L=0.15U W=0.42U AS=0.0882P
+ AD=0.1113P PS=0.84U PD=1.37U
* device instance $1739 r0 *1 33.605,11.615 sky130_fd_pr__pfet_01v8
M$1739 191 164 168 168 sky130_fd_pr__pfet_01v8 L=0.15U W=2U AS=0.44P AD=0.3P
+ PS=3.88U PD=2.6U
* device instance $1740 r0 *1 34.035,11.615 sky130_fd_pr__pfet_01v8
M$1740 72 69 191 191 sky130_fd_pr__pfet_01v8 L=0.15U W=2U AS=0.28P AD=0.315P
+ PS=2.56U PD=2.63U
* device instance $1743 r0 *1 35.435,11.615 sky130_fd_pr__pfet_01v8
M$1743 72 192 168 168 sky130_fd_pr__pfet_01v8 L=0.15U W=2U AS=0.3P AD=0.405P
+ PS=2.6U PD=3.81U
* device instance $1745 r0 *1 37.34,10.435 sky130_fd_pr__pfet_01v8
M$1745 117 159 168 168 sky130_fd_pr__pfet_01v8 L=0.15U W=0.42U AS=0.1113P
+ AD=0.0609P PS=1.37U PD=0.71U
* device instance $1746 r0 *1 37.78,10.435 sky130_fd_pr__pfet_01v8
M$1746 117 109 168 168 sky130_fd_pr__pfet_01v8 L=0.15U W=0.42U AS=0.1841P
+ AD=0.0609P PS=1.26U PD=0.71U
* device instance $1747 r0 *1 38.55,10.325 sky130_fd_pr__pfet_01v8
M$1747 165 117 168 168 sky130_fd_pr__pfet_01v8 L=0.15U W=0.64U AS=0.1841P
+ AD=0.1696P PS=1.26U PD=1.81U
* device instance $1748 r0 *1 40.95,11.615 sky130_fd_pr__pfet_01v8
M$1748 194 119 193 193 sky130_fd_pr__pfet_01v8 L=0.15U W=1U AS=0.26P AD=0.135P
+ PS=2.52U PD=1.27U
* device instance $1749 r0 *1 41.37,11.615 sky130_fd_pr__pfet_01v8
M$1749 211 232 194 194 sky130_fd_pr__pfet_01v8 L=0.15U W=1U AS=0.135P AD=0.135P
+ PS=1.27U PD=1.27U
* device instance $1750 r0 *1 41.79,11.615 sky130_fd_pr__pfet_01v8
M$1750 194 90 211 211 sky130_fd_pr__pfet_01v8 L=0.15U W=1U AS=0.135P AD=0.26P
+ PS=1.27U PD=2.52U
* device instance $1751 r0 *1 42.73,11.615 sky130_fd_pr__pfet_01v8
M$1751 211 138 168 168 sky130_fd_pr__pfet_01v8 L=0.15U W=1U AS=0.26P AD=0.165P
+ PS=2.52U PD=1.33U
* device instance $1752 r0 *1 43.21,11.615 sky130_fd_pr__pfet_01v8
M$1752 168 57 211 211 sky130_fd_pr__pfet_01v8 L=0.15U W=1U AS=0.165P AD=0.1575P
+ PS=1.33U PD=1.315U
* device instance $1753 r0 *1 43.675,11.615 sky130_fd_pr__pfet_01v8
M$1753 195 193 168 168 sky130_fd_pr__pfet_01v8 L=0.15U W=1U AS=0.1575P AD=0.26P
+ PS=1.315U PD=2.52U
* device instance $1754 r0 *1 44.7,10.435 sky130_fd_pr__pfet_01v8
M$1754 118 160 168 168 sky130_fd_pr__pfet_01v8 L=0.15U W=0.42U AS=0.1113P
+ AD=0.0609P PS=1.37U PD=0.71U
* device instance $1755 r0 *1 45.14,10.435 sky130_fd_pr__pfet_01v8
M$1755 118 109 168 168 sky130_fd_pr__pfet_01v8 L=0.15U W=0.42U AS=0.1841P
+ AD=0.0609P PS=1.26U PD=0.71U
* device instance $1756 r0 *1 45.91,10.325 sky130_fd_pr__pfet_01v8
M$1756 119 118 168 168 sky130_fd_pr__pfet_01v8 L=0.15U W=0.64U AS=0.1841P
+ AD=0.1696P PS=1.26U PD=1.81U
* device instance $1757 r0 *1 48.29,11.435 sky130_fd_pr__pfet_01v8
M$1757 227 120 199 199 sky130_fd_pr__pfet_01v8 L=0.15U W=0.64U AS=0.1664P
+ AD=0.0672P PS=1.8U PD=0.85U
* device instance $1758 r0 *1 48.65,11.435 sky130_fd_pr__pfet_01v8
M$1758 168 198 227 227 sky130_fd_pr__pfet_01v8 L=0.15U W=0.64U AS=0.0672P
+ AD=0.1664P PS=0.85U PD=1.8U
* device instance $1759 r0 *1 51.315,11.325 sky130_fd_pr__pfet_01v8
M$1759 200 197 199 199 sky130_fd_pr__pfet_01v8 L=0.15U W=0.42U AS=0.15985P
+ AD=0.06405P PS=1.265U PD=0.725U
* device instance $1760 r0 *1 51.77,11.325 sky130_fd_pr__pfet_01v8
M$1760 230 196 200 200 sky130_fd_pr__pfet_01v8 L=0.15U W=0.42U AS=0.06405P
+ AD=0.07665P PS=0.725U PD=0.785U
* device instance $1761 r0 *1 52.285,11.325 sky130_fd_pr__pfet_01v8
M$1761 168 201 230 230 sky130_fd_pr__pfet_01v8 L=0.15U W=0.42U AS=0.07665P
+ AD=0.178875P PS=0.785U PD=1.26U
* device instance $1762 r0 *1 49.59,11.435 sky130_fd_pr__pfet_01v8
M$1762 168 93 198 198 sky130_fd_pr__pfet_01v8 L=0.15U W=0.64U AS=0.1664P
+ AD=0.0928P PS=1.8U PD=0.93U
* device instance $1763 r0 *1 50.03,11.435 sky130_fd_pr__pfet_01v8
M$1763 228 93 168 168 sky130_fd_pr__pfet_01v8 L=0.15U W=0.64U AS=0.0928P
+ AD=0.1152P PS=0.93U PD=1U
* device instance $1764 r0 *1 50.54,11.435 sky130_fd_pr__pfet_01v8
M$1764 199 203 228 228 sky130_fd_pr__pfet_01v8 L=0.15U W=0.64U AS=0.1152P
+ AD=0.15985P PS=1U PD=1.265U
* device instance $1765 r0 *1 52.945,11.49 sky130_fd_pr__pfet_01v8
M$1765 201 200 168 168 sky130_fd_pr__pfet_01v8 L=0.15U W=0.75U AS=0.178875P
+ AD=0.195P PS=1.26U PD=2.02U
* device instance $1766 r0 *1 53.885,11.325 sky130_fd_pr__pfet_01v8
M$1766 229 201 168 168 sky130_fd_pr__pfet_01v8 L=0.15U W=0.42U AS=0.1092P
+ AD=0.06405P PS=1.36U PD=0.725U
* device instance $1767 r0 *1 54.34,11.325 sky130_fd_pr__pfet_01v8
M$1767 202 196 229 229 sky130_fd_pr__pfet_01v8 L=0.15U W=0.42U AS=0.06405P
+ AD=0.0567P PS=0.725U PD=0.69U
* device instance $1768 r0 *1 54.76,11.325 sky130_fd_pr__pfet_01v8
M$1768 226 197 202 202 sky130_fd_pr__pfet_01v8 L=0.15U W=0.42U AS=0.0567P
+ AD=0.0882P PS=0.69U PD=0.84U
* device instance $1769 r0 *1 55.33,11.325 sky130_fd_pr__pfet_01v8
M$1769 168 203 226 226 sky130_fd_pr__pfet_01v8 L=0.15U W=0.42U AS=0.0882P
+ AD=0.1113P PS=0.84U PD=1.37U
* device instance $1770 r0 *1 56.385,11.435 sky130_fd_pr__pfet_01v8
M$1770 168 202 203 203 sky130_fd_pr__pfet_01v8 L=0.15U W=0.64U AS=0.1728P
+ AD=0.154P PS=1.82U PD=1.335U
* device instance $1771 r0 *1 56.87,11.615 sky130_fd_pr__pfet_01v8
M$1771 232 202 168 168 sky130_fd_pr__pfet_01v8 L=0.15U W=1U AS=0.154P AD=0.28P
+ PS=1.335U PD=2.56U
* device instance $1772 r0 *1 57.58,10.435 sky130_fd_pr__pfet_01v8
M$1772 123 161 168 168 sky130_fd_pr__pfet_01v8 L=0.15U W=0.42U AS=0.1113P
+ AD=0.0609P PS=1.37U PD=0.71U
* device instance $1773 r0 *1 58.02,10.435 sky130_fd_pr__pfet_01v8
M$1773 123 109 168 168 sky130_fd_pr__pfet_01v8 L=0.15U W=0.42U AS=0.1841P
+ AD=0.0609P PS=1.26U PD=0.71U
* device instance $1774 r0 *1 58.79,10.325 sky130_fd_pr__pfet_01v8
M$1774 124 123 168 168 sky130_fd_pr__pfet_01v8 L=0.15U W=0.64U AS=0.1841P
+ AD=0.1696P PS=1.26U PD=1.81U
* device instance $1775 r0 *1 61.69,11.615 sky130_fd_pr__pfet_01v8
M$1775 225 212 204 204 sky130_fd_pr__pfet_01v8 L=0.15U W=1U AS=0.26P AD=0.135P
+ PS=2.52U PD=1.27U
* device instance $1776 r0 *1 62.11,11.615 sky130_fd_pr__pfet_01v8
M$1776 168 213 225 225 sky130_fd_pr__pfet_01v8 L=0.15U W=1U AS=0.135P AD=0.135P
+ PS=1.27U PD=1.27U
* device instance $1777 r0 *1 62.53,11.615 sky130_fd_pr__pfet_01v8
M$1777 205 213 168 168 sky130_fd_pr__pfet_01v8 L=0.15U W=1U AS=0.135P AD=0.135P
+ PS=1.27U PD=1.27U
* device instance $1778 r0 *1 62.95,11.615 sky130_fd_pr__pfet_01v8
M$1778 168 212 205 205 sky130_fd_pr__pfet_01v8 L=0.15U W=1U AS=0.135P AD=0.26P
+ PS=1.27U PD=2.52U
* device instance $1779 r0 *1 63.89,11.615 sky130_fd_pr__pfet_01v8
M$1779 1 204 205 205 sky130_fd_pr__pfet_01v8 L=0.15U W=1U AS=0.26P AD=0.3P
+ PS=2.52U PD=2.6U
* device instance $1780 r0 *1 66.29,11.615 sky130_fd_pr__pfet_01v8
M$1780 220 20 206 206 sky130_fd_pr__pfet_01v8 L=0.15U W=1U AS=0.26P AD=0.135P
+ PS=2.52U PD=1.27U
* device instance $1781 r0 *1 66.71,11.615 sky130_fd_pr__pfet_01v8
M$1781 168 137 220 220 sky130_fd_pr__pfet_01v8 L=0.15U W=1U AS=0.135P AD=0.135P
+ PS=1.27U PD=1.27U
* device instance $1782 r0 *1 67.13,11.615 sky130_fd_pr__pfet_01v8
M$1782 207 137 168 168 sky130_fd_pr__pfet_01v8 L=0.15U W=1U AS=0.135P AD=0.135P
+ PS=1.27U PD=1.27U
* device instance $1783 r0 *1 67.55,11.615 sky130_fd_pr__pfet_01v8
M$1783 168 20 207 207 sky130_fd_pr__pfet_01v8 L=0.15U W=1U AS=0.135P AD=0.26P
+ PS=1.27U PD=2.52U
* device instance $1784 r0 *1 68.49,11.615 sky130_fd_pr__pfet_01v8
M$1784 213 206 207 207 sky130_fd_pr__pfet_01v8 L=0.15U W=1U AS=0.26P AD=0.3P
+ PS=2.52U PD=2.6U
* device instance $1785 r0 *1 69.47,11.905 sky130_fd_pr__pfet_01v8
M$1785 214 137 168 168 sky130_fd_pr__pfet_01v8 L=0.15U W=0.42U AS=0.14575P
+ AD=0.1092P PS=1.335U PD=1.36U
* device instance $1786 r0 *1 69.955,11.615 sky130_fd_pr__pfet_01v8
M$1786 208 20 168 168 sky130_fd_pr__pfet_01v8 L=0.15U W=1U AS=0.14575P
+ AD=0.135P PS=1.335U PD=1.27U
* device instance $1787 r0 *1 70.375,11.615 sky130_fd_pr__pfet_01v8
M$1787 168 214 208 208 sky130_fd_pr__pfet_01v8 L=0.15U W=1U AS=0.135P AD=0.265P
+ PS=1.27U PD=2.53U
* device instance $1788 r0 *1 12.67,15.295 sky130_fd_pr__pfet_01v8
M$1788 168 50 256 256 sky130_fd_pr__pfet_01v8 L=0.15U W=0.42U AS=0.1092P
+ AD=0.1573P PS=1.36U PD=1.39U
* device instance $1789 r0 *1 13.21,15.585 sky130_fd_pr__pfet_01v8
M$1789 285 129 168 168 sky130_fd_pr__pfet_01v8 L=0.15U W=1U AS=0.1573P
+ AD=0.105P PS=1.39U PD=1.21U
* device instance $1790 r0 *1 13.57,15.585 sky130_fd_pr__pfet_01v8
M$1790 257 256 285 285 sky130_fd_pr__pfet_01v8 L=0.15U W=1U AS=0.105P AD=0.26P
+ PS=1.21U PD=2.52U
* device instance $1791 r0 *1 13.82,17.055 sky130_fd_pr__pfet_01v8
M$1791 168 294 293 293 sky130_fd_pr__pfet_01v8 L=0.15U W=1U AS=0.26P AD=0.26P
+ PS=2.52U PD=2.52U
* device instance $1792 r0 *1 14.73,15.665 sky130_fd_pr__pfet_01v8
M$1792 258 210 168 168 sky130_fd_pr__pfet_01v8 L=0.15U W=1.68U AS=0.3318P
+ AD=0.3486P PS=3.31U PD=3.35U
* device instance $1794 r0 *1 14.76,17.055 sky130_fd_pr__pfet_01v8
M$1794 295 257 294 294 sky130_fd_pr__pfet_01v8 L=0.15U W=1U AS=0.26P AD=0.1375P
+ PS=2.52U PD=1.275U
* device instance $1795 r0 *1 15.185,17.055 sky130_fd_pr__pfet_01v8
M$1795 168 231 295 295 sky130_fd_pr__pfet_01v8 L=0.15U W=1U AS=0.1375P AD=0.14P
+ PS=1.275U PD=1.28U
* device instance $1796 r0 *1 15.615,17.055 sky130_fd_pr__pfet_01v8
M$1796 295 258 168 168 sky130_fd_pr__pfet_01v8 L=0.15U W=1U AS=0.14P AD=0.265P
+ PS=1.28U PD=2.53U
* device instance $1797 r0 *1 19.33,11.465 sky130_fd_pr__pfet_01v8
M$1797 168 31 182 182 sky130_fd_pr__pfet_01v8 L=0.15U W=0.64U AS=0.1664P
+ AD=0.0864P PS=1.8U PD=0.91U
* device instance $1798 r0 *1 19.75,11.465 sky130_fd_pr__pfet_01v8
M$1798 183 182 168 168 sky130_fd_pr__pfet_01v8 L=0.15U W=0.64U AS=0.0864P
+ AD=0.1664P PS=0.91U PD=1.8U
* device instance $1799 r0 *1 28.57,15.585 sky130_fd_pr__pfet_01v8
M$1799 259 190 168 168 sky130_fd_pr__pfet_01v8 L=0.15U W=1U AS=0.3P AD=0.135P
+ PS=2.6U PD=1.27U
* device instance $1800 r0 *1 28.99,15.585 sky130_fd_pr__pfet_01v8
M$1800 168 164 259 259 sky130_fd_pr__pfet_01v8 L=0.15U W=1U AS=0.135P AD=0.365P
+ PS=1.27U PD=1.73U
* device instance $1801 r0 *1 29.87,15.585 sky130_fd_pr__pfet_01v8
M$1801 288 164 168 168 sky130_fd_pr__pfet_01v8 L=0.15U W=1U AS=0.365P AD=0.105P
+ PS=1.73U PD=1.21U
* device instance $1802 r0 *1 30.23,15.585 sky130_fd_pr__pfet_01v8
M$1802 277 190 288 288 sky130_fd_pr__pfet_01v8 L=0.15U W=1U AS=0.105P AD=0.165P
+ PS=1.21U PD=1.33U
* device instance $1803 r0 *1 30.71,15.585 sky130_fd_pr__pfet_01v8
M$1803 168 259 277 277 sky130_fd_pr__pfet_01v8 L=0.15U W=1U AS=0.165P AD=0.36P
+ PS=1.33U PD=2.72U
* device instance $1804 r0 *1 31.99,15.295 sky130_fd_pr__pfet_01v8
M$1804 168 192 261 261 sky130_fd_pr__pfet_01v8 L=0.15U W=0.42U AS=0.1092P
+ AD=0.1573P PS=1.36U PD=1.39U
* device instance $1805 r0 *1 32.53,15.585 sky130_fd_pr__pfet_01v8
M$1805 290 276 168 168 sky130_fd_pr__pfet_01v8 L=0.15U W=1U AS=0.1573P
+ AD=0.105P PS=1.39U PD=1.21U
* device instance $1806 r0 *1 32.89,15.585 sky130_fd_pr__pfet_01v8
M$1806 89 261 290 290 sky130_fd_pr__pfet_01v8 L=0.15U W=1U AS=0.105P AD=0.26P
+ PS=1.21U PD=2.52U
* device instance $1807 r0 *1 34.05,15.585 sky130_fd_pr__pfet_01v8
M$1807 192 277 168 168 sky130_fd_pr__pfet_01v8 L=0.15U W=2U AS=0.395P AD=0.27P
+ PS=3.79U PD=2.54U
* device instance $1809 r0 *1 34.89,15.585 sky130_fd_pr__pfet_01v8
M$1809 192 263 168 168 sky130_fd_pr__pfet_01v8 L=0.15U W=2U AS=0.27P AD=0.395P
+ PS=2.54U PD=3.79U
* device instance $1811 r0 *1 34.07,17.055 sky130_fd_pr__pfet_01v8
M$1811 296 277 276 276 sky130_fd_pr__pfet_01v8 L=0.15U W=1U AS=0.265P AD=0.14P
+ PS=2.53U PD=1.28U
* device instance $1812 r0 *1 34.5,17.055 sky130_fd_pr__pfet_01v8
M$1812 168 263 296 296 sky130_fd_pr__pfet_01v8 L=0.15U W=1U AS=0.14P AD=0.1475P
+ PS=1.28U PD=1.295U
* device instance $1813 r0 *1 34.945,17.055 sky130_fd_pr__pfet_01v8
M$1813 296 278 168 168 sky130_fd_pr__pfet_01v8 L=0.15U W=1U AS=0.1475P
+ AD=0.265P PS=1.295U PD=2.53U
* device instance $1814 r0 *1 35.89,17.055 sky130_fd_pr__pfet_01v8
M$1814 313 69 280 280 sky130_fd_pr__pfet_01v8 L=0.15U W=1U AS=0.26P AD=0.105P
+ PS=2.52U PD=1.21U
* device instance $1815 r0 *1 36.25,17.055 sky130_fd_pr__pfet_01v8
M$1815 168 164 313 313 sky130_fd_pr__pfet_01v8 L=0.15U W=1U AS=0.105P AD=0.26P
+ PS=1.21U PD=2.52U
* device instance $1816 r0 *1 36.25,15.585 sky130_fd_pr__pfet_01v8
M$1816 192 278 168 168 sky130_fd_pr__pfet_01v8 L=0.15U W=2U AS=0.395P AD=0.445P
+ PS=3.79U PD=3.89U
* device instance $1818 r0 *1 37.73,15.585 sky130_fd_pr__pfet_01v8
M$1818 283 263 168 168 sky130_fd_pr__pfet_01v8 L=0.15U W=2U AS=0.395P AD=0.27P
+ PS=3.79U PD=2.54U
* device instance $1820 r0 *1 38.57,15.585 sky130_fd_pr__pfet_01v8
M$1820 283 279 168 168 sky130_fd_pr__pfet_01v8 L=0.15U W=2U AS=0.275P AD=0.285P
+ PS=2.55U PD=2.57U
* device instance $1822 r0 *1 39.44,15.585 sky130_fd_pr__pfet_01v8
M$1822 283 277 168 168 sky130_fd_pr__pfet_01v8 L=0.15U W=2U AS=0.28P AD=0.395P
+ PS=2.56U PD=3.79U
* device instance $1824 r0 *1 40.8,15.585 sky130_fd_pr__pfet_01v8
M$1824 283 280 284 284 sky130_fd_pr__pfet_01v8 L=0.15U W=2U AS=0.395P AD=0.395P
+ PS=3.79U PD=2.79U
* device instance $1826 r0 *1 41.89,15.585 sky130_fd_pr__pfet_01v8
M$1826 267 268 284 284 sky130_fd_pr__pfet_01v8 L=0.15U W=2U AS=0.395P AD=0.395P
+ PS=2.79U PD=3.79U
* device instance $1828 r0 *1 45.33,15.295 sky130_fd_pr__pfet_01v8
M$1828 168 135 269 269 sky130_fd_pr__pfet_01v8 L=0.15U W=0.42U AS=0.1092P
+ AD=0.1573P PS=1.36U PD=1.39U
* device instance $1829 r0 *1 45.87,15.585 sky130_fd_pr__pfet_01v8
M$1829 292 232 168 168 sky130_fd_pr__pfet_01v8 L=0.15U W=1U AS=0.1573P
+ AD=0.105P PS=1.39U PD=1.21U
* device instance $1830 r0 *1 46.23,15.585 sky130_fd_pr__pfet_01v8
M$1830 268 269 292 292 sky130_fd_pr__pfet_01v8 L=0.15U W=1U AS=0.105P AD=0.26P
+ PS=1.21U PD=2.52U
* device instance $1831 r0 *1 45.53,16.875 sky130_fd_pr__pfet_01v8
M$1831 315 195 299 299 sky130_fd_pr__pfet_01v8 L=0.15U W=0.64U AS=0.1664P
+ AD=0.0672P PS=1.8U PD=0.85U
* device instance $1832 r0 *1 45.89,16.875 sky130_fd_pr__pfet_01v8
M$1832 168 300 315 315 sky130_fd_pr__pfet_01v8 L=0.15U W=0.64U AS=0.0672P
+ AD=0.1664P PS=0.85U PD=1.8U
* device instance $1833 r0 *1 48.555,16.765 sky130_fd_pr__pfet_01v8
M$1833 301 298 299 299 sky130_fd_pr__pfet_01v8 L=0.15U W=0.42U AS=0.15985P
+ AD=0.06405P PS=1.265U PD=0.725U
* device instance $1834 r0 *1 49.01,16.765 sky130_fd_pr__pfet_01v8
M$1834 308 297 301 301 sky130_fd_pr__pfet_01v8 L=0.15U W=0.42U AS=0.06405P
+ AD=0.07665P PS=0.725U PD=0.785U
* device instance $1835 r0 *1 49.525,16.765 sky130_fd_pr__pfet_01v8
M$1835 168 302 308 308 sky130_fd_pr__pfet_01v8 L=0.15U W=0.42U AS=0.07665P
+ AD=0.178875P PS=0.785U PD=1.26U
* device instance $1836 r0 *1 46.83,16.875 sky130_fd_pr__pfet_01v8
M$1836 168 16 300 300 sky130_fd_pr__pfet_01v8 L=0.15U W=0.64U AS=0.1664P
+ AD=0.0928P PS=1.8U PD=0.93U
* device instance $1837 r0 *1 47.27,16.875 sky130_fd_pr__pfet_01v8
M$1837 314 16 168 168 sky130_fd_pr__pfet_01v8 L=0.15U W=0.64U AS=0.0928P
+ AD=0.1152P PS=0.93U PD=1U
* device instance $1838 r0 *1 47.78,16.875 sky130_fd_pr__pfet_01v8
M$1838 299 304 314 314 sky130_fd_pr__pfet_01v8 L=0.15U W=0.64U AS=0.1152P
+ AD=0.15985P PS=1U PD=1.265U
* device instance $1839 r0 *1 50.185,16.93 sky130_fd_pr__pfet_01v8
M$1839 302 301 168 168 sky130_fd_pr__pfet_01v8 L=0.15U W=0.75U AS=0.178875P
+ AD=0.195P PS=1.26U PD=2.02U
* device instance $1840 r0 *1 46.93,11.465 sky130_fd_pr__pfet_01v8
M$1840 168 329 196 196 sky130_fd_pr__pfet_01v8 L=0.15U W=0.64U AS=0.1664P
+ AD=0.0864P PS=1.8U PD=0.91U
* device instance $1841 r0 *1 47.35,11.465 sky130_fd_pr__pfet_01v8
M$1841 197 196 168 168 sky130_fd_pr__pfet_01v8 L=0.15U W=0.64U AS=0.0864P
+ AD=0.1664P PS=0.91U PD=1.8U
* device instance $1842 r0 *1 47.39,15.585 sky130_fd_pr__pfet_01v8
M$1842 291 281 55 55 sky130_fd_pr__pfet_01v8 L=0.15U W=1U AS=0.26P AD=0.105P
+ PS=2.52U PD=1.21U
* device instance $1843 r0 *1 47.75,15.585 sky130_fd_pr__pfet_01v8
M$1843 168 268 291 291 sky130_fd_pr__pfet_01v8 L=0.15U W=1U AS=0.105P AD=0.26P
+ PS=1.21U PD=2.52U
* device instance $1844 r0 *1 50.39,15.295 sky130_fd_pr__pfet_01v8
M$1844 168 232 270 270 sky130_fd_pr__pfet_01v8 L=0.15U W=0.42U AS=0.1092P
+ AD=0.1573P PS=1.36U PD=1.39U
* device instance $1845 r0 *1 50.93,15.585 sky130_fd_pr__pfet_01v8
M$1845 289 135 168 168 sky130_fd_pr__pfet_01v8 L=0.15U W=1U AS=0.1573P
+ AD=0.105P PS=1.39U PD=1.21U
* device instance $1846 r0 *1 51.29,15.585 sky130_fd_pr__pfet_01v8
M$1846 281 270 289 289 sky130_fd_pr__pfet_01v8 L=0.15U W=1U AS=0.105P AD=0.26P
+ PS=1.21U PD=2.52U
* device instance $1847 r0 *1 51.125,16.765 sky130_fd_pr__pfet_01v8
M$1847 310 302 168 168 sky130_fd_pr__pfet_01v8 L=0.15U W=0.42U AS=0.1092P
+ AD=0.06405P PS=1.36U PD=0.725U
* device instance $1848 r0 *1 51.58,16.765 sky130_fd_pr__pfet_01v8
M$1848 303 297 310 310 sky130_fd_pr__pfet_01v8 L=0.15U W=0.42U AS=0.06405P
+ AD=0.0567P PS=0.725U PD=0.69U
* device instance $1849 r0 *1 52,16.765 sky130_fd_pr__pfet_01v8
M$1849 309 298 303 303 sky130_fd_pr__pfet_01v8 L=0.15U W=0.42U AS=0.0567P
+ AD=0.0882P PS=0.69U PD=0.84U
* device instance $1850 r0 *1 52.57,16.765 sky130_fd_pr__pfet_01v8
M$1850 168 304 309 309 sky130_fd_pr__pfet_01v8 L=0.15U W=0.42U AS=0.0882P
+ AD=0.1113P PS=0.84U PD=1.37U
* device instance $1851 r0 *1 53.625,16.875 sky130_fd_pr__pfet_01v8
M$1851 168 303 304 304 sky130_fd_pr__pfet_01v8 L=0.15U W=0.64U AS=0.1728P
+ AD=0.154P PS=1.82U PD=1.335U
* device instance $1852 r0 *1 54.11,17.055 sky130_fd_pr__pfet_01v8
M$1852 135 303 168 168 sky130_fd_pr__pfet_01v8 L=0.15U W=1U AS=0.154P AD=0.28P
+ PS=1.335U PD=2.56U
* device instance $1853 r0 *1 57.715,15.295 sky130_fd_pr__pfet_01v8
M$1853 287 281 271 271 sky130_fd_pr__pfet_01v8 L=0.15U W=0.42U AS=0.1092P
+ AD=0.0441P PS=1.36U PD=0.63U
* device instance $1854 r0 *1 58.075,15.295 sky130_fd_pr__pfet_01v8
M$1854 168 267 287 287 sky130_fd_pr__pfet_01v8 L=0.15U W=0.42U AS=0.0441P
+ AD=0.14575P PS=0.63U PD=1.335U
* device instance $1855 r0 *1 58.56,15.585 sky130_fd_pr__pfet_01v8
M$1855 272 271 168 168 sky130_fd_pr__pfet_01v8 L=0.15U W=1U AS=0.14575P
+ AD=0.34P PS=1.335U PD=2.68U
* device instance $1856 r0 *1 59.93,17.055 sky130_fd_pr__pfet_01v8
M$1856 168 213 306 306 sky130_fd_pr__pfet_01v8 L=0.15U W=2U AS=0.395P AD=0.27P
+ PS=3.79U PD=2.54U
* device instance $1858 r0 *1 60.77,17.055 sky130_fd_pr__pfet_01v8
M$1858 307 267 306 306 sky130_fd_pr__pfet_01v8 L=0.15U W=2U AS=0.27P AD=0.395P
+ PS=2.54U PD=3.79U
* device instance $1860 r0 *1 62.13,17.055 sky130_fd_pr__pfet_01v8
M$1860 307 281 305 305 sky130_fd_pr__pfet_01v8 L=0.15U W=2U AS=0.395P AD=0.27P
+ PS=3.79U PD=2.54U
* device instance $1862 r0 *1 62.97,17.055 sky130_fd_pr__pfet_01v8
M$1862 168 208 305 305 sky130_fd_pr__pfet_01v8 L=0.15U W=2U AS=0.44P AD=0.51P
+ PS=2.88U PD=3.02U
* device instance $1864 r0 *1 64.29,17.055 sky130_fd_pr__pfet_01v8
M$1864 168 312 305 305 sky130_fd_pr__pfet_01v8 L=0.15U W=2U AS=0.34P AD=0.395P
+ PS=2.68U PD=3.79U
* device instance $1866 r0 *1 63.515,15.765 sky130_fd_pr__pfet_01v8
M$1866 273 208 168 168 sky130_fd_pr__pfet_01v8 L=0.15U W=0.64U AS=0.1824P
+ AD=0.0896P PS=1.85U PD=0.92U
* device instance $1867 r0 *1 63.945,15.765 sky130_fd_pr__pfet_01v8
M$1867 286 272 273 273 sky130_fd_pr__pfet_01v8 L=0.15U W=0.64U AS=0.0896P
+ AD=0.0768P PS=0.92U PD=0.88U
* device instance $1868 r0 *1 64.335,15.765 sky130_fd_pr__pfet_01v8
M$1868 286 213 168 168 sky130_fd_pr__pfet_01v8 L=0.15U W=0.64U AS=0.314P
+ AD=0.0768P PS=1.835U PD=0.88U
* device instance $1869 r0 *1 65.32,15.585 sky130_fd_pr__pfet_01v8
M$1869 212 275 168 168 sky130_fd_pr__pfet_01v8 L=0.15U W=4U AS=0.719P AD=0.54P
+ PS=5.645U PD=5.08U
* device instance $1873 r0 *1 67,15.585 sky130_fd_pr__pfet_01v8
M$1873 275 272 168 168 sky130_fd_pr__pfet_01v8 L=0.15U W=1U AS=0.135P AD=0.26P
+ PS=1.27U PD=2.52U
* device instance $1874 r0 *1 17.03,21.025 sky130_fd_pr__pfet_01v8
M$1874 168 334 335 335 sky130_fd_pr__pfet_01v8 L=0.15U W=1U AS=0.26P AD=0.135P
+ PS=2.52U PD=1.27U
* device instance $1875 r0 *1 17.45,21.025 sky130_fd_pr__pfet_01v8
M$1875 231 335 168 168 sky130_fd_pr__pfet_01v8 L=0.15U W=4U AS=0.54P AD=0.665P
+ PS=5.08U PD=6.33U
* device instance $1879 r0 *1 19.65,21.025 sky130_fd_pr__pfet_01v8
M$1879 168 334 344 344 sky130_fd_pr__pfet_01v8 L=0.15U W=4U AS=0.665P AD=0.54P
+ PS=6.33U PD=5.08U
* device instance $1882 r0 *1 20.91,21.025 sky130_fd_pr__pfet_01v8
M$1882 344 258 168 168 sky130_fd_pr__pfet_01v8 L=0.15U W=4U AS=0.54P AD=0.54P
+ PS=5.08U PD=5.08U
* device instance $1887 r0 *1 23.01,21.025 sky130_fd_pr__pfet_01v8
M$1887 345 337 344 344 sky130_fd_pr__pfet_01v8 L=0.15U W=2U AS=0.27P AD=0.27P
+ PS=2.54U PD=2.54U
* device instance $1889 r0 *1 23.85,21.025 sky130_fd_pr__pfet_01v8
M$1889 349 337 344 344 sky130_fd_pr__pfet_01v8 L=0.15U W=1U AS=0.135P AD=0.15P
+ PS=1.27U PD=1.3U
* device instance $1890 r0 *1 24.3,21.025 sky130_fd_pr__pfet_01v8
M$1890 336 257 349 349 sky130_fd_pr__pfet_01v8 L=0.15U W=1U AS=0.15P AD=0.14P
+ PS=1.3U PD=1.28U
* device instance $1891 r0 *1 24.73,21.025 sky130_fd_pr__pfet_01v8
M$1891 345 257 336 336 sky130_fd_pr__pfet_01v8 L=0.15U W=2U AS=0.28P AD=0.29P
+ PS=2.56U PD=2.58U
* device instance $1893 r0 *1 25.61,21.025 sky130_fd_pr__pfet_01v8
M$1893 350 257 336 336 sky130_fd_pr__pfet_01v8 L=0.15U W=1U AS=0.15P AD=0.155P
+ PS=1.3U PD=1.31U
* device instance $1894 r0 *1 26.07,21.025 sky130_fd_pr__pfet_01v8
M$1894 344 337 350 350 sky130_fd_pr__pfet_01v8 L=0.15U W=1U AS=0.155P AD=0.26P
+ PS=1.31U PD=2.52U
* device instance $1895 r0 *1 27.155,21.025 sky130_fd_pr__pfet_01v8
M$1895 326 311 168 168 sky130_fd_pr__pfet_01v8 L=0.15U W=4U AS=0.685P AD=0.56P
+ PS=6.37U PD=5.12U
* device instance $1899 r0 *1 28.875,21.025 sky130_fd_pr__pfet_01v8
M$1899 31 326 168 168 sky130_fd_pr__pfet_01v8 L=0.15U W=16U AS=2.2375P
+ AD=2.4875P PS=20.475U PD=20.975U
* device instance $1915 r0 *1 36.25,21.025 sky130_fd_pr__pfet_01v8
M$1915 278 327 168 168 sky130_fd_pr__pfet_01v8 L=0.15U W=4U AS=0.795P AD=0.54P
+ PS=5.59U PD=5.08U
* device instance $1919 r0 *1 37.93,21.025 sky130_fd_pr__pfet_01v8
M$1919 327 279 168 168 sky130_fd_pr__pfet_01v8 L=0.15U W=1U AS=0.135P AD=0.26P
+ PS=1.27U PD=2.52U
* device instance $1920 r0 *1 44.17,16.905 sky130_fd_pr__pfet_01v8
M$1920 168 329 297 297 sky130_fd_pr__pfet_01v8 L=0.15U W=0.64U AS=0.1664P
+ AD=0.0864P PS=1.8U PD=0.91U
* device instance $1921 r0 *1 44.59,16.905 sky130_fd_pr__pfet_01v8
M$1921 298 297 168 168 sky130_fd_pr__pfet_01v8 L=0.15U W=0.64U AS=0.0864P
+ AD=0.1664P PS=0.91U PD=1.8U
* device instance $1922 r0 *1 46.475,21.025 sky130_fd_pr__pfet_01v8
M$1922 328 311 168 168 sky130_fd_pr__pfet_01v8 L=0.15U W=4U AS=0.685P AD=0.56P
+ PS=6.37U PD=5.12U
* device instance $1926 r0 *1 48.195,21.025 sky130_fd_pr__pfet_01v8
M$1926 329 328 168 168 sky130_fd_pr__pfet_01v8 L=0.15U W=16U AS=2.2375P
+ AD=2.3625P PS=20.475U PD=21.725U
* device instance $1942 r0 *1 63.51,21.025 sky130_fd_pr__pfet_01v8
M$1942 330 338 168 168 sky130_fd_pr__pfet_01v8 L=0.15U W=1U AS=0.26P AD=0.135P
+ PS=2.52U PD=1.27U
* device instance $1943 r0 *1 63.93,21.025 sky130_fd_pr__pfet_01v8
M$1943 168 312 330 330 sky130_fd_pr__pfet_01v8 L=0.15U W=1U AS=0.135P AD=0.26P
+ PS=1.27U PD=2.52U
* device instance $1944 r0 *1 64.91,21.025 sky130_fd_pr__pfet_01v8
M$1944 331 273 168 168 sky130_fd_pr__pfet_01v8 L=0.15U W=1U AS=0.3P AD=0.135P
+ PS=2.6U PD=1.27U
* device instance $1945 r0 *1 65.33,21.025 sky130_fd_pr__pfet_01v8
M$1945 168 330 331 331 sky130_fd_pr__pfet_01v8 L=0.15U W=1U AS=0.135P AD=0.365P
+ PS=1.27U PD=1.73U
* device instance $1946 r0 *1 66.21,21.025 sky130_fd_pr__pfet_01v8
M$1946 348 330 168 168 sky130_fd_pr__pfet_01v8 L=0.15U W=1U AS=0.365P AD=0.105P
+ PS=1.73U PD=1.21U
* device instance $1947 r0 *1 66.57,21.025 sky130_fd_pr__pfet_01v8
M$1947 346 273 348 348 sky130_fd_pr__pfet_01v8 L=0.15U W=1U AS=0.105P AD=0.165P
+ PS=1.21U PD=1.33U
* device instance $1948 r0 *1 67.05,21.025 sky130_fd_pr__pfet_01v8
M$1948 168 331 346 346 sky130_fd_pr__pfet_01v8 L=0.15U W=1U AS=0.165P AD=0.36P
+ PS=1.33U PD=2.72U
* device instance $1949 r0 *1 68.33,20.735 sky130_fd_pr__pfet_01v8
M$1949 168 339 340 340 sky130_fd_pr__pfet_01v8 L=0.15U W=0.42U AS=0.1092P
+ AD=0.1573P PS=1.36U PD=1.39U
* device instance $1950 r0 *1 68.87,21.025 sky130_fd_pr__pfet_01v8
M$1950 347 341 168 168 sky130_fd_pr__pfet_01v8 L=0.15U W=1U AS=0.1573P
+ AD=0.105P PS=1.39U PD=1.21U
* device instance $1951 r0 *1 69.23,21.025 sky130_fd_pr__pfet_01v8
M$1951 333 340 347 347 sky130_fd_pr__pfet_01v8 L=0.15U W=1U AS=0.105P AD=0.26P
+ PS=1.21U PD=2.52U
* device instance $1952 r0 *1 6.98,22.205 sky130_fd_pr__pfet_01v8
M$1952 382 380 168 168 sky130_fd_pr__pfet_01v8 L=0.15U W=0.42U AS=0.1113P
+ AD=0.0609P PS=1.37U PD=0.71U
* device instance $1953 r0 *1 7.42,22.205 sky130_fd_pr__pfet_01v8
M$1953 168 109 382 382 sky130_fd_pr__pfet_01v8 L=0.15U W=0.42U AS=0.0609P
+ AD=0.1841P PS=0.71U PD=1.26U
* device instance $1954 r0 *1 8.19,22.315 sky130_fd_pr__pfet_01v8
M$1954 351 382 168 168 sky130_fd_pr__pfet_01v8 L=0.15U W=0.64U AS=0.1841P
+ AD=0.1696P PS=1.26U PD=1.81U
* device instance $1955 r0 *1 9.21,22.495 sky130_fd_pr__pfet_01v8
M$1955 353 351 352 352 sky130_fd_pr__pfet_01v8 L=0.15U W=1U AS=0.26P AD=0.135P
+ PS=2.52U PD=1.27U
* device instance $1956 r0 *1 9.63,22.495 sky130_fd_pr__pfet_01v8
M$1956 383 354 353 353 sky130_fd_pr__pfet_01v8 L=0.15U W=1U AS=0.135P AD=0.135P
+ PS=1.27U PD=1.27U
* device instance $1957 r0 *1 10.05,22.495 sky130_fd_pr__pfet_01v8
M$1957 353 90 383 383 sky130_fd_pr__pfet_01v8 L=0.15U W=1U AS=0.135P AD=0.26P
+ PS=1.27U PD=2.52U
* device instance $1958 r0 *1 10.99,22.495 sky130_fd_pr__pfet_01v8
M$1958 383 87 168 168 sky130_fd_pr__pfet_01v8 L=0.15U W=1U AS=0.26P AD=0.165P
+ PS=2.52U PD=1.33U
* device instance $1959 r0 *1 11.47,22.495 sky130_fd_pr__pfet_01v8
M$1959 168 381 383 383 sky130_fd_pr__pfet_01v8 L=0.15U W=1U AS=0.165P
+ AD=0.1575P PS=1.33U PD=1.315U
* device instance $1960 r0 *1 11.935,22.495 sky130_fd_pr__pfet_01v8
M$1960 405 352 168 168 sky130_fd_pr__pfet_01v8 L=0.15U W=1U AS=0.1575P AD=0.26P
+ PS=1.315U PD=2.52U
* device instance $1961 r0 *1 12.93,22.495 sky130_fd_pr__pfet_01v8
M$1961 393 384 355 355 sky130_fd_pr__pfet_01v8 L=0.15U W=1U AS=0.26P AD=0.135P
+ PS=2.52U PD=1.27U
* device instance $1962 r0 *1 13.35,22.495 sky130_fd_pr__pfet_01v8
M$1962 168 293 393 393 sky130_fd_pr__pfet_01v8 L=0.15U W=1U AS=0.135P AD=0.135P
+ PS=1.27U PD=1.27U
* device instance $1963 r0 *1 13.77,22.495 sky130_fd_pr__pfet_01v8
M$1963 356 293 168 168 sky130_fd_pr__pfet_01v8 L=0.15U W=1U AS=0.135P AD=0.135P
+ PS=1.27U PD=1.27U
* device instance $1964 r0 *1 14.19,22.495 sky130_fd_pr__pfet_01v8
M$1964 168 384 356 356 sky130_fd_pr__pfet_01v8 L=0.15U W=1U AS=0.135P AD=0.26P
+ PS=1.27U PD=2.52U
* device instance $1965 r0 *1 15.13,22.495 sky130_fd_pr__pfet_01v8
M$1965 381 355 356 356 sky130_fd_pr__pfet_01v8 L=0.15U W=1U AS=0.26P AD=0.3P
+ PS=2.52U PD=2.6U
* device instance $1966 r0 *1 27.195,22.495 sky130_fd_pr__pfet_01v8
M$1966 357 31 168 168 sky130_fd_pr__pfet_01v8 L=0.15U W=6U AS=1.005P AD=1.045P
+ PS=9.01U PD=9.09U
* device instance $1972 r0 *1 41.41,22.345 sky130_fd_pr__pfet_01v8
M$1972 168 329 358 358 sky130_fd_pr__pfet_01v8 L=0.15U W=0.64U AS=0.1664P
+ AD=0.0864P PS=1.8U PD=0.91U
* device instance $1973 r0 *1 41.83,22.345 sky130_fd_pr__pfet_01v8
M$1973 359 358 168 168 sky130_fd_pr__pfet_01v8 L=0.15U W=0.64U AS=0.0864P
+ AD=0.1664P PS=0.91U PD=1.8U
* device instance $1974 r0 *1 42.77,22.315 sky130_fd_pr__pfet_01v8
M$1974 400 386 361 361 sky130_fd_pr__pfet_01v8 L=0.15U W=0.64U AS=0.1664P
+ AD=0.0672P PS=1.8U PD=0.85U
* device instance $1975 r0 *1 43.13,22.315 sky130_fd_pr__pfet_01v8
M$1975 168 360 400 400 sky130_fd_pr__pfet_01v8 L=0.15U W=0.64U AS=0.0672P
+ AD=0.1664P PS=0.85U PD=1.8U
* device instance $1976 r0 *1 45.795,22.205 sky130_fd_pr__pfet_01v8
M$1976 362 359 361 361 sky130_fd_pr__pfet_01v8 L=0.15U W=0.42U AS=0.15985P
+ AD=0.06405P PS=1.265U PD=0.725U
* device instance $1977 r0 *1 46.25,22.205 sky130_fd_pr__pfet_01v8
M$1977 402 358 362 362 sky130_fd_pr__pfet_01v8 L=0.15U W=0.42U AS=0.06405P
+ AD=0.07665P PS=0.725U PD=0.785U
* device instance $1978 r0 *1 46.765,22.205 sky130_fd_pr__pfet_01v8
M$1978 168 363 402 402 sky130_fd_pr__pfet_01v8 L=0.15U W=0.42U AS=0.07665P
+ AD=0.178875P PS=0.785U PD=1.26U
* device instance $1979 r0 *1 44.07,22.315 sky130_fd_pr__pfet_01v8
M$1979 168 93 360 360 sky130_fd_pr__pfet_01v8 L=0.15U W=0.64U AS=0.1664P
+ AD=0.0928P PS=1.8U PD=0.93U
* device instance $1980 r0 *1 44.51,22.315 sky130_fd_pr__pfet_01v8
M$1980 401 93 168 168 sky130_fd_pr__pfet_01v8 L=0.15U W=0.64U AS=0.0928P
+ AD=0.1152P PS=0.93U PD=1U
* device instance $1981 r0 *1 45.02,22.315 sky130_fd_pr__pfet_01v8
M$1981 361 365 401 401 sky130_fd_pr__pfet_01v8 L=0.15U W=0.64U AS=0.1152P
+ AD=0.15985P PS=1U PD=1.265U
* device instance $1982 r0 *1 47.425,22.37 sky130_fd_pr__pfet_01v8
M$1982 363 362 168 168 sky130_fd_pr__pfet_01v8 L=0.15U W=0.75U AS=0.178875P
+ AD=0.195P PS=1.26U PD=2.02U
* device instance $1983 r0 *1 48.365,22.205 sky130_fd_pr__pfet_01v8
M$1983 403 363 168 168 sky130_fd_pr__pfet_01v8 L=0.15U W=0.42U AS=0.1092P
+ AD=0.06405P PS=1.36U PD=0.725U
* device instance $1984 r0 *1 48.82,22.205 sky130_fd_pr__pfet_01v8
M$1984 364 358 403 403 sky130_fd_pr__pfet_01v8 L=0.15U W=0.42U AS=0.06405P
+ AD=0.0567P PS=0.725U PD=0.69U
* device instance $1985 r0 *1 49.24,22.205 sky130_fd_pr__pfet_01v8
M$1985 404 359 364 364 sky130_fd_pr__pfet_01v8 L=0.15U W=0.42U AS=0.0567P
+ AD=0.0882P PS=0.69U PD=0.84U
* device instance $1986 r0 *1 49.81,22.205 sky130_fd_pr__pfet_01v8
M$1986 168 365 404 404 sky130_fd_pr__pfet_01v8 L=0.15U W=0.42U AS=0.0882P
+ AD=0.1113P PS=0.84U PD=1.37U
* device instance $1987 r0 *1 50.865,22.315 sky130_fd_pr__pfet_01v8
M$1987 168 364 365 365 sky130_fd_pr__pfet_01v8 L=0.15U W=0.64U AS=0.1728P
+ AD=0.154P PS=1.82U PD=1.335U
* device instance $1988 r0 *1 51.35,22.495 sky130_fd_pr__pfet_01v8
M$1988 366 364 168 168 sky130_fd_pr__pfet_01v8 L=0.15U W=1U AS=0.154P AD=0.28P
+ PS=1.335U PD=2.56U
* device instance $1989 r0 *1 53.39,22.495 sky130_fd_pr__pfet_01v8
M$1989 168 387 367 367 sky130_fd_pr__pfet_01v8 L=0.15U W=2U AS=0.415P AD=0.27P
+ PS=3.83U PD=2.54U
* device instance $1991 r0 *1 54.23,22.495 sky130_fd_pr__pfet_01v8
M$1991 368 341 367 367 sky130_fd_pr__pfet_01v8 L=0.15U W=2U AS=0.27P AD=0.415P
+ PS=2.54U PD=3.83U
* device instance $1993 r0 *1 55.63,22.495 sky130_fd_pr__pfet_01v8
M$1993 368 137 369 369 sky130_fd_pr__pfet_01v8 L=0.15U W=2U AS=0.415P AD=0.27P
+ PS=3.83U PD=2.54U
* device instance $1995 r0 *1 56.47,22.495 sky130_fd_pr__pfet_01v8
M$1995 407 232 369 369 sky130_fd_pr__pfet_01v8 L=0.15U W=2U AS=0.27P AD=0.395P
+ PS=2.54U PD=3.79U
* device instance $1997 r0 *1 60.73,22.495 sky130_fd_pr__pfet_01v8
M$1997 371 388 370 370 sky130_fd_pr__pfet_01v8 L=0.15U W=1U AS=0.26P AD=0.135P
+ PS=2.52U PD=1.27U
* device instance $1998 r0 *1 61.15,22.495 sky130_fd_pr__pfet_01v8
M$1998 389 341 371 371 sky130_fd_pr__pfet_01v8 L=0.15U W=1U AS=0.135P AD=0.135P
+ PS=1.27U PD=1.27U
* device instance $1999 r0 *1 61.57,22.495 sky130_fd_pr__pfet_01v8
M$1999 371 90 389 389 sky130_fd_pr__pfet_01v8 L=0.15U W=1U AS=0.135P AD=0.26P
+ PS=1.27U PD=2.52U
* device instance $2000 r0 *1 62.51,22.495 sky130_fd_pr__pfet_01v8
M$2000 389 138 168 168 sky130_fd_pr__pfet_01v8 L=0.15U W=1U AS=0.26P AD=0.165P
+ PS=2.52U PD=1.33U
* device instance $2001 r0 *1 62.99,22.495 sky130_fd_pr__pfet_01v8
M$2001 168 346 389 389 sky130_fd_pr__pfet_01v8 L=0.15U W=1U AS=0.165P
+ AD=0.1575P PS=1.33U PD=1.315U
* device instance $2002 r0 *1 63.455,22.495 sky130_fd_pr__pfet_01v8
M$2002 408 370 168 168 sky130_fd_pr__pfet_01v8 L=0.15U W=1U AS=0.1575P AD=0.26P
+ PS=1.315U PD=2.52U
* device instance $2003 r0 *1 64.41,22.345 sky130_fd_pr__pfet_01v8
M$2003 168 329 372 372 sky130_fd_pr__pfet_01v8 L=0.15U W=0.64U AS=0.1664P
+ AD=0.0864P PS=1.8U PD=0.91U
* device instance $2004 r0 *1 64.83,22.345 sky130_fd_pr__pfet_01v8
M$2004 373 372 168 168 sky130_fd_pr__pfet_01v8 L=0.15U W=0.64U AS=0.0864P
+ AD=0.1664P PS=0.91U PD=1.8U
* device instance $2005 r0 *1 65.77,22.315 sky130_fd_pr__pfet_01v8
M$2005 399 390 375 375 sky130_fd_pr__pfet_01v8 L=0.15U W=0.64U AS=0.1664P
+ AD=0.0672P PS=1.8U PD=0.85U
* device instance $2006 r0 *1 66.13,22.315 sky130_fd_pr__pfet_01v8
M$2006 168 374 399 399 sky130_fd_pr__pfet_01v8 L=0.15U W=0.64U AS=0.0672P
+ AD=0.1664P PS=0.85U PD=1.8U
* device instance $2007 r0 *1 68.795,22.205 sky130_fd_pr__pfet_01v8
M$2007 376 373 375 375 sky130_fd_pr__pfet_01v8 L=0.15U W=0.42U AS=0.15985P
+ AD=0.06405P PS=1.265U PD=0.725U
* device instance $2008 r0 *1 69.25,22.205 sky130_fd_pr__pfet_01v8
M$2008 394 372 376 376 sky130_fd_pr__pfet_01v8 L=0.15U W=0.42U AS=0.06405P
+ AD=0.07665P PS=0.725U PD=0.785U
* device instance $2009 r0 *1 69.765,22.205 sky130_fd_pr__pfet_01v8
M$2009 168 377 394 394 sky130_fd_pr__pfet_01v8 L=0.15U W=0.42U AS=0.07665P
+ AD=0.178875P PS=0.785U PD=1.26U
* device instance $2010 r0 *1 67.07,22.315 sky130_fd_pr__pfet_01v8
M$2010 168 1102 374 374 sky130_fd_pr__pfet_01v8 L=0.15U W=0.64U AS=0.1664P
+ AD=0.0928P PS=1.8U PD=0.93U
* device instance $2011 r0 *1 67.51,22.315 sky130_fd_pr__pfet_01v8
M$2011 398 1102 168 168 sky130_fd_pr__pfet_01v8 L=0.15U W=0.64U AS=0.0928P
+ AD=0.1152P PS=0.93U PD=1U
* device instance $2012 r0 *1 68.02,22.315 sky130_fd_pr__pfet_01v8
M$2012 375 379 398 398 sky130_fd_pr__pfet_01v8 L=0.15U W=0.64U AS=0.1152P
+ AD=0.15985P PS=1U PD=1.265U
* device instance $2013 r0 *1 70.425,22.37 sky130_fd_pr__pfet_01v8
M$2013 377 376 168 168 sky130_fd_pr__pfet_01v8 L=0.15U W=0.75U AS=0.178875P
+ AD=0.195P PS=1.26U PD=2.02U
* device instance $2014 r0 *1 71.365,22.205 sky130_fd_pr__pfet_01v8
M$2014 392 377 168 168 sky130_fd_pr__pfet_01v8 L=0.15U W=0.42U AS=0.1092P
+ AD=0.06405P PS=1.36U PD=0.725U
* device instance $2015 r0 *1 71.82,22.205 sky130_fd_pr__pfet_01v8
M$2015 378 372 392 392 sky130_fd_pr__pfet_01v8 L=0.15U W=0.42U AS=0.06405P
+ AD=0.0567P PS=0.725U PD=0.69U
* device instance $2016 r0 *1 72.24,22.205 sky130_fd_pr__pfet_01v8
M$2016 391 373 378 378 sky130_fd_pr__pfet_01v8 L=0.15U W=0.42U AS=0.0567P
+ AD=0.0882P PS=0.69U PD=0.84U
* device instance $2017 r0 *1 72.81,22.205 sky130_fd_pr__pfet_01v8
M$2017 168 379 391 391 sky130_fd_pr__pfet_01v8 L=0.15U W=0.42U AS=0.0882P
+ AD=0.1113P PS=0.84U PD=1.37U
* device instance $2018 r0 *1 73.865,22.315 sky130_fd_pr__pfet_01v8
M$2018 168 378 379 379 sky130_fd_pr__pfet_01v8 L=0.15U W=0.64U AS=0.1728P
+ AD=0.154P PS=1.82U PD=1.335U
* device instance $2019 r0 *1 74.35,22.495 sky130_fd_pr__pfet_01v8
M$2019 341 378 168 168 sky130_fd_pr__pfet_01v8 L=0.15U W=1U AS=0.154P AD=0.28P
+ PS=1.335U PD=2.56U
* device instance $2020 r0 *1 4.61,26.615 sky130_fd_pr__pfet_01v8
M$2020 168 31 425 425 sky130_fd_pr__pfet_01v8 L=0.15U W=0.64U AS=0.1664P
+ AD=0.0864P PS=1.8U PD=0.91U
* device instance $2021 r0 *1 5.03,26.615 sky130_fd_pr__pfet_01v8
M$2021 426 425 168 168 sky130_fd_pr__pfet_01v8 L=0.15U W=0.64U AS=0.0864P
+ AD=0.1664P PS=0.91U PD=1.8U
* device instance $2022 r0 *1 5.97,26.645 sky130_fd_pr__pfet_01v8
M$2022 464 447 427 427 sky130_fd_pr__pfet_01v8 L=0.15U W=0.64U AS=0.1664P
+ AD=0.0672P PS=1.8U PD=0.85U
* device instance $2023 r0 *1 6.33,26.645 sky130_fd_pr__pfet_01v8
M$2023 168 428 464 464 sky130_fd_pr__pfet_01v8 L=0.15U W=0.64U AS=0.0672P
+ AD=0.1664P PS=0.85U PD=1.8U
* device instance $2024 r0 *1 7.27,26.645 sky130_fd_pr__pfet_01v8
M$2024 168 93 428 428 sky130_fd_pr__pfet_01v8 L=0.15U W=0.64U AS=0.1664P
+ AD=0.0928P PS=1.8U PD=0.93U
* device instance $2025 r0 *1 7.71,26.645 sky130_fd_pr__pfet_01v8
M$2025 467 93 168 168 sky130_fd_pr__pfet_01v8 L=0.15U W=0.64U AS=0.0928P
+ AD=0.1152P PS=0.93U PD=1U
* device instance $2026 r0 *1 8.22,26.645 sky130_fd_pr__pfet_01v8
M$2026 427 448 467 467 sky130_fd_pr__pfet_01v8 L=0.15U W=0.64U AS=0.1152P
+ AD=0.15985P PS=1U PD=1.265U
* device instance $2027 r0 *1 8.995,26.755 sky130_fd_pr__pfet_01v8
M$2027 429 426 427 427 sky130_fd_pr__pfet_01v8 L=0.15U W=0.42U AS=0.15985P
+ AD=0.06405P PS=1.265U PD=0.725U
* device instance $2028 r0 *1 9.45,26.755 sky130_fd_pr__pfet_01v8
M$2028 468 425 429 429 sky130_fd_pr__pfet_01v8 L=0.15U W=0.42U AS=0.06405P
+ AD=0.07665P PS=0.725U PD=0.785U
* device instance $2029 r0 *1 9.965,26.755 sky130_fd_pr__pfet_01v8
M$2029 468 430 168 168 sky130_fd_pr__pfet_01v8 L=0.15U W=0.42U AS=0.178875P
+ AD=0.07665P PS=1.26U PD=0.785U
* device instance $2030 r0 *1 10.625,26.59 sky130_fd_pr__pfet_01v8
M$2030 430 429 168 168 sky130_fd_pr__pfet_01v8 L=0.15U W=0.75U AS=0.178875P
+ AD=0.195P PS=1.26U PD=2.02U
* device instance $2031 r0 *1 11.565,26.755 sky130_fd_pr__pfet_01v8
M$2031 469 430 168 168 sky130_fd_pr__pfet_01v8 L=0.15U W=0.42U AS=0.1092P
+ AD=0.06405P PS=1.36U PD=0.725U
* device instance $2032 r0 *1 12.02,26.755 sky130_fd_pr__pfet_01v8
M$2032 431 425 469 469 sky130_fd_pr__pfet_01v8 L=0.15U W=0.42U AS=0.06405P
+ AD=0.0567P PS=0.725U PD=0.69U
* device instance $2033 r0 *1 12.44,26.755 sky130_fd_pr__pfet_01v8
M$2033 470 426 431 431 sky130_fd_pr__pfet_01v8 L=0.15U W=0.42U AS=0.0567P
+ AD=0.0882P PS=0.69U PD=0.84U
* device instance $2034 r0 *1 13.01,26.755 sky130_fd_pr__pfet_01v8
M$2034 168 448 470 470 sky130_fd_pr__pfet_01v8 L=0.15U W=0.42U AS=0.0882P
+ AD=0.1113P PS=0.84U PD=1.37U
* device instance $2035 r0 *1 14.065,26.645 sky130_fd_pr__pfet_01v8
M$2035 448 431 168 168 sky130_fd_pr__pfet_01v8 L=0.15U W=0.64U AS=0.154P
+ AD=0.1728P PS=1.335U PD=1.82U
* device instance $2036 r0 *1 14.55,26.465 sky130_fd_pr__pfet_01v8
M$2036 354 431 168 168 sky130_fd_pr__pfet_01v8 L=0.15U W=1U AS=0.154P AD=0.28P
+ PS=1.335U PD=2.56U
* device instance $2037 r0 *1 17.49,22.785 sky130_fd_pr__pfet_01v8
M$2037 395 599 385 385 sky130_fd_pr__pfet_01v8 L=0.15U W=0.42U AS=0.1092P
+ AD=0.0693P PS=1.36U PD=0.75U
* device instance $2038 r0 *1 17.97,22.785 sky130_fd_pr__pfet_01v8
M$2038 396 129 395 395 sky130_fd_pr__pfet_01v8 L=0.15U W=0.42U AS=0.0693P
+ AD=0.0441P PS=0.75U PD=0.63U
* device instance $2039 r0 *1 18.33,22.785 sky130_fd_pr__pfet_01v8
M$2039 397 354 396 396 sky130_fd_pr__pfet_01v8 L=0.15U W=0.42U AS=0.0441P
+ AD=0.0693P PS=0.63U PD=0.75U
* device instance $2040 r0 *1 18.81,22.785 sky130_fd_pr__pfet_01v8
M$2040 397 164 168 168 sky130_fd_pr__pfet_01v8 L=0.15U W=0.42U AS=0.14825P
+ AD=0.0693P PS=1.34U PD=0.75U
* device instance $2041 r0 *1 19.3,22.495 sky130_fd_pr__pfet_01v8
M$2041 406 385 168 168 sky130_fd_pr__pfet_01v8 L=0.15U W=1U AS=0.14825P
+ AD=0.27P PS=1.34U PD=2.54U
* device instance $2042 r0 *1 18.19,26.175 sky130_fd_pr__pfet_01v8
M$2042 168 354 432 432 sky130_fd_pr__pfet_01v8 L=0.15U W=0.42U AS=0.1092P
+ AD=0.1573P PS=1.36U PD=1.39U
* device instance $2043 r0 *1 18.73,26.465 sky130_fd_pr__pfet_01v8
M$2043 471 449 168 168 sky130_fd_pr__pfet_01v8 L=0.15U W=1U AS=0.1573P
+ AD=0.105P PS=1.39U PD=1.21U
* device instance $2044 r0 *1 19.09,26.465 sky130_fd_pr__pfet_01v8
M$2044 433 432 471 471 sky130_fd_pr__pfet_01v8 L=0.15U W=1U AS=0.105P AD=0.26P
+ PS=1.21U PD=2.52U
* device instance $2045 r0 *1 20.25,26.465 sky130_fd_pr__pfet_01v8
M$2045 472 433 384 384 sky130_fd_pr__pfet_01v8 L=0.15U W=1U AS=0.26P AD=0.105P
+ PS=2.52U PD=1.21U
* device instance $2046 r0 *1 20.61,26.465 sky130_fd_pr__pfet_01v8
M$2046 168 337 472 472 sky130_fd_pr__pfet_01v8 L=0.15U W=1U AS=0.105P AD=0.26P
+ PS=1.21U PD=2.52U
* device instance $2047 r0 *1 21.87,26.175 sky130_fd_pr__pfet_01v8
M$2047 168 449 434 434 sky130_fd_pr__pfet_01v8 L=0.15U W=0.42U AS=0.1092P
+ AD=0.1573P PS=1.36U PD=1.39U
* device instance $2048 r0 *1 22.41,26.465 sky130_fd_pr__pfet_01v8
M$2048 473 354 168 168 sky130_fd_pr__pfet_01v8 L=0.15U W=1U AS=0.1573P
+ AD=0.105P PS=1.39U PD=1.21U
* device instance $2049 r0 *1 22.77,26.465 sky130_fd_pr__pfet_01v8
M$2049 337 434 473 473 sky130_fd_pr__pfet_01v8 L=0.15U W=1U AS=0.105P AD=0.26P
+ PS=1.21U PD=2.52U
* device instance $2050 r0 *1 34.985,26.465 sky130_fd_pr__pfet_01v8
M$2050 168 436 450 450 sky130_fd_pr__pfet_01v8 L=0.15U W=2U AS=0.41P AD=0.27P
+ PS=3.82U PD=2.54U
* device instance $2052 r0 *1 35.825,26.465 sky130_fd_pr__pfet_01v8
M$2052 168 437 450 450 sky130_fd_pr__pfet_01v8 L=0.15U W=2U AS=0.27P AD=0.415P
+ PS=2.54U PD=3.83U
* device instance $2054 r0 *1 37.225,26.465 sky130_fd_pr__pfet_01v8
M$2054 168 437 463 463 sky130_fd_pr__pfet_01v8 L=0.15U W=2U AS=0.415P AD=0.27P
+ PS=3.83U PD=2.54U
* device instance $2056 r0 *1 38.065,26.465 sky130_fd_pr__pfet_01v8
M$2056 439 436 463 463 sky130_fd_pr__pfet_01v8 L=0.15U W=2U AS=0.2875P
+ AD=0.4125P PS=2.575U PD=3.825U
* device instance $2058 r0 *1 39.46,26.465 sky130_fd_pr__pfet_01v8
M$2058 439 450 168 168 sky130_fd_pr__pfet_01v8 L=0.15U W=2U AS=0.395P AD=0.415P
+ PS=3.79U PD=3.83U
* device instance $2060 r0 *1 46.47,26.465 sky130_fd_pr__pfet_01v8
M$2060 168 329 440 440 sky130_fd_pr__pfet_01v8 L=0.15U W=3U AS=0.53P AD=0.405P
+ PS=5.06U PD=3.81U
* device instance $2063 r0 *1 47.73,26.465 sky130_fd_pr__pfet_01v8
M$2063 441 440 168 168 sky130_fd_pr__pfet_01v8 L=0.15U W=6U AS=0.81P AD=0.81P
+ PS=7.62U PD=7.62U
* device instance $2069 r0 *1 50.25,26.465 sky130_fd_pr__pfet_01v8
M$2069 442 441 168 168 sky130_fd_pr__pfet_01v8 L=0.15U W=16U AS=2.16P AD=2.285P
+ PS=20.32U PD=21.57U
* device instance $2085 r0 *1 61.26,26.755 sky130_fd_pr__pfet_01v8
M$2085 443 462 168 168 sky130_fd_pr__pfet_01v8 L=0.15U W=0.42U AS=0.1113P
+ AD=0.0609P PS=1.37U PD=0.71U
* device instance $2086 r0 *1 61.7,26.755 sky130_fd_pr__pfet_01v8
M$2086 443 109 168 168 sky130_fd_pr__pfet_01v8 L=0.15U W=0.42U AS=0.1841P
+ AD=0.0609P PS=1.26U PD=0.71U
* device instance $2087 r0 *1 62.47,26.645 sky130_fd_pr__pfet_01v8
M$2087 388 443 168 168 sky130_fd_pr__pfet_01v8 L=0.15U W=0.64U AS=0.1841P
+ AD=0.1696P PS=1.26U PD=1.81U
* device instance $2088 r0 *1 63.95,26.545 sky130_fd_pr__pfet_01v8
M$2088 312 333 168 168 sky130_fd_pr__pfet_01v8 L=0.15U W=1.68U AS=0.3318P
+ AD=0.3486P PS=3.31U PD=3.35U
* device instance $2090 r0 *1 65.33,26.175 sky130_fd_pr__pfet_01v8
M$2090 168 339 451 451 sky130_fd_pr__pfet_01v8 L=0.15U W=0.42U AS=0.1092P
+ AD=0.14575P PS=1.36U PD=1.335U
* device instance $2091 r0 *1 65.815,26.465 sky130_fd_pr__pfet_01v8
M$2091 338 341 168 168 sky130_fd_pr__pfet_01v8 L=0.15U W=1U AS=0.14575P
+ AD=0.135P PS=1.335U PD=1.27U
* device instance $2092 r0 *1 66.235,26.465 sky130_fd_pr__pfet_01v8
M$2092 168 451 338 338 sky130_fd_pr__pfet_01v8 L=0.15U W=1U AS=0.135P AD=0.265P
+ PS=1.27U PD=2.53U
* device instance $2093 r0 *1 68.175,26.56 sky130_fd_pr__pfet_01v8
M$2093 466 71 168 168 sky130_fd_pr__pfet_01v8 L=0.15U W=0.42U AS=0.15835P
+ AD=0.07665P PS=1.395U PD=0.785U
* device instance $2094 r0 *1 68.69,26.56 sky130_fd_pr__pfet_01v8
M$2094 444 339 466 466 sky130_fd_pr__pfet_01v8 L=0.15U W=0.42U AS=0.07665P
+ AD=0.1932P PS=0.785U PD=1.34U
* device instance $2095 r0 *1 69.76,26.56 sky130_fd_pr__pfet_01v8
M$2095 465 445 444 444 sky130_fd_pr__pfet_01v8 L=0.15U W=0.42U AS=0.1932P
+ AD=0.0441P PS=1.34U PD=0.63U
* device instance $2096 r0 *1 70.12,26.56 sky130_fd_pr__pfet_01v8
M$2096 168 446 465 465 sky130_fd_pr__pfet_01v8 L=0.15U W=0.42U AS=0.0441P
+ AD=0.0693P PS=0.63U PD=0.75U
* device instance $2097 r0 *1 70.6,26.56 sky130_fd_pr__pfet_01v8
M$2097 446 71 168 168 sky130_fd_pr__pfet_01v8 L=0.15U W=0.42U AS=0.0693P
+ AD=0.1176P PS=0.75U PD=1.4U
* device instance $2098 r0 *1 67.63,26.465 sky130_fd_pr__pfet_01v8
M$2098 168 444 390 390 sky130_fd_pr__pfet_01v8 L=0.15U W=1U AS=0.26P
+ AD=0.15835P PS=2.52U PD=1.395U
* device instance $2099 r0 *1 5.615,27.84 sky130_fd_pr__pfet_01v8
M$2099 500 71 168 168 sky130_fd_pr__pfet_01v8 L=0.15U W=0.42U AS=0.15835P
+ AD=0.07665P PS=1.395U PD=0.785U
* device instance $2100 r0 *1 6.13,27.84 sky130_fd_pr__pfet_01v8
M$2100 474 449 500 500 sky130_fd_pr__pfet_01v8 L=0.15U W=0.42U AS=0.07665P
+ AD=0.1932P PS=0.785U PD=1.34U
* device instance $2101 r0 *1 7.2,27.84 sky130_fd_pr__pfet_01v8
M$2101 501 461 474 474 sky130_fd_pr__pfet_01v8 L=0.15U W=0.42U AS=0.1932P
+ AD=0.0441P PS=1.34U PD=0.63U
* device instance $2102 r0 *1 7.56,27.84 sky130_fd_pr__pfet_01v8
M$2102 168 514 501 501 sky130_fd_pr__pfet_01v8 L=0.15U W=0.42U AS=0.0441P
+ AD=0.0693P PS=0.63U PD=0.75U
* device instance $2103 r0 *1 8.04,27.84 sky130_fd_pr__pfet_01v8
M$2103 514 71 168 168 sky130_fd_pr__pfet_01v8 L=0.15U W=0.42U AS=0.0693P
+ AD=0.1176P PS=0.75U PD=1.4U
* device instance $2104 r0 *1 5.07,27.935 sky130_fd_pr__pfet_01v8
M$2104 168 474 447 447 sky130_fd_pr__pfet_01v8 L=0.15U W=1U AS=0.26P
+ AD=0.15835P PS=2.52U PD=1.395U
* device instance $2105 r0 *1 9.21,27.785 sky130_fd_pr__pfet_01v8
M$2105 168 31 475 475 sky130_fd_pr__pfet_01v8 L=0.15U W=0.64U AS=0.1664P
+ AD=0.0864P PS=1.8U PD=0.91U
* device instance $2106 r0 *1 9.63,27.785 sky130_fd_pr__pfet_01v8
M$2106 476 475 168 168 sky130_fd_pr__pfet_01v8 L=0.15U W=0.64U AS=0.0864P
+ AD=0.1664P PS=0.91U PD=1.8U
* device instance $2107 r0 *1 10.57,27.755 sky130_fd_pr__pfet_01v8
M$2107 503 405 478 478 sky130_fd_pr__pfet_01v8 L=0.15U W=0.64U AS=0.1664P
+ AD=0.0672P PS=1.8U PD=0.85U
* device instance $2108 r0 *1 10.93,27.755 sky130_fd_pr__pfet_01v8
M$2108 168 477 503 503 sky130_fd_pr__pfet_01v8 L=0.15U W=0.64U AS=0.0672P
+ AD=0.1664P PS=0.85U PD=1.8U
* device instance $2109 r0 *1 13.595,27.645 sky130_fd_pr__pfet_01v8
M$2109 479 476 478 478 sky130_fd_pr__pfet_01v8 L=0.15U W=0.42U AS=0.15985P
+ AD=0.06405P PS=1.265U PD=0.725U
* device instance $2110 r0 *1 14.05,27.645 sky130_fd_pr__pfet_01v8
M$2110 507 475 479 479 sky130_fd_pr__pfet_01v8 L=0.15U W=0.42U AS=0.06405P
+ AD=0.07665P PS=0.725U PD=0.785U
* device instance $2111 r0 *1 14.565,27.645 sky130_fd_pr__pfet_01v8
M$2111 168 480 507 507 sky130_fd_pr__pfet_01v8 L=0.15U W=0.42U AS=0.07665P
+ AD=0.178875P PS=0.785U PD=1.26U
* device instance $2112 r0 *1 11.87,27.755 sky130_fd_pr__pfet_01v8
M$2112 168 16 477 477 sky130_fd_pr__pfet_01v8 L=0.15U W=0.64U AS=0.1664P
+ AD=0.0928P PS=1.8U PD=0.93U
* device instance $2113 r0 *1 12.31,27.755 sky130_fd_pr__pfet_01v8
M$2113 505 16 168 168 sky130_fd_pr__pfet_01v8 L=0.15U W=0.64U AS=0.0928P
+ AD=0.1152P PS=0.93U PD=1U
* device instance $2114 r0 *1 12.82,27.755 sky130_fd_pr__pfet_01v8
M$2114 478 482 505 505 sky130_fd_pr__pfet_01v8 L=0.15U W=0.64U AS=0.1152P
+ AD=0.15985P PS=1U PD=1.265U
* device instance $2115 r0 *1 15.225,27.81 sky130_fd_pr__pfet_01v8
M$2115 480 479 168 168 sky130_fd_pr__pfet_01v8 L=0.15U W=0.75U AS=0.178875P
+ AD=0.195P PS=1.26U PD=2.02U
* device instance $2116 r0 *1 16.165,27.645 sky130_fd_pr__pfet_01v8
M$2116 508 480 168 168 sky130_fd_pr__pfet_01v8 L=0.15U W=0.42U AS=0.1092P
+ AD=0.06405P PS=1.36U PD=0.725U
* device instance $2117 r0 *1 16.62,27.645 sky130_fd_pr__pfet_01v8
M$2117 481 475 508 508 sky130_fd_pr__pfet_01v8 L=0.15U W=0.42U AS=0.06405P
+ AD=0.0567P PS=0.725U PD=0.69U
* device instance $2118 r0 *1 17.04,27.645 sky130_fd_pr__pfet_01v8
M$2118 509 476 481 481 sky130_fd_pr__pfet_01v8 L=0.15U W=0.42U AS=0.0567P
+ AD=0.0882P PS=0.69U PD=0.84U
* device instance $2119 r0 *1 17.61,27.645 sky130_fd_pr__pfet_01v8
M$2119 168 482 509 509 sky130_fd_pr__pfet_01v8 L=0.15U W=0.42U AS=0.0882P
+ AD=0.1113P PS=0.84U PD=1.37U
* device instance $2120 r0 *1 18.665,27.755 sky130_fd_pr__pfet_01v8
M$2120 168 481 482 482 sky130_fd_pr__pfet_01v8 L=0.15U W=0.64U AS=0.1728P
+ AD=0.154P PS=1.82U PD=1.335U
* device instance $2121 r0 *1 19.15,27.935 sky130_fd_pr__pfet_01v8
M$2121 449 481 168 168 sky130_fd_pr__pfet_01v8 L=0.15U W=1U AS=0.154P AD=0.28P
+ PS=1.335U PD=2.56U
* device instance $2122 r0 *1 28.08,31.615 sky130_fd_pr__pfet_01v8
M$2122 548 336 534 534 sky130_fd_pr__pfet_01v8 L=0.15U W=0.42U AS=0.1092P
+ AD=0.0441P PS=1.36U PD=0.63U
* device instance $2123 r0 *1 28.44,31.615 sky130_fd_pr__pfet_01v8
M$2123 549 433 548 548 sky130_fd_pr__pfet_01v8 L=0.15U W=0.42U AS=0.0441P
+ AD=0.0693P PS=0.63U PD=0.75U
* device instance $2124 r0 *1 28.92,31.615 sky130_fd_pr__pfet_01v8
M$2124 168 495 549 549 sky130_fd_pr__pfet_01v8 L=0.15U W=0.42U AS=0.0693P
+ AD=0.14825P PS=0.75U PD=1.34U
* device instance $2125 r0 *1 29.41,31.905 sky130_fd_pr__pfet_01v8
M$2125 544 534 168 168 sky130_fd_pr__pfet_01v8 L=0.15U W=1U AS=0.14825P
+ AD=0.28P PS=1.34U PD=2.56U
* device instance $2126 r0 *1 30.91,27.935 sky130_fd_pr__pfet_01v8
M$2126 168 336 494 494 sky130_fd_pr__pfet_01v8 L=0.15U W=4U AS=0.685P AD=0.54P
+ PS=6.37U PD=5.08U
* device instance $2130 r0 *1 32.59,27.935 sky130_fd_pr__pfet_01v8
M$2130 483 433 494 494 sky130_fd_pr__pfet_01v8 L=0.15U W=4U AS=0.54P AD=0.665P
+ PS=5.08U PD=6.33U
* device instance $2134 r0 *1 31.77,31.905 sky130_fd_pr__pfet_01v8
M$2134 437 544 168 168 sky130_fd_pr__pfet_01v8 L=0.15U W=1U AS=0.26P AD=0.135P
+ PS=2.52U PD=1.27U
* device instance $2135 r0 *1 32.19,31.905 sky130_fd_pr__pfet_01v8
M$2135 168 496 437 437 sky130_fd_pr__pfet_01v8 L=0.15U W=1U AS=0.135P AD=0.26P
+ PS=1.27U PD=2.52U
* device instance $2136 r0 *1 34.79,27.935 sky130_fd_pr__pfet_01v8
M$2136 483 495 279 279 sky130_fd_pr__pfet_01v8 L=0.15U W=4U AS=0.665P AD=0.55P
+ PS=6.33U PD=5.1U
* device instance $2140 r0 *1 36.49,27.935 sky130_fd_pr__pfet_01v8
M$2140 168 496 279 279 sky130_fd_pr__pfet_01v8 L=0.15U W=4U AS=0.55P AD=0.54P
+ PS=5.1U PD=5.08U
* device instance $2144 r0 *1 38.17,27.935 sky130_fd_pr__pfet_01v8
M$2144 168 484 279 279 sky130_fd_pr__pfet_01v8 L=0.15U W=4U AS=0.54P AD=0.665P
+ PS=5.08U PD=6.33U
* device instance $2148 r0 *1 35.91,31.905 sky130_fd_pr__pfet_01v8
M$2148 436 263 168 168 sky130_fd_pr__pfet_01v8 L=0.15U W=1U AS=0.26P AD=0.135P
+ PS=2.52U PD=1.27U
* device instance $2149 r0 *1 36.33,31.905 sky130_fd_pr__pfet_01v8
M$2149 168 484 436 436 sky130_fd_pr__pfet_01v8 L=0.15U W=1U AS=0.135P AD=0.26P
+ PS=1.27U PD=2.52U
* device instance $2150 r0 *1 38.19,31.905 sky130_fd_pr__pfet_01v8
M$2150 545 165 535 535 sky130_fd_pr__pfet_01v8 L=0.15U W=1U AS=0.26P AD=0.135P
+ PS=2.52U PD=1.27U
* device instance $2151 r0 *1 38.61,31.905 sky130_fd_pr__pfet_01v8
M$2151 546 366 545 545 sky130_fd_pr__pfet_01v8 L=0.15U W=1U AS=0.135P AD=0.135P
+ PS=1.27U PD=1.27U
* device instance $2152 r0 *1 39.03,31.905 sky130_fd_pr__pfet_01v8
M$2152 545 90 546 546 sky130_fd_pr__pfet_01v8 L=0.15U W=1U AS=0.135P AD=0.26P
+ PS=1.27U PD=2.52U
* device instance $2153 r0 *1 39.97,31.905 sky130_fd_pr__pfet_01v8
M$2153 546 138 168 168 sky130_fd_pr__pfet_01v8 L=0.15U W=1U AS=0.26P AD=0.165P
+ PS=2.52U PD=1.33U
* device instance $2154 r0 *1 40.45,31.905 sky130_fd_pr__pfet_01v8
M$2154 168 439 546 546 sky130_fd_pr__pfet_01v8 L=0.15U W=1U AS=0.165P
+ AD=0.1575P PS=1.33U PD=1.315U
* device instance $2155 r0 *1 40.915,31.905 sky130_fd_pr__pfet_01v8
M$2155 547 535 168 168 sky130_fd_pr__pfet_01v8 L=0.15U W=1U AS=0.1575P AD=0.26P
+ PS=1.315U PD=2.52U
* device instance $2156 r0 *1 41.87,28.225 sky130_fd_pr__pfet_01v8
M$2156 498 497 168 168 sky130_fd_pr__pfet_01v8 L=0.15U W=0.42U AS=0.14575P
+ AD=0.1092P PS=1.335U PD=1.36U
* device instance $2157 r0 *1 42.355,27.935 sky130_fd_pr__pfet_01v8
M$2157 263 366 168 168 sky130_fd_pr__pfet_01v8 L=0.15U W=1U AS=0.14575P
+ AD=0.135P PS=1.335U PD=1.27U
* device instance $2158 r0 *1 42.775,27.935 sky130_fd_pr__pfet_01v8
M$2158 168 498 263 263 sky130_fd_pr__pfet_01v8 L=0.15U W=1U AS=0.135P AD=0.265P
+ PS=1.27U PD=2.53U
* device instance $2159 r0 *1 44.715,27.84 sky130_fd_pr__pfet_01v8
M$2159 513 71 168 168 sky130_fd_pr__pfet_01v8 L=0.15U W=0.42U AS=0.15835P
+ AD=0.07665P PS=1.395U PD=0.785U
* device instance $2160 r0 *1 45.23,27.84 sky130_fd_pr__pfet_01v8
M$2160 485 497 513 513 sky130_fd_pr__pfet_01v8 L=0.15U W=0.42U AS=0.07665P
+ AD=0.1932P PS=0.785U PD=1.34U
* device instance $2161 r0 *1 46.3,27.84 sky130_fd_pr__pfet_01v8
M$2161 512 499 485 485 sky130_fd_pr__pfet_01v8 L=0.15U W=0.42U AS=0.1932P
+ AD=0.0441P PS=1.34U PD=0.63U
* device instance $2162 r0 *1 46.66,27.84 sky130_fd_pr__pfet_01v8
M$2162 168 516 512 512 sky130_fd_pr__pfet_01v8 L=0.15U W=0.42U AS=0.0441P
+ AD=0.0693P PS=0.63U PD=0.75U
* device instance $2163 r0 *1 47.14,27.84 sky130_fd_pr__pfet_01v8
M$2163 516 71 168 168 sky130_fd_pr__pfet_01v8 L=0.15U W=0.42U AS=0.0693P
+ AD=0.1176P PS=0.75U PD=1.4U
* device instance $2164 r0 *1 44.17,27.935 sky130_fd_pr__pfet_01v8
M$2164 168 485 386 386 sky130_fd_pr__pfet_01v8 L=0.15U W=1U AS=0.26P
+ AD=0.15835P PS=2.52U PD=1.395U
* device instance $2165 r0 *1 44.87,31.615 sky130_fd_pr__pfet_01v8
M$2165 168 497 537 537 sky130_fd_pr__pfet_01v8 L=0.15U W=0.42U AS=0.1092P
+ AD=0.1573P PS=1.36U PD=1.39U
* device instance $2166 r0 *1 45.41,31.905 sky130_fd_pr__pfet_01v8
M$2166 550 366 168 168 sky130_fd_pr__pfet_01v8 L=0.15U W=1U AS=0.1573P
+ AD=0.105P PS=1.39U PD=1.21U
* device instance $2167 r0 *1 45.77,31.905 sky130_fd_pr__pfet_01v8
M$2167 536 537 550 550 sky130_fd_pr__pfet_01v8 L=0.15U W=1U AS=0.105P AD=0.26P
+ PS=1.21U PD=2.52U
* device instance $2168 r0 *1 46.995,31.905 sky130_fd_pr__pfet_01v8
M$2168 538 997 168 168 sky130_fd_pr__pfet_01v8 L=0.15U W=2U AS=0.395P AD=0.27P
+ PS=3.79U PD=2.54U
* device instance $2170 r0 *1 47.835,31.905 sky130_fd_pr__pfet_01v8
M$2170 138 538 168 168 sky130_fd_pr__pfet_01v8 L=0.15U W=6U AS=0.81P AD=0.935P
+ PS=7.62U PD=8.87U
* device instance $2176 r0 *1 60.73,27.785 sky130_fd_pr__pfet_01v8
M$2176 168 329 486 486 sky130_fd_pr__pfet_01v8 L=0.15U W=0.64U AS=0.1664P
+ AD=0.0864P PS=1.8U PD=0.91U
* device instance $2177 r0 *1 61.15,27.785 sky130_fd_pr__pfet_01v8
M$2177 487 486 168 168 sky130_fd_pr__pfet_01v8 L=0.15U W=0.64U AS=0.0864P
+ AD=0.1664P PS=0.91U PD=1.8U
* device instance $2178 r0 *1 62.09,27.755 sky130_fd_pr__pfet_01v8
M$2178 511 408 489 489 sky130_fd_pr__pfet_01v8 L=0.15U W=0.64U AS=0.1664P
+ AD=0.0672P PS=1.8U PD=0.85U
* device instance $2179 r0 *1 62.45,27.755 sky130_fd_pr__pfet_01v8
M$2179 168 488 511 511 sky130_fd_pr__pfet_01v8 L=0.15U W=0.64U AS=0.0672P
+ AD=0.1664P PS=0.85U PD=1.8U
* device instance $2180 r0 *1 65.115,27.645 sky130_fd_pr__pfet_01v8
M$2180 490 487 489 489 sky130_fd_pr__pfet_01v8 L=0.15U W=0.42U AS=0.15985P
+ AD=0.06405P PS=1.265U PD=0.725U
* device instance $2181 r0 *1 65.57,27.645 sky130_fd_pr__pfet_01v8
M$2181 506 486 490 490 sky130_fd_pr__pfet_01v8 L=0.15U W=0.42U AS=0.06405P
+ AD=0.07665P PS=0.725U PD=0.785U
* device instance $2182 r0 *1 66.085,27.645 sky130_fd_pr__pfet_01v8
M$2182 168 491 506 506 sky130_fd_pr__pfet_01v8 L=0.15U W=0.42U AS=0.07665P
+ AD=0.178875P PS=0.785U PD=1.26U
* device instance $2183 r0 *1 63.39,27.755 sky130_fd_pr__pfet_01v8
M$2183 168 16 488 488 sky130_fd_pr__pfet_01v8 L=0.15U W=0.64U AS=0.1664P
+ AD=0.0928P PS=1.8U PD=0.93U
* device instance $2184 r0 *1 63.83,27.755 sky130_fd_pr__pfet_01v8
M$2184 510 16 168 168 sky130_fd_pr__pfet_01v8 L=0.15U W=0.64U AS=0.0928P
+ AD=0.1152P PS=0.93U PD=1U
* device instance $2185 r0 *1 64.34,27.755 sky130_fd_pr__pfet_01v8
M$2185 489 493 510 510 sky130_fd_pr__pfet_01v8 L=0.15U W=0.64U AS=0.1152P
+ AD=0.15985P PS=1U PD=1.265U
* device instance $2186 r0 *1 66.745,27.81 sky130_fd_pr__pfet_01v8
M$2186 491 490 168 168 sky130_fd_pr__pfet_01v8 L=0.15U W=0.75U AS=0.178875P
+ AD=0.195P PS=1.26U PD=2.02U
* device instance $2187 r0 *1 67.685,27.645 sky130_fd_pr__pfet_01v8
M$2187 504 491 168 168 sky130_fd_pr__pfet_01v8 L=0.15U W=0.42U AS=0.1092P
+ AD=0.06405P PS=1.36U PD=0.725U
* device instance $2188 r0 *1 68.14,27.645 sky130_fd_pr__pfet_01v8
M$2188 492 486 504 504 sky130_fd_pr__pfet_01v8 L=0.15U W=0.42U AS=0.06405P
+ AD=0.0567P PS=0.725U PD=0.69U
* device instance $2189 r0 *1 68.56,27.645 sky130_fd_pr__pfet_01v8
M$2189 502 487 492 492 sky130_fd_pr__pfet_01v8 L=0.15U W=0.42U AS=0.0567P
+ AD=0.0882P PS=0.69U PD=0.84U
* device instance $2190 r0 *1 69.13,27.645 sky130_fd_pr__pfet_01v8
M$2190 168 493 502 502 sky130_fd_pr__pfet_01v8 L=0.15U W=0.42U AS=0.0882P
+ AD=0.1113P PS=0.84U PD=1.37U
* device instance $2191 r0 *1 70.185,27.755 sky130_fd_pr__pfet_01v8
M$2191 168 492 493 493 sky130_fd_pr__pfet_01v8 L=0.15U W=0.64U AS=0.1728P
+ AD=0.154P PS=1.82U PD=1.335U
* device instance $2192 r0 *1 70.67,27.935 sky130_fd_pr__pfet_01v8
M$2192 339 492 168 168 sky130_fd_pr__pfet_01v8 L=0.15U W=1U AS=0.154P AD=0.28P
+ PS=1.335U PD=2.56U
* device instance $2193 r0 *1 13.35,33.295 sky130_fd_pr__pfet_01v8
M$2193 553 552 168 168 sky130_fd_pr__pfet_01v8 L=0.15U W=1.68U AS=0.3318P
+ AD=0.3486P PS=3.31U PD=3.35U
* device instance $2195 r0 *1 26.285,32.085 sky130_fd_pr__pfet_01v8
M$2195 551 433 168 168 sky130_fd_pr__pfet_01v8 L=0.15U W=0.64U AS=0.1696P
+ AD=0.0768P PS=1.81U PD=0.88U
* device instance $2196 r0 *1 26.675,32.085 sky130_fd_pr__pfet_01v8
M$2196 543 336 551 551 sky130_fd_pr__pfet_01v8 L=0.15U W=0.64U AS=0.0768P
+ AD=0.0896P PS=0.88U PD=0.92U
* device instance $2197 r0 *1 27.105,32.085 sky130_fd_pr__pfet_01v8
M$2197 168 495 543 543 sky130_fd_pr__pfet_01v8 L=0.15U W=0.64U AS=0.0896P
+ AD=0.1824P PS=0.92U PD=1.85U
* device instance $2198 r0 *1 27.155,33.375 sky130_fd_pr__pfet_01v8
M$2198 555 544 168 168 sky130_fd_pr__pfet_01v8 L=0.15U W=1U AS=0.265P AD=0.14P
+ PS=2.53U PD=1.28U
* device instance $2199 r0 *1 27.585,33.375 sky130_fd_pr__pfet_01v8
M$2199 168 543 555 555 sky130_fd_pr__pfet_01v8 L=0.15U W=1U AS=0.14P AD=0.1775P
+ PS=1.28U PD=1.355U
* device instance $2200 r0 *1 28.09,33.375 sky130_fd_pr__pfet_01v8
M$2200 554 555 168 168 sky130_fd_pr__pfet_01v8 L=0.15U W=4U AS=0.5975P
+ AD=0.705P PS=5.195U PD=6.41U
* device instance $2204 r0 *1 41.85,33.195 sky130_fd_pr__pfet_01v8
M$2204 575 547 558 558 sky130_fd_pr__pfet_01v8 L=0.15U W=0.64U AS=0.1664P
+ AD=0.0672P PS=1.8U PD=0.85U
* device instance $2205 r0 *1 42.21,33.195 sky130_fd_pr__pfet_01v8
M$2205 168 559 575 575 sky130_fd_pr__pfet_01v8 L=0.15U W=0.64U AS=0.0672P
+ AD=0.1664P PS=0.85U PD=1.8U
* device instance $2206 r0 *1 41.87,31.985 sky130_fd_pr__pfet_01v8
M$2206 484 536 168 168 sky130_fd_pr__pfet_01v8 L=0.15U W=1.68U AS=0.3318P
+ AD=0.3486P PS=3.31U PD=3.35U
* device instance $2208 r0 *1 44.875,33.085 sky130_fd_pr__pfet_01v8
M$2208 560 557 558 558 sky130_fd_pr__pfet_01v8 L=0.15U W=0.42U AS=0.15985P
+ AD=0.06405P PS=1.265U PD=0.725U
* device instance $2209 r0 *1 45.33,33.085 sky130_fd_pr__pfet_01v8
M$2209 571 556 560 560 sky130_fd_pr__pfet_01v8 L=0.15U W=0.42U AS=0.06405P
+ AD=0.07665P PS=0.725U PD=0.785U
* device instance $2210 r0 *1 45.845,33.085 sky130_fd_pr__pfet_01v8
M$2210 168 561 571 571 sky130_fd_pr__pfet_01v8 L=0.15U W=0.42U AS=0.07665P
+ AD=0.178875P PS=0.785U PD=1.26U
* device instance $2211 r0 *1 43.15,33.195 sky130_fd_pr__pfet_01v8
M$2211 168 16 559 559 sky130_fd_pr__pfet_01v8 L=0.15U W=0.64U AS=0.1664P
+ AD=0.0928P PS=1.8U PD=0.93U
* device instance $2212 r0 *1 43.59,33.195 sky130_fd_pr__pfet_01v8
M$2212 576 16 168 168 sky130_fd_pr__pfet_01v8 L=0.15U W=0.64U AS=0.0928P
+ AD=0.1152P PS=0.93U PD=1U
* device instance $2213 r0 *1 44.1,33.195 sky130_fd_pr__pfet_01v8
M$2213 558 563 576 576 sky130_fd_pr__pfet_01v8 L=0.15U W=0.64U AS=0.1152P
+ AD=0.15985P PS=1U PD=1.265U
* device instance $2214 r0 *1 46.505,33.25 sky130_fd_pr__pfet_01v8
M$2214 561 560 168 168 sky130_fd_pr__pfet_01v8 L=0.15U W=0.75U AS=0.178875P
+ AD=0.195P PS=1.26U PD=2.02U
* device instance $2215 r0 *1 47.445,33.085 sky130_fd_pr__pfet_01v8
M$2215 570 561 168 168 sky130_fd_pr__pfet_01v8 L=0.15U W=0.42U AS=0.1092P
+ AD=0.06405P PS=1.36U PD=0.725U
* device instance $2216 r0 *1 47.9,33.085 sky130_fd_pr__pfet_01v8
M$2216 562 556 570 570 sky130_fd_pr__pfet_01v8 L=0.15U W=0.42U AS=0.06405P
+ AD=0.0567P PS=0.725U PD=0.69U
* device instance $2217 r0 *1 48.32,33.085 sky130_fd_pr__pfet_01v8
M$2217 569 557 562 562 sky130_fd_pr__pfet_01v8 L=0.15U W=0.42U AS=0.0567P
+ AD=0.0882P PS=0.69U PD=0.84U
* device instance $2218 r0 *1 48.89,33.085 sky130_fd_pr__pfet_01v8
M$2218 168 563 569 569 sky130_fd_pr__pfet_01v8 L=0.15U W=0.42U AS=0.0882P
+ AD=0.1113P PS=0.84U PD=1.37U
* device instance $2219 r0 *1 49.945,33.195 sky130_fd_pr__pfet_01v8
M$2219 168 562 563 563 sky130_fd_pr__pfet_01v8 L=0.15U W=0.64U AS=0.1728P
+ AD=0.154P PS=1.82U PD=1.335U
* device instance $2220 r0 *1 50.43,33.375 sky130_fd_pr__pfet_01v8
M$2220 497 562 168 168 sky130_fd_pr__pfet_01v8 L=0.15U W=1U AS=0.154P AD=0.28P
+ PS=1.335U PD=2.56U
* device instance $2221 r0 *1 59.81,33.375 sky130_fd_pr__pfet_01v8
M$2221 168 305 564 564 sky130_fd_pr__pfet_01v8 L=0.15U W=1U AS=0.26P AD=0.135P
+ PS=2.52U PD=1.27U
* device instance $2222 r0 *1 60.23,33.375 sky130_fd_pr__pfet_01v8
M$2222 577 564 168 168 sky130_fd_pr__pfet_01v8 L=0.15U W=4U AS=0.54P AD=0.665P
+ PS=5.08U PD=6.33U
* device instance $2226 r0 *1 62.57,33.375 sky130_fd_pr__pfet_01v8
M$2226 566 572 565 565 sky130_fd_pr__pfet_01v8 L=0.15U W=1U AS=0.26P AD=0.135P
+ PS=2.52U PD=1.27U
* device instance $2227 r0 *1 62.99,33.375 sky130_fd_pr__pfet_01v8
M$2227 567 573 566 566 sky130_fd_pr__pfet_01v8 L=0.15U W=1U AS=0.135P AD=0.135P
+ PS=1.27U PD=1.27U
* device instance $2228 r0 *1 63.41,33.375 sky130_fd_pr__pfet_01v8
M$2228 566 90 567 567 sky130_fd_pr__pfet_01v8 L=0.15U W=1U AS=0.135P AD=0.26P
+ PS=1.27U PD=2.52U
* device instance $2229 r0 *1 64.35,33.375 sky130_fd_pr__pfet_01v8
M$2229 567 87 168 168 sky130_fd_pr__pfet_01v8 L=0.15U W=1U AS=0.26P AD=0.165P
+ PS=2.52U PD=1.33U
* device instance $2230 r0 *1 64.83,33.375 sky130_fd_pr__pfet_01v8
M$2230 168 574 567 567 sky130_fd_pr__pfet_01v8 L=0.15U W=1U AS=0.165P
+ AD=0.1575P PS=1.33U PD=1.315U
* device instance $2231 r0 *1 65.295,33.375 sky130_fd_pr__pfet_01v8
M$2231 568 565 168 168 sky130_fd_pr__pfet_01v8 L=0.15U W=1U AS=0.1575P AD=0.26P
+ PS=1.315U PD=2.52U
* device instance $2232 r0 *1 8.75,37.345 sky130_fd_pr__pfet_01v8
M$2232 612 598 586 586 sky130_fd_pr__pfet_01v8 L=0.15U W=1U AS=0.26P AD=0.135P
+ PS=2.52U PD=1.27U
* device instance $2233 r0 *1 9.17,37.345 sky130_fd_pr__pfet_01v8
M$2233 613 599 612 612 sky130_fd_pr__pfet_01v8 L=0.15U W=1U AS=0.135P AD=0.135P
+ PS=1.27U PD=1.27U
* device instance $2234 r0 *1 9.59,37.345 sky130_fd_pr__pfet_01v8
M$2234 612 90 613 613 sky130_fd_pr__pfet_01v8 L=0.15U W=1U AS=0.135P AD=0.26P
+ PS=1.27U PD=2.52U
* device instance $2235 r0 *1 10.53,37.345 sky130_fd_pr__pfet_01v8
M$2235 613 87 168 168 sky130_fd_pr__pfet_01v8 L=0.15U W=1U AS=0.26P AD=0.165P
+ PS=2.52U PD=1.33U
* device instance $2236 r0 *1 11.01,37.345 sky130_fd_pr__pfet_01v8
M$2236 168 600 613 613 sky130_fd_pr__pfet_01v8 L=0.15U W=1U AS=0.165P
+ AD=0.1575P PS=1.33U PD=1.315U
* device instance $2237 r0 *1 11.475,37.345 sky130_fd_pr__pfet_01v8
M$2237 587 586 168 168 sky130_fd_pr__pfet_01v8 L=0.15U W=1U AS=0.1575P AD=0.26P
+ PS=1.315U PD=2.52U
* device instance $2238 r0 *1 12.53,37.525 sky130_fd_pr__pfet_01v8
M$2238 617 553 588 588 sky130_fd_pr__pfet_01v8 L=0.15U W=0.64U AS=0.1664P
+ AD=0.0672P PS=1.8U PD=0.85U
* device instance $2239 r0 *1 12.89,37.525 sky130_fd_pr__pfet_01v8
M$2239 168 589 617 617 sky130_fd_pr__pfet_01v8 L=0.15U W=0.64U AS=0.0672P
+ AD=0.0864P PS=0.85U PD=0.91U
* device instance $2240 r0 *1 13.31,37.525 sky130_fd_pr__pfet_01v8
M$2240 618 589 168 168 sky130_fd_pr__pfet_01v8 L=0.15U W=0.64U AS=0.0864P
+ AD=0.0672P PS=0.91U PD=0.85U
* device instance $2241 r0 *1 13.67,37.525 sky130_fd_pr__pfet_01v8
M$2241 588 590 618 618 sky130_fd_pr__pfet_01v8 L=0.15U W=0.64U AS=0.0672P
+ AD=0.0864P PS=0.85U PD=0.91U
* device instance $2242 r0 *1 14.09,37.525 sky130_fd_pr__pfet_01v8
M$2242 619 590 588 588 sky130_fd_pr__pfet_01v8 L=0.15U W=0.64U AS=0.0864P
+ AD=0.0672P PS=0.91U PD=0.85U
* device instance $2243 r0 *1 14.45,37.525 sky130_fd_pr__pfet_01v8
M$2243 619 553 168 168 sky130_fd_pr__pfet_01v8 L=0.15U W=0.64U AS=0.237P
+ AD=0.0672P PS=1.6U PD=0.85U
* device instance $2244 r0 *1 15.2,37.345 sky130_fd_pr__pfet_01v8
M$2244 334 588 168 168 sky130_fd_pr__pfet_01v8 L=0.15U W=2U AS=0.372P AD=0.405P
+ PS=2.87U PD=3.81U
* device instance $2246 r0 *1 31.29,37.425 sky130_fd_pr__pfet_01v8
M$2246 495 601 168 168 sky130_fd_pr__pfet_01v8 L=0.15U W=1.68U AS=0.3318P
+ AD=0.3486P PS=3.31U PD=3.35U
* device instance $2248 r0 *1 34.05,37.055 sky130_fd_pr__pfet_01v8
M$2248 168 629 591 591 sky130_fd_pr__pfet_01v8 L=0.15U W=0.42U AS=0.1092P
+ AD=0.14575P PS=1.36U PD=1.335U
* device instance $2249 r0 *1 34.535,37.345 sky130_fd_pr__pfet_01v8
M$2249 496 602 168 168 sky130_fd_pr__pfet_01v8 L=0.15U W=1U AS=0.14575P
+ AD=0.135P PS=1.335U PD=1.27U
* device instance $2250 r0 *1 34.955,37.345 sky130_fd_pr__pfet_01v8
M$2250 168 591 496 496 sky130_fd_pr__pfet_01v8 L=0.15U W=1U AS=0.135P AD=0.265P
+ PS=1.27U PD=2.53U
* device instance $2251 r0 *1 40.49,33.225 sky130_fd_pr__pfet_01v8
M$2251 168 329 556 556 sky130_fd_pr__pfet_01v8 L=0.15U W=0.64U AS=0.1664P
+ AD=0.0864P PS=1.8U PD=0.91U
* device instance $2252 r0 *1 40.91,33.225 sky130_fd_pr__pfet_01v8
M$2252 557 556 168 168 sky130_fd_pr__pfet_01v8 L=0.15U W=0.64U AS=0.0864P
+ AD=0.1664P PS=0.91U PD=1.8U
* device instance $2253 r0 *1 59.42,37.635 sky130_fd_pr__pfet_01v8
M$2253 592 614 168 168 sky130_fd_pr__pfet_01v8 L=0.15U W=0.42U AS=0.1113P
+ AD=0.0609P PS=1.37U PD=0.71U
* device instance $2254 r0 *1 59.86,37.635 sky130_fd_pr__pfet_01v8
M$2254 592 109 168 168 sky130_fd_pr__pfet_01v8 L=0.15U W=0.42U AS=0.1841P
+ AD=0.0609P PS=1.26U PD=0.71U
* device instance $2255 r0 *1 60.63,37.525 sky130_fd_pr__pfet_01v8
M$2255 572 592 168 168 sky130_fd_pr__pfet_01v8 L=0.15U W=0.64U AS=0.1841P
+ AD=0.1696P PS=1.26U PD=1.81U
* device instance $2256 r0 *1 61.67,37.345 sky130_fd_pr__pfet_01v8
M$2256 593 577 168 168 sky130_fd_pr__pfet_01v8 L=0.15U W=1U AS=0.26P AD=0.135P
+ PS=2.52U PD=1.27U
* device instance $2257 r0 *1 62.09,37.345 sky130_fd_pr__pfet_01v8
M$2257 168 338 593 593 sky130_fd_pr__pfet_01v8 L=0.15U W=1U AS=0.135P AD=0.26P
+ PS=1.27U PD=2.52U
* device instance $2258 r0 *1 63.07,37.345 sky130_fd_pr__pfet_01v8
M$2258 594 593 168 168 sky130_fd_pr__pfet_01v8 L=0.15U W=1U AS=0.3P AD=0.135P
+ PS=2.6U PD=1.27U
* device instance $2259 r0 *1 63.49,37.345 sky130_fd_pr__pfet_01v8
M$2259 168 641 594 594 sky130_fd_pr__pfet_01v8 L=0.15U W=1U AS=0.135P AD=0.365P
+ PS=1.27U PD=1.73U
* device instance $2260 r0 *1 64.37,37.345 sky130_fd_pr__pfet_01v8
M$2260 616 641 168 168 sky130_fd_pr__pfet_01v8 L=0.15U W=1U AS=0.365P AD=0.105P
+ PS=1.73U PD=1.21U
* device instance $2261 r0 *1 64.73,37.345 sky130_fd_pr__pfet_01v8
M$2261 574 593 616 616 sky130_fd_pr__pfet_01v8 L=0.15U W=1U AS=0.105P AD=0.165P
+ PS=1.21U PD=1.33U
* device instance $2262 r0 *1 65.21,37.345 sky130_fd_pr__pfet_01v8
M$2262 168 594 574 574 sky130_fd_pr__pfet_01v8 L=0.15U W=1U AS=0.165P AD=0.36P
+ PS=1.33U PD=2.72U
* device instance $2263 r0 *1 66.49,37.055 sky130_fd_pr__pfet_01v8
M$2263 168 644 596 596 sky130_fd_pr__pfet_01v8 L=0.15U W=0.42U AS=0.1092P
+ AD=0.1573P PS=1.36U PD=1.39U
* device instance $2264 r0 *1 67.03,37.345 sky130_fd_pr__pfet_01v8
M$2264 615 573 168 168 sky130_fd_pr__pfet_01v8 L=0.15U W=1U AS=0.1573P
+ AD=0.105P PS=1.39U PD=1.21U
* device instance $2265 r0 *1 67.39,37.345 sky130_fd_pr__pfet_01v8
M$2265 597 596 615 615 sky130_fd_pr__pfet_01v8 L=0.15U W=1U AS=0.105P AD=0.26P
+ PS=1.21U PD=2.52U
* device instance $2266 r0 *1 4.68,38.525 sky130_fd_pr__pfet_01v8
M$2266 621 637 168 168 sky130_fd_pr__pfet_01v8 L=0.15U W=0.42U AS=0.1113P
+ AD=0.0609P PS=1.37U PD=0.71U
* device instance $2267 r0 *1 5.12,38.525 sky130_fd_pr__pfet_01v8
M$2267 168 109 621 621 sky130_fd_pr__pfet_01v8 L=0.15U W=0.42U AS=0.0609P
+ AD=0.1841P PS=0.71U PD=1.26U
* device instance $2268 r0 *1 5.89,38.635 sky130_fd_pr__pfet_01v8
M$2268 598 621 168 168 sky130_fd_pr__pfet_01v8 L=0.15U W=0.64U AS=0.1841P
+ AD=0.1696P PS=1.26U PD=1.81U
* device instance $2269 r0 *1 7.455,38.72 sky130_fd_pr__pfet_01v8
M$2269 648 71 168 168 sky130_fd_pr__pfet_01v8 L=0.15U W=0.42U AS=0.15835P
+ AD=0.07665P PS=1.395U PD=0.785U
* device instance $2270 r0 *1 7.97,38.72 sky130_fd_pr__pfet_01v8
M$2270 622 590 648 648 sky130_fd_pr__pfet_01v8 L=0.15U W=0.42U AS=0.07665P
+ AD=0.1932P PS=0.785U PD=1.34U
* device instance $2271 r0 *1 9.04,38.72 sky130_fd_pr__pfet_01v8
M$2271 649 620 622 622 sky130_fd_pr__pfet_01v8 L=0.15U W=0.42U AS=0.1932P
+ AD=0.0441P PS=1.34U PD=0.63U
* device instance $2272 r0 *1 9.4,38.72 sky130_fd_pr__pfet_01v8
M$2272 168 650 649 649 sky130_fd_pr__pfet_01v8 L=0.15U W=0.42U AS=0.0441P
+ AD=0.0693P PS=0.63U PD=0.75U
* device instance $2273 r0 *1 9.88,38.72 sky130_fd_pr__pfet_01v8
M$2273 650 71 168 168 sky130_fd_pr__pfet_01v8 L=0.15U W=0.42U AS=0.0693P
+ AD=0.1176P PS=0.75U PD=1.4U
* device instance $2274 r0 *1 6.91,38.815 sky130_fd_pr__pfet_01v8
M$2274 168 622 663 663 sky130_fd_pr__pfet_01v8 L=0.15U W=1U AS=0.26P
+ AD=0.15835P PS=2.52U PD=1.395U
* device instance $2275 r0 *1 11.09,38.815 sky130_fd_pr__pfet_01v8
M$2275 623 638 168 168 sky130_fd_pr__pfet_01v8 L=0.15U W=1U AS=0.3P AD=0.135P
+ PS=2.6U PD=1.27U
* device instance $2276 r0 *1 11.51,38.815 sky130_fd_pr__pfet_01v8
M$2276 168 624 623 623 sky130_fd_pr__pfet_01v8 L=0.15U W=1U AS=0.135P AD=0.365P
+ PS=1.27U PD=1.73U
* device instance $2277 r0 *1 12.39,38.815 sky130_fd_pr__pfet_01v8
M$2277 658 624 168 168 sky130_fd_pr__pfet_01v8 L=0.15U W=1U AS=0.365P AD=0.105P
+ PS=1.73U PD=1.21U
* device instance $2278 r0 *1 12.75,38.815 sky130_fd_pr__pfet_01v8
M$2278 600 638 658 658 sky130_fd_pr__pfet_01v8 L=0.15U W=1U AS=0.105P AD=0.165P
+ PS=1.21U PD=1.33U
* device instance $2279 r0 *1 13.23,38.815 sky130_fd_pr__pfet_01v8
M$2279 168 623 600 600 sky130_fd_pr__pfet_01v8 L=0.15U W=1U AS=0.165P AD=0.36P
+ PS=1.33U PD=2.72U
* device instance $2280 r0 *1 14.31,38.815 sky130_fd_pr__pfet_01v8
M$2280 660 590 625 625 sky130_fd_pr__pfet_01v8 L=0.15U W=1U AS=0.26P AD=0.135P
+ PS=2.52U PD=1.27U
* device instance $2281 r0 *1 14.73,38.815 sky130_fd_pr__pfet_01v8
M$2281 168 599 660 660 sky130_fd_pr__pfet_01v8 L=0.15U W=1U AS=0.135P AD=0.135P
+ PS=1.27U PD=1.27U
* device instance $2282 r0 *1 15.15,38.815 sky130_fd_pr__pfet_01v8
M$2282 626 599 168 168 sky130_fd_pr__pfet_01v8 L=0.15U W=1U AS=0.135P AD=0.135P
+ PS=1.27U PD=1.27U
* device instance $2283 r0 *1 15.57,38.815 sky130_fd_pr__pfet_01v8
M$2283 168 590 626 626 sky130_fd_pr__pfet_01v8 L=0.15U W=1U AS=0.135P AD=0.26P
+ PS=1.27U PD=2.52U
* device instance $2284 r0 *1 16.51,38.815 sky130_fd_pr__pfet_01v8
M$2284 638 625 626 626 sky130_fd_pr__pfet_01v8 L=0.15U W=1U AS=0.26P AD=0.3P
+ PS=2.52U PD=2.6U
* device instance $2285 r0 *1 25.77,38.815 sky130_fd_pr__pfet_01v8
M$2285 628 652 627 627 sky130_fd_pr__pfet_01v8 L=0.15U W=1U AS=0.26P AD=0.135P
+ PS=2.52U PD=1.27U
* device instance $2286 r0 *1 26.19,38.815 sky130_fd_pr__pfet_01v8
M$2286 639 629 628 628 sky130_fd_pr__pfet_01v8 L=0.15U W=1U AS=0.135P AD=0.135P
+ PS=1.27U PD=1.27U
* device instance $2287 r0 *1 26.61,38.815 sky130_fd_pr__pfet_01v8
M$2287 628 90 639 639 sky130_fd_pr__pfet_01v8 L=0.15U W=1U AS=0.135P AD=0.26P
+ PS=1.27U PD=2.52U
* device instance $2288 r0 *1 27.55,38.815 sky130_fd_pr__pfet_01v8
M$2288 639 138 168 168 sky130_fd_pr__pfet_01v8 L=0.15U W=1U AS=0.26P AD=0.165P
+ PS=2.52U PD=1.33U
* device instance $2289 r0 *1 28.03,38.815 sky130_fd_pr__pfet_01v8
M$2289 168 554 639 639 sky130_fd_pr__pfet_01v8 L=0.15U W=1U AS=0.165P
+ AD=0.1575P PS=1.33U PD=1.315U
* device instance $2290 r0 *1 28.495,38.815 sky130_fd_pr__pfet_01v8
M$2290 640 627 168 168 sky130_fd_pr__pfet_01v8 L=0.15U W=1U AS=0.1575P AD=0.26P
+ PS=1.315U PD=2.52U
* device instance $2291 r0 *1 30.87,38.815 sky130_fd_pr__pfet_01v8
M$2291 630 602 168 168 sky130_fd_pr__pfet_01v8 L=0.15U W=1U AS=0.3P AD=0.135P
+ PS=2.6U PD=1.27U
* device instance $2292 r0 *1 31.29,38.815 sky130_fd_pr__pfet_01v8
M$2292 168 629 630 630 sky130_fd_pr__pfet_01v8 L=0.15U W=1U AS=0.135P AD=0.365P
+ PS=1.27U PD=1.73U
* device instance $2293 r0 *1 32.17,38.815 sky130_fd_pr__pfet_01v8
M$2293 662 629 168 168 sky130_fd_pr__pfet_01v8 L=0.15U W=1U AS=0.365P AD=0.105P
+ PS=1.73U PD=1.21U
* device instance $2294 r0 *1 32.53,38.815 sky130_fd_pr__pfet_01v8
M$2294 601 602 662 662 sky130_fd_pr__pfet_01v8 L=0.15U W=1U AS=0.105P AD=0.165P
+ PS=1.21U PD=1.33U
* device instance $2295 r0 *1 33.01,38.815 sky130_fd_pr__pfet_01v8
M$2295 168 630 601 601 sky130_fd_pr__pfet_01v8 L=0.15U W=1U AS=0.165P AD=0.36P
+ PS=1.33U PD=2.72U
* device instance $2296 r0 *1 35.435,38.815 sky130_fd_pr__pfet_01v8
M$2296 631 654 168 168 sky130_fd_pr__pfet_01v8 L=0.15U W=4U AS=0.685P AD=0.56P
+ PS=6.37U PD=5.12U
* device instance $2300 r0 *1 37.155,38.815 sky130_fd_pr__pfet_01v8
M$2300 311 631 168 168 sky130_fd_pr__pfet_01v8 L=0.15U W=16U AS=2.2375P
+ AD=2.3625P PS=20.475U PD=21.725U
* device instance $2316 r0 *1 55.67,38.815 sky130_fd_pr__pfet_01v8
M$2316 632 577 168 168 sky130_fd_pr__pfet_01v8 L=0.15U W=1U AS=0.26P AD=0.135P
+ PS=2.52U PD=1.27U
* device instance $2317 r0 *1 56.09,38.815 sky130_fd_pr__pfet_01v8
M$2317 168 338 632 632 sky130_fd_pr__pfet_01v8 L=0.15U W=1U AS=0.135P
+ AD=0.1525P PS=1.27U PD=1.305U
* device instance $2318 r0 *1 56.545,38.815 sky130_fd_pr__pfet_01v8
M$2318 632 641 168 168 sky130_fd_pr__pfet_01v8 L=0.15U W=1U AS=0.1525P
+ AD=0.1625P PS=1.305U PD=1.325U
* device instance $2319 r0 *1 57.02,38.815 sky130_fd_pr__pfet_01v8
M$2319 633 597 632 632 sky130_fd_pr__pfet_01v8 L=0.15U W=1U AS=0.1625P AD=0.27P
+ PS=1.325U PD=2.54U
* device instance $2320 r0 *1 59.35,38.815 sky130_fd_pr__pfet_01v8
M$2320 642 338 168 168 sky130_fd_pr__pfet_01v8 L=0.15U W=1U AS=0.26P AD=0.1375P
+ PS=2.52U PD=1.275U
* device instance $2321 r0 *1 59.775,38.815 sky130_fd_pr__pfet_01v8
M$2321 168 305 642 642 sky130_fd_pr__pfet_01v8 L=0.15U W=1U AS=0.1375P AD=0.14P
+ PS=1.275U PD=1.28U
* device instance $2322 r0 *1 60.205,38.815 sky130_fd_pr__pfet_01v8
M$2322 642 641 168 168 sky130_fd_pr__pfet_01v8 L=0.15U W=1U AS=0.14P AD=0.165P
+ PS=1.28U PD=1.33U
* device instance $2323 r0 *1 60.685,38.815 sky130_fd_pr__pfet_01v8
M$2323 661 597 642 642 sky130_fd_pr__pfet_01v8 L=0.15U W=1U AS=0.165P
+ AD=0.1725P PS=1.33U PD=1.345U
* device instance $2324 r0 *1 61.18,38.815 sky130_fd_pr__pfet_01v8
M$2324 643 655 661 661 sky130_fd_pr__pfet_01v8 L=0.15U W=1U AS=0.1725P AD=0.26P
+ PS=1.345U PD=2.52U
* device instance $2325 r0 *1 64.45,38.815 sky130_fd_pr__pfet_01v8
M$2325 634 644 168 168 sky130_fd_pr__pfet_01v8 L=0.15U W=1U AS=0.3P AD=0.135P
+ PS=2.6U PD=1.27U
* device instance $2326 r0 *1 64.87,38.815 sky130_fd_pr__pfet_01v8
M$2326 168 573 634 634 sky130_fd_pr__pfet_01v8 L=0.15U W=1U AS=0.135P AD=0.365P
+ PS=1.27U PD=1.73U
* device instance $2327 r0 *1 65.75,38.815 sky130_fd_pr__pfet_01v8
M$2327 659 573 168 168 sky130_fd_pr__pfet_01v8 L=0.15U W=1U AS=0.365P AD=0.105P
+ PS=1.73U PD=1.21U
* device instance $2328 r0 *1 66.11,38.815 sky130_fd_pr__pfet_01v8
M$2328 641 644 659 659 sky130_fd_pr__pfet_01v8 L=0.15U W=1U AS=0.105P AD=0.165P
+ PS=1.21U PD=1.33U
* device instance $2329 r0 *1 66.59,38.815 sky130_fd_pr__pfet_01v8
M$2329 168 634 641 641 sky130_fd_pr__pfet_01v8 L=0.15U W=1U AS=0.165P AD=0.36P
+ PS=1.33U PD=2.72U
* device instance $2330 r0 *1 68.635,38.72 sky130_fd_pr__pfet_01v8
M$2330 647 71 168 168 sky130_fd_pr__pfet_01v8 L=0.15U W=0.42U AS=0.15835P
+ AD=0.07665P PS=1.395U PD=0.785U
* device instance $2331 r0 *1 69.15,38.72 sky130_fd_pr__pfet_01v8
M$2331 636 644 647 647 sky130_fd_pr__pfet_01v8 L=0.15U W=0.42U AS=0.07665P
+ AD=0.1932P PS=0.785U PD=1.34U
* device instance $2332 r0 *1 70.22,38.72 sky130_fd_pr__pfet_01v8
M$2332 646 645 636 636 sky130_fd_pr__pfet_01v8 L=0.15U W=0.42U AS=0.1932P
+ AD=0.0441P PS=1.34U PD=0.63U
* device instance $2333 r0 *1 70.58,38.72 sky130_fd_pr__pfet_01v8
M$2333 168 657 646 646 sky130_fd_pr__pfet_01v8 L=0.15U W=0.42U AS=0.0441P
+ AD=0.0693P PS=0.63U PD=0.75U
* device instance $2334 r0 *1 71.06,38.72 sky130_fd_pr__pfet_01v8
M$2334 657 71 168 168 sky130_fd_pr__pfet_01v8 L=0.15U W=0.42U AS=0.0693P
+ AD=0.1176P PS=0.75U PD=1.4U
* device instance $2335 r0 *1 68.09,38.815 sky130_fd_pr__pfet_01v8
M$2335 168 636 635 635 sky130_fd_pr__pfet_01v8 L=0.15U W=1U AS=0.26P
+ AD=0.15835P PS=2.52U PD=1.395U
* device instance $2336 r0 *1 2.77,42.935 sky130_fd_pr__pfet_01v8
M$2336 168 936 679 679 sky130_fd_pr__pfet_01v8 L=0.15U W=0.64U AS=0.1664P
+ AD=0.0864P PS=1.8U PD=0.91U
* device instance $2337 r0 *1 3.19,42.935 sky130_fd_pr__pfet_01v8
M$2337 680 679 168 168 sky130_fd_pr__pfet_01v8 L=0.15U W=0.64U AS=0.0864P
+ AD=0.1664P PS=0.91U PD=1.8U
* device instance $2338 r0 *1 4.13,42.965 sky130_fd_pr__pfet_01v8
M$2338 735 663 681 681 sky130_fd_pr__pfet_01v8 L=0.15U W=0.64U AS=0.1664P
+ AD=0.0672P PS=1.8U PD=0.85U
* device instance $2339 r0 *1 4.49,42.965 sky130_fd_pr__pfet_01v8
M$2339 168 682 735 735 sky130_fd_pr__pfet_01v8 L=0.15U W=0.64U AS=0.0672P
+ AD=0.1664P PS=0.85U PD=1.8U
* device instance $2340 r0 *1 5.43,42.965 sky130_fd_pr__pfet_01v8
M$2340 168 93 682 682 sky130_fd_pr__pfet_01v8 L=0.15U W=0.64U AS=0.1664P
+ AD=0.0928P PS=1.8U PD=0.93U
* device instance $2341 r0 *1 5.87,42.965 sky130_fd_pr__pfet_01v8
M$2341 736 93 168 168 sky130_fd_pr__pfet_01v8 L=0.15U W=0.64U AS=0.0928P
+ AD=0.1152P PS=0.93U PD=1U
* device instance $2342 r0 *1 6.38,42.965 sky130_fd_pr__pfet_01v8
M$2342 681 705 736 736 sky130_fd_pr__pfet_01v8 L=0.15U W=0.64U AS=0.1152P
+ AD=0.15985P PS=1U PD=1.265U
* device instance $2343 r0 *1 7.155,43.075 sky130_fd_pr__pfet_01v8
M$2343 683 680 681 681 sky130_fd_pr__pfet_01v8 L=0.15U W=0.42U AS=0.15985P
+ AD=0.06405P PS=1.265U PD=0.725U
* device instance $2344 r0 *1 7.61,43.075 sky130_fd_pr__pfet_01v8
M$2344 737 679 683 683 sky130_fd_pr__pfet_01v8 L=0.15U W=0.42U AS=0.06405P
+ AD=0.07665P PS=0.725U PD=0.785U
* device instance $2345 r0 *1 8.125,43.075 sky130_fd_pr__pfet_01v8
M$2345 737 684 168 168 sky130_fd_pr__pfet_01v8 L=0.15U W=0.42U AS=0.178875P
+ AD=0.07665P PS=1.26U PD=0.785U
* device instance $2346 r0 *1 8.785,42.91 sky130_fd_pr__pfet_01v8
M$2346 684 683 168 168 sky130_fd_pr__pfet_01v8 L=0.15U W=0.75U AS=0.178875P
+ AD=0.195P PS=1.26U PD=2.02U
* device instance $2347 r0 *1 12.225,42.965 sky130_fd_pr__pfet_01v8
M$2347 705 685 168 168 sky130_fd_pr__pfet_01v8 L=0.15U W=0.64U AS=0.154P
+ AD=0.1728P PS=1.335U PD=1.82U
* device instance $2348 r0 *1 12.71,42.785 sky130_fd_pr__pfet_01v8
M$2348 552 685 168 168 sky130_fd_pr__pfet_01v8 L=0.15U W=1U AS=0.154P AD=0.28P
+ PS=1.335U PD=2.56U
* device instance $2349 r0 *1 13.81,42.785 sky130_fd_pr__pfet_01v8
M$2349 168 552 706 706 sky130_fd_pr__pfet_01v8 L=0.15U W=1U AS=0.26P AD=0.135P
+ PS=2.52U PD=1.27U
* device instance $2350 r0 *1 14.23,42.785 sky130_fd_pr__pfet_01v8
M$2350 599 706 168 168 sky130_fd_pr__pfet_01v8 L=0.15U W=4U AS=0.54P AD=0.665P
+ PS=5.08U PD=6.33U
* device instance $2354 r0 *1 17.03,42.785 sky130_fd_pr__pfet_01v8
M$2354 168 589 707 707 sky130_fd_pr__pfet_01v8 L=0.15U W=1U AS=0.26P AD=0.135P
+ PS=2.52U PD=1.27U
* device instance $2355 r0 *1 17.45,42.785 sky130_fd_pr__pfet_01v8
M$2355 624 707 168 168 sky130_fd_pr__pfet_01v8 L=0.15U W=4U AS=0.54P
+ AD=0.742525P PS=5.08U PD=5.66U
* device instance $2359 r0 *1 19.71,43.075 sky130_fd_pr__pfet_01v8
M$2359 686 732 168 168 sky130_fd_pr__pfet_01v8 L=0.15U W=0.42U AS=0.337525P
+ AD=0.0609P PS=1.85U PD=0.71U
* device instance $2360 r0 *1 20.15,43.075 sky130_fd_pr__pfet_01v8
M$2360 686 109 168 168 sky130_fd_pr__pfet_01v8 L=0.15U W=0.42U AS=0.1841P
+ AD=0.0609P PS=1.26U PD=0.71U
* device instance $2361 r0 *1 20.92,42.965 sky130_fd_pr__pfet_01v8
M$2361 652 686 168 168 sky130_fd_pr__pfet_01v8 L=0.15U W=0.64U AS=0.1841P
+ AD=0.1696P PS=1.26U PD=1.81U
* device instance $2362 r0 *1 26.23,42.935 sky130_fd_pr__pfet_01v8
M$2362 168 936 687 687 sky130_fd_pr__pfet_01v8 L=0.15U W=0.64U AS=0.1664P
+ AD=0.0864P PS=1.8U PD=0.91U
* device instance $2363 r0 *1 26.65,42.935 sky130_fd_pr__pfet_01v8
M$2363 688 687 168 168 sky130_fd_pr__pfet_01v8 L=0.15U W=0.64U AS=0.0864P
+ AD=0.1664P PS=0.91U PD=1.8U
* device instance $2364 r0 *1 27.59,42.965 sky130_fd_pr__pfet_01v8
M$2364 745 708 689 689 sky130_fd_pr__pfet_01v8 L=0.15U W=0.64U AS=0.1664P
+ AD=0.0672P PS=1.8U PD=0.85U
* device instance $2365 r0 *1 27.95,42.965 sky130_fd_pr__pfet_01v8
M$2365 168 690 745 745 sky130_fd_pr__pfet_01v8 L=0.15U W=0.64U AS=0.0672P
+ AD=0.1664P PS=0.85U PD=1.8U
* device instance $2366 r0 *1 28.89,42.965 sky130_fd_pr__pfet_01v8
M$2366 168 93 690 690 sky130_fd_pr__pfet_01v8 L=0.15U W=0.64U AS=0.1664P
+ AD=0.0928P PS=1.8U PD=0.93U
* device instance $2367 r0 *1 29.33,42.965 sky130_fd_pr__pfet_01v8
M$2367 747 93 168 168 sky130_fd_pr__pfet_01v8 L=0.15U W=0.64U AS=0.0928P
+ AD=0.1152P PS=0.93U PD=1U
* device instance $2368 r0 *1 29.84,42.965 sky130_fd_pr__pfet_01v8
M$2368 689 709 747 747 sky130_fd_pr__pfet_01v8 L=0.15U W=0.64U AS=0.1152P
+ AD=0.15985P PS=1U PD=1.265U
* device instance $2369 r0 *1 30.615,43.075 sky130_fd_pr__pfet_01v8
M$2369 691 688 689 689 sky130_fd_pr__pfet_01v8 L=0.15U W=0.42U AS=0.15985P
+ AD=0.06405P PS=1.265U PD=0.725U
* device instance $2370 r0 *1 31.07,43.075 sky130_fd_pr__pfet_01v8
M$2370 748 687 691 691 sky130_fd_pr__pfet_01v8 L=0.15U W=0.42U AS=0.06405P
+ AD=0.07665P PS=0.725U PD=0.785U
* device instance $2371 r0 *1 31.585,43.075 sky130_fd_pr__pfet_01v8
M$2371 748 692 168 168 sky130_fd_pr__pfet_01v8 L=0.15U W=0.42U AS=0.178875P
+ AD=0.07665P PS=1.26U PD=0.785U
* device instance $2372 r0 *1 32.245,42.91 sky130_fd_pr__pfet_01v8
M$2372 692 691 168 168 sky130_fd_pr__pfet_01v8 L=0.15U W=0.75U AS=0.178875P
+ AD=0.195P PS=1.26U PD=2.02U
* device instance $2373 r0 *1 35.685,42.965 sky130_fd_pr__pfet_01v8
M$2373 709 693 168 168 sky130_fd_pr__pfet_01v8 L=0.15U W=0.64U AS=0.154P
+ AD=0.1728P PS=1.335U PD=1.82U
* device instance $2374 r0 *1 36.17,42.785 sky130_fd_pr__pfet_01v8
M$2374 629 693 168 168 sky130_fd_pr__pfet_01v8 L=0.15U W=1U AS=0.154P AD=0.28P
+ PS=1.335U PD=2.56U
* device instance $2375 r0 *1 44.63,42.785 sky130_fd_pr__pfet_01v8
M$2375 753 629 733 733 sky130_fd_pr__pfet_01v8 L=0.15U W=1U AS=0.26P AD=0.13P
+ PS=2.52U PD=1.26U
* device instance $2376 r0 *1 45.04,42.785 sky130_fd_pr__pfet_01v8
M$2376 752 366 753 753 sky130_fd_pr__pfet_01v8 L=0.15U W=1U AS=0.13P AD=0.19P
+ PS=1.26U PD=1.38U
* device instance $2377 r0 *1 45.57,42.785 sky130_fd_pr__pfet_01v8
M$2377 751 710 752 752 sky130_fd_pr__pfet_01v8 L=0.15U W=1U AS=0.19P AD=0.135P
+ PS=1.38U PD=1.27U
* device instance $2378 r0 *1 45.99,42.785 sky130_fd_pr__pfet_01v8
M$2378 168 694 751 751 sky130_fd_pr__pfet_01v8 L=0.15U W=1U AS=0.135P AD=0.26P
+ PS=1.27U PD=2.52U
* device instance $2379 r0 *1 49.23,42.785 sky130_fd_pr__pfet_01v8
M$2379 893 733 168 168 sky130_fd_pr__pfet_01v8 L=0.15U W=1U AS=0.26P AD=0.135P
+ PS=2.52U PD=1.27U
* device instance $2380 r0 *1 49.65,42.785 sky130_fd_pr__pfet_01v8
M$2380 168 695 893 893 sky130_fd_pr__pfet_01v8 L=0.15U W=1U AS=0.135P AD=0.165P
+ PS=1.27U PD=1.33U
* device instance $2381 r0 *1 50.13,42.785 sky130_fd_pr__pfet_01v8
M$2381 893 407 168 168 sky130_fd_pr__pfet_01v8 L=0.15U W=1U AS=0.165P AD=0.26P
+ PS=1.33U PD=2.52U
* device instance $2382 r0 *1 57.55,42.785 sky130_fd_pr__pfet_01v8
M$2382 696 711 168 168 sky130_fd_pr__pfet_01v8 L=0.15U W=1U AS=0.3P AD=0.135P
+ PS=2.6U PD=1.27U
* device instance $2383 r0 *1 57.97,42.785 sky130_fd_pr__pfet_01v8
M$2383 168 633 696 696 sky130_fd_pr__pfet_01v8 L=0.15U W=1U AS=0.135P AD=0.365P
+ PS=1.27U PD=1.73U
* device instance $2384 r0 *1 58.85,42.785 sky130_fd_pr__pfet_01v8
M$2384 746 633 168 168 sky130_fd_pr__pfet_01v8 L=0.15U W=1U AS=0.365P AD=0.105P
+ PS=1.73U PD=1.21U
* device instance $2385 r0 *1 59.21,42.785 sky130_fd_pr__pfet_01v8
M$2385 734 711 746 746 sky130_fd_pr__pfet_01v8 L=0.15U W=1U AS=0.105P AD=0.165P
+ PS=1.21U PD=1.33U
* device instance $2386 r0 *1 59.69,42.785 sky130_fd_pr__pfet_01v8
M$2386 168 696 734 734 sky130_fd_pr__pfet_01v8 L=0.15U W=1U AS=0.165P AD=0.36P
+ PS=1.33U PD=2.72U
* device instance $2387 r0 *1 60.73,42.935 sky130_fd_pr__pfet_01v8
M$2387 168 996 698 698 sky130_fd_pr__pfet_01v8 L=0.15U W=0.64U AS=0.1664P
+ AD=0.0864P PS=1.8U PD=0.91U
* device instance $2388 r0 *1 61.15,42.935 sky130_fd_pr__pfet_01v8
M$2388 699 698 168 168 sky130_fd_pr__pfet_01v8 L=0.15U W=0.64U AS=0.0864P
+ AD=0.1664P PS=0.91U PD=1.8U
* device instance $2389 r0 *1 62.09,42.965 sky130_fd_pr__pfet_01v8
M$2389 744 568 700 700 sky130_fd_pr__pfet_01v8 L=0.15U W=0.64U AS=0.1664P
+ AD=0.0672P PS=1.8U PD=0.85U
* device instance $2390 r0 *1 62.45,42.965 sky130_fd_pr__pfet_01v8
M$2390 168 701 744 744 sky130_fd_pr__pfet_01v8 L=0.15U W=0.64U AS=0.0672P
+ AD=0.1664P PS=0.85U PD=1.8U
* device instance $2391 r0 *1 63.39,42.965 sky130_fd_pr__pfet_01v8
M$2391 168 16 701 701 sky130_fd_pr__pfet_01v8 L=0.15U W=0.64U AS=0.1664P
+ AD=0.0928P PS=1.8U PD=0.93U
* device instance $2392 r0 *1 63.83,42.965 sky130_fd_pr__pfet_01v8
M$2392 743 16 168 168 sky130_fd_pr__pfet_01v8 L=0.15U W=0.64U AS=0.0928P
+ AD=0.1152P PS=0.93U PD=1U
* device instance $2393 r0 *1 64.34,42.965 sky130_fd_pr__pfet_01v8
M$2393 700 712 743 743 sky130_fd_pr__pfet_01v8 L=0.15U W=0.64U AS=0.1152P
+ AD=0.15985P PS=1U PD=1.265U
* device instance $2394 r0 *1 65.115,43.075 sky130_fd_pr__pfet_01v8
M$2394 702 699 700 700 sky130_fd_pr__pfet_01v8 L=0.15U W=0.42U AS=0.15985P
+ AD=0.06405P PS=1.265U PD=0.725U
* device instance $2395 r0 *1 65.57,43.075 sky130_fd_pr__pfet_01v8
M$2395 742 698 702 702 sky130_fd_pr__pfet_01v8 L=0.15U W=0.42U AS=0.06405P
+ AD=0.07665P PS=0.725U PD=0.785U
* device instance $2396 r0 *1 66.085,43.075 sky130_fd_pr__pfet_01v8
M$2396 742 703 168 168 sky130_fd_pr__pfet_01v8 L=0.15U W=0.42U AS=0.178875P
+ AD=0.07665P PS=1.26U PD=0.785U
* device instance $2397 r0 *1 66.745,42.91 sky130_fd_pr__pfet_01v8
M$2397 703 702 168 168 sky130_fd_pr__pfet_01v8 L=0.15U W=0.75U AS=0.178875P
+ AD=0.195P PS=1.26U PD=2.02U
* device instance $2398 r0 *1 70.185,42.965 sky130_fd_pr__pfet_01v8
M$2398 712 704 168 168 sky130_fd_pr__pfet_01v8 L=0.15U W=0.64U AS=0.154P
+ AD=0.1728P PS=1.335U PD=1.82U
* device instance $2399 r0 *1 70.67,42.785 sky130_fd_pr__pfet_01v8
M$2399 644 704 168 168 sky130_fd_pr__pfet_01v8 L=0.15U W=1U AS=0.154P AD=0.28P
+ PS=1.335U PD=2.56U
* device instance $2400 r0 *1 9.725,43.075 sky130_fd_pr__pfet_01v8
M$2400 738 684 168 168 sky130_fd_pr__pfet_01v8 L=0.15U W=0.42U AS=0.1092P
+ AD=0.06405P PS=1.36U PD=0.725U
* device instance $2401 r0 *1 10.18,43.075 sky130_fd_pr__pfet_01v8
M$2401 685 679 738 738 sky130_fd_pr__pfet_01v8 L=0.15U W=0.42U AS=0.06405P
+ AD=0.0567P PS=0.725U PD=0.69U
* device instance $2402 r0 *1 10.6,43.075 sky130_fd_pr__pfet_01v8
M$2402 740 680 685 685 sky130_fd_pr__pfet_01v8 L=0.15U W=0.42U AS=0.0567P
+ AD=0.0882P PS=0.69U PD=0.84U
* device instance $2403 r0 *1 11.17,43.075 sky130_fd_pr__pfet_01v8
M$2403 168 705 740 740 sky130_fd_pr__pfet_01v8 L=0.15U W=0.42U AS=0.0882P
+ AD=0.1113P PS=0.84U PD=1.37U
* device instance $2404 r0 *1 10.57,44.075 sky130_fd_pr__pfet_01v8
M$2404 789 587 756 756 sky130_fd_pr__pfet_01v8 L=0.15U W=0.64U AS=0.1664P
+ AD=0.0672P PS=1.8U PD=0.85U
* device instance $2405 r0 *1 10.93,44.075 sky130_fd_pr__pfet_01v8
M$2405 168 757 789 789 sky130_fd_pr__pfet_01v8 L=0.15U W=0.64U AS=0.0672P
+ AD=0.1664P PS=0.85U PD=1.8U
* device instance $2406 r0 *1 13.595,43.965 sky130_fd_pr__pfet_01v8
M$2406 758 755 756 756 sky130_fd_pr__pfet_01v8 L=0.15U W=0.42U AS=0.15985P
+ AD=0.06405P PS=1.265U PD=0.725U
* device instance $2407 r0 *1 14.05,43.965 sky130_fd_pr__pfet_01v8
M$2407 792 754 758 758 sky130_fd_pr__pfet_01v8 L=0.15U W=0.42U AS=0.06405P
+ AD=0.07665P PS=0.725U PD=0.785U
* device instance $2408 r0 *1 14.565,43.965 sky130_fd_pr__pfet_01v8
M$2408 168 759 792 792 sky130_fd_pr__pfet_01v8 L=0.15U W=0.42U AS=0.07665P
+ AD=0.178875P PS=0.785U PD=1.26U
* device instance $2409 r0 *1 11.87,44.075 sky130_fd_pr__pfet_01v8
M$2409 168 16 757 757 sky130_fd_pr__pfet_01v8 L=0.15U W=0.64U AS=0.1664P
+ AD=0.0928P PS=1.8U PD=0.93U
* device instance $2410 r0 *1 12.31,44.075 sky130_fd_pr__pfet_01v8
M$2410 791 16 168 168 sky130_fd_pr__pfet_01v8 L=0.15U W=0.64U AS=0.0928P
+ AD=0.1152P PS=0.93U PD=1U
* device instance $2411 r0 *1 12.82,44.075 sky130_fd_pr__pfet_01v8
M$2411 756 761 791 791 sky130_fd_pr__pfet_01v8 L=0.15U W=0.64U AS=0.1152P
+ AD=0.15985P PS=1U PD=1.265U
* device instance $2412 r0 *1 15.225,44.13 sky130_fd_pr__pfet_01v8
M$2412 759 758 168 168 sky130_fd_pr__pfet_01v8 L=0.15U W=0.75U AS=0.178875P
+ AD=0.195P PS=1.26U PD=2.02U
* device instance $2413 r0 *1 16.165,43.965 sky130_fd_pr__pfet_01v8
M$2413 794 759 168 168 sky130_fd_pr__pfet_01v8 L=0.15U W=0.42U AS=0.1092P
+ AD=0.06405P PS=1.36U PD=0.725U
* device instance $2414 r0 *1 16.62,43.965 sky130_fd_pr__pfet_01v8
M$2414 760 754 794 794 sky130_fd_pr__pfet_01v8 L=0.15U W=0.42U AS=0.06405P
+ AD=0.0567P PS=0.725U PD=0.69U
* device instance $2415 r0 *1 17.04,43.965 sky130_fd_pr__pfet_01v8
M$2415 796 755 760 760 sky130_fd_pr__pfet_01v8 L=0.15U W=0.42U AS=0.0567P
+ AD=0.0882P PS=0.69U PD=0.84U
* device instance $2416 r0 *1 17.61,43.965 sky130_fd_pr__pfet_01v8
M$2416 168 761 796 796 sky130_fd_pr__pfet_01v8 L=0.15U W=0.42U AS=0.0882P
+ AD=0.1113P PS=0.84U PD=1.37U
* device instance $2417 r0 *1 18.665,44.075 sky130_fd_pr__pfet_01v8
M$2417 168 760 761 761 sky130_fd_pr__pfet_01v8 L=0.15U W=0.64U AS=0.1728P
+ AD=0.154P PS=1.82U PD=1.335U
* device instance $2418 r0 *1 19.15,44.255 sky130_fd_pr__pfet_01v8
M$2418 590 760 168 168 sky130_fd_pr__pfet_01v8 L=0.15U W=1U AS=0.154P AD=0.28P
+ PS=1.335U PD=2.56U
* device instance $2419 r0 *1 26.775,44.16 sky130_fd_pr__pfet_01v8
M$2419 798 71 168 168 sky130_fd_pr__pfet_01v8 L=0.15U W=0.42U AS=0.15835P
+ AD=0.07665P PS=1.395U PD=0.785U
* device instance $2420 r0 *1 27.29,44.16 sky130_fd_pr__pfet_01v8
M$2420 762 602 798 798 sky130_fd_pr__pfet_01v8 L=0.15U W=0.42U AS=0.07665P
+ AD=0.1932P PS=0.785U PD=1.34U
* device instance $2421 r0 *1 28.36,44.16 sky130_fd_pr__pfet_01v8
M$2421 799 782 762 762 sky130_fd_pr__pfet_01v8 L=0.15U W=0.42U AS=0.1932P
+ AD=0.0441P PS=1.34U PD=0.63U
* device instance $2422 r0 *1 28.72,44.16 sky130_fd_pr__pfet_01v8
M$2422 168 810 799 799 sky130_fd_pr__pfet_01v8 L=0.15U W=0.42U AS=0.0441P
+ AD=0.0693P PS=0.63U PD=0.75U
* device instance $2423 r0 *1 29.2,44.16 sky130_fd_pr__pfet_01v8
M$2423 810 71 168 168 sky130_fd_pr__pfet_01v8 L=0.15U W=0.42U AS=0.0693P
+ AD=0.1176P PS=0.75U PD=1.4U
* device instance $2424 r0 *1 26.23,44.255 sky130_fd_pr__pfet_01v8
M$2424 168 762 708 708 sky130_fd_pr__pfet_01v8 L=0.15U W=1U AS=0.26P
+ AD=0.15835P PS=2.52U PD=1.395U
* device instance $2425 r0 *1 33.185,43.075 sky130_fd_pr__pfet_01v8
M$2425 749 692 168 168 sky130_fd_pr__pfet_01v8 L=0.15U W=0.42U AS=0.1092P
+ AD=0.06405P PS=1.36U PD=0.725U
* device instance $2426 r0 *1 33.64,43.075 sky130_fd_pr__pfet_01v8
M$2426 693 687 749 749 sky130_fd_pr__pfet_01v8 L=0.15U W=0.42U AS=0.06405P
+ AD=0.0567P PS=0.725U PD=0.69U
* device instance $2427 r0 *1 34.06,43.075 sky130_fd_pr__pfet_01v8
M$2427 750 688 693 693 sky130_fd_pr__pfet_01v8 L=0.15U W=0.42U AS=0.0567P
+ AD=0.0882P PS=0.69U PD=0.84U
* device instance $2428 r0 *1 34.63,43.075 sky130_fd_pr__pfet_01v8
M$2428 168 709 750 750 sky130_fd_pr__pfet_01v8 L=0.15U W=0.42U AS=0.0882P
+ AD=0.1113P PS=0.84U PD=1.37U
* device instance $2429 r0 *1 34.95,44.075 sky130_fd_pr__pfet_01v8
M$2429 801 783 765 765 sky130_fd_pr__pfet_01v8 L=0.15U W=0.64U AS=0.1664P
+ AD=0.0672P PS=1.8U PD=0.85U
* device instance $2430 r0 *1 35.31,44.075 sky130_fd_pr__pfet_01v8
M$2430 168 766 801 801 sky130_fd_pr__pfet_01v8 L=0.15U W=0.64U AS=0.0672P
+ AD=0.1664P PS=0.85U PD=1.8U
* device instance $2431 r0 *1 37.975,43.965 sky130_fd_pr__pfet_01v8
M$2431 767 764 765 765 sky130_fd_pr__pfet_01v8 L=0.15U W=0.42U AS=0.15985P
+ AD=0.06405P PS=1.265U PD=0.725U
* device instance $2432 r0 *1 38.43,43.965 sky130_fd_pr__pfet_01v8
M$2432 803 763 767 767 sky130_fd_pr__pfet_01v8 L=0.15U W=0.42U AS=0.06405P
+ AD=0.07665P PS=0.725U PD=0.785U
* device instance $2433 r0 *1 38.945,43.965 sky130_fd_pr__pfet_01v8
M$2433 168 768 803 803 sky130_fd_pr__pfet_01v8 L=0.15U W=0.42U AS=0.07665P
+ AD=0.178875P PS=0.785U PD=1.26U
* device instance $2434 r0 *1 36.25,44.075 sky130_fd_pr__pfet_01v8
M$2434 168 93 766 766 sky130_fd_pr__pfet_01v8 L=0.15U W=0.64U AS=0.1664P
+ AD=0.0928P PS=1.8U PD=0.93U
* device instance $2435 r0 *1 36.69,44.075 sky130_fd_pr__pfet_01v8
M$2435 802 93 168 168 sky130_fd_pr__pfet_01v8 L=0.15U W=0.64U AS=0.0928P
+ AD=0.1152P PS=0.93U PD=1U
* device instance $2436 r0 *1 37.2,44.075 sky130_fd_pr__pfet_01v8
M$2436 765 770 802 802 sky130_fd_pr__pfet_01v8 L=0.15U W=0.64U AS=0.1152P
+ AD=0.15985P PS=1U PD=1.265U
* device instance $2437 r0 *1 39.605,44.13 sky130_fd_pr__pfet_01v8
M$2437 768 767 168 168 sky130_fd_pr__pfet_01v8 L=0.15U W=0.75U AS=0.178875P
+ AD=0.195P PS=1.26U PD=2.02U
* device instance $2438 r0 *1 40.545,43.965 sky130_fd_pr__pfet_01v8
M$2438 805 768 168 168 sky130_fd_pr__pfet_01v8 L=0.15U W=0.42U AS=0.1092P
+ AD=0.06405P PS=1.36U PD=0.725U
* device instance $2439 r0 *1 41,43.965 sky130_fd_pr__pfet_01v8
M$2439 769 763 805 805 sky130_fd_pr__pfet_01v8 L=0.15U W=0.42U AS=0.06405P
+ AD=0.0567P PS=0.725U PD=0.69U
* device instance $2440 r0 *1 41.42,43.965 sky130_fd_pr__pfet_01v8
M$2440 806 764 769 769 sky130_fd_pr__pfet_01v8 L=0.15U W=0.42U AS=0.0567P
+ AD=0.0882P PS=0.69U PD=0.84U
* device instance $2441 r0 *1 41.99,43.965 sky130_fd_pr__pfet_01v8
M$2441 168 770 806 806 sky130_fd_pr__pfet_01v8 L=0.15U W=0.42U AS=0.0882P
+ AD=0.1113P PS=0.84U PD=1.37U
* device instance $2442 r0 *1 43.045,44.075 sky130_fd_pr__pfet_01v8
M$2442 168 769 770 770 sky130_fd_pr__pfet_01v8 L=0.15U W=0.64U AS=0.1728P
+ AD=0.154P PS=1.82U PD=1.335U
* device instance $2443 r0 *1 43.53,44.255 sky130_fd_pr__pfet_01v8
M$2443 710 769 168 168 sky130_fd_pr__pfet_01v8 L=0.15U W=1U AS=0.154P AD=0.28P
+ PS=1.335U PD=2.56U
* device instance $2444 r0 *1 44.63,44.255 sky130_fd_pr__pfet_01v8
M$2444 772 784 771 771 sky130_fd_pr__pfet_01v8 L=0.15U W=1U AS=0.26P AD=0.135P
+ PS=2.52U PD=1.27U
* device instance $2445 r0 *1 45.05,44.255 sky130_fd_pr__pfet_01v8
M$2445 785 710 772 772 sky130_fd_pr__pfet_01v8 L=0.15U W=1U AS=0.135P AD=0.135P
+ PS=1.27U PD=1.27U
* device instance $2446 r0 *1 45.47,44.255 sky130_fd_pr__pfet_01v8
M$2446 772 90 785 785 sky130_fd_pr__pfet_01v8 L=0.15U W=1U AS=0.135P AD=0.26P
+ PS=1.27U PD=2.52U
* device instance $2447 r0 *1 46.41,44.255 sky130_fd_pr__pfet_01v8
M$2447 785 138 168 168 sky130_fd_pr__pfet_01v8 L=0.15U W=1U AS=0.26P AD=0.165P
+ PS=2.52U PD=1.33U
* device instance $2448 r0 *1 46.89,44.255 sky130_fd_pr__pfet_01v8
M$2448 168 734 785 785 sky130_fd_pr__pfet_01v8 L=0.15U W=1U AS=0.165P
+ AD=0.1575P PS=1.33U PD=1.315U
* device instance $2449 r0 *1 47.355,44.255 sky130_fd_pr__pfet_01v8
M$2449 811 771 168 168 sky130_fd_pr__pfet_01v8 L=0.15U W=1U AS=0.1575P AD=0.26P
+ PS=1.315U PD=2.52U
* device instance $2450 r0 *1 48.31,44.175 sky130_fd_pr__pfet_01v8
M$2450 773 786 168 168 sky130_fd_pr__pfet_01v8 L=0.15U W=1.68U AS=0.3318P
+ AD=0.3486P PS=3.31U PD=3.35U
* device instance $2452 r0 *1 49.69,44.255 sky130_fd_pr__pfet_01v8
M$2452 809 773 655 655 sky130_fd_pr__pfet_01v8 L=0.15U W=1U AS=0.26P AD=0.105P
+ PS=2.52U PD=1.21U
* device instance $2453 r0 *1 50.05,44.255 sky130_fd_pr__pfet_01v8
M$2453 168 710 809 809 sky130_fd_pr__pfet_01v8 L=0.15U W=1U AS=0.105P AD=0.26P
+ PS=1.21U PD=2.52U
* device instance $2454 r0 *1 51.31,44.545 sky130_fd_pr__pfet_01v8
M$2454 787 710 168 168 sky130_fd_pr__pfet_01v8 L=0.15U W=0.42U AS=0.1573P
+ AD=0.1092P PS=1.39U PD=1.36U
* device instance $2455 r0 *1 51.85,44.255 sky130_fd_pr__pfet_01v8
M$2455 808 786 168 168 sky130_fd_pr__pfet_01v8 L=0.15U W=1U AS=0.1573P
+ AD=0.105P PS=1.39U PD=1.21U
* device instance $2456 r0 *1 52.21,44.255 sky130_fd_pr__pfet_01v8
M$2456 788 787 808 808 sky130_fd_pr__pfet_01v8 L=0.15U W=1U AS=0.105P AD=0.26P
+ PS=1.21U PD=2.52U
* device instance $2457 r0 *1 56.59,44.255 sky130_fd_pr__pfet_01v8
M$2457 807 788 711 711 sky130_fd_pr__pfet_01v8 L=0.15U W=1U AS=0.26P AD=0.105P
+ PS=2.52U PD=1.21U
* device instance $2458 r0 *1 56.95,44.255 sky130_fd_pr__pfet_01v8
M$2458 168 655 807 807 sky130_fd_pr__pfet_01v8 L=0.15U W=1U AS=0.105P AD=0.26P
+ PS=1.21U PD=2.52U
* device instance $2459 r0 *1 61.19,44.255 sky130_fd_pr__pfet_01v8
M$2459 804 573 695 695 sky130_fd_pr__pfet_01v8 L=0.15U W=1U AS=0.26P AD=0.105P
+ PS=2.52U PD=1.21U
* device instance $2460 r0 *1 61.55,44.255 sky130_fd_pr__pfet_01v8
M$2460 168 918 804 804 sky130_fd_pr__pfet_01v8 L=0.15U W=1U AS=0.105P AD=0.26P
+ PS=1.21U PD=2.52U
* device instance $2461 r0 *1 66.23,44.075 sky130_fd_pr__pfet_01v8
M$2461 800 635 776 776 sky130_fd_pr__pfet_01v8 L=0.15U W=0.64U AS=0.1664P
+ AD=0.0672P PS=1.8U PD=0.85U
* device instance $2462 r0 *1 66.59,44.075 sky130_fd_pr__pfet_01v8
M$2462 168 777 800 800 sky130_fd_pr__pfet_01v8 L=0.15U W=0.64U AS=0.0672P
+ AD=0.1664P PS=0.85U PD=1.8U
* device instance $2463 r0 *1 69.255,43.965 sky130_fd_pr__pfet_01v8
M$2463 778 775 776 776 sky130_fd_pr__pfet_01v8 L=0.15U W=0.42U AS=0.15985P
+ AD=0.06405P PS=1.265U PD=0.725U
* device instance $2464 r0 *1 69.71,43.965 sky130_fd_pr__pfet_01v8
M$2464 795 774 778 778 sky130_fd_pr__pfet_01v8 L=0.15U W=0.42U AS=0.06405P
+ AD=0.07665P PS=0.725U PD=0.785U
* device instance $2465 r0 *1 70.225,43.965 sky130_fd_pr__pfet_01v8
M$2465 168 779 795 795 sky130_fd_pr__pfet_01v8 L=0.15U W=0.42U AS=0.07665P
+ AD=0.178875P PS=0.785U PD=1.26U
* device instance $2466 r0 *1 67.53,44.075 sky130_fd_pr__pfet_01v8
M$2466 168 1102 777 777 sky130_fd_pr__pfet_01v8 L=0.15U W=0.64U AS=0.1664P
+ AD=0.0928P PS=1.8U PD=0.93U
* device instance $2467 r0 *1 67.97,44.075 sky130_fd_pr__pfet_01v8
M$2467 797 1102 168 168 sky130_fd_pr__pfet_01v8 L=0.15U W=0.64U AS=0.0928P
+ AD=0.1152P PS=0.93U PD=1U
* device instance $2468 r0 *1 68.48,44.075 sky130_fd_pr__pfet_01v8
M$2468 776 781 797 797 sky130_fd_pr__pfet_01v8 L=0.15U W=0.64U AS=0.1152P
+ AD=0.15985P PS=1U PD=1.265U
* device instance $2469 r0 *1 70.885,44.13 sky130_fd_pr__pfet_01v8
M$2469 779 778 168 168 sky130_fd_pr__pfet_01v8 L=0.15U W=0.75U AS=0.178875P
+ AD=0.195P PS=1.26U PD=2.02U
* device instance $2470 r0 *1 67.685,43.075 sky130_fd_pr__pfet_01v8
M$2470 741 703 168 168 sky130_fd_pr__pfet_01v8 L=0.15U W=0.42U AS=0.1092P
+ AD=0.06405P PS=1.36U PD=0.725U
* device instance $2471 r0 *1 68.14,43.075 sky130_fd_pr__pfet_01v8
M$2471 704 698 741 741 sky130_fd_pr__pfet_01v8 L=0.15U W=0.42U AS=0.06405P
+ AD=0.0567P PS=0.725U PD=0.69U
* device instance $2472 r0 *1 68.56,43.075 sky130_fd_pr__pfet_01v8
M$2472 739 699 704 704 sky130_fd_pr__pfet_01v8 L=0.15U W=0.42U AS=0.0567P
+ AD=0.0882P PS=0.69U PD=0.84U
* device instance $2473 r0 *1 69.13,43.075 sky130_fd_pr__pfet_01v8
M$2473 168 712 739 739 sky130_fd_pr__pfet_01v8 L=0.15U W=0.42U AS=0.0882P
+ AD=0.1113P PS=0.84U PD=1.37U
* device instance $2474 r0 *1 71.825,43.965 sky130_fd_pr__pfet_01v8
M$2474 793 779 168 168 sky130_fd_pr__pfet_01v8 L=0.15U W=0.42U AS=0.1092P
+ AD=0.06405P PS=1.36U PD=0.725U
* device instance $2475 r0 *1 72.28,43.965 sky130_fd_pr__pfet_01v8
M$2475 780 774 793 793 sky130_fd_pr__pfet_01v8 L=0.15U W=0.42U AS=0.06405P
+ AD=0.0567P PS=0.725U PD=0.69U
* device instance $2476 r0 *1 72.7,43.965 sky130_fd_pr__pfet_01v8
M$2476 790 775 780 780 sky130_fd_pr__pfet_01v8 L=0.15U W=0.42U AS=0.0567P
+ AD=0.0882P PS=0.69U PD=0.84U
* device instance $2477 r0 *1 73.27,43.965 sky130_fd_pr__pfet_01v8
M$2477 168 781 790 790 sky130_fd_pr__pfet_01v8 L=0.15U W=0.42U AS=0.0882P
+ AD=0.1113P PS=0.84U PD=1.37U
* device instance $2478 r0 *1 74.325,44.075 sky130_fd_pr__pfet_01v8
M$2478 168 780 781 781 sky130_fd_pr__pfet_01v8 L=0.15U W=0.64U AS=0.1728P
+ AD=0.154P PS=1.82U PD=1.335U
* device instance $2479 r0 *1 74.81,44.255 sky130_fd_pr__pfet_01v8
M$2479 573 780 168 168 sky130_fd_pr__pfet_01v8 L=0.15U W=1U AS=0.154P AD=0.28P
+ PS=1.335U PD=2.56U
* device instance $2480 r0 *1 7.83,48.225 sky130_fd_pr__pfet_01v8
M$2480 870 862 831 831 sky130_fd_pr__pfet_01v8 L=0.15U W=1U AS=0.26P AD=0.135P
+ PS=2.52U PD=1.27U
* device instance $2481 r0 *1 8.25,48.225 sky130_fd_pr__pfet_01v8
M$2481 871 863 870 870 sky130_fd_pr__pfet_01v8 L=0.15U W=1U AS=0.135P AD=0.135P
+ PS=1.27U PD=1.27U
* device instance $2482 r0 *1 8.67,48.225 sky130_fd_pr__pfet_01v8
M$2482 870 90 871 871 sky130_fd_pr__pfet_01v8 L=0.15U W=1U AS=0.135P AD=0.26P
+ PS=1.27U PD=2.52U
* device instance $2483 r0 *1 9.21,44.105 sky130_fd_pr__pfet_01v8
M$2483 168 936 754 754 sky130_fd_pr__pfet_01v8 L=0.15U W=0.64U AS=0.1664P
+ AD=0.0864P PS=1.8U PD=0.91U
* device instance $2484 r0 *1 9.63,44.105 sky130_fd_pr__pfet_01v8
M$2484 755 754 168 168 sky130_fd_pr__pfet_01v8 L=0.15U W=0.64U AS=0.0864P
+ AD=0.1664P PS=0.91U PD=1.8U
* device instance $2485 r0 *1 9.61,48.225 sky130_fd_pr__pfet_01v8
M$2485 871 87 168 168 sky130_fd_pr__pfet_01v8 L=0.15U W=1U AS=0.26P AD=0.165P
+ PS=2.52U PD=1.33U
* device instance $2486 r0 *1 10.09,48.225 sky130_fd_pr__pfet_01v8
M$2486 168 864 871 871 sky130_fd_pr__pfet_01v8 L=0.15U W=1U AS=0.165P
+ AD=0.1575P PS=1.33U PD=1.315U
* device instance $2487 r0 *1 10.555,48.225 sky130_fd_pr__pfet_01v8
M$2487 872 831 168 168 sky130_fd_pr__pfet_01v8 L=0.15U W=1U AS=0.1575P AD=0.26P
+ PS=1.315U PD=2.52U
* device instance $2488 r0 *1 11.51,48.225 sky130_fd_pr__pfet_01v8
M$2488 168 865 832 832 sky130_fd_pr__pfet_01v8 L=0.15U W=1U AS=0.26P AD=0.26P
+ PS=2.52U PD=2.52U
* device instance $2489 r0 *1 12.45,48.225 sky130_fd_pr__pfet_01v8
M$2489 589 832 168 168 sky130_fd_pr__pfet_01v8 L=0.15U W=4U AS=0.665P
+ AD=0.5475P PS=6.33U PD=5.095U
* device instance $2493 r0 *1 14.145,48.225 sky130_fd_pr__pfet_01v8
M$2493 589 834 168 168 sky130_fd_pr__pfet_01v8 L=0.15U W=4U AS=0.5475P
+ AD=0.795P PS=5.095U PD=6.59U
* device instance $2497 r0 *1 25.77,48.375 sky130_fd_pr__pfet_01v8
M$2497 168 936 835 835 sky130_fd_pr__pfet_01v8 L=0.15U W=0.64U AS=0.1664P
+ AD=0.0864P PS=1.8U PD=0.91U
* device instance $2498 r0 *1 26.19,48.375 sky130_fd_pr__pfet_01v8
M$2498 836 835 168 168 sky130_fd_pr__pfet_01v8 L=0.15U W=0.64U AS=0.0864P
+ AD=0.1664P PS=0.91U PD=1.8U
* device instance $2499 r0 *1 27.13,48.405 sky130_fd_pr__pfet_01v8
M$2499 883 640 837 837 sky130_fd_pr__pfet_01v8 L=0.15U W=0.64U AS=0.1664P
+ AD=0.0672P PS=1.8U PD=0.85U
* device instance $2500 r0 *1 27.49,48.405 sky130_fd_pr__pfet_01v8
M$2500 168 838 883 883 sky130_fd_pr__pfet_01v8 L=0.15U W=0.64U AS=0.0672P
+ AD=0.1664P PS=0.85U PD=1.8U
* device instance $2501 r0 *1 28.43,48.405 sky130_fd_pr__pfet_01v8
M$2501 168 16 838 838 sky130_fd_pr__pfet_01v8 L=0.15U W=0.64U AS=0.1664P
+ AD=0.0928P PS=1.8U PD=0.93U
* device instance $2502 r0 *1 28.87,48.405 sky130_fd_pr__pfet_01v8
M$2502 882 16 168 168 sky130_fd_pr__pfet_01v8 L=0.15U W=0.64U AS=0.0928P
+ AD=0.1152P PS=0.93U PD=1U
* device instance $2503 r0 *1 29.38,48.405 sky130_fd_pr__pfet_01v8
M$2503 837 866 882 882 sky130_fd_pr__pfet_01v8 L=0.15U W=0.64U AS=0.1152P
+ AD=0.15985P PS=1U PD=1.265U
* device instance $2504 r0 *1 30.155,48.515 sky130_fd_pr__pfet_01v8
M$2504 839 836 837 837 sky130_fd_pr__pfet_01v8 L=0.15U W=0.42U AS=0.15985P
+ AD=0.06405P PS=1.265U PD=0.725U
* device instance $2505 r0 *1 30.61,48.515 sky130_fd_pr__pfet_01v8
M$2505 881 835 839 839 sky130_fd_pr__pfet_01v8 L=0.15U W=0.42U AS=0.06405P
+ AD=0.07665P PS=0.725U PD=0.785U
* device instance $2506 r0 *1 31.125,48.515 sky130_fd_pr__pfet_01v8
M$2506 881 840 168 168 sky130_fd_pr__pfet_01v8 L=0.15U W=0.42U AS=0.178875P
+ AD=0.07665P PS=1.26U PD=0.785U
* device instance $2507 r0 *1 31.785,48.35 sky130_fd_pr__pfet_01v8
M$2507 840 839 168 168 sky130_fd_pr__pfet_01v8 L=0.15U W=0.75U AS=0.178875P
+ AD=0.195P PS=1.26U PD=2.02U
* device instance $2508 r0 *1 32.725,48.515 sky130_fd_pr__pfet_01v8
M$2508 880 840 168 168 sky130_fd_pr__pfet_01v8 L=0.15U W=0.42U AS=0.1092P
+ AD=0.06405P PS=1.36U PD=0.725U
* device instance $2509 r0 *1 33.18,48.515 sky130_fd_pr__pfet_01v8
M$2509 841 835 880 880 sky130_fd_pr__pfet_01v8 L=0.15U W=0.42U AS=0.06405P
+ AD=0.0567P PS=0.725U PD=0.69U
* device instance $2510 r0 *1 33.6,48.515 sky130_fd_pr__pfet_01v8
M$2510 879 836 841 841 sky130_fd_pr__pfet_01v8 L=0.15U W=0.42U AS=0.0567P
+ AD=0.0882P PS=0.69U PD=0.84U
* device instance $2511 r0 *1 34.17,48.515 sky130_fd_pr__pfet_01v8
M$2511 168 866 879 879 sky130_fd_pr__pfet_01v8 L=0.15U W=0.42U AS=0.0882P
+ AD=0.1113P PS=0.84U PD=1.37U
* device instance $2512 r0 *1 33.59,44.105 sky130_fd_pr__pfet_01v8
M$2512 168 936 763 763 sky130_fd_pr__pfet_01v8 L=0.15U W=0.64U AS=0.1664P
+ AD=0.0864P PS=1.8U PD=0.91U
* device instance $2513 r0 *1 34.01,44.105 sky130_fd_pr__pfet_01v8
M$2513 764 763 168 168 sky130_fd_pr__pfet_01v8 L=0.15U W=0.64U AS=0.0864P
+ AD=0.1664P PS=0.91U PD=1.8U
* device instance $2514 r0 *1 35.225,48.405 sky130_fd_pr__pfet_01v8
M$2514 866 841 168 168 sky130_fd_pr__pfet_01v8 L=0.15U W=0.64U AS=0.154P
+ AD=0.1728P PS=1.335U PD=1.82U
* device instance $2515 r0 *1 35.71,48.225 sky130_fd_pr__pfet_01v8
M$2515 602 841 168 168 sky130_fd_pr__pfet_01v8 L=0.15U W=1U AS=0.154P AD=0.28P
+ PS=1.335U PD=2.56U
* device instance $2516 r0 *1 41.005,48.405 sky130_fd_pr__pfet_01v8
M$2516 878 773 168 168 sky130_fd_pr__pfet_01v8 L=0.15U W=0.64U AS=0.1696P
+ AD=0.0768P PS=1.81U PD=0.88U
* device instance $2517 r0 *1 41.395,48.405 sky130_fd_pr__pfet_01v8
M$2517 783 71 878 878 sky130_fd_pr__pfet_01v8 L=0.15U W=0.64U AS=0.0768P
+ AD=0.0896P PS=0.88U PD=0.92U
* device instance $2518 r0 *1 41.825,48.405 sky130_fd_pr__pfet_01v8
M$2518 168 1242 783 783 sky130_fd_pr__pfet_01v8 L=0.15U W=0.64U AS=0.0896P
+ AD=0.1824P PS=0.92U PD=1.85U
* device instance $2519 r0 *1 44.63,48.375 sky130_fd_pr__pfet_01v8
M$2519 168 996 843 843 sky130_fd_pr__pfet_01v8 L=0.15U W=0.64U AS=0.1664P
+ AD=0.0864P PS=1.8U PD=0.91U
* device instance $2520 r0 *1 45.05,48.375 sky130_fd_pr__pfet_01v8
M$2520 844 843 168 168 sky130_fd_pr__pfet_01v8 L=0.15U W=0.64U AS=0.0864P
+ AD=0.1664P PS=0.91U PD=1.8U
* device instance $2521 r0 *1 45.99,48.405 sky130_fd_pr__pfet_01v8
M$2521 877 811 845 845 sky130_fd_pr__pfet_01v8 L=0.15U W=0.64U AS=0.1664P
+ AD=0.0672P PS=1.8U PD=0.85U
* device instance $2522 r0 *1 46.35,48.405 sky130_fd_pr__pfet_01v8
M$2522 168 846 877 877 sky130_fd_pr__pfet_01v8 L=0.15U W=0.64U AS=0.0672P
+ AD=0.1664P PS=0.85U PD=1.8U
* device instance $2523 r0 *1 47.29,48.405 sky130_fd_pr__pfet_01v8
M$2523 168 16 846 846 sky130_fd_pr__pfet_01v8 L=0.15U W=0.64U AS=0.1664P
+ AD=0.0928P PS=1.8U PD=0.93U
* device instance $2524 r0 *1 47.73,48.405 sky130_fd_pr__pfet_01v8
M$2524 876 16 168 168 sky130_fd_pr__pfet_01v8 L=0.15U W=0.64U AS=0.0928P
+ AD=0.1152P PS=0.93U PD=1U
* device instance $2525 r0 *1 48.24,48.405 sky130_fd_pr__pfet_01v8
M$2525 845 867 876 876 sky130_fd_pr__pfet_01v8 L=0.15U W=0.64U AS=0.1152P
+ AD=0.15985P PS=1U PD=1.265U
* device instance $2526 r0 *1 49.015,48.515 sky130_fd_pr__pfet_01v8
M$2526 847 844 845 845 sky130_fd_pr__pfet_01v8 L=0.15U W=0.42U AS=0.15985P
+ AD=0.06405P PS=1.265U PD=0.725U
* device instance $2527 r0 *1 49.47,48.515 sky130_fd_pr__pfet_01v8
M$2527 875 843 847 847 sky130_fd_pr__pfet_01v8 L=0.15U W=0.42U AS=0.06405P
+ AD=0.07665P PS=0.725U PD=0.785U
* device instance $2528 r0 *1 49.985,48.515 sky130_fd_pr__pfet_01v8
M$2528 875 848 168 168 sky130_fd_pr__pfet_01v8 L=0.15U W=0.42U AS=0.178875P
+ AD=0.07665P PS=1.26U PD=0.785U
* device instance $2529 r0 *1 50.645,48.35 sky130_fd_pr__pfet_01v8
M$2529 848 847 168 168 sky130_fd_pr__pfet_01v8 L=0.15U W=0.75U AS=0.178875P
+ AD=0.195P PS=1.26U PD=2.02U
* device instance $2530 r0 *1 51.585,48.515 sky130_fd_pr__pfet_01v8
M$2530 874 848 168 168 sky130_fd_pr__pfet_01v8 L=0.15U W=0.42U AS=0.1092P
+ AD=0.06405P PS=1.36U PD=0.725U
* device instance $2531 r0 *1 52.04,48.515 sky130_fd_pr__pfet_01v8
M$2531 849 843 874 874 sky130_fd_pr__pfet_01v8 L=0.15U W=0.42U AS=0.06405P
+ AD=0.0567P PS=0.725U PD=0.69U
* device instance $2532 r0 *1 52.46,48.515 sky130_fd_pr__pfet_01v8
M$2532 873 844 849 849 sky130_fd_pr__pfet_01v8 L=0.15U W=0.42U AS=0.0567P
+ AD=0.0882P PS=0.69U PD=0.84U
* device instance $2533 r0 *1 53.03,48.515 sky130_fd_pr__pfet_01v8
M$2533 168 867 873 873 sky130_fd_pr__pfet_01v8 L=0.15U W=0.42U AS=0.0882P
+ AD=0.1113P PS=0.84U PD=1.37U
* device instance $2534 r0 *1 54.085,48.405 sky130_fd_pr__pfet_01v8
M$2534 867 849 168 168 sky130_fd_pr__pfet_01v8 L=0.15U W=0.64U AS=0.154P
+ AD=0.1728P PS=1.335U PD=1.82U
* device instance $2535 r0 *1 54.57,48.225 sky130_fd_pr__pfet_01v8
M$2535 786 849 168 168 sky130_fd_pr__pfet_01v8 L=0.15U W=1U AS=0.154P AD=0.28P
+ PS=1.335U PD=2.56U
* device instance $2536 r0 *1 61.65,48.225 sky130_fd_pr__pfet_01v8
M$2536 168 643 850 850 sky130_fd_pr__pfet_01v8 L=0.15U W=1U AS=0.26P AD=0.135P
+ PS=2.52U PD=1.27U
* device instance $2537 r0 *1 62.07,48.225 sky130_fd_pr__pfet_01v8
M$2537 851 850 168 168 sky130_fd_pr__pfet_01v8 L=0.15U W=4U AS=0.54P AD=0.665P
+ PS=5.08U PD=6.33U
* device instance $2541 r0 *1 64.87,44.105 sky130_fd_pr__pfet_01v8
M$2541 168 996 774 774 sky130_fd_pr__pfet_01v8 L=0.15U W=0.64U AS=0.1664P
+ AD=0.0864P PS=1.8U PD=0.91U
* device instance $2542 r0 *1 65.29,44.105 sky130_fd_pr__pfet_01v8
M$2542 775 774 168 168 sky130_fd_pr__pfet_01v8 L=0.15U W=0.64U AS=0.0864P
+ AD=0.1664P PS=0.91U PD=1.8U
* device instance $2543 r0 *1 4.68,49.405 sky130_fd_pr__pfet_01v8
M$2543 884 906 168 168 sky130_fd_pr__pfet_01v8 L=0.15U W=0.42U AS=0.1113P
+ AD=0.0609P PS=1.37U PD=0.71U
* device instance $2544 r0 *1 5.12,49.405 sky130_fd_pr__pfet_01v8
M$2544 168 109 884 884 sky130_fd_pr__pfet_01v8 L=0.15U W=0.42U AS=0.0609P
+ AD=0.1841P PS=0.71U PD=1.26U
* device instance $2545 r0 *1 5.89,49.515 sky130_fd_pr__pfet_01v8
M$2545 862 884 168 168 sky130_fd_pr__pfet_01v8 L=0.15U W=0.64U AS=0.1841P
+ AD=0.1696P PS=1.26U PD=1.81U
* device instance $2546 r0 *1 7.455,49.6 sky130_fd_pr__pfet_01v8
M$2546 909 71 168 168 sky130_fd_pr__pfet_01v8 L=0.15U W=0.42U AS=0.15835P
+ AD=0.07665P PS=1.395U PD=0.785U
* device instance $2547 r0 *1 7.97,49.6 sky130_fd_pr__pfet_01v8
M$2547 886 915 909 909 sky130_fd_pr__pfet_01v8 L=0.15U W=0.42U AS=0.07665P
+ AD=0.1932P PS=0.785U PD=1.34U
* device instance $2548 r0 *1 9.04,49.6 sky130_fd_pr__pfet_01v8
M$2548 910 914 886 886 sky130_fd_pr__pfet_01v8 L=0.15U W=0.42U AS=0.1932P
+ AD=0.0441P PS=1.34U PD=0.63U
* device instance $2549 r0 *1 9.4,49.6 sky130_fd_pr__pfet_01v8
M$2549 168 916 910 910 sky130_fd_pr__pfet_01v8 L=0.15U W=0.42U AS=0.0441P
+ AD=0.0693P PS=0.63U PD=0.75U
* device instance $2550 r0 *1 9.88,49.6 sky130_fd_pr__pfet_01v8
M$2550 916 71 168 168 sky130_fd_pr__pfet_01v8 L=0.15U W=0.42U AS=0.0693P
+ AD=0.1176P PS=0.75U PD=1.4U
* device instance $2551 r0 *1 6.91,49.695 sky130_fd_pr__pfet_01v8
M$2551 168 886 885 885 sky130_fd_pr__pfet_01v8 L=0.15U W=1U AS=0.26P
+ AD=0.15835P PS=2.52U PD=1.395U
* device instance $2552 r0 *1 11.09,49.695 sky130_fd_pr__pfet_01v8
M$2552 911 863 887 887 sky130_fd_pr__pfet_01v8 L=0.15U W=1U AS=0.26P AD=0.135P
+ PS=2.52U PD=1.27U
* device instance $2553 r0 *1 11.51,49.695 sky130_fd_pr__pfet_01v8
M$2553 168 915 911 911 sky130_fd_pr__pfet_01v8 L=0.15U W=1U AS=0.135P AD=0.135P
+ PS=1.27U PD=1.27U
* device instance $2554 r0 *1 11.93,49.695 sky130_fd_pr__pfet_01v8
M$2554 888 915 168 168 sky130_fd_pr__pfet_01v8 L=0.15U W=1U AS=0.135P AD=0.135P
+ PS=1.27U PD=1.27U
* device instance $2555 r0 *1 12.35,49.695 sky130_fd_pr__pfet_01v8
M$2555 168 863 888 888 sky130_fd_pr__pfet_01v8 L=0.15U W=1U AS=0.135P AD=0.26P
+ PS=1.27U PD=2.52U
* device instance $2556 r0 *1 12.225,53.845 sky130_fd_pr__pfet_01v8
M$2556 944 934 168 168 sky130_fd_pr__pfet_01v8 L=0.15U W=0.64U AS=0.154P
+ AD=0.1728P PS=1.335U PD=1.82U
* device instance $2557 r0 *1 12.71,53.665 sky130_fd_pr__pfet_01v8
M$2557 834 934 168 168 sky130_fd_pr__pfet_01v8 L=0.15U W=1U AS=0.154P AD=0.28P
+ PS=1.335U PD=2.56U
* device instance $2558 r0 *1 13.29,49.695 sky130_fd_pr__pfet_01v8
M$2558 864 887 888 888 sky130_fd_pr__pfet_01v8 L=0.15U W=1U AS=0.26P AD=0.3P
+ PS=2.52U PD=2.6U
* device instance $2559 r0 *1 13.81,53.665 sky130_fd_pr__pfet_01v8
M$2559 168 865 945 945 sky130_fd_pr__pfet_01v8 L=0.15U W=1U AS=0.26P AD=0.135P
+ PS=2.52U PD=1.27U
* device instance $2560 r0 *1 14.23,53.665 sky130_fd_pr__pfet_01v8
M$2560 915 945 168 168 sky130_fd_pr__pfet_01v8 L=0.15U W=4U AS=0.54P AD=0.665P
+ PS=5.08U PD=6.33U
* device instance $2564 r0 *1 17.03,53.665 sky130_fd_pr__pfet_01v8
M$2564 168 834 946 946 sky130_fd_pr__pfet_01v8 L=0.15U W=1U AS=0.26P AD=0.135P
+ PS=2.52U PD=1.27U
* device instance $2565 r0 *1 17.45,53.665 sky130_fd_pr__pfet_01v8
M$2565 863 946 168 168 sky130_fd_pr__pfet_01v8 L=0.15U W=4U AS=0.54P AD=0.795P
+ PS=5.08U PD=5.59U
* device instance $2569 r0 *1 19.64,53.665 sky130_fd_pr__pfet_01v8
M$2569 936 935 168 168 sky130_fd_pr__pfet_01v8 L=0.15U W=16U AS=2.4875P
+ AD=2.2375P PS=20.975U PD=20.475U
* device instance $2585 r0 *1 26.515,53.665 sky130_fd_pr__pfet_01v8
M$2585 935 311 168 168 sky130_fd_pr__pfet_01v8 L=0.15U W=4U AS=0.56P AD=0.685P
+ PS=5.12U PD=6.37U
* device instance $2589 r0 *1 21.19,49.695 sky130_fd_pr__pfet_01v8
M$2589 168 863 889 889 sky130_fd_pr__pfet_01v8 L=0.15U W=4U AS=0.685P AD=0.54P
+ PS=6.37U PD=5.08U
* device instance $2593 r0 *1 22.87,49.695 sky130_fd_pr__pfet_01v8
M$2593 891 890 889 889 sky130_fd_pr__pfet_01v8 L=0.15U W=4U AS=0.54P AD=0.665P
+ PS=5.08U PD=6.33U
* device instance $2597 r0 *1 25.07,49.695 sky130_fd_pr__pfet_01v8
M$2597 891 893 892 892 sky130_fd_pr__pfet_01v8 L=0.15U W=4U AS=0.665P AD=0.54P
+ PS=6.33U PD=5.08U
* device instance $2601 r0 *1 26.75,49.695 sky130_fd_pr__pfet_01v8
M$2601 917 406 892 892 sky130_fd_pr__pfet_01v8 L=0.15U W=4U AS=0.54P AD=0.665P
+ PS=5.08U PD=6.33U
* device instance $2605 r0 *1 43.32,49.405 sky130_fd_pr__pfet_01v8
M$2605 894 907 168 168 sky130_fd_pr__pfet_01v8 L=0.15U W=0.42U AS=0.1113P
+ AD=0.0609P PS=1.37U PD=0.71U
* device instance $2606 r0 *1 43.76,49.405 sky130_fd_pr__pfet_01v8
M$2606 168 109 894 894 sky130_fd_pr__pfet_01v8 L=0.15U W=0.42U AS=0.0609P
+ AD=0.1841P PS=0.71U PD=1.26U
* device instance $2607 r0 *1 44.53,49.515 sky130_fd_pr__pfet_01v8
M$2607 784 894 168 168 sky130_fd_pr__pfet_01v8 L=0.15U W=0.64U AS=0.1841P
+ AD=0.1696P PS=1.26U PD=1.81U
* device instance $2608 r0 *1 56.13,53.665 sky130_fd_pr__pfet_01v8
M$2608 963 947 937 937 sky130_fd_pr__pfet_01v8 L=0.15U W=1U AS=0.26P AD=0.135P
+ PS=2.52U PD=1.27U
* device instance $2609 r0 *1 56.55,53.665 sky130_fd_pr__pfet_01v8
M$2609 964 788 963 963 sky130_fd_pr__pfet_01v8 L=0.15U W=1U AS=0.135P AD=0.135P
+ PS=1.27U PD=1.27U
* device instance $2610 r0 *1 56.97,53.665 sky130_fd_pr__pfet_01v8
M$2610 168 978 964 964 sky130_fd_pr__pfet_01v8 L=0.15U W=1U AS=0.135P AD=0.4P
+ PS=1.27U PD=1.8U
* device instance $2611 r0 *1 57.92,53.665 sky130_fd_pr__pfet_01v8
M$2611 938 937 168 168 sky130_fd_pr__pfet_01v8 L=0.15U W=4U AS=0.805P AD=0.87P
+ PS=5.61U PD=5.74U
* device instance $2615 r0 *1 60.26,53.665 sky130_fd_pr__pfet_01v8
M$2615 947 939 168 168 sky130_fd_pr__pfet_01v8 L=0.15U W=4U AS=0.87P AD=0.54P
+ PS=5.74U PD=5.08U
* device instance $2619 r0 *1 61.94,53.665 sky130_fd_pr__pfet_01v8
M$2619 939 851 168 168 sky130_fd_pr__pfet_01v8 L=0.15U W=1U AS=0.135P AD=0.26P
+ PS=1.27U PD=2.52U
* device instance $2620 r0 *1 64.87,49.545 sky130_fd_pr__pfet_01v8
M$2620 168 996 895 895 sky130_fd_pr__pfet_01v8 L=0.15U W=0.64U AS=0.1664P
+ AD=0.0864P PS=1.8U PD=0.91U
* device instance $2621 r0 *1 65.29,49.545 sky130_fd_pr__pfet_01v8
M$2621 896 895 168 168 sky130_fd_pr__pfet_01v8 L=0.15U W=0.64U AS=0.0864P
+ AD=0.1664P PS=0.91U PD=1.8U
* device instance $2622 r0 *1 66.23,49.515 sky130_fd_pr__pfet_01v8
M$2622 913 908 897 897 sky130_fd_pr__pfet_01v8 L=0.15U W=0.64U AS=0.1664P
+ AD=0.0672P PS=1.8U PD=0.85U
* device instance $2623 r0 *1 66.59,49.515 sky130_fd_pr__pfet_01v8
M$2623 168 898 913 913 sky130_fd_pr__pfet_01v8 L=0.15U W=0.64U AS=0.0672P
+ AD=0.1664P PS=0.85U PD=1.8U
* device instance $2624 r0 *1 69.255,49.405 sky130_fd_pr__pfet_01v8
M$2624 899 896 897 897 sky130_fd_pr__pfet_01v8 L=0.15U W=0.42U AS=0.15985P
+ AD=0.06405P PS=1.265U PD=0.725U
* device instance $2625 r0 *1 69.71,49.405 sky130_fd_pr__pfet_01v8
M$2625 905 895 899 899 sky130_fd_pr__pfet_01v8 L=0.15U W=0.42U AS=0.06405P
+ AD=0.07665P PS=0.725U PD=0.785U
* device instance $2626 r0 *1 70.225,49.405 sky130_fd_pr__pfet_01v8
M$2626 168 900 905 905 sky130_fd_pr__pfet_01v8 L=0.15U W=0.42U AS=0.07665P
+ AD=0.178875P PS=0.785U PD=1.26U
* device instance $2627 r0 *1 67.53,49.515 sky130_fd_pr__pfet_01v8
M$2627 168 1102 898 898 sky130_fd_pr__pfet_01v8 L=0.15U W=0.64U AS=0.1664P
+ AD=0.0928P PS=1.8U PD=0.93U
* device instance $2628 r0 *1 67.97,49.515 sky130_fd_pr__pfet_01v8
M$2628 912 1102 168 168 sky130_fd_pr__pfet_01v8 L=0.15U W=0.64U AS=0.0928P
+ AD=0.1152P PS=0.93U PD=1U
* device instance $2629 r0 *1 68.48,49.515 sky130_fd_pr__pfet_01v8
M$2629 897 902 912 912 sky130_fd_pr__pfet_01v8 L=0.15U W=0.64U AS=0.1152P
+ AD=0.15985P PS=1U PD=1.265U
* device instance $2630 r0 *1 70.885,49.57 sky130_fd_pr__pfet_01v8
M$2630 900 899 168 168 sky130_fd_pr__pfet_01v8 L=0.15U W=0.75U AS=0.178875P
+ AD=0.195P PS=1.26U PD=2.02U
* device instance $2631 r0 *1 68.175,53.76 sky130_fd_pr__pfet_01v8
M$2631 960 71 168 168 sky130_fd_pr__pfet_01v8 L=0.15U W=0.42U AS=0.15835P
+ AD=0.07665P PS=1.395U PD=0.785U
* device instance $2632 r0 *1 68.69,53.76 sky130_fd_pr__pfet_01v8
M$2632 940 948 960 960 sky130_fd_pr__pfet_01v8 L=0.15U W=0.42U AS=0.07665P
+ AD=0.1932P PS=0.785U PD=1.34U
* device instance $2633 r0 *1 69.76,53.76 sky130_fd_pr__pfet_01v8
M$2633 957 941 940 940 sky130_fd_pr__pfet_01v8 L=0.15U W=0.42U AS=0.1932P
+ AD=0.0441P PS=1.34U PD=0.63U
* device instance $2634 r0 *1 70.12,53.76 sky130_fd_pr__pfet_01v8
M$2634 168 942 957 957 sky130_fd_pr__pfet_01v8 L=0.15U W=0.42U AS=0.0441P
+ AD=0.0693P PS=0.63U PD=0.75U
* device instance $2635 r0 *1 70.6,53.76 sky130_fd_pr__pfet_01v8
M$2635 942 71 168 168 sky130_fd_pr__pfet_01v8 L=0.15U W=0.42U AS=0.0693P
+ AD=0.1176P PS=0.75U PD=1.4U
* device instance $2636 r0 *1 67.63,53.665 sky130_fd_pr__pfet_01v8
M$2636 168 940 908 908 sky130_fd_pr__pfet_01v8 L=0.15U W=1U AS=0.26P
+ AD=0.15835P PS=2.52U PD=1.395U
* device instance $2637 r0 *1 71.825,49.405 sky130_fd_pr__pfet_01v8
M$2637 904 900 168 168 sky130_fd_pr__pfet_01v8 L=0.15U W=0.42U AS=0.1092P
+ AD=0.06405P PS=1.36U PD=0.725U
* device instance $2638 r0 *1 72.28,49.405 sky130_fd_pr__pfet_01v8
M$2638 901 895 904 904 sky130_fd_pr__pfet_01v8 L=0.15U W=0.42U AS=0.06405P
+ AD=0.0567P PS=0.725U PD=0.69U
* device instance $2639 r0 *1 72.7,49.405 sky130_fd_pr__pfet_01v8
M$2639 903 896 901 901 sky130_fd_pr__pfet_01v8 L=0.15U W=0.42U AS=0.0567P
+ AD=0.0882P PS=0.69U PD=0.84U
* device instance $2640 r0 *1 73.27,49.405 sky130_fd_pr__pfet_01v8
M$2640 168 902 903 903 sky130_fd_pr__pfet_01v8 L=0.15U W=0.42U AS=0.0882P
+ AD=0.1113P PS=0.84U PD=1.37U
* device instance $2641 r0 *1 74.325,49.515 sky130_fd_pr__pfet_01v8
M$2641 168 901 902 902 sky130_fd_pr__pfet_01v8 L=0.15U W=0.64U AS=0.1728P
+ AD=0.154P PS=1.82U PD=1.335U
* device instance $2642 r0 *1 74.81,49.695 sky130_fd_pr__pfet_01v8
M$2642 918 901 168 168 sky130_fd_pr__pfet_01v8 L=0.15U W=1U AS=0.154P AD=0.28P
+ PS=1.335U PD=2.56U
* device instance $2643 r0 *1 2.77,53.815 sky130_fd_pr__pfet_01v8
M$2643 168 936 929 929 sky130_fd_pr__pfet_01v8 L=0.15U W=0.64U AS=0.1664P
+ AD=0.0864P PS=1.8U PD=0.91U
* device instance $2644 r0 *1 3.19,53.815 sky130_fd_pr__pfet_01v8
M$2644 930 929 168 168 sky130_fd_pr__pfet_01v8 L=0.15U W=0.64U AS=0.0864P
+ AD=0.1664P PS=0.91U PD=1.8U
* device instance $2645 r0 *1 4.13,53.845 sky130_fd_pr__pfet_01v8
M$2645 956 885 931 931 sky130_fd_pr__pfet_01v8 L=0.15U W=0.64U AS=0.1664P
+ AD=0.0672P PS=1.8U PD=0.85U
* device instance $2646 r0 *1 4.49,53.845 sky130_fd_pr__pfet_01v8
M$2646 168 943 956 956 sky130_fd_pr__pfet_01v8 L=0.15U W=0.64U AS=0.0672P
+ AD=0.1664P PS=0.85U PD=1.8U
* device instance $2647 r0 *1 5.43,53.845 sky130_fd_pr__pfet_01v8
M$2647 168 93 943 943 sky130_fd_pr__pfet_01v8 L=0.15U W=0.64U AS=0.1664P
+ AD=0.0928P PS=1.8U PD=0.93U
* device instance $2648 r0 *1 5.87,53.845 sky130_fd_pr__pfet_01v8
M$2648 958 93 168 168 sky130_fd_pr__pfet_01v8 L=0.15U W=0.64U AS=0.0928P
+ AD=0.1152P PS=0.93U PD=1U
* device instance $2649 r0 *1 6.38,53.845 sky130_fd_pr__pfet_01v8
M$2649 931 944 958 958 sky130_fd_pr__pfet_01v8 L=0.15U W=0.64U AS=0.1152P
+ AD=0.15985P PS=1U PD=1.265U
* device instance $2650 r0 *1 7.155,53.955 sky130_fd_pr__pfet_01v8
M$2650 932 930 931 931 sky130_fd_pr__pfet_01v8 L=0.15U W=0.42U AS=0.15985P
+ AD=0.06405P PS=1.265U PD=0.725U
* device instance $2651 r0 *1 7.61,53.955 sky130_fd_pr__pfet_01v8
M$2651 959 929 932 932 sky130_fd_pr__pfet_01v8 L=0.15U W=0.42U AS=0.06405P
+ AD=0.07665P PS=0.725U PD=0.785U
* device instance $2652 r0 *1 8.125,53.955 sky130_fd_pr__pfet_01v8
M$2652 959 933 168 168 sky130_fd_pr__pfet_01v8 L=0.15U W=0.42U AS=0.178875P
+ AD=0.07665P PS=1.26U PD=0.785U
* device instance $2653 r0 *1 8.785,53.79 sky130_fd_pr__pfet_01v8
M$2653 933 932 168 168 sky130_fd_pr__pfet_01v8 L=0.15U W=0.75U AS=0.178875P
+ AD=0.195P PS=1.26U PD=2.02U
* device instance $2654 r0 *1 9.725,53.955 sky130_fd_pr__pfet_01v8
M$2654 961 933 168 168 sky130_fd_pr__pfet_01v8 L=0.15U W=0.42U AS=0.1092P
+ AD=0.06405P PS=1.36U PD=0.725U
* device instance $2655 r0 *1 10.18,53.955 sky130_fd_pr__pfet_01v8
M$2655 934 929 961 961 sky130_fd_pr__pfet_01v8 L=0.15U W=0.42U AS=0.06405P
+ AD=0.0567P PS=0.725U PD=0.69U
* device instance $2656 r0 *1 10.6,53.955 sky130_fd_pr__pfet_01v8
M$2656 962 930 934 934 sky130_fd_pr__pfet_01v8 L=0.15U W=0.42U AS=0.0567P
+ AD=0.0882P PS=0.69U PD=0.84U
* device instance $2657 r0 *1 11.17,53.955 sky130_fd_pr__pfet_01v8
M$2657 168 944 962 962 sky130_fd_pr__pfet_01v8 L=0.15U W=0.42U AS=0.0882P
+ AD=0.1113P PS=0.84U PD=1.37U
* device instance $2658 r0 *1 10.57,54.955 sky130_fd_pr__pfet_01v8
M$2658 986 872 967 967 sky130_fd_pr__pfet_01v8 L=0.15U W=0.64U AS=0.1664P
+ AD=0.0672P PS=1.8U PD=0.85U
* device instance $2659 r0 *1 10.93,54.955 sky130_fd_pr__pfet_01v8
M$2659 168 968 986 986 sky130_fd_pr__pfet_01v8 L=0.15U W=0.64U AS=0.0672P
+ AD=0.1664P PS=0.85U PD=1.8U
* device instance $2660 r0 *1 13.595,54.845 sky130_fd_pr__pfet_01v8
M$2660 969 966 967 967 sky130_fd_pr__pfet_01v8 L=0.15U W=0.42U AS=0.15985P
+ AD=0.06405P PS=1.265U PD=0.725U
* device instance $2661 r0 *1 14.05,54.845 sky130_fd_pr__pfet_01v8
M$2661 989 965 969 969 sky130_fd_pr__pfet_01v8 L=0.15U W=0.42U AS=0.06405P
+ AD=0.07665P PS=0.725U PD=0.785U
* device instance $2662 r0 *1 14.565,54.845 sky130_fd_pr__pfet_01v8
M$2662 168 970 989 989 sky130_fd_pr__pfet_01v8 L=0.15U W=0.42U AS=0.07665P
+ AD=0.178875P PS=0.785U PD=1.26U
* device instance $2663 r0 *1 11.87,54.955 sky130_fd_pr__pfet_01v8
M$2663 168 16 968 968 sky130_fd_pr__pfet_01v8 L=0.15U W=0.64U AS=0.1664P
+ AD=0.0928P PS=1.8U PD=0.93U
* device instance $2664 r0 *1 12.31,54.955 sky130_fd_pr__pfet_01v8
M$2664 987 16 168 168 sky130_fd_pr__pfet_01v8 L=0.15U W=0.64U AS=0.0928P
+ AD=0.1152P PS=0.93U PD=1U
* device instance $2665 r0 *1 12.82,54.955 sky130_fd_pr__pfet_01v8
M$2665 967 972 987 987 sky130_fd_pr__pfet_01v8 L=0.15U W=0.64U AS=0.1152P
+ AD=0.15985P PS=1U PD=1.265U
* device instance $2666 r0 *1 15.225,55.01 sky130_fd_pr__pfet_01v8
M$2666 970 969 168 168 sky130_fd_pr__pfet_01v8 L=0.15U W=0.75U AS=0.178875P
+ AD=0.195P PS=1.26U PD=2.02U
* device instance $2667 r0 *1 16.165,54.845 sky130_fd_pr__pfet_01v8
M$2667 990 970 168 168 sky130_fd_pr__pfet_01v8 L=0.15U W=0.42U AS=0.1092P
+ AD=0.06405P PS=1.36U PD=0.725U
* device instance $2668 r0 *1 16.62,54.845 sky130_fd_pr__pfet_01v8
M$2668 971 965 990 990 sky130_fd_pr__pfet_01v8 L=0.15U W=0.42U AS=0.06405P
+ AD=0.0567P PS=0.725U PD=0.69U
* device instance $2669 r0 *1 17.04,54.845 sky130_fd_pr__pfet_01v8
M$2669 991 966 971 971 sky130_fd_pr__pfet_01v8 L=0.15U W=0.42U AS=0.0567P
+ AD=0.0882P PS=0.69U PD=0.84U
* device instance $2670 r0 *1 17.61,54.845 sky130_fd_pr__pfet_01v8
M$2670 168 972 991 991 sky130_fd_pr__pfet_01v8 L=0.15U W=0.42U AS=0.0882P
+ AD=0.1113P PS=0.84U PD=1.37U
* device instance $2671 r0 *1 18.665,54.955 sky130_fd_pr__pfet_01v8
M$2671 168 971 972 972 sky130_fd_pr__pfet_01v8 L=0.15U W=0.64U AS=0.1728P
+ AD=0.154P PS=1.82U PD=1.335U
* device instance $2672 r0 *1 19.15,55.135 sky130_fd_pr__pfet_01v8
M$2672 865 971 168 168 sky130_fd_pr__pfet_01v8 L=0.15U W=1U AS=0.154P AD=0.28P
+ PS=1.335U PD=2.56U
* device instance $2673 r0 *1 28.31,55.425 sky130_fd_pr__pfet_01v8
M$2673 983 890 168 168 sky130_fd_pr__pfet_01v8 L=0.15U W=0.42U AS=0.1573P
+ AD=0.1092P PS=1.39U PD=1.36U
* device instance $2674 r0 *1 28.85,55.135 sky130_fd_pr__pfet_01v8
M$2674 992 995 168 168 sky130_fd_pr__pfet_01v8 L=0.15U W=1U AS=0.1573P
+ AD=0.105P PS=1.39U PD=1.21U
* device instance $2675 r0 *1 29.21,55.135 sky130_fd_pr__pfet_01v8
M$2675 994 983 992 992 sky130_fd_pr__pfet_01v8 L=0.15U W=1U AS=0.105P AD=0.26P
+ PS=1.21U PD=2.52U
* device instance $2676 r0 *1 30.85,55.135 sky130_fd_pr__pfet_01v8
M$2676 168 984 973 973 sky130_fd_pr__pfet_01v8 L=0.15U W=4U AS=0.685P AD=0.54P
+ PS=6.37U PD=5.08U
* device instance $2680 r0 *1 32.53,55.135 sky130_fd_pr__pfet_01v8
M$2680 974 109 973 973 sky130_fd_pr__pfet_01v8 L=0.15U W=4U AS=0.54P AD=0.665P
+ PS=5.08U PD=6.33U
* device instance $2683 r0 *1 33.79,55.135 sky130_fd_pr__pfet_01v8
M$2683 997 994 974 974 sky130_fd_pr__pfet_01v8 L=0.15U W=4U AS=0.54P AD=0.54P
+ PS=5.08U PD=5.08U
* device instance $2688 r0 *1 42.815,55.135 sky130_fd_pr__pfet_01v8
M$2688 168 996 975 975 sky130_fd_pr__pfet_01v8 L=0.15U W=3U AS=0.545P AD=0.545P
+ PS=5.09U PD=5.09U
* device instance $2691 r0 *1 44.635,55.135 sky130_fd_pr__pfet_01v8
M$2691 976 311 168 168 sky130_fd_pr__pfet_01v8 L=0.15U W=4U AS=0.685P AD=0.56P
+ PS=6.37U PD=5.12U
* device instance $2695 r0 *1 46.355,55.135 sky130_fd_pr__pfet_01v8
M$2695 996 976 168 168 sky130_fd_pr__pfet_01v8 L=0.15U W=16U AS=2.2375P
+ AD=2.3625P PS=20.475U PD=21.725U
* device instance $2711 r0 *1 59.405,54.955 sky130_fd_pr__pfet_01v8
M$2711 993 788 168 168 sky130_fd_pr__pfet_01v8 L=0.15U W=0.64U AS=0.1696P
+ AD=0.0768P PS=1.81U PD=0.88U
* device instance $2712 r0 *1 59.795,54.955 sky130_fd_pr__pfet_01v8
M$2712 977 947 993 993 sky130_fd_pr__pfet_01v8 L=0.15U W=0.64U AS=0.0768P
+ AD=0.0896P PS=0.88U PD=0.92U
* device instance $2713 r0 *1 60.225,54.955 sky130_fd_pr__pfet_01v8
M$2713 168 978 977 977 sky130_fd_pr__pfet_01v8 L=0.15U W=0.64U AS=0.0896P
+ AD=0.1824P PS=0.92U PD=1.85U
* device instance $2714 r0 *1 62.115,55.135 sky130_fd_pr__pfet_01v8
M$2714 979 938 168 168 sky130_fd_pr__pfet_01v8 L=0.15U W=1U AS=0.265P AD=0.14P
+ PS=2.53U PD=1.28U
* device instance $2715 r0 *1 62.545,55.135 sky130_fd_pr__pfet_01v8
M$2715 168 977 979 979 sky130_fd_pr__pfet_01v8 L=0.15U W=1U AS=0.14P AD=0.1775P
+ PS=1.28U PD=1.355U
* device instance $2716 r0 *1 63.05,55.135 sky130_fd_pr__pfet_01v8
M$2716 980 979 168 168 sky130_fd_pr__pfet_01v8 L=0.15U W=4U AS=0.5975P
+ AD=0.705P PS=5.195U PD=6.41U
* device instance $2720 r0 *1 65.33,55.055 sky130_fd_pr__pfet_01v8
M$2720 978 981 168 168 sky130_fd_pr__pfet_01v8 L=0.15U W=1.68U AS=0.3318P
+ AD=0.3486P PS=3.31U PD=3.35U
* device instance $2722 r0 *1 66.71,55.425 sky130_fd_pr__pfet_01v8
M$2722 985 918 168 168 sky130_fd_pr__pfet_01v8 L=0.15U W=0.42U AS=0.14575P
+ AD=0.1092P PS=1.335U PD=1.36U
* device instance $2723 r0 *1 67.195,55.135 sky130_fd_pr__pfet_01v8
M$2723 1020 948 168 168 sky130_fd_pr__pfet_01v8 L=0.15U W=1U AS=0.14575P
+ AD=0.135P PS=1.335U PD=1.27U
* device instance $2724 r0 *1 67.615,55.135 sky130_fd_pr__pfet_01v8
M$2724 168 985 1020 1020 sky130_fd_pr__pfet_01v8 L=0.15U W=1U AS=0.135P
+ AD=0.265P PS=1.27U PD=2.53U
* device instance $2725 r0 *1 69.05,55.135 sky130_fd_pr__pfet_01v8
M$2725 982 948 168 168 sky130_fd_pr__pfet_01v8 L=0.15U W=1U AS=0.3P AD=0.135P
+ PS=2.6U PD=1.27U
* device instance $2726 r0 *1 69.47,55.135 sky130_fd_pr__pfet_01v8
M$2726 168 918 982 982 sky130_fd_pr__pfet_01v8 L=0.15U W=1U AS=0.135P AD=0.365P
+ PS=1.27U PD=1.73U
* device instance $2727 r0 *1 70.35,55.135 sky130_fd_pr__pfet_01v8
M$2727 988 918 168 168 sky130_fd_pr__pfet_01v8 L=0.15U W=1U AS=0.365P AD=0.105P
+ PS=1.73U PD=1.21U
* device instance $2728 r0 *1 70.71,55.135 sky130_fd_pr__pfet_01v8
M$2728 981 948 988 988 sky130_fd_pr__pfet_01v8 L=0.15U W=1U AS=0.105P AD=0.165P
+ PS=1.21U PD=1.33U
* device instance $2729 r0 *1 71.19,55.135 sky130_fd_pr__pfet_01v8
M$2729 168 982 981 981 sky130_fd_pr__pfet_01v8 L=0.15U W=1U AS=0.165P AD=0.36P
+ PS=1.33U PD=2.72U
* device instance $2730 r0 *1 9.21,54.985 sky130_fd_pr__pfet_01v8
M$2730 168 936 965 965 sky130_fd_pr__pfet_01v8 L=0.15U W=0.64U AS=0.1664P
+ AD=0.0864P PS=1.8U PD=0.91U
* device instance $2731 r0 *1 9.63,54.985 sky130_fd_pr__pfet_01v8
M$2731 966 965 168 168 sky130_fd_pr__pfet_01v8 L=0.15U W=0.64U AS=0.0864P
+ AD=0.1664P PS=0.91U PD=1.8U
* device instance $2732 r0 *1 11.03,60.285 sky130_fd_pr__pfet_01v8
M$2732 1042 1080 168 168 sky130_fd_pr__pfet_01v8 L=0.15U W=0.42U AS=0.1092P
+ AD=0.0672P PS=1.36U PD=0.74U
* device instance $2733 r0 *1 11.5,60.285 sky130_fd_pr__pfet_01v8
M$2733 1043 1041 1042 1042 sky130_fd_pr__pfet_01v8 L=0.15U W=0.42U AS=0.0672P
+ AD=0.06615P PS=0.74U PD=0.735U
* device instance $2734 r0 *1 11.965,60.285 sky130_fd_pr__pfet_01v8
M$2734 1071 1040 1043 1043 sky130_fd_pr__pfet_01v8 L=0.15U W=0.42U AS=0.06615P
+ AD=0.0693P PS=0.735U PD=0.75U
* device instance $2735 r0 *1 12.445,60.285 sky130_fd_pr__pfet_01v8
M$2735 168 1044 1071 1071 sky130_fd_pr__pfet_01v8 L=0.15U W=0.42U AS=0.0693P
+ AD=0.178875P PS=0.75U PD=1.26U
* device instance $2736 r0 *1 13.58,60.285 sky130_fd_pr__pfet_01v8
M$2736 1061 1040 1044 1044 sky130_fd_pr__pfet_01v8 L=0.15U W=0.42U AS=0.1095P
+ AD=0.0567P PS=1.075U PD=0.69U
* device instance $2737 r0 *1 14,60.285 sky130_fd_pr__pfet_01v8
M$2737 1073 1041 1061 1061 sky130_fd_pr__pfet_01v8 L=0.15U W=0.42U AS=0.0567P
+ AD=0.09135P PS=0.69U PD=0.855U
* device instance $2738 r0 *1 14.585,60.285 sky130_fd_pr__pfet_01v8
M$2738 168 1045 1073 1073 sky130_fd_pr__pfet_01v8 L=0.15U W=0.42U AS=0.09135P
+ AD=0.1218P PS=0.855U PD=1.42U
* device instance $2739 r0 *1 13.105,60.45 sky130_fd_pr__pfet_01v8
M$2739 1044 1043 168 168 sky130_fd_pr__pfet_01v8 L=0.15U W=0.75U AS=0.178875P
+ AD=0.1095P PS=1.26U PD=1.075U
* device instance $2740 r0 *1 15.665,60.575 sky130_fd_pr__pfet_01v8
M$2740 168 1061 1045 1045 sky130_fd_pr__pfet_01v8 L=0.15U W=1U AS=0.28P
+ AD=0.1625P PS=2.56U PD=1.325U
* device instance $2741 r0 *1 16.14,60.575 sky130_fd_pr__pfet_01v8
M$2741 71 1045 168 168 sky130_fd_pr__pfet_01v8 L=0.15U W=4U AS=0.575P
+ AD=0.6925P PS=5.15U PD=6.385U
* device instance $2745 r0 *1 20.73,60.575 sky130_fd_pr__pfet_01v8
M$2745 168 1100 1046 1046 sky130_fd_pr__pfet_01v8 L=0.15U W=4U AS=0.685P
+ AD=0.54P PS=6.37U PD=5.08U
* device instance $2749 r0 *1 22.41,60.575 sky130_fd_pr__pfet_01v8
M$2749 1062 1008 1046 1046 sky130_fd_pr__pfet_01v8 L=0.15U W=4U AS=0.54P
+ AD=0.675P PS=5.08U PD=6.35U
* device instance $2753 r0 *1 24.84,60.575 sky130_fd_pr__pfet_01v8
M$2753 93 1047 168 168 sky130_fd_pr__pfet_01v8 L=0.15U W=8U AS=1.205P AD=1.08P
+ PS=11.41U PD=10.16U
* device instance $2761 r0 *1 28.2,60.575 sky130_fd_pr__pfet_01v8
M$2761 1047 1062 168 168 sky130_fd_pr__pfet_01v8 L=0.15U W=3U AS=0.405P
+ AD=0.53P PS=3.81U PD=5.06U
* device instance $2764 r0 *1 24.87,59.105 sky130_fd_pr__pfet_01v8
M$2764 168 71 1030 1030 sky130_fd_pr__pfet_01v8 L=0.15U W=2U AS=0.415P AD=0.27P
+ PS=3.83U PD=2.54U
* device instance $2766 r0 *1 25.71,59.105 sky130_fd_pr__pfet_01v8
M$2766 1031 994 1030 1030 sky130_fd_pr__pfet_01v8 L=0.15U W=2U AS=0.27P
+ AD=0.415P PS=2.54U PD=3.83U
* device instance $2768 r0 *1 27.09,59.105 sky130_fd_pr__pfet_01v8
M$2768 1008 1024 1031 1031 sky130_fd_pr__pfet_01v8 L=0.15U W=2U AS=0.395P
+ AD=0.395P PS=3.79U PD=3.79U
* device instance $2770 r0 *1 28.65,59.105 sky130_fd_pr__pfet_01v8
M$2770 168 109 1009 1009 sky130_fd_pr__pfet_01v8 L=0.15U W=1U AS=0.38P
+ AD=0.135P PS=2.76U PD=1.27U
* device instance $2771 r0 *1 29.07,59.105 sky130_fd_pr__pfet_01v8
M$2771 90 1010 168 168 sky130_fd_pr__pfet_01v8 L=0.15U W=4U AS=0.54P AD=0.54P
+ PS=5.08U PD=5.08U
* device instance $2775 r0 *1 30.75,59.105 sky130_fd_pr__pfet_01v8
M$2775 1010 1009 168 168 sky130_fd_pr__pfet_01v8 L=0.15U W=2U AS=0.27P
+ AD=0.395P PS=2.54U PD=3.79U
* device instance $2777 r0 *1 32.11,59.105 sky130_fd_pr__pfet_01v8
M$2777 1010 1024 1032 1032 sky130_fd_pr__pfet_01v8 L=0.15U W=2U AS=0.395P
+ AD=0.27P PS=3.79U PD=2.54U
* device instance $2779 r0 *1 32.95,59.105 sky130_fd_pr__pfet_01v8
M$2779 168 994 1032 1032 sky130_fd_pr__pfet_01v8 L=0.15U W=2U AS=0.27P
+ AD=0.415P PS=2.54U PD=3.83U
* device instance $2781 r0 *1 32.21,60.575 sky130_fd_pr__pfet_01v8
M$2781 1076 994 1048 1048 sky130_fd_pr__pfet_01v8 L=0.15U W=1U AS=0.26P
+ AD=0.105P PS=2.52U PD=1.21U
* device instance $2782 r0 *1 32.57,60.575 sky130_fd_pr__pfet_01v8
M$2782 168 1063 1076 1076 sky130_fd_pr__pfet_01v8 L=0.15U W=1U AS=0.105P
+ AD=0.26P PS=1.21U PD=2.52U
* device instance $2783 r0 *1 33.83,60.865 sky130_fd_pr__pfet_01v8
M$2783 1064 995 168 168 sky130_fd_pr__pfet_01v8 L=0.15U W=0.42U AS=0.1573P
+ AD=0.1092P PS=1.39U PD=1.36U
* device instance $2784 r0 *1 34.37,60.575 sky130_fd_pr__pfet_01v8
M$2784 1078 890 168 168 sky130_fd_pr__pfet_01v8 L=0.15U W=1U AS=0.1573P
+ AD=0.105P PS=1.39U PD=1.21U
* device instance $2785 r0 *1 34.73,60.575 sky130_fd_pr__pfet_01v8
M$2785 1063 1064 1078 1078 sky130_fd_pr__pfet_01v8 L=0.15U W=1U AS=0.105P
+ AD=0.26P PS=1.21U PD=2.52U
* device instance $2786 r0 *1 34.97,59.105 sky130_fd_pr__pfet_01v8
M$2786 168 984 1012 1012 sky130_fd_pr__pfet_01v8 L=0.15U W=1U AS=0.26P
+ AD=0.135P PS=2.52U PD=1.27U
* device instance $2787 r0 *1 35.39,59.105 sky130_fd_pr__pfet_01v8
M$2787 1024 1012 168 168 sky130_fd_pr__pfet_01v8 L=0.15U W=4U AS=0.54P AD=0.71P
+ PS=5.08U PD=5.42U
* device instance $2791 r0 *1 37.41,59.105 sky130_fd_pr__pfet_01v8
M$2791 1013 997 168 168 sky130_fd_pr__pfet_01v8 L=0.15U W=2U AS=0.44P AD=0.27P
+ PS=2.88U PD=2.54U
* device instance $2793 r0 *1 38.25,59.105 sky130_fd_pr__pfet_01v8
M$2793 87 1013 168 168 sky130_fd_pr__pfet_01v8 L=0.15U W=6U AS=0.81P AD=0.935P
+ PS=7.62U PD=8.87U
* device instance $2799 r0 *1 40.03,60.575 sky130_fd_pr__pfet_01v8
M$2799 1049 1068 168 168 sky130_fd_pr__pfet_01v8 L=0.15U W=2U AS=0.395P
+ AD=0.27P PS=3.79U PD=2.54U
* device instance $2801 r0 *1 40.87,60.575 sky130_fd_pr__pfet_01v8
M$2801 1049 1034 168 168 sky130_fd_pr__pfet_01v8 L=0.15U W=2U AS=0.275P
+ AD=0.285P PS=2.55U PD=2.57U
* device instance $2803 r0 *1 41.74,60.575 sky130_fd_pr__pfet_01v8
M$2803 1049 1081 168 168 sky130_fd_pr__pfet_01v8 L=0.15U W=2U AS=0.28P
+ AD=0.395P PS=2.56U PD=3.79U
* device instance $2805 r0 *1 42.33,59.105 sky130_fd_pr__pfet_01v8
M$2805 1039 1025 1014 1014 sky130_fd_pr__pfet_01v8 L=0.15U W=1U AS=0.26P
+ AD=0.105P PS=2.52U PD=1.21U
* device instance $2806 r0 *1 42.69,59.105 sky130_fd_pr__pfet_01v8
M$2806 168 1015 1039 1039 sky130_fd_pr__pfet_01v8 L=0.15U W=1U AS=0.105P
+ AD=0.26P PS=1.21U PD=2.52U
* device instance $2807 r0 *1 43.1,60.575 sky130_fd_pr__pfet_01v8
M$2807 1049 1063 1050 1050 sky130_fd_pr__pfet_01v8 L=0.15U W=2U AS=0.395P
+ AD=0.395P PS=3.79U PD=2.79U
* device instance $2809 r0 *1 44.19,60.575 sky130_fd_pr__pfet_01v8
M$2809 1065 1066 1050 1050 sky130_fd_pr__pfet_01v8 L=0.15U W=2U AS=0.395P
+ AD=0.395P PS=2.79U PD=3.79U
* device instance $2811 r0 *1 45.57,60.575 sky130_fd_pr__pfet_01v8
M$2811 1051 1081 1015 1015 sky130_fd_pr__pfet_01v8 L=0.15U W=1U AS=0.265P
+ AD=0.14P PS=2.53U PD=1.28U
* device instance $2812 r0 *1 46,60.575 sky130_fd_pr__pfet_01v8
M$2812 168 1068 1051 1051 sky130_fd_pr__pfet_01v8 L=0.15U W=1U AS=0.14P
+ AD=0.1475P PS=1.28U PD=1.295U
* device instance $2813 r0 *1 46.445,60.575 sky130_fd_pr__pfet_01v8
M$2813 1051 1069 168 168 sky130_fd_pr__pfet_01v8 L=0.15U W=1U AS=0.1475P
+ AD=0.265P PS=1.295U PD=2.53U
* device instance $2814 r0 *1 46.01,59.105 sky130_fd_pr__pfet_01v8
M$2814 168 997 1016 1016 sky130_fd_pr__pfet_01v8 L=0.15U W=1U AS=0.26P
+ AD=0.135P PS=2.52U PD=1.27U
* device instance $2815 r0 *1 46.43,59.105 sky130_fd_pr__pfet_01v8
M$2815 1017 1016 168 168 sky130_fd_pr__pfet_01v8 L=0.15U W=4U AS=0.54P
+ AD=0.665P PS=5.08U PD=6.33U
* device instance $2819 r0 *1 48.7,59.105 sky130_fd_pr__pfet_01v8
M$2819 168 851 1033 1033 sky130_fd_pr__pfet_01v8 L=0.15U W=4U AS=0.685P
+ AD=0.54P PS=6.37U PD=5.08U
* device instance $2823 r0 *1 50.38,59.105 sky130_fd_pr__pfet_01v8
M$2823 1038 788 1033 1033 sky130_fd_pr__pfet_01v8 L=0.15U W=4U AS=0.54P
+ AD=0.665P PS=5.08U PD=6.33U
* device instance $2827 r0 *1 49.69,60.575 sky130_fd_pr__pfet_01v8
M$2827 168 1068 1052 1052 sky130_fd_pr__pfet_01v8 L=0.15U W=2U AS=0.395P
+ AD=0.27P PS=3.79U PD=2.54U
* device instance $2829 r0 *1 50.53,60.575 sky130_fd_pr__pfet_01v8
M$2829 168 1069 1052 1052 sky130_fd_pr__pfet_01v8 L=0.15U W=2U AS=0.27P
+ AD=0.27P PS=2.54U PD=2.54U
* device instance $2831 r0 *1 51.37,60.575 sky130_fd_pr__pfet_01v8
M$2831 168 1081 1052 1052 sky130_fd_pr__pfet_01v8 L=0.15U W=2U AS=0.545P
+ AD=0.59P PS=3.09U PD=3.18U
* device instance $2833 r0 *1 52.85,60.575 sky130_fd_pr__pfet_01v8
M$2833 1070 1066 1052 1052 sky130_fd_pr__pfet_01v8 L=0.15U W=2U AS=0.355P
+ AD=0.435P PS=2.71U PD=3.87U
* device instance $2835 r0 *1 52.58,59.105 sky130_fd_pr__pfet_01v8
M$2835 1038 978 1034 1034 sky130_fd_pr__pfet_01v8 L=0.15U W=4U AS=0.665P
+ AD=0.55P PS=6.33U PD=5.1U
* device instance $2839 r0 *1 54.28,59.105 sky130_fd_pr__pfet_01v8
M$2839 168 1020 1034 1034 sky130_fd_pr__pfet_01v8 L=0.15U W=4U AS=0.55P
+ AD=0.54P PS=5.1U PD=5.08U
* device instance $2843 r0 *1 55.96,59.105 sky130_fd_pr__pfet_01v8
M$2843 168 1021 1034 1034 sky130_fd_pr__pfet_01v8 L=0.15U W=4U AS=0.54P
+ AD=0.665P PS=5.08U PD=6.33U
* device instance $2847 r0 *1 60.27,59.105 sky130_fd_pr__pfet_01v8
M$2847 1035 1026 1022 1022 sky130_fd_pr__pfet_01v8 L=0.15U W=1U AS=0.26P
+ AD=0.135P PS=2.52U PD=1.27U
* device instance $2848 r0 *1 60.69,59.105 sky130_fd_pr__pfet_01v8
M$2848 1036 918 1035 1035 sky130_fd_pr__pfet_01v8 L=0.15U W=1U AS=0.135P
+ AD=0.135P PS=1.27U PD=1.27U
* device instance $2849 r0 *1 61.11,59.105 sky130_fd_pr__pfet_01v8
M$2849 1035 90 1036 1036 sky130_fd_pr__pfet_01v8 L=0.15U W=1U AS=0.135P
+ AD=0.26P PS=1.27U PD=2.52U
* device instance $2850 r0 *1 62.05,59.105 sky130_fd_pr__pfet_01v8
M$2850 1036 1017 168 168 sky130_fd_pr__pfet_01v8 L=0.15U W=1U AS=0.26P
+ AD=0.165P PS=2.52U PD=1.33U
* device instance $2851 r0 *1 62.53,59.105 sky130_fd_pr__pfet_01v8
M$2851 168 980 1036 1036 sky130_fd_pr__pfet_01v8 L=0.15U W=1U AS=0.165P
+ AD=0.1575P PS=1.33U PD=1.315U
* device instance $2852 r0 *1 62.995,59.105 sky130_fd_pr__pfet_01v8
M$2852 1037 1022 168 168 sky130_fd_pr__pfet_01v8 L=0.15U W=1U AS=0.1575P
+ AD=0.26P PS=1.315U PD=2.52U
* device instance $2853 r0 *1 63.97,59.105 sky130_fd_pr__pfet_01v8
M$2853 1023 938 168 168 sky130_fd_pr__pfet_01v8 L=0.15U W=1U AS=0.26P AD=0.135P
+ PS=2.52U PD=1.27U
* device instance $2854 r0 *1 64.39,59.105 sky130_fd_pr__pfet_01v8
M$2854 168 1020 1023 1023 sky130_fd_pr__pfet_01v8 L=0.15U W=1U AS=0.135P
+ AD=0.26P PS=1.27U PD=2.52U
* device instance $2855 r0 *1 64.85,60.395 sky130_fd_pr__pfet_01v8
M$2855 1079 1037 1055 1055 sky130_fd_pr__pfet_01v8 L=0.15U W=0.64U AS=0.1664P
+ AD=0.0672P PS=1.8U PD=0.85U
* device instance $2856 r0 *1 65.21,60.395 sky130_fd_pr__pfet_01v8
M$2856 168 1056 1079 1079 sky130_fd_pr__pfet_01v8 L=0.15U W=0.64U AS=0.0672P
+ AD=0.1664P PS=0.85U PD=1.8U
* device instance $2857 r0 *1 67.875,60.285 sky130_fd_pr__pfet_01v8
M$2857 1057 1054 1055 1055 sky130_fd_pr__pfet_01v8 L=0.15U W=0.42U AS=0.15985P
+ AD=0.06405P PS=1.265U PD=0.725U
* device instance $2858 r0 *1 68.33,60.285 sky130_fd_pr__pfet_01v8
M$2858 1075 1053 1057 1057 sky130_fd_pr__pfet_01v8 L=0.15U W=0.42U AS=0.06405P
+ AD=0.07665P PS=0.725U PD=0.785U
* device instance $2859 r0 *1 68.845,60.285 sky130_fd_pr__pfet_01v8
M$2859 168 1058 1075 1075 sky130_fd_pr__pfet_01v8 L=0.15U W=0.42U AS=0.07665P
+ AD=0.178875P PS=0.785U PD=1.26U
* device instance $2860 r0 *1 66.15,60.395 sky130_fd_pr__pfet_01v8
M$2860 168 16 1056 1056 sky130_fd_pr__pfet_01v8 L=0.15U W=0.64U AS=0.1664P
+ AD=0.0928P PS=1.8U PD=0.93U
* device instance $2861 r0 *1 66.59,60.395 sky130_fd_pr__pfet_01v8
M$2861 1077 16 168 168 sky130_fd_pr__pfet_01v8 L=0.15U W=0.64U AS=0.0928P
+ AD=0.1152P PS=0.93U PD=1U
* device instance $2862 r0 *1 67.1,60.395 sky130_fd_pr__pfet_01v8
M$2862 1055 1060 1077 1077 sky130_fd_pr__pfet_01v8 L=0.15U W=0.64U AS=0.1152P
+ AD=0.15985P PS=1U PD=1.265U
* device instance $2863 r0 *1 69.505,60.45 sky130_fd_pr__pfet_01v8
M$2863 1058 1057 168 168 sky130_fd_pr__pfet_01v8 L=0.15U W=0.75U AS=0.178875P
+ AD=0.195P PS=1.26U PD=2.02U
* device instance $2864 r0 *1 70.445,60.285 sky130_fd_pr__pfet_01v8
M$2864 1074 1058 168 168 sky130_fd_pr__pfet_01v8 L=0.15U W=0.42U AS=0.1092P
+ AD=0.06405P PS=1.36U PD=0.725U
* device instance $2865 r0 *1 70.9,60.285 sky130_fd_pr__pfet_01v8
M$2865 1059 1053 1074 1074 sky130_fd_pr__pfet_01v8 L=0.15U W=0.42U AS=0.06405P
+ AD=0.0567P PS=0.725U PD=0.69U
* device instance $2866 r0 *1 71.32,60.285 sky130_fd_pr__pfet_01v8
M$2866 1072 1054 1059 1059 sky130_fd_pr__pfet_01v8 L=0.15U W=0.42U AS=0.0567P
+ AD=0.0882P PS=0.69U PD=0.84U
* device instance $2867 r0 *1 71.89,60.285 sky130_fd_pr__pfet_01v8
M$2867 168 1060 1072 1072 sky130_fd_pr__pfet_01v8 L=0.15U W=0.42U AS=0.0882P
+ AD=0.1113P PS=0.84U PD=1.37U
* device instance $2868 r0 *1 72.945,60.395 sky130_fd_pr__pfet_01v8
M$2868 168 1059 1060 1060 sky130_fd_pr__pfet_01v8 L=0.15U W=0.64U AS=0.1728P
+ AD=0.154P PS=1.82U PD=1.335U
* device instance $2869 r0 *1 73.43,60.575 sky130_fd_pr__pfet_01v8
M$2869 948 1059 168 168 sky130_fd_pr__pfet_01v8 L=0.15U W=1U AS=0.154P AD=0.28P
+ PS=1.335U PD=2.56U
* device instance $2870 r0 *1 7.83,64.625 sky130_fd_pr__pfet_01v8
M$2870 1199 1117 168 168 sky130_fd_pr__pfet_01v8 L=0.15U W=1.68U AS=0.3318P
+ AD=0.3486P PS=3.31U PD=3.35U
* device instance $2872 r0 *1 9.21,64.545 sky130_fd_pr__pfet_01v8
M$2872 1134 1118 168 168 sky130_fd_pr__pfet_01v8 L=0.15U W=1U AS=0.26P
+ AD=0.1125P PS=2.52U PD=1.225U
* device instance $2873 r0 *1 9.585,64.545 sky130_fd_pr__pfet_01v8
M$2873 1097 1117 1134 1134 sky130_fd_pr__pfet_01v8 L=0.15U W=1U AS=0.1125P
+ AD=0.2325P PS=1.225U PD=1.465U
* device instance $2874 r0 *1 10.2,64.545 sky130_fd_pr__pfet_01v8
M$2874 1135 1098 1097 1097 sky130_fd_pr__pfet_01v8 L=0.15U W=1U AS=0.2325P
+ AD=0.105P PS=1.465U PD=1.21U
* device instance $2875 r0 *1 10.56,64.545 sky130_fd_pr__pfet_01v8
M$2875 168 917 1135 1135 sky130_fd_pr__pfet_01v8 L=0.15U W=1U AS=0.105P
+ AD=0.27P PS=1.21U PD=2.54U
* device instance $2876 r0 *1 9.67,60.425 sky130_fd_pr__pfet_01v8
M$2876 168 936 1040 1040 sky130_fd_pr__pfet_01v8 L=0.15U W=0.64U AS=0.1664P
+ AD=0.0864P PS=1.8U PD=0.91U
* device instance $2877 r0 *1 10.09,60.425 sky130_fd_pr__pfet_01v8
M$2877 1041 1040 168 168 sky130_fd_pr__pfet_01v8 L=0.15U W=0.64U AS=0.0864P
+ AD=0.1664P PS=0.91U PD=1.8U
* device instance $2878 r0 *1 11.53,64.545 sky130_fd_pr__pfet_01v8
M$2878 109 1119 168 168 sky130_fd_pr__pfet_01v8 L=0.15U W=1U AS=0.26P AD=0.135P
+ PS=2.52U PD=1.27U
* device instance $2879 r0 *1 11.95,64.545 sky130_fd_pr__pfet_01v8
M$2879 168 1099 109 109 sky130_fd_pr__pfet_01v8 L=0.15U W=1U AS=0.135P AD=0.26P
+ PS=1.27U PD=2.52U
* device instance $2880 r0 *1 12.89,64.625 sky130_fd_pr__pfet_01v8
M$2880 1099 71 168 168 sky130_fd_pr__pfet_01v8 L=0.15U W=1.68U AS=0.3318P
+ AD=0.3486P PS=3.31U PD=3.35U
* device instance $2882 r0 *1 17.05,64.545 sky130_fd_pr__pfet_01v8
M$2882 168 1119 1132 1132 sky130_fd_pr__pfet_01v8 L=0.15U W=4U AS=0.685P
+ AD=0.54P PS=6.37U PD=5.08U
* device instance $2886 r0 *1 18.73,64.545 sky130_fd_pr__pfet_01v8
M$2886 1100 71 1132 1132 sky130_fd_pr__pfet_01v8 L=0.15U W=4U AS=0.54P
+ AD=0.675P PS=5.08U PD=6.35U
* device instance $2890 r0 *1 22.255,64.545 sky130_fd_pr__pfet_01v8
M$2890 16 1100 168 168 sky130_fd_pr__pfet_01v8 L=0.15U W=8U AS=1.205P AD=1.205P
+ PS=11.41U PD=11.41U
* device instance $2898 r0 *1 26.49,64.545 sky130_fd_pr__pfet_01v8
M$2898 1101 1062 168 168 sky130_fd_pr__pfet_01v8 L=0.15U W=2U AS=0.395P
+ AD=0.27P PS=3.79U PD=2.54U
* device instance $2900 r0 *1 27.33,64.545 sky130_fd_pr__pfet_01v8
M$2900 1102 1101 168 168 sky130_fd_pr__pfet_01v8 L=0.15U W=6U AS=0.81P
+ AD=0.935P PS=7.62U PD=8.87U
* device instance $2906 r0 *1 30.37,64.695 sky130_fd_pr__pfet_01v8
M$2906 168 936 1103 1103 sky130_fd_pr__pfet_01v8 L=0.15U W=0.64U AS=0.1664P
+ AD=0.0864P PS=1.8U PD=0.91U
* device instance $2907 r0 *1 30.79,64.695 sky130_fd_pr__pfet_01v8
M$2907 1104 1103 168 168 sky130_fd_pr__pfet_01v8 L=0.15U W=0.64U AS=0.0864P
+ AD=0.1664P PS=0.91U PD=1.8U
* device instance $2908 r0 *1 31.73,64.725 sky130_fd_pr__pfet_01v8
M$2908 1138 1133 1105 1105 sky130_fd_pr__pfet_01v8 L=0.15U W=0.64U AS=0.1664P
+ AD=0.0672P PS=1.8U PD=0.85U
* device instance $2909 r0 *1 32.09,64.725 sky130_fd_pr__pfet_01v8
M$2909 168 1106 1138 1138 sky130_fd_pr__pfet_01v8 L=0.15U W=0.64U AS=0.0672P
+ AD=0.1664P PS=0.85U PD=1.8U
* device instance $2910 r0 *1 33.03,64.725 sky130_fd_pr__pfet_01v8
M$2910 168 16 1106 1106 sky130_fd_pr__pfet_01v8 L=0.15U W=0.64U AS=0.1664P
+ AD=0.0928P PS=1.8U PD=0.93U
* device instance $2911 r0 *1 33.47,64.725 sky130_fd_pr__pfet_01v8
M$2911 1140 16 168 168 sky130_fd_pr__pfet_01v8 L=0.15U W=0.64U AS=0.0928P
+ AD=0.1152P PS=0.93U PD=1U
* device instance $2912 r0 *1 33.98,64.725 sky130_fd_pr__pfet_01v8
M$2912 1105 1120 1140 1140 sky130_fd_pr__pfet_01v8 L=0.15U W=0.64U AS=0.1152P
+ AD=0.15985P PS=1U PD=1.265U
* device instance $2913 r0 *1 34.755,64.835 sky130_fd_pr__pfet_01v8
M$2913 1107 1104 1105 1105 sky130_fd_pr__pfet_01v8 L=0.15U W=0.42U AS=0.15985P
+ AD=0.06405P PS=1.265U PD=0.725U
* device instance $2914 r0 *1 35.21,64.835 sky130_fd_pr__pfet_01v8
M$2914 1142 1103 1107 1107 sky130_fd_pr__pfet_01v8 L=0.15U W=0.42U AS=0.06405P
+ AD=0.07665P PS=0.725U PD=0.785U
* device instance $2915 r0 *1 35.725,64.835 sky130_fd_pr__pfet_01v8
M$2915 1142 1108 168 168 sky130_fd_pr__pfet_01v8 L=0.15U W=0.42U AS=0.178875P
+ AD=0.07665P PS=1.26U PD=0.785U
* device instance $2916 r0 *1 36.385,64.67 sky130_fd_pr__pfet_01v8
M$2916 1108 1107 168 168 sky130_fd_pr__pfet_01v8 L=0.15U W=0.75U AS=0.178875P
+ AD=0.195P PS=1.26U PD=2.02U
* device instance $2917 r0 *1 39.825,64.725 sky130_fd_pr__pfet_01v8
M$2917 1120 1109 168 168 sky130_fd_pr__pfet_01v8 L=0.15U W=0.64U AS=0.154P
+ AD=0.1728P PS=1.335U PD=1.82U
* device instance $2918 r0 *1 40.31,64.545 sky130_fd_pr__pfet_01v8
M$2918 995 1109 168 168 sky130_fd_pr__pfet_01v8 L=0.15U W=1U AS=0.154P AD=0.28P
+ PS=1.335U PD=2.56U
* device instance $2919 r0 *1 41.41,64.545 sky130_fd_pr__pfet_01v8
M$2919 168 1065 1110 1110 sky130_fd_pr__pfet_01v8 L=0.15U W=1U AS=0.26P
+ AD=0.135P PS=2.52U PD=1.27U
* device instance $2920 r0 *1 41.83,64.545 sky130_fd_pr__pfet_01v8
M$2920 984 1110 168 168 sky130_fd_pr__pfet_01v8 L=0.15U W=4U AS=0.54P AD=0.665P
+ PS=5.08U PD=6.33U
* device instance $2924 r0 *1 45.65,64.545 sky130_fd_pr__pfet_01v8
M$2924 1081 1111 168 168 sky130_fd_pr__pfet_01v8 L=0.15U W=1U AS=0.36P
+ AD=0.165P PS=2.72U PD=1.33U
* device instance $2925 r0 *1 46.13,64.545 sky130_fd_pr__pfet_01v8
M$2925 1137 694 1081 1081 sky130_fd_pr__pfet_01v8 L=0.15U W=1U AS=0.165P
+ AD=0.105P PS=1.33U PD=1.21U
* device instance $2926 r0 *1 46.49,64.545 sky130_fd_pr__pfet_01v8
M$2926 168 1121 1137 1137 sky130_fd_pr__pfet_01v8 L=0.15U W=1U AS=0.105P
+ AD=0.365P PS=1.21U PD=1.73U
* device instance $2927 r0 *1 47.37,64.545 sky130_fd_pr__pfet_01v8
M$2927 1111 1121 168 168 sky130_fd_pr__pfet_01v8 L=0.15U W=1U AS=0.365P
+ AD=0.135P PS=1.73U PD=1.27U
* device instance $2928 r0 *1 47.79,64.545 sky130_fd_pr__pfet_01v8
M$2928 168 694 1111 1111 sky130_fd_pr__pfet_01v8 L=0.15U W=1U AS=0.135P
+ AD=0.41P PS=1.27U PD=1.82U
* device instance $2929 r0 *1 48.76,64.545 sky130_fd_pr__pfet_01v8
M$2929 1069 1113 168 168 sky130_fd_pr__pfet_01v8 L=0.15U W=4U AS=0.815P
+ AD=0.54P PS=5.63U PD=5.08U
* device instance $2933 r0 *1 50.44,64.545 sky130_fd_pr__pfet_01v8
M$2933 1113 1034 168 168 sky130_fd_pr__pfet_01v8 L=0.15U W=1U AS=0.135P
+ AD=0.26P PS=1.27U PD=2.52U
* device instance $2934 r0 *1 47.39,60.85 sky130_fd_pr__pfet_01v8
M$2934 168 1081 1067 1067 sky130_fd_pr__pfet_01v8 L=0.15U W=0.42U AS=0.1092P
+ AD=0.0567P PS=1.36U PD=0.69U
* device instance $2935 r0 *1 47.81,60.85 sky130_fd_pr__pfet_01v8
M$2935 1067 1068 168 168 sky130_fd_pr__pfet_01v8 L=0.15U W=0.42U AS=0.0567P
+ AD=0.06615P PS=0.69U PD=0.735U
* device instance $2936 r0 *1 48.275,60.85 sky130_fd_pr__pfet_01v8
M$2936 1067 1069 168 168 sky130_fd_pr__pfet_01v8 L=0.15U W=0.42U AS=0.142225P
+ AD=0.06615P PS=1.335U PD=0.735U
* device instance $2937 r0 *1 48.75,60.575 sky130_fd_pr__pfet_01v8
M$2937 1025 1067 168 168 sky130_fd_pr__pfet_01v8 L=0.15U W=1U AS=0.142225P
+ AD=0.26P PS=1.335U PD=2.52U
* device instance $2938 r0 *1 51.77,64.255 sky130_fd_pr__pfet_01v8
M$2938 168 1121 1114 1114 sky130_fd_pr__pfet_01v8 L=0.15U W=0.42U AS=0.1092P
+ AD=0.1573P PS=1.36U PD=1.39U
* device instance $2939 r0 *1 52.31,64.545 sky130_fd_pr__pfet_01v8
M$2939 1136 694 168 168 sky130_fd_pr__pfet_01v8 L=0.15U W=1U AS=0.1573P
+ AD=0.105P PS=1.39U PD=1.21U
* device instance $2940 r0 *1 52.67,64.545 sky130_fd_pr__pfet_01v8
M$2940 1066 1114 1136 1136 sky130_fd_pr__pfet_01v8 L=0.15U W=1U AS=0.105P
+ AD=0.26P PS=1.21U PD=2.52U
* device instance $2941 r0 *1 63.49,60.425 sky130_fd_pr__pfet_01v8
M$2941 168 996 1053 1053 sky130_fd_pr__pfet_01v8 L=0.15U W=0.64U AS=0.1664P
+ AD=0.0864P PS=1.8U PD=0.91U
* device instance $2942 r0 *1 63.91,60.425 sky130_fd_pr__pfet_01v8
M$2942 1054 1053 168 168 sky130_fd_pr__pfet_01v8 L=0.15U W=0.64U AS=0.0864P
+ AD=0.1664P PS=0.91U PD=1.8U
* device instance $2943 r0 *1 64.41,64.255 sky130_fd_pr__pfet_01v8
M$2943 168 1122 1115 1115 sky130_fd_pr__pfet_01v8 L=0.15U W=0.42U AS=0.1092P
+ AD=0.14575P PS=1.36U PD=1.335U
* device instance $2944 r0 *1 64.895,64.545 sky130_fd_pr__pfet_01v8
M$2944 1068 1123 168 168 sky130_fd_pr__pfet_01v8 L=0.15U W=1U AS=0.14575P
+ AD=0.135P PS=1.335U PD=1.27U
* device instance $2945 r0 *1 65.315,64.545 sky130_fd_pr__pfet_01v8
M$2945 168 1115 1068 1068 sky130_fd_pr__pfet_01v8 L=0.15U W=1U AS=0.135P
+ AD=0.595P PS=1.27U PD=2.19U
* device instance $2946 r0 *1 66.655,64.545 sky130_fd_pr__pfet_01v8
M$2946 387 1116 168 168 sky130_fd_pr__pfet_01v8 L=0.15U W=4U AS=1P AD=0.54P
+ PS=6U PD=5.08U
* device instance $2950 r0 *1 68.335,64.545 sky130_fd_pr__pfet_01v8
M$2950 1116 1123 168 168 sky130_fd_pr__pfet_01v8 L=0.15U W=1U AS=0.135P
+ AD=0.26P PS=1.27U PD=2.52U
* device instance $2951 r0 *1 5.09,66.015 sky130_fd_pr__pfet_01v8
M$2951 1118 1143 168 168 sky130_fd_pr__pfet_01v8 L=0.15U W=1U AS=0.26P
+ AD=0.135P PS=2.52U PD=1.27U
* device instance $2952 r0 *1 5.51,66.015 sky130_fd_pr__pfet_01v8
M$2952 168 71 1118 1118 sky130_fd_pr__pfet_01v8 L=0.15U W=1U AS=0.135P AD=0.26P
+ PS=1.27U PD=2.52U
* device instance $2953 r0 *1 8.805,65.835 sky130_fd_pr__pfet_01v8
M$2953 1185 1099 168 168 sky130_fd_pr__pfet_01v8 L=0.15U W=0.64U AS=0.1696P
+ AD=0.0768P PS=1.81U PD=0.88U
* device instance $2954 r0 *1 9.195,65.835 sky130_fd_pr__pfet_01v8
M$2954 1080 1143 1185 1185 sky130_fd_pr__pfet_01v8 L=0.15U W=0.64U AS=0.0768P
+ AD=0.0896P PS=0.88U PD=0.92U
* device instance $2955 r0 *1 9.625,65.835 sky130_fd_pr__pfet_01v8
M$2955 168 1144 1080 1080 sky130_fd_pr__pfet_01v8 L=0.15U W=0.64U AS=0.0896P
+ AD=0.1824P PS=0.92U PD=1.85U
* device instance $2956 r0 *1 10.61,66.015 sky130_fd_pr__pfet_01v8
M$2956 1098 1199 168 168 sky130_fd_pr__pfet_01v8 L=0.15U W=1U AS=0.26P
+ AD=0.135P PS=2.52U PD=1.27U
* device instance $2957 r0 *1 11.03,66.015 sky130_fd_pr__pfet_01v8
M$2957 168 1119 1098 1098 sky130_fd_pr__pfet_01v8 L=0.15U W=1U AS=0.135P
+ AD=0.26P PS=1.27U PD=2.52U
* device instance $2958 r0 *1 12.04,66.015 sky130_fd_pr__pfet_01v8
M$2958 168 1177 1145 1145 sky130_fd_pr__pfet_01v8 L=0.15U W=1U AS=0.33P
+ AD=0.2425P PS=2.66U PD=1.485U
* device instance $2959 r0 *1 12.675,66.015 sky130_fd_pr__pfet_01v8
M$2959 1146 917 168 168 sky130_fd_pr__pfet_01v8 L=0.15U W=1U AS=0.2425P
+ AD=0.165P PS=1.485U PD=1.33U
* device instance $2960 r0 *1 13.155,66.015 sky130_fd_pr__pfet_01v8
M$2960 168 1199 1146 1146 sky130_fd_pr__pfet_01v8 L=0.15U W=1U AS=0.165P
+ AD=0.225P PS=1.33U PD=1.45U
* device instance $2961 r0 *1 13.755,66.015 sky130_fd_pr__pfet_01v8
M$2961 1146 1119 168 168 sky130_fd_pr__pfet_01v8 L=0.15U W=1U AS=0.225P
+ AD=0.185P PS=1.45U PD=1.37U
* device instance $2962 r0 *1 14.275,66.015 sky130_fd_pr__pfet_01v8
M$2962 1177 1144 1146 1146 sky130_fd_pr__pfet_01v8 L=0.15U W=1U AS=0.185P
+ AD=0.14P PS=1.37U PD=1.28U
* device instance $2963 r0 *1 14.705,66.015 sky130_fd_pr__pfet_01v8
M$2963 1146 1147 1177 1177 sky130_fd_pr__pfet_01v8 L=0.15U W=1U AS=0.14P
+ AD=0.265P PS=1.28U PD=2.53U
* device instance $2964 r0 *1 24.46,65.725 sky130_fd_pr__pfet_01v8
M$2964 1149 1179 168 168 sky130_fd_pr__pfet_01v8 L=0.15U W=0.42U AS=0.1113P
+ AD=0.0609P PS=1.37U PD=0.71U
* device instance $2965 r0 *1 24.9,65.725 sky130_fd_pr__pfet_01v8
M$2965 168 109 1149 1149 sky130_fd_pr__pfet_01v8 L=0.15U W=0.42U AS=0.0609P
+ AD=0.1841P PS=0.71U PD=1.26U
* device instance $2966 r0 *1 25.67,65.835 sky130_fd_pr__pfet_01v8
M$2966 1150 1149 168 168 sky130_fd_pr__pfet_01v8 L=0.15U W=0.64U AS=0.1841P
+ AD=0.1696P PS=1.26U PD=1.81U
* device instance $2967 r0 *1 26.69,66.015 sky130_fd_pr__pfet_01v8
M$2967 1152 1150 1151 1151 sky130_fd_pr__pfet_01v8 L=0.15U W=1U AS=0.26P
+ AD=0.135P PS=2.52U PD=1.27U
* device instance $2968 r0 *1 27.11,66.015 sky130_fd_pr__pfet_01v8
M$2968 1180 890 1152 1152 sky130_fd_pr__pfet_01v8 L=0.15U W=1U AS=0.135P
+ AD=0.135P PS=1.27U PD=1.27U
* device instance $2969 r0 *1 27.53,66.015 sky130_fd_pr__pfet_01v8
M$2969 1152 90 1180 1180 sky130_fd_pr__pfet_01v8 L=0.15U W=1U AS=0.135P
+ AD=0.26P PS=1.27U PD=2.52U
* device instance $2970 r0 *1 28.47,66.015 sky130_fd_pr__pfet_01v8
M$2970 1180 1181 168 168 sky130_fd_pr__pfet_01v8 L=0.15U W=1U AS=0.26P
+ AD=0.165P PS=2.52U PD=1.33U
* device instance $2971 r0 *1 28.95,66.015 sky130_fd_pr__pfet_01v8
M$2971 168 997 1180 1180 sky130_fd_pr__pfet_01v8 L=0.15U W=1U AS=0.165P
+ AD=0.1575P PS=1.33U PD=1.315U
* device instance $2972 r0 *1 29.415,66.015 sky130_fd_pr__pfet_01v8
M$2972 1133 1151 168 168 sky130_fd_pr__pfet_01v8 L=0.15U W=1U AS=0.1575P
+ AD=0.26P PS=1.315U PD=2.52U
* device instance $2973 r0 *1 32.25,66.015 sky130_fd_pr__pfet_01v8
M$2973 1153 1070 168 168 sky130_fd_pr__pfet_01v8 L=0.15U W=1U AS=0.3P AD=0.135P
+ PS=2.6U PD=1.27U
* device instance $2974 r0 *1 32.67,66.015 sky130_fd_pr__pfet_01v8
M$2974 168 1048 1153 1153 sky130_fd_pr__pfet_01v8 L=0.15U W=1U AS=0.135P
+ AD=0.365P PS=1.27U PD=1.73U
* device instance $2975 r0 *1 33.55,66.015 sky130_fd_pr__pfet_01v8
M$2975 1191 1048 168 168 sky130_fd_pr__pfet_01v8 L=0.15U W=1U AS=0.365P
+ AD=0.105P PS=1.73U PD=1.21U
* device instance $2976 r0 *1 33.91,66.015 sky130_fd_pr__pfet_01v8
M$2976 1181 1070 1191 1191 sky130_fd_pr__pfet_01v8 L=0.15U W=1U AS=0.105P
+ AD=0.165P PS=1.21U PD=1.33U
* device instance $2977 r0 *1 34.39,66.015 sky130_fd_pr__pfet_01v8
M$2977 168 1153 1181 1181 sky130_fd_pr__pfet_01v8 L=0.15U W=1U AS=0.165P
+ AD=0.36P PS=1.33U PD=2.72U
* device instance $2978 r0 *1 36.81,66.015 sky130_fd_pr__pfet_01v8
M$2978 1155 1200 1154 1154 sky130_fd_pr__pfet_01v8 L=0.15U W=1U AS=0.26P
+ AD=0.135P PS=2.52U PD=1.27U
* device instance $2979 r0 *1 37.23,66.015 sky130_fd_pr__pfet_01v8
M$2979 1182 694 1155 1155 sky130_fd_pr__pfet_01v8 L=0.15U W=1U AS=0.135P
+ AD=0.135P PS=1.27U PD=1.27U
* device instance $2980 r0 *1 37.65,66.015 sky130_fd_pr__pfet_01v8
M$2980 1155 90 1182 1182 sky130_fd_pr__pfet_01v8 L=0.15U W=1U AS=0.135P
+ AD=0.26P PS=1.27U PD=2.52U
* device instance $2981 r0 *1 37.325,64.835 sky130_fd_pr__pfet_01v8
M$2981 1141 1108 168 168 sky130_fd_pr__pfet_01v8 L=0.15U W=0.42U AS=0.1092P
+ AD=0.06405P PS=1.36U PD=0.725U
* device instance $2982 r0 *1 37.78,64.835 sky130_fd_pr__pfet_01v8
M$2982 1109 1103 1141 1141 sky130_fd_pr__pfet_01v8 L=0.15U W=0.42U AS=0.06405P
+ AD=0.0567P PS=0.725U PD=0.69U
* device instance $2983 r0 *1 38.2,64.835 sky130_fd_pr__pfet_01v8
M$2983 1139 1104 1109 1109 sky130_fd_pr__pfet_01v8 L=0.15U W=0.42U AS=0.0567P
+ AD=0.0882P PS=0.69U PD=0.84U
* device instance $2984 r0 *1 38.77,64.835 sky130_fd_pr__pfet_01v8
M$2984 168 1120 1139 1139 sky130_fd_pr__pfet_01v8 L=0.15U W=0.42U AS=0.0882P
+ AD=0.1113P PS=0.84U PD=1.37U
* device instance $2985 r0 *1 38.59,66.015 sky130_fd_pr__pfet_01v8
M$2985 1182 1286 168 168 sky130_fd_pr__pfet_01v8 L=0.15U W=1U AS=0.26P
+ AD=0.165P PS=2.52U PD=1.33U
* device instance $2986 r0 *1 39.07,66.015 sky130_fd_pr__pfet_01v8
M$2986 168 1014 1182 1182 sky130_fd_pr__pfet_01v8 L=0.15U W=1U AS=0.165P
+ AD=0.1575P PS=1.33U PD=1.315U
* device instance $2987 r0 *1 39.535,66.015 sky130_fd_pr__pfet_01v8
M$2987 1156 1154 168 168 sky130_fd_pr__pfet_01v8 L=0.15U W=1U AS=0.1575P
+ AD=0.26P PS=1.315U PD=2.52U
* device instance $2988 r0 *1 41.85,65.835 sky130_fd_pr__pfet_01v8
M$2988 1193 1183 1160 1160 sky130_fd_pr__pfet_01v8 L=0.15U W=0.64U AS=0.1664P
+ AD=0.0672P PS=1.8U PD=0.85U
* device instance $2989 r0 *1 42.21,65.835 sky130_fd_pr__pfet_01v8
M$2989 168 1159 1193 1193 sky130_fd_pr__pfet_01v8 L=0.15U W=0.64U AS=0.0672P
+ AD=0.1664P PS=0.85U PD=1.8U
* device instance $2990 r0 *1 44.875,65.725 sky130_fd_pr__pfet_01v8
M$2990 1161 1158 1160 1160 sky130_fd_pr__pfet_01v8 L=0.15U W=0.42U AS=0.15985P
+ AD=0.06405P PS=1.265U PD=0.725U
* device instance $2991 r0 *1 45.33,65.725 sky130_fd_pr__pfet_01v8
M$2991 1195 1157 1161 1161 sky130_fd_pr__pfet_01v8 L=0.15U W=0.42U AS=0.06405P
+ AD=0.07665P PS=0.725U PD=0.785U
* device instance $2992 r0 *1 45.845,65.725 sky130_fd_pr__pfet_01v8
M$2992 168 1162 1195 1195 sky130_fd_pr__pfet_01v8 L=0.15U W=0.42U AS=0.07665P
+ AD=0.178875P PS=0.785U PD=1.26U
* device instance $2993 r0 *1 43.15,65.835 sky130_fd_pr__pfet_01v8
M$2993 168 1102 1159 1159 sky130_fd_pr__pfet_01v8 L=0.15U W=0.64U AS=0.1664P
+ AD=0.0928P PS=1.8U PD=0.93U
* device instance $2994 r0 *1 43.59,65.835 sky130_fd_pr__pfet_01v8
M$2994 1194 1102 168 168 sky130_fd_pr__pfet_01v8 L=0.15U W=0.64U AS=0.0928P
+ AD=0.1152P PS=0.93U PD=1U
* device instance $2995 r0 *1 44.1,65.835 sky130_fd_pr__pfet_01v8
M$2995 1160 1164 1194 1194 sky130_fd_pr__pfet_01v8 L=0.15U W=0.64U AS=0.1152P
+ AD=0.15985P PS=1U PD=1.265U
* device instance $2996 r0 *1 46.505,65.89 sky130_fd_pr__pfet_01v8
M$2996 1162 1161 168 168 sky130_fd_pr__pfet_01v8 L=0.15U W=0.75U AS=0.178875P
+ AD=0.195P PS=1.26U PD=2.02U
* device instance $2997 r0 *1 47.445,65.725 sky130_fd_pr__pfet_01v8
M$2997 1196 1162 168 168 sky130_fd_pr__pfet_01v8 L=0.15U W=0.42U AS=0.1092P
+ AD=0.06405P PS=1.36U PD=0.725U
* device instance $2998 r0 *1 47.9,65.725 sky130_fd_pr__pfet_01v8
M$2998 1163 1157 1196 1196 sky130_fd_pr__pfet_01v8 L=0.15U W=0.42U AS=0.06405P
+ AD=0.0567P PS=0.725U PD=0.69U
* device instance $2999 r0 *1 48.32,65.725 sky130_fd_pr__pfet_01v8
M$2999 1197 1158 1163 1163 sky130_fd_pr__pfet_01v8 L=0.15U W=0.42U AS=0.0567P
+ AD=0.0882P PS=0.69U PD=0.84U
* device instance $3000 r0 *1 48.89,65.725 sky130_fd_pr__pfet_01v8
M$3000 168 1164 1197 1197 sky130_fd_pr__pfet_01v8 L=0.15U W=0.42U AS=0.0882P
+ AD=0.1113P PS=0.84U PD=1.37U
* device instance $3001 r0 *1 49.945,65.835 sky130_fd_pr__pfet_01v8
M$3001 168 1163 1164 1164 sky130_fd_pr__pfet_01v8 L=0.15U W=0.64U AS=0.1728P
+ AD=0.154P PS=1.82U PD=1.335U
* device instance $3002 r0 *1 50.43,66.015 sky130_fd_pr__pfet_01v8
M$3002 694 1163 168 168 sky130_fd_pr__pfet_01v8 L=0.15U W=1U AS=0.154P AD=0.28P
+ PS=1.335U PD=2.56U
* device instance $3003 r0 *1 60.34,65.725 sky130_fd_pr__pfet_01v8
M$3003 1165 1021 168 168 sky130_fd_pr__pfet_01v8 L=0.15U W=0.42U AS=0.1113P
+ AD=0.0609P PS=1.37U PD=0.71U
* device instance $3004 r0 *1 60.78,65.725 sky130_fd_pr__pfet_01v8
M$3004 168 1068 1165 1165 sky130_fd_pr__pfet_01v8 L=0.15U W=0.42U AS=0.0609P
+ AD=0.1841P PS=0.71U PD=1.26U
* device instance $3005 r0 *1 61.55,65.835 sky130_fd_pr__pfet_01v8
M$3005 1166 1165 168 168 sky130_fd_pr__pfet_01v8 L=0.15U W=0.64U AS=0.1841P
+ AD=0.1696P PS=1.26U PD=1.81U
* device instance $3006 r0 *1 62.61,66.015 sky130_fd_pr__pfet_01v8
M$3006 1192 1023 1167 1167 sky130_fd_pr__pfet_01v8 L=0.15U W=1U AS=0.26P
+ AD=0.135P PS=2.52U PD=1.27U
* device instance $3007 r0 *1 63.03,66.015 sky130_fd_pr__pfet_01v8
M$3007 168 1166 1192 1192 sky130_fd_pr__pfet_01v8 L=0.15U W=1U AS=0.135P
+ AD=0.135P PS=1.27U PD=1.27U
* device instance $3008 r0 *1 63.45,66.015 sky130_fd_pr__pfet_01v8
M$3008 1168 1166 168 168 sky130_fd_pr__pfet_01v8 L=0.15U W=1U AS=0.135P
+ AD=0.135P PS=1.27U PD=1.27U
* device instance $3009 r0 *1 63.87,66.015 sky130_fd_pr__pfet_01v8
M$3009 168 1023 1168 1168 sky130_fd_pr__pfet_01v8 L=0.15U W=1U AS=0.135P
+ AD=0.26P PS=1.27U PD=2.52U
* device instance $3010 r0 *1 64.81,66.015 sky130_fd_pr__pfet_01v8
M$3010 1184 1167 1168 1168 sky130_fd_pr__pfet_01v8 L=0.15U W=1U AS=0.26P
+ AD=0.3P PS=2.52U PD=2.6U
* device instance $3011 r0 *1 67.15,65.835 sky130_fd_pr__pfet_01v8
M$3011 1190 1201 1172 1172 sky130_fd_pr__pfet_01v8 L=0.15U W=0.64U AS=0.1664P
+ AD=0.0672P PS=1.8U PD=0.85U
* device instance $3012 r0 *1 67.51,65.835 sky130_fd_pr__pfet_01v8
M$3012 168 1171 1190 1190 sky130_fd_pr__pfet_01v8 L=0.15U W=0.64U AS=0.0672P
+ AD=0.1664P PS=0.85U PD=1.8U
* device instance $3013 r0 *1 70.175,65.725 sky130_fd_pr__pfet_01v8
M$3013 1173 1170 1172 1172 sky130_fd_pr__pfet_01v8 L=0.15U W=0.42U AS=0.15985P
+ AD=0.06405P PS=1.265U PD=0.725U
* device instance $3014 r0 *1 70.63,65.725 sky130_fd_pr__pfet_01v8
M$3014 1188 1169 1173 1173 sky130_fd_pr__pfet_01v8 L=0.15U W=0.42U AS=0.06405P
+ AD=0.07665P PS=0.725U PD=0.785U
* device instance $3015 r0 *1 71.145,65.725 sky130_fd_pr__pfet_01v8
M$3015 168 1174 1188 1188 sky130_fd_pr__pfet_01v8 L=0.15U W=0.42U AS=0.07665P
+ AD=0.178875P PS=0.785U PD=1.26U
* device instance $3016 r0 *1 68.45,65.835 sky130_fd_pr__pfet_01v8
M$3016 168 1102 1171 1171 sky130_fd_pr__pfet_01v8 L=0.15U W=0.64U AS=0.1664P
+ AD=0.0928P PS=1.8U PD=0.93U
* device instance $3017 r0 *1 68.89,65.835 sky130_fd_pr__pfet_01v8
M$3017 1189 1102 168 168 sky130_fd_pr__pfet_01v8 L=0.15U W=0.64U AS=0.0928P
+ AD=0.1152P PS=0.93U PD=1U
* device instance $3018 r0 *1 69.4,65.835 sky130_fd_pr__pfet_01v8
M$3018 1172 1176 1189 1189 sky130_fd_pr__pfet_01v8 L=0.15U W=0.64U AS=0.1152P
+ AD=0.15985P PS=1U PD=1.265U
* device instance $3019 r0 *1 71.805,65.89 sky130_fd_pr__pfet_01v8
M$3019 1174 1173 168 168 sky130_fd_pr__pfet_01v8 L=0.15U W=0.75U AS=0.178875P
+ AD=0.195P PS=1.26U PD=2.02U
* device instance $3020 r0 *1 72.745,65.725 sky130_fd_pr__pfet_01v8
M$3020 1187 1174 168 168 sky130_fd_pr__pfet_01v8 L=0.15U W=0.42U AS=0.1092P
+ AD=0.06405P PS=1.36U PD=0.725U
* device instance $3021 r0 *1 73.2,65.725 sky130_fd_pr__pfet_01v8
M$3021 1175 1169 1187 1187 sky130_fd_pr__pfet_01v8 L=0.15U W=0.42U AS=0.06405P
+ AD=0.0567P PS=0.725U PD=0.69U
* device instance $3022 r0 *1 73.62,65.725 sky130_fd_pr__pfet_01v8
M$3022 1186 1170 1175 1175 sky130_fd_pr__pfet_01v8 L=0.15U W=0.42U AS=0.0567P
+ AD=0.0882P PS=0.69U PD=0.84U
* device instance $3023 r0 *1 74.19,65.725 sky130_fd_pr__pfet_01v8
M$3023 168 1176 1186 1186 sky130_fd_pr__pfet_01v8 L=0.15U W=0.42U AS=0.0882P
+ AD=0.1113P PS=0.84U PD=1.37U
* device instance $3024 r0 *1 75.245,65.835 sky130_fd_pr__pfet_01v8
M$3024 168 1175 1176 1176 sky130_fd_pr__pfet_01v8 L=0.15U W=0.64U AS=0.1728P
+ AD=0.154P PS=1.82U PD=1.335U
* device instance $3025 r0 *1 75.73,66.015 sky130_fd_pr__pfet_01v8
M$3025 1123 1175 168 168 sky130_fd_pr__pfet_01v8 L=0.15U W=1U AS=0.154P
+ AD=0.28P PS=1.335U PD=2.56U
* device instance $3026 r0 *1 5.55,69.985 sky130_fd_pr__pfet_01v8
M$3026 168 1198 1285 1285 sky130_fd_pr__pfet_01v8 L=0.15U W=2U AS=0.415P
+ AD=0.275P PS=3.83U PD=2.55U
* device instance $3027 r0 *1 5.98,69.985 sky130_fd_pr__pfet_01v8
M$3027 1285 1148 168 168 sky130_fd_pr__pfet_01v8 L=0.15U W=2U AS=0.28P
+ AD=0.275P PS=2.56U PD=2.55U
* device instance $3030 r0 *1 7.25,69.985 sky130_fd_pr__pfet_01v8
M$3030 1144 1117 1285 1285 sky130_fd_pr__pfet_01v8 L=0.15U W=2U AS=0.27P
+ AD=0.495P PS=2.54U PD=3.99U
* device instance $3032 r0 *1 8.75,70.135 sky130_fd_pr__pfet_01v8
M$3032 168 936 1228 1228 sky130_fd_pr__pfet_01v8 L=0.15U W=0.64U AS=0.1664P
+ AD=0.0864P PS=1.8U PD=0.91U
* device instance $3033 r0 *1 9.17,70.135 sky130_fd_pr__pfet_01v8
M$3033 1229 1228 168 168 sky130_fd_pr__pfet_01v8 L=0.15U W=0.64U AS=0.0864P
+ AD=0.1664P PS=0.91U PD=1.8U
* device instance $3034 r0 *1 10.11,70.275 sky130_fd_pr__pfet_01v8
M$3034 1230 1145 168 168 sky130_fd_pr__pfet_01v8 L=0.15U W=0.42U AS=0.1092P
+ AD=0.05775P PS=1.36U PD=0.695U
* device instance $3035 r0 *1 10.535,70.275 sky130_fd_pr__pfet_01v8
M$3035 1231 1229 1230 1230 sky130_fd_pr__pfet_01v8 L=0.15U W=0.42U AS=0.05775P
+ AD=0.06825P PS=0.695U PD=0.745U
* device instance $3036 r0 *1 11.01,70.275 sky130_fd_pr__pfet_01v8
M$3036 1295 1228 1231 1231 sky130_fd_pr__pfet_01v8 L=0.15U W=0.42U AS=0.06825P
+ AD=0.07665P PS=0.745U PD=0.785U
* device instance $3037 r0 *1 11.525,70.275 sky130_fd_pr__pfet_01v8
M$3037 1295 1232 168 168 sky130_fd_pr__pfet_01v8 L=0.15U W=0.42U AS=0.178875P
+ AD=0.07665P PS=1.26U PD=0.785U
* device instance $3038 r0 *1 12.185,70.11 sky130_fd_pr__pfet_01v8
M$3038 1232 1231 168 168 sky130_fd_pr__pfet_01v8 L=0.15U W=0.75U AS=0.178875P
+ AD=0.1095P PS=1.26U PD=1.075U
* device instance $3039 r0 *1 12.66,70.275 sky130_fd_pr__pfet_01v8
M$3039 1233 1228 1232 1232 sky130_fd_pr__pfet_01v8 L=0.15U W=0.42U AS=0.1095P
+ AD=0.0567P PS=1.075U PD=0.69U
* device instance $3040 r0 *1 13.08,70.275 sky130_fd_pr__pfet_01v8
M$3040 1296 1229 1233 1233 sky130_fd_pr__pfet_01v8 L=0.15U W=0.42U AS=0.0567P
+ AD=0.0882P PS=0.69U PD=0.84U
* device instance $3041 r0 *1 13.65,70.275 sky130_fd_pr__pfet_01v8
M$3041 168 1234 1296 1296 sky130_fd_pr__pfet_01v8 L=0.15U W=0.42U AS=0.0882P
+ AD=0.1113P PS=0.84U PD=1.37U
* device instance $3042 r0 *1 14.7,69.985 sky130_fd_pr__pfet_01v8
M$3042 168 1233 1234 1234 sky130_fd_pr__pfet_01v8 L=0.15U W=1U AS=0.27P
+ AD=0.135P PS=2.54U PD=1.27U
* device instance $3043 r0 *1 15.12,69.985 sky130_fd_pr__pfet_01v8
M$3043 1147 1234 168 168 sky130_fd_pr__pfet_01v8 L=0.15U W=1U AS=0.135P
+ AD=0.26P PS=1.27U PD=2.52U
* device instance $3044 r0 *1 15.83,65.935 sky130_fd_pr__pfet_01v8
M$3044 1178 1147 168 168 sky130_fd_pr__pfet_01v8 L=0.15U W=0.42U AS=0.1176P
+ AD=0.0567P PS=1.4U PD=0.69U
* device instance $3045 r0 *1 16.25,65.935 sky130_fd_pr__pfet_01v8
M$3045 1178 1100 168 168 sky130_fd_pr__pfet_01v8 L=0.15U W=0.42U AS=0.16655P
+ AD=0.0567P PS=1.39U PD=0.69U
* device instance $3046 r0 *1 16.79,66.015 sky130_fd_pr__pfet_01v8
M$3046 1148 1178 168 168 sky130_fd_pr__pfet_01v8 L=0.15U W=1U AS=0.16655P
+ AD=0.475P PS=1.39U PD=2.95U
* device instance $3047 r0 *1 22.09,70.135 sky130_fd_pr__pfet_01v8
M$3047 168 936 1235 1235 sky130_fd_pr__pfet_01v8 L=0.15U W=0.64U AS=0.1664P
+ AD=0.0864P PS=1.8U PD=0.91U
* device instance $3048 r0 *1 22.51,70.135 sky130_fd_pr__pfet_01v8
M$3048 1236 1235 168 168 sky130_fd_pr__pfet_01v8 L=0.15U W=0.64U AS=0.0864P
+ AD=0.1664P PS=0.91U PD=1.8U
* device instance $3049 r0 *1 23.45,70.165 sky130_fd_pr__pfet_01v8
M$3049 1297 1255 1237 1237 sky130_fd_pr__pfet_01v8 L=0.15U W=0.64U AS=0.1664P
+ AD=0.0672P PS=1.8U PD=0.85U
* device instance $3050 r0 *1 23.81,70.165 sky130_fd_pr__pfet_01v8
M$3050 168 1238 1297 1297 sky130_fd_pr__pfet_01v8 L=0.15U W=0.64U AS=0.0672P
+ AD=0.1664P PS=0.85U PD=1.8U
* device instance $3051 r0 *1 24.75,70.165 sky130_fd_pr__pfet_01v8
M$3051 168 1102 1238 1238 sky130_fd_pr__pfet_01v8 L=0.15U W=0.64U AS=0.1664P
+ AD=0.0928P PS=1.8U PD=0.93U
* device instance $3052 r0 *1 25.19,70.165 sky130_fd_pr__pfet_01v8
M$3052 1298 1102 168 168 sky130_fd_pr__pfet_01v8 L=0.15U W=0.64U AS=0.0928P
+ AD=0.1152P PS=0.93U PD=1U
* device instance $3053 r0 *1 25.7,70.165 sky130_fd_pr__pfet_01v8
M$3053 1237 1256 1298 1298 sky130_fd_pr__pfet_01v8 L=0.15U W=0.64U AS=0.1152P
+ AD=0.15985P PS=1U PD=1.265U
* device instance $3054 r0 *1 26.475,70.275 sky130_fd_pr__pfet_01v8
M$3054 1239 1236 1237 1237 sky130_fd_pr__pfet_01v8 L=0.15U W=0.42U AS=0.15985P
+ AD=0.06405P PS=1.265U PD=0.725U
* device instance $3055 r0 *1 26.93,70.275 sky130_fd_pr__pfet_01v8
M$3055 1299 1235 1239 1239 sky130_fd_pr__pfet_01v8 L=0.15U W=0.42U AS=0.06405P
+ AD=0.07665P PS=0.725U PD=0.785U
* device instance $3056 r0 *1 27.445,70.275 sky130_fd_pr__pfet_01v8
M$3056 1299 1240 168 168 sky130_fd_pr__pfet_01v8 L=0.15U W=0.42U AS=0.178875P
+ AD=0.07665P PS=1.26U PD=0.785U
* device instance $3057 r0 *1 28.105,70.11 sky130_fd_pr__pfet_01v8
M$3057 1240 1239 168 168 sky130_fd_pr__pfet_01v8 L=0.15U W=0.75U AS=0.178875P
+ AD=0.195P PS=1.26U PD=2.02U
* device instance $3058 r0 *1 29.045,70.275 sky130_fd_pr__pfet_01v8
M$3058 1300 1240 168 168 sky130_fd_pr__pfet_01v8 L=0.15U W=0.42U AS=0.1092P
+ AD=0.06405P PS=1.36U PD=0.725U
* device instance $3059 r0 *1 29.5,70.275 sky130_fd_pr__pfet_01v8
M$3059 1241 1235 1300 1300 sky130_fd_pr__pfet_01v8 L=0.15U W=0.42U AS=0.06405P
+ AD=0.0567P PS=0.725U PD=0.69U
* device instance $3060 r0 *1 29.92,70.275 sky130_fd_pr__pfet_01v8
M$3060 1301 1236 1241 1241 sky130_fd_pr__pfet_01v8 L=0.15U W=0.42U AS=0.0567P
+ AD=0.0882P PS=0.69U PD=0.84U
* device instance $3061 r0 *1 30.49,70.275 sky130_fd_pr__pfet_01v8
M$3061 168 1256 1301 1301 sky130_fd_pr__pfet_01v8 L=0.15U W=0.42U AS=0.0882P
+ AD=0.1113P PS=0.84U PD=1.37U
* device instance $3062 r0 *1 31.545,70.165 sky130_fd_pr__pfet_01v8
M$3062 1256 1241 168 168 sky130_fd_pr__pfet_01v8 L=0.15U W=0.64U AS=0.154P
+ AD=0.1728P PS=1.335U PD=1.82U
* device instance $3063 r0 *1 32.03,69.985 sky130_fd_pr__pfet_01v8
M$3063 890 1241 168 168 sky130_fd_pr__pfet_01v8 L=0.15U W=1U AS=0.154P AD=0.28P
+ PS=1.335U PD=2.56U
* device instance $3064 r0 *1 33.13,69.985 sky130_fd_pr__pfet_01v8
M$3064 168 997 1257 1257 sky130_fd_pr__pfet_01v8 L=0.15U W=1U AS=0.26P
+ AD=0.135P PS=2.52U PD=1.27U
* device instance $3065 r0 *1 33.55,69.985 sky130_fd_pr__pfet_01v8
M$3065 1286 1257 168 168 sky130_fd_pr__pfet_01v8 L=0.15U W=4U AS=0.54P
+ AD=0.665P PS=5.08U PD=6.33U
* device instance $3069 r0 *1 35.91,69.985 sky130_fd_pr__pfet_01v8
M$3069 1242 1258 168 168 sky130_fd_pr__pfet_01v8 L=0.15U W=1U AS=0.26P
+ AD=0.135P PS=2.52U PD=1.27U
* device instance $3070 r0 *1 36.33,69.985 sky130_fd_pr__pfet_01v8
M$3070 168 71 1242 1242 sky130_fd_pr__pfet_01v8 L=0.15U W=1U AS=0.135P AD=0.26P
+ PS=1.27U PD=2.52U
* device instance $3071 r0 *1 40.49,65.865 sky130_fd_pr__pfet_01v8
M$3071 168 996 1157 1157 sky130_fd_pr__pfet_01v8 L=0.15U W=0.64U AS=0.1664P
+ AD=0.0864P PS=1.8U PD=0.91U
* device instance $3072 r0 *1 40.91,65.865 sky130_fd_pr__pfet_01v8
M$3072 1158 1157 168 168 sky130_fd_pr__pfet_01v8 L=0.15U W=0.64U AS=0.0864P
+ AD=0.1664P PS=0.91U PD=1.8U
* device instance $3073 r0 *1 41.94,70.275 sky130_fd_pr__pfet_01v8
M$3073 1243 1287 168 168 sky130_fd_pr__pfet_01v8 L=0.15U W=0.42U AS=0.1113P
+ AD=0.0609P PS=1.37U PD=0.71U
* device instance $3074 r0 *1 42.38,70.275 sky130_fd_pr__pfet_01v8
M$3074 1243 109 168 168 sky130_fd_pr__pfet_01v8 L=0.15U W=0.42U AS=0.1841P
+ AD=0.0609P PS=1.26U PD=0.71U
* device instance $3075 r0 *1 43.15,70.165 sky130_fd_pr__pfet_01v8
M$3075 1200 1243 168 168 sky130_fd_pr__pfet_01v8 L=0.15U W=0.64U AS=0.1841P
+ AD=0.1696P PS=1.26U PD=1.81U
* device instance $3076 r0 *1 44.63,70.135 sky130_fd_pr__pfet_01v8
M$3076 168 996 1244 1244 sky130_fd_pr__pfet_01v8 L=0.15U W=0.64U AS=0.1664P
+ AD=0.0864P PS=1.8U PD=0.91U
* device instance $3077 r0 *1 45.05,70.135 sky130_fd_pr__pfet_01v8
M$3077 1245 1244 168 168 sky130_fd_pr__pfet_01v8 L=0.15U W=0.64U AS=0.0864P
+ AD=0.1664P PS=0.91U PD=1.8U
* device instance $3078 r0 *1 45.99,70.165 sky130_fd_pr__pfet_01v8
M$3078 1304 1156 1246 1246 sky130_fd_pr__pfet_01v8 L=0.15U W=0.64U AS=0.1664P
+ AD=0.0672P PS=1.8U PD=0.85U
* device instance $3079 r0 *1 46.35,70.165 sky130_fd_pr__pfet_01v8
M$3079 168 1247 1304 1304 sky130_fd_pr__pfet_01v8 L=0.15U W=0.64U AS=0.0672P
+ AD=0.1664P PS=0.85U PD=1.8U
* device instance $3080 r0 *1 47.29,70.165 sky130_fd_pr__pfet_01v8
M$3080 168 16 1247 1247 sky130_fd_pr__pfet_01v8 L=0.15U W=0.64U AS=0.1664P
+ AD=0.0928P PS=1.8U PD=0.93U
* device instance $3081 r0 *1 47.73,70.165 sky130_fd_pr__pfet_01v8
M$3081 1306 16 168 168 sky130_fd_pr__pfet_01v8 L=0.15U W=0.64U AS=0.0928P
+ AD=0.1152P PS=0.93U PD=1U
* device instance $3082 r0 *1 48.24,70.165 sky130_fd_pr__pfet_01v8
M$3082 1246 1259 1306 1306 sky130_fd_pr__pfet_01v8 L=0.15U W=0.64U AS=0.1152P
+ AD=0.15985P PS=1U PD=1.265U
* device instance $3083 r0 *1 49.015,70.275 sky130_fd_pr__pfet_01v8
M$3083 1248 1245 1246 1246 sky130_fd_pr__pfet_01v8 L=0.15U W=0.42U AS=0.15985P
+ AD=0.06405P PS=1.265U PD=0.725U
* device instance $3084 r0 *1 49.47,70.275 sky130_fd_pr__pfet_01v8
M$3084 1305 1244 1248 1248 sky130_fd_pr__pfet_01v8 L=0.15U W=0.42U AS=0.06405P
+ AD=0.07665P PS=0.725U PD=0.785U
* device instance $3085 r0 *1 49.985,70.275 sky130_fd_pr__pfet_01v8
M$3085 1305 1249 168 168 sky130_fd_pr__pfet_01v8 L=0.15U W=0.42U AS=0.178875P
+ AD=0.07665P PS=1.26U PD=0.785U
* device instance $3086 r0 *1 50.645,70.11 sky130_fd_pr__pfet_01v8
M$3086 1249 1248 168 168 sky130_fd_pr__pfet_01v8 L=0.15U W=0.75U AS=0.178875P
+ AD=0.195P PS=1.26U PD=2.02U
* device instance $3087 r0 *1 51.585,70.275 sky130_fd_pr__pfet_01v8
M$3087 1303 1249 168 168 sky130_fd_pr__pfet_01v8 L=0.15U W=0.42U AS=0.1092P
+ AD=0.06405P PS=1.36U PD=0.725U
* device instance $3088 r0 *1 52.04,70.275 sky130_fd_pr__pfet_01v8
M$3088 1250 1244 1303 1303 sky130_fd_pr__pfet_01v8 L=0.15U W=0.42U AS=0.06405P
+ AD=0.0567P PS=0.725U PD=0.69U
* device instance $3089 r0 *1 52.46,70.275 sky130_fd_pr__pfet_01v8
M$3089 1302 1245 1250 1250 sky130_fd_pr__pfet_01v8 L=0.15U W=0.42U AS=0.0567P
+ AD=0.0882P PS=0.69U PD=0.84U
* device instance $3090 r0 *1 53.03,70.275 sky130_fd_pr__pfet_01v8
M$3090 168 1259 1302 1302 sky130_fd_pr__pfet_01v8 L=0.15U W=0.42U AS=0.0882P
+ AD=0.1113P PS=0.84U PD=1.37U
* device instance $3091 r0 *1 54.085,70.165 sky130_fd_pr__pfet_01v8
M$3091 1259 1250 168 168 sky130_fd_pr__pfet_01v8 L=0.15U W=0.64U AS=0.154P
+ AD=0.1728P PS=1.335U PD=1.82U
* device instance $3092 r0 *1 54.57,69.985 sky130_fd_pr__pfet_01v8
M$3092 1121 1250 168 168 sky130_fd_pr__pfet_01v8 L=0.15U W=1U AS=0.154P
+ AD=0.28P PS=1.335U PD=2.56U
* device instance $3093 r0 *1 57.12,70.275 sky130_fd_pr__pfet_01v8
M$3093 1251 1288 168 168 sky130_fd_pr__pfet_01v8 L=0.15U W=0.42U AS=0.1113P
+ AD=0.0609P PS=1.37U PD=0.71U
* device instance $3094 r0 *1 57.56,70.275 sky130_fd_pr__pfet_01v8
M$3094 1251 109 168 168 sky130_fd_pr__pfet_01v8 L=0.15U W=0.42U AS=0.1841P
+ AD=0.0609P PS=1.26U PD=0.71U
* device instance $3095 r0 *1 58.33,70.165 sky130_fd_pr__pfet_01v8
M$3095 1026 1251 168 168 sky130_fd_pr__pfet_01v8 L=0.15U W=0.64U AS=0.1841P
+ AD=0.1696P PS=1.26U PD=1.81U
* device instance $3096 r0 *1 60.27,69.985 sky130_fd_pr__pfet_01v8
M$3096 1292 1260 1252 1252 sky130_fd_pr__pfet_01v8 L=0.15U W=1U AS=0.26P
+ AD=0.135P PS=2.52U PD=1.27U
* device instance $3097 r0 *1 60.69,69.985 sky130_fd_pr__pfet_01v8
M$3097 1289 1261 1292 1292 sky130_fd_pr__pfet_01v8 L=0.15U W=1U AS=0.135P
+ AD=0.135P PS=1.27U PD=1.27U
* device instance $3098 r0 *1 61.11,69.985 sky130_fd_pr__pfet_01v8
M$3098 1292 90 1289 1289 sky130_fd_pr__pfet_01v8 L=0.15U W=1U AS=0.135P
+ AD=0.26P PS=1.27U PD=2.52U
* device instance $3099 r0 *1 62.05,69.985 sky130_fd_pr__pfet_01v8
M$3099 1289 1017 168 168 sky130_fd_pr__pfet_01v8 L=0.15U W=1U AS=0.26P
+ AD=0.165P PS=2.52U PD=1.33U
* device instance $3100 r0 *1 62.53,69.985 sky130_fd_pr__pfet_01v8
M$3100 168 1184 1289 1289 sky130_fd_pr__pfet_01v8 L=0.15U W=1U AS=0.165P
+ AD=0.1575P PS=1.33U PD=1.315U
* device instance $3101 r0 *1 62.995,69.985 sky130_fd_pr__pfet_01v8
M$3101 1290 1252 168 168 sky130_fd_pr__pfet_01v8 L=0.15U W=1U AS=0.1575P
+ AD=0.26P PS=1.315U PD=2.52U
* device instance $3102 r0 *1 63.95,69.695 sky130_fd_pr__pfet_01v8
M$3102 168 1123 1262 1262 sky130_fd_pr__pfet_01v8 L=0.15U W=0.42U AS=0.1092P
+ AD=0.14575P PS=1.36U PD=1.335U
* device instance $3103 r0 *1 64.435,69.985 sky130_fd_pr__pfet_01v8
M$3103 1021 1122 168 168 sky130_fd_pr__pfet_01v8 L=0.15U W=1U AS=0.14575P
+ AD=0.135P PS=1.335U PD=1.27U
* device instance $3104 r0 *1 64.855,69.985 sky130_fd_pr__pfet_01v8
M$3104 168 1262 1021 1021 sky130_fd_pr__pfet_01v8 L=0.15U W=1U AS=0.135P
+ AD=0.265P PS=1.27U PD=2.53U
* device instance $3105 r0 *1 65.79,65.865 sky130_fd_pr__pfet_01v8
M$3105 168 996 1169 1169 sky130_fd_pr__pfet_01v8 L=0.15U W=0.64U AS=0.1664P
+ AD=0.0864P PS=1.8U PD=0.91U
* device instance $3106 r0 *1 66.21,65.865 sky130_fd_pr__pfet_01v8
M$3106 1170 1169 168 168 sky130_fd_pr__pfet_01v8 L=0.15U W=0.64U AS=0.0864P
+ AD=0.1664P PS=0.91U PD=1.8U
* device instance $3107 r0 *1 68.175,70.08 sky130_fd_pr__pfet_01v8
M$3107 1294 71 168 168 sky130_fd_pr__pfet_01v8 L=0.15U W=0.42U AS=0.15835P
+ AD=0.07665P PS=1.395U PD=0.785U
* device instance $3108 r0 *1 68.69,70.08 sky130_fd_pr__pfet_01v8
M$3108 1253 1122 1294 1294 sky130_fd_pr__pfet_01v8 L=0.15U W=0.42U AS=0.07665P
+ AD=0.1932P PS=0.785U PD=1.34U
* device instance $3109 r0 *1 69.76,70.08 sky130_fd_pr__pfet_01v8
M$3109 1293 1291 1253 1253 sky130_fd_pr__pfet_01v8 L=0.15U W=0.42U AS=0.1932P
+ AD=0.0441P PS=1.34U PD=0.63U
* device instance $3110 r0 *1 70.12,70.08 sky130_fd_pr__pfet_01v8
M$3110 168 1254 1293 1293 sky130_fd_pr__pfet_01v8 L=0.15U W=0.42U AS=0.0441P
+ AD=0.0693P PS=0.63U PD=0.75U
* device instance $3111 r0 *1 70.6,70.08 sky130_fd_pr__pfet_01v8
M$3111 1254 71 168 168 sky130_fd_pr__pfet_01v8 L=0.15U W=0.42U AS=0.0693P
+ AD=0.1176P PS=0.75U PD=1.4U
* device instance $3112 r0 *1 67.63,69.985 sky130_fd_pr__pfet_01v8
M$3112 168 1253 1201 1201 sky130_fd_pr__pfet_01v8 L=0.15U W=1U AS=0.26P
+ AD=0.15835P PS=2.52U PD=1.395U
* device instance $3113 r0 *1 8.29,71.305 sky130_fd_pr__pfet_01v8
M$3113 168 936 1307 1307 sky130_fd_pr__pfet_01v8 L=0.15U W=0.64U AS=0.1664P
+ AD=0.0864P PS=1.8U PD=0.91U
* device instance $3114 r0 *1 8.71,71.305 sky130_fd_pr__pfet_01v8
M$3114 1308 1307 168 168 sky130_fd_pr__pfet_01v8 L=0.15U W=0.64U AS=0.0864P
+ AD=0.1664P PS=0.91U PD=1.8U
* device instance $3115 r0 *1 9.65,71.165 sky130_fd_pr__pfet_01v8
M$3115 1309 1097 168 168 sky130_fd_pr__pfet_01v8 L=0.15U W=0.42U AS=0.1092P
+ AD=0.05775P PS=1.36U PD=0.695U
* device instance $3116 r0 *1 10.075,71.165 sky130_fd_pr__pfet_01v8
M$3116 1310 1308 1309 1309 sky130_fd_pr__pfet_01v8 L=0.15U W=0.42U AS=0.05775P
+ AD=0.06825P PS=0.695U PD=0.745U
* device instance $3117 r0 *1 10.55,71.165 sky130_fd_pr__pfet_01v8
M$3117 1325 1307 1310 1310 sky130_fd_pr__pfet_01v8 L=0.15U W=0.42U AS=0.06825P
+ AD=0.07665P PS=0.745U PD=0.785U
* device instance $3118 r0 *1 11.065,71.165 sky130_fd_pr__pfet_01v8
M$3118 168 1311 1325 1325 sky130_fd_pr__pfet_01v8 L=0.15U W=0.42U AS=0.07665P
+ AD=0.178875P PS=0.785U PD=1.26U
* device instance $3119 r0 *1 12.2,71.165 sky130_fd_pr__pfet_01v8
M$3119 1312 1307 1311 1311 sky130_fd_pr__pfet_01v8 L=0.15U W=0.42U AS=0.1095P
+ AD=0.0567P PS=1.075U PD=0.69U
* device instance $3120 r0 *1 12.62,71.165 sky130_fd_pr__pfet_01v8
M$3120 1327 1308 1312 1312 sky130_fd_pr__pfet_01v8 L=0.15U W=0.42U AS=0.0567P
+ AD=0.0882P PS=0.69U PD=0.84U
* device instance $3121 r0 *1 13.19,71.165 sky130_fd_pr__pfet_01v8
M$3121 168 1313 1327 1327 sky130_fd_pr__pfet_01v8 L=0.15U W=0.42U AS=0.0882P
+ AD=0.1113P PS=0.84U PD=1.37U
* device instance $3122 r0 *1 11.725,71.33 sky130_fd_pr__pfet_01v8
M$3122 1311 1310 168 168 sky130_fd_pr__pfet_01v8 L=0.15U W=0.75U AS=0.178875P
+ AD=0.1095P PS=1.26U PD=1.075U
* device instance $3123 r0 *1 14.24,71.455 sky130_fd_pr__pfet_01v8
M$3123 168 1312 1313 1313 sky130_fd_pr__pfet_01v8 L=0.15U W=1U AS=0.27P
+ AD=0.135P PS=2.54U PD=1.27U
* device instance $3124 r0 *1 14.66,71.455 sky130_fd_pr__pfet_01v8
M$3124 1119 1313 168 168 sky130_fd_pr__pfet_01v8 L=0.15U W=1U AS=0.135P
+ AD=0.26P PS=1.27U PD=2.52U
* device instance $3125 r0 *1 26.775,71.36 sky130_fd_pr__pfet_01v8
M$3125 1335 71 168 168 sky130_fd_pr__pfet_01v8 L=0.15U W=0.42U AS=0.15835P
+ AD=0.07665P PS=1.395U PD=0.785U
* device instance $3126 r0 *1 27.29,71.36 sky130_fd_pr__pfet_01v8
M$3126 1314 995 1335 1335 sky130_fd_pr__pfet_01v8 L=0.15U W=0.42U AS=0.07665P
+ AD=0.1932P PS=0.785U PD=1.34U
* device instance $3127 r0 *1 28.36,71.36 sky130_fd_pr__pfet_01v8
M$3127 1336 1330 1314 1314 sky130_fd_pr__pfet_01v8 L=0.15U W=0.42U AS=0.1932P
+ AD=0.0441P PS=1.34U PD=0.63U
* device instance $3128 r0 *1 28.72,71.36 sky130_fd_pr__pfet_01v8
M$3128 168 1339 1336 1336 sky130_fd_pr__pfet_01v8 L=0.15U W=0.42U AS=0.0441P
+ AD=0.0693P PS=0.63U PD=0.75U
* device instance $3129 r0 *1 29.2,71.36 sky130_fd_pr__pfet_01v8
M$3129 1339 71 168 168 sky130_fd_pr__pfet_01v8 L=0.15U W=0.42U AS=0.0693P
+ AD=0.1176P PS=0.75U PD=1.4U
* device instance $3130 r0 *1 26.23,71.455 sky130_fd_pr__pfet_01v8
M$3130 168 1314 1255 1255 sky130_fd_pr__pfet_01v8 L=0.15U W=1U AS=0.26P
+ AD=0.15835P PS=2.52U PD=1.395U
* device instance $3131 r0 *1 45.175,71.36 sky130_fd_pr__pfet_01v8
M$3131 1337 71 168 168 sky130_fd_pr__pfet_01v8 L=0.15U W=0.42U AS=0.15835P
+ AD=0.07665P PS=1.395U PD=0.785U
* device instance $3132 r0 *1 45.69,71.36 sky130_fd_pr__pfet_01v8
M$3132 1315 1121 1337 1337 sky130_fd_pr__pfet_01v8 L=0.15U W=0.42U AS=0.07665P
+ AD=0.1932P PS=0.785U PD=1.34U
* device instance $3133 r0 *1 46.76,71.36 sky130_fd_pr__pfet_01v8
M$3133 1338 1331 1315 1315 sky130_fd_pr__pfet_01v8 L=0.15U W=0.42U AS=0.1932P
+ AD=0.0441P PS=1.34U PD=0.63U
* device instance $3134 r0 *1 47.12,71.36 sky130_fd_pr__pfet_01v8
M$3134 168 1340 1338 1338 sky130_fd_pr__pfet_01v8 L=0.15U W=0.42U AS=0.0441P
+ AD=0.0693P PS=0.63U PD=0.75U
* device instance $3135 r0 *1 47.6,71.36 sky130_fd_pr__pfet_01v8
M$3135 1340 71 168 168 sky130_fd_pr__pfet_01v8 L=0.15U W=0.42U AS=0.0693P
+ AD=0.1176P PS=0.75U PD=1.4U
* device instance $3136 r0 *1 44.63,71.455 sky130_fd_pr__pfet_01v8
M$3136 168 1315 1183 1183 sky130_fd_pr__pfet_01v8 L=0.15U W=1U AS=0.26P
+ AD=0.15835P PS=2.52U PD=1.395U
* device instance $3137 r0 *1 58.5,71.165 sky130_fd_pr__pfet_01v8
M$3137 1316 1332 168 168 sky130_fd_pr__pfet_01v8 L=0.15U W=0.42U AS=0.1113P
+ AD=0.0609P PS=1.37U PD=0.71U
* device instance $3138 r0 *1 58.94,71.165 sky130_fd_pr__pfet_01v8
M$3138 168 109 1316 1316 sky130_fd_pr__pfet_01v8 L=0.15U W=0.42U AS=0.0609P
+ AD=0.1841P PS=0.71U PD=1.26U
* device instance $3139 r0 *1 59.71,71.275 sky130_fd_pr__pfet_01v8
M$3139 1260 1316 168 168 sky130_fd_pr__pfet_01v8 L=0.15U W=0.64U AS=0.1841P
+ AD=0.1696P PS=1.26U PD=1.81U
* device instance $3140 r0 *1 60.73,71.305 sky130_fd_pr__pfet_01v8
M$3140 168 996 1317 1317 sky130_fd_pr__pfet_01v8 L=0.15U W=0.64U AS=0.1664P
+ AD=0.0864P PS=1.8U PD=0.91U
* device instance $3141 r0 *1 61.15,71.305 sky130_fd_pr__pfet_01v8
M$3141 1318 1317 168 168 sky130_fd_pr__pfet_01v8 L=0.15U W=0.64U AS=0.0864P
+ AD=0.1664P PS=0.91U PD=1.8U
* device instance $3142 r0 *1 62.09,71.275 sky130_fd_pr__pfet_01v8
M$3142 1334 1290 1319 1319 sky130_fd_pr__pfet_01v8 L=0.15U W=0.64U AS=0.1664P
+ AD=0.0672P PS=1.8U PD=0.85U
* device instance $3143 r0 *1 62.45,71.275 sky130_fd_pr__pfet_01v8
M$3143 168 1320 1334 1334 sky130_fd_pr__pfet_01v8 L=0.15U W=0.64U AS=0.0672P
+ AD=0.1664P PS=0.85U PD=1.8U
* device instance $3144 r0 *1 65.115,71.165 sky130_fd_pr__pfet_01v8
M$3144 1321 1318 1319 1319 sky130_fd_pr__pfet_01v8 L=0.15U W=0.42U AS=0.15985P
+ AD=0.06405P PS=1.265U PD=0.725U
* device instance $3145 r0 *1 65.57,71.165 sky130_fd_pr__pfet_01v8
M$3145 1329 1317 1321 1321 sky130_fd_pr__pfet_01v8 L=0.15U W=0.42U AS=0.06405P
+ AD=0.07665P PS=0.725U PD=0.785U
* device instance $3146 r0 *1 66.085,71.165 sky130_fd_pr__pfet_01v8
M$3146 168 1322 1329 1329 sky130_fd_pr__pfet_01v8 L=0.15U W=0.42U AS=0.07665P
+ AD=0.178875P PS=0.785U PD=1.26U
* device instance $3147 r0 *1 63.39,71.275 sky130_fd_pr__pfet_01v8
M$3147 168 16 1320 1320 sky130_fd_pr__pfet_01v8 L=0.15U W=0.64U AS=0.1664P
+ AD=0.0928P PS=1.8U PD=0.93U
* device instance $3148 r0 *1 63.83,71.275 sky130_fd_pr__pfet_01v8
M$3148 1333 16 168 168 sky130_fd_pr__pfet_01v8 L=0.15U W=0.64U AS=0.0928P
+ AD=0.1152P PS=0.93U PD=1U
* device instance $3149 r0 *1 64.34,71.275 sky130_fd_pr__pfet_01v8
M$3149 1319 1324 1333 1333 sky130_fd_pr__pfet_01v8 L=0.15U W=0.64U AS=0.1152P
+ AD=0.15985P PS=1U PD=1.265U
* device instance $3150 r0 *1 66.745,71.33 sky130_fd_pr__pfet_01v8
M$3150 1322 1321 168 168 sky130_fd_pr__pfet_01v8 L=0.15U W=0.75U AS=0.178875P
+ AD=0.195P PS=1.26U PD=2.02U
* device instance $3151 r0 *1 65.79,75.425 sky130_fd_pr__pfet_01v8
M$3151 168 1123 1353 1353 sky130_fd_pr__pfet_01v8 L=0.15U W=1U AS=0.26P
+ AD=0.135P PS=2.52U PD=1.27U
* device instance $3152 r0 *1 66.21,75.425 sky130_fd_pr__pfet_01v8
M$3152 1261 1353 168 168 sky130_fd_pr__pfet_01v8 L=0.15U W=4U AS=0.54P
+ AD=0.665P PS=5.08U PD=6.33U
* device instance $3156 r0 *1 67.685,71.165 sky130_fd_pr__pfet_01v8
M$3156 1328 1322 168 168 sky130_fd_pr__pfet_01v8 L=0.15U W=0.42U AS=0.1092P
+ AD=0.06405P PS=1.36U PD=0.725U
* device instance $3157 r0 *1 68.14,71.165 sky130_fd_pr__pfet_01v8
M$3157 1323 1317 1328 1328 sky130_fd_pr__pfet_01v8 L=0.15U W=0.42U AS=0.06405P
+ AD=0.0567P PS=0.725U PD=0.69U
* device instance $3158 r0 *1 68.56,71.165 sky130_fd_pr__pfet_01v8
M$3158 1326 1318 1323 1323 sky130_fd_pr__pfet_01v8 L=0.15U W=0.42U AS=0.0567P
+ AD=0.0882P PS=0.69U PD=0.84U
* device instance $3159 r0 *1 69.13,71.165 sky130_fd_pr__pfet_01v8
M$3159 168 1324 1326 1326 sky130_fd_pr__pfet_01v8 L=0.15U W=0.42U AS=0.0882P
+ AD=0.1113P PS=0.84U PD=1.37U
* device instance $3160 r0 *1 70.185,71.275 sky130_fd_pr__pfet_01v8
M$3160 168 1323 1324 1324 sky130_fd_pr__pfet_01v8 L=0.15U W=0.64U AS=0.1728P
+ AD=0.154P PS=1.82U PD=1.335U
* device instance $3161 r0 *1 70.67,71.455 sky130_fd_pr__pfet_01v8
M$3161 1122 1323 168 168 sky130_fd_pr__pfet_01v8 L=0.15U W=1U AS=0.154P
+ AD=0.28P PS=1.335U PD=2.56U
.ENDS gcd
