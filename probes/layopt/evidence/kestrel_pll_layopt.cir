* layopt extraction of kestrel_pll_top (sky130)
.SUBCKT kestrel_pll_top
M1 1 11 5 5 sky130_fd_pr__nfet_01v8 L=0.15U W=0.3U AS=0.075P AD=0.15P PS=1.1U PD=1.6U
M2 5 12 4 4 sky130_fd_pr__nfet_01v8 L=0.36U W=4.61U AS=1.1525P AD=2.305P PS=9.72U PD=10.22U
M3 17 14 16 16 sky130_fd_pr__pfet_01v8 L=0.36U W=4.095U AS=1.02375P AD=1.02375P PS=4.595U PD=4.595U
M4 18 15 17 17 sky130_fd_pr__pfet_01v8 L=0.36U W=4.095U AS=1.02375P AD=2.0475P PS=4.595U PD=9.19U
M5 16 13 9 9 sky130_fd_pr__pfet_01v8 L=0.36U W=4.095U AS=1.02375P AD=1.02375P PS=8.69U PD=4.595U
M6 1 19 5 5 sky130_fd_pr__nfet_01v8 L=0.15U W=0.3U AS=0.075P AD=0.15P PS=1.1U PD=1.6U
M7 24 20 23 23 sky130_fd_pr__pfet_01v8 L=0.36U W=4.095U AS=1.02375P AD=1.02375P PS=8.69U PD=4.595U
M8 25 21 24 24 sky130_fd_pr__pfet_01v8 L=0.36U W=4.095U AS=1.02375P AD=1.02375P PS=4.595U PD=4.595U
M9 26 22 25 25 sky130_fd_pr__pfet_01v8 L=0.36U W=4.095U AS=1.02375P AD=2.0475P PS=4.595U PD=9.19U
M10 32 29 31 31 sky130_fd_pr__pfet_01v8 L=0.36U W=4.095U AS=1.02375P AD=2.0475P PS=4.595U PD=9.19U
M11 30 27 10 10 sky130_fd_pr__pfet_01v8 L=0.36U W=4.095U AS=1.02375P AD=1.02375P PS=8.69U PD=4.595U
M12 31 28 30 30 sky130_fd_pr__pfet_01v8 L=0.36U W=4.095U AS=1.02375P AD=1.02375P PS=4.595U PD=4.595U
M13 37 33 36 36 sky130_fd_pr__pfet_01v8 L=0.36U W=4.095U AS=1.02375P AD=1.02375P PS=8.69U PD=4.595U
M14 38 34 37 37 sky130_fd_pr__pfet_01v8 L=0.36U W=4.095U AS=1.02375P AD=1.02375P PS=4.595U PD=4.595U
M15 39 35 38 38 sky130_fd_pr__pfet_01v8 L=0.36U W=4.095U AS=1.02375P AD=2.0475P PS=4.595U PD=9.19U
M16 1 47 41 41 sky130_fd_pr__nfet_01v8 L=0.15U W=0.3U AS=0.075P AD=0.15P PS=1.1U PD=1.6U
M17 41 48 40 40 sky130_fd_pr__nfet_01v8 L=0.36U W=4.61U AS=1.1525P AD=2.305P PS=9.72U PD=10.22U
M18 53 50 52 52 sky130_fd_pr__pfet_01v8 L=0.36U W=4.095U AS=1.02375P AD=1.02375P PS=4.595U PD=4.595U
M19 54 51 53 53 sky130_fd_pr__pfet_01v8 L=0.36U W=4.095U AS=1.02375P AD=2.0475P PS=4.595U PD=9.19U
M20 52 49 45 45 sky130_fd_pr__pfet_01v8 L=0.36U W=4.095U AS=1.02375P AD=1.02375P PS=8.69U PD=4.595U
M21 1 55 41 41 sky130_fd_pr__nfet_01v8 L=0.15U W=0.3U AS=0.075P AD=0.15P PS=1.1U PD=1.6U
M22 60 56 59 59 sky130_fd_pr__pfet_01v8 L=0.36U W=4.095U AS=1.02375P AD=1.02375P PS=8.69U PD=4.595U
M23 61 57 60 60 sky130_fd_pr__pfet_01v8 L=0.36U W=4.095U AS=1.02375P AD=1.02375P PS=4.595U PD=4.595U
M24 62 58 61 61 sky130_fd_pr__pfet_01v8 L=0.36U W=4.095U AS=1.02375P AD=2.0475P PS=4.595U PD=9.19U
M25 68 65 67 67 sky130_fd_pr__pfet_01v8 L=0.36U W=4.095U AS=1.02375P AD=2.0475P PS=4.595U PD=9.19U
M26 66 63 46 46 sky130_fd_pr__pfet_01v8 L=0.36U W=4.095U AS=1.02375P AD=1.02375P PS=8.69U PD=4.595U
M27 67 64 66 66 sky130_fd_pr__pfet_01v8 L=0.36U W=4.095U AS=1.02375P AD=1.02375P PS=4.595U PD=4.595U
M28 73 69 72 72 sky130_fd_pr__pfet_01v8 L=0.36U W=4.095U AS=1.02375P AD=1.02375P PS=8.69U PD=4.595U
M29 74 70 73 73 sky130_fd_pr__pfet_01v8 L=0.36U W=4.095U AS=1.02375P AD=1.02375P PS=4.595U PD=4.595U
M30 75 71 74 74 sky130_fd_pr__pfet_01v8 L=0.36U W=4.095U AS=1.02375P AD=2.0475P PS=4.595U PD=9.19U
M31 1 83 77 77 sky130_fd_pr__nfet_01v8 L=0.15U W=0.3U AS=0.075P AD=0.15P PS=1.1U PD=1.6U
M32 77 84 76 76 sky130_fd_pr__nfet_01v8 L=0.36U W=4.61U AS=1.1525P AD=2.305P PS=9.72U PD=10.22U
M33 89 86 88 88 sky130_fd_pr__pfet_01v8 L=0.36U W=4.095U AS=1.02375P AD=1.02375P PS=4.595U PD=4.595U
M34 90 87 89 89 sky130_fd_pr__pfet_01v8 L=0.36U W=4.095U AS=1.02375P AD=2.0475P PS=4.595U PD=9.19U
M35 88 85 81 81 sky130_fd_pr__pfet_01v8 L=0.36U W=4.095U AS=1.02375P AD=1.02375P PS=8.69U PD=4.595U
M36 1 91 77 77 sky130_fd_pr__nfet_01v8 L=0.15U W=0.3U AS=0.075P AD=0.15P PS=1.1U PD=1.6U
M37 96 92 95 95 sky130_fd_pr__pfet_01v8 L=0.36U W=4.095U AS=1.02375P AD=1.02375P PS=8.69U PD=4.595U
M38 97 93 96 96 sky130_fd_pr__pfet_01v8 L=0.36U W=4.095U AS=1.02375P AD=1.02375P PS=4.595U PD=4.595U
M39 98 94 97 97 sky130_fd_pr__pfet_01v8 L=0.36U W=4.095U AS=1.02375P AD=2.0475P PS=4.595U PD=9.19U
M40 104 101 103 103 sky130_fd_pr__pfet_01v8 L=0.36U W=4.095U AS=1.02375P AD=2.0475P PS=4.595U PD=9.19U
M41 102 99 82 82 sky130_fd_pr__pfet_01v8 L=0.36U W=4.095U AS=1.02375P AD=1.02375P PS=8.69U PD=4.595U
M42 103 100 102 102 sky130_fd_pr__pfet_01v8 L=0.36U W=4.095U AS=1.02375P AD=1.02375P PS=4.595U PD=4.595U
M43 109 105 108 108 sky130_fd_pr__pfet_01v8 L=0.36U W=4.095U AS=1.02375P AD=1.02375P PS=8.69U PD=4.595U
M44 110 106 109 109 sky130_fd_pr__pfet_01v8 L=0.36U W=4.095U AS=1.02375P AD=1.02375P PS=4.595U PD=4.595U
M45 111 107 110 110 sky130_fd_pr__pfet_01v8 L=0.36U W=4.095U AS=1.02375P AD=2.0475P PS=4.595U PD=9.19U
M46 1 119 113 113 sky130_fd_pr__nfet_01v8 L=0.15U W=0.3U AS=0.075P AD=0.15P PS=1.1U PD=1.6U
M47 113 120 112 112 sky130_fd_pr__nfet_01v8 L=0.36U W=4.61U AS=1.1525P AD=2.305P PS=9.72U PD=10.22U
M48 125 122 124 124 sky130_fd_pr__pfet_01v8 L=0.36U W=4.095U AS=1.02375P AD=1.02375P PS=4.595U PD=4.595U
M49 126 123 125 125 sky130_fd_pr__pfet_01v8 L=0.36U W=4.095U AS=1.02375P AD=2.0475P PS=4.595U PD=9.19U
M50 124 121 117 117 sky130_fd_pr__pfet_01v8 L=0.36U W=4.095U AS=1.02375P AD=1.02375P PS=8.69U PD=4.595U
M51 1 127 113 113 sky130_fd_pr__nfet_01v8 L=0.15U W=0.3U AS=0.075P AD=0.15P PS=1.1U PD=1.6U
M52 132 128 131 131 sky130_fd_pr__pfet_01v8 L=0.36U W=4.095U AS=1.02375P AD=1.02375P PS=8.69U PD=4.595U
M53 133 129 132 132 sky130_fd_pr__pfet_01v8 L=0.36U W=4.095U AS=1.02375P AD=1.02375P PS=4.595U PD=4.595U
M54 134 130 133 133 sky130_fd_pr__pfet_01v8 L=0.36U W=4.095U AS=1.02375P AD=2.0475P PS=4.595U PD=9.19U
M55 140 137 139 139 sky130_fd_pr__pfet_01v8 L=0.36U W=4.095U AS=1.02375P AD=2.0475P PS=4.595U PD=9.19U
M56 138 135 118 118 sky130_fd_pr__pfet_01v8 L=0.36U W=4.095U AS=1.02375P AD=1.02375P PS=8.69U PD=4.595U
M57 139 136 138 138 sky130_fd_pr__pfet_01v8 L=0.36U W=4.095U AS=1.02375P AD=1.02375P PS=4.595U PD=4.595U
M58 145 141 144 144 sky130_fd_pr__pfet_01v8 L=0.36U W=4.095U AS=1.02375P AD=1.02375P PS=8.69U PD=4.595U
M59 146 142 145 145 sky130_fd_pr__pfet_01v8 L=0.36U W=4.095U AS=1.02375P AD=1.02375P PS=4.595U PD=4.595U
M60 147 143 146 146 sky130_fd_pr__pfet_01v8 L=0.36U W=4.095U AS=1.02375P AD=2.0475P PS=4.595U PD=9.19U
M61 150 148 149 149 sky130_fd_pr__pfet_01v8 L=0.15U W=1U AS=0.25P AD=0.5P PS=2.5U PD=3U
M62 153 151 152 152 sky130_fd_pr__nfet_01v8 L=0.15U W=0.5U AS=0.125P AD=0.25P PS=1.5U PD=2U
M63 156 154 155 155 sky130_fd_pr__nfet_01v8 L=0.15U W=0.5U AS=0.125P AD=0.25P PS=1.5U PD=2U
M64 159 157 158 158 sky130_fd_pr__nfet_01v8 L=0.15U W=0.5U AS=0.125P AD=0.25P PS=1.5U PD=2U
M65 162 160 161 161 sky130_fd_pr__pfet_01v8 L=0.15U W=1U AS=0.25P AD=0.5P PS=2.5U PD=3U
M66 165 163 164 164 sky130_fd_pr__pfet_01v8 L=0.15U W=1U AS=0.25P AD=0.5P PS=2.5U PD=3U
M67 168 166 167 167 sky130_fd_pr__pfet_01v8 L=0.15U W=1U AS=0.25P AD=0.5P PS=2.5U PD=3U
M68 171 169 170 170 sky130_fd_pr__nfet_01v8 L=0.15U W=0.5U AS=0.125P AD=0.25P PS=1.5U PD=2U
M69 174 172 173 173 sky130_fd_pr__nfet_01v8 L=0.15U W=0.5U AS=0.125P AD=0.25P PS=1.5U PD=2U
M70 177 175 176 176 sky130_fd_pr__nfet_01v8 L=0.15U W=0.5U AS=0.125P AD=0.25P PS=1.5U PD=2U
M71 180 178 179 179 sky130_fd_pr__pfet_01v8 L=0.15U W=1U AS=0.25P AD=0.5P PS=2.5U PD=3U
M72 183 181 182 182 sky130_fd_pr__pfet_01v8 L=0.15U W=1U AS=0.25P AD=0.5P PS=2.5U PD=3U
M73 186 184 185 185 sky130_fd_pr__nfet_01v8 L=0.15U W=0.5U AS=0.125P AD=0.25P PS=1.5U PD=2U
M74 189 187 188 188 sky130_fd_pr__nfet_01v8 L=0.15U W=0.5U AS=0.125P AD=0.25P PS=1.5U PD=2U
M75 192 190 191 191 sky130_fd_pr__pfet_01v8 L=0.15U W=1U AS=0.25P AD=0.5P PS=2.5U PD=3U
M76 195 193 194 194 sky130_fd_pr__pfet_01v8 L=0.15U W=1U AS=0.25P AD=0.5P PS=2.5U PD=3U
M77 198 196 197 197 sky130_fd_pr__pfet_01v8 L=0.15U W=1U AS=0.25P AD=0.5P PS=2.5U PD=3U
M78 201 199 200 200 sky130_fd_pr__nfet_01v8 L=0.15U W=0.5U AS=0.125P AD=0.25P PS=1.5U PD=2U
M79 206 202 205 205 sky130_fd_pr__pfet_01v8 L=0.36U W=4.265U AS=1.06625P AD=1.06625P PS=9.03U PD=4.765U
M80 207 203 206 206 sky130_fd_pr__pfet_01v8 L=0.36U W=4.265U AS=1.06625P AD=1.06625P PS=4.765U PD=4.765U
M81 208 204 207 207 sky130_fd_pr__pfet_01v8 L=0.36U W=4.265U AS=1.06625P AD=2.1325P PS=4.765U PD=9.53U
M82 213 209 212 212 sky130_fd_pr__pfet_01v8 L=0.36U W=4.265U AS=1.06625P AD=1.06625P PS=9.03U PD=4.765U
M83 214 210 213 213 sky130_fd_pr__pfet_01v8 L=0.36U W=4.265U AS=1.06625P AD=1.06625P PS=4.765U PD=4.765U
M84 215 211 214 214 sky130_fd_pr__pfet_01v8 L=0.36U W=4.265U AS=1.06625P AD=2.1325P PS=4.765U PD=9.53U
M85 223 216 222 222 sky130_fd_pr__pfet_01v8 L=0.15U W=4.265U AS=1.06625P AD=1.06625P PS=9.03U PD=4.765U
M86 224 217 223 223 sky130_fd_pr__pfet_01v8 L=0.15U W=4.265U AS=1.06625P AD=1.06625P PS=4.765U PD=4.765U
M87 225 218 224 224 sky130_fd_pr__pfet_01v8 L=0.15U W=4.265U AS=1.06625P AD=1.06625P PS=4.765U PD=4.765U
M88 226 219 225 225 sky130_fd_pr__pfet_01v8 L=0.15U W=4.265U AS=1.06625P AD=1.06625P PS=4.765U PD=4.765U
M89 227 220 226 226 sky130_fd_pr__pfet_01v8 L=0.15U W=4.265U AS=1.06625P AD=1.06625P PS=4.765U PD=4.765U
M90 228 221 227 227 sky130_fd_pr__pfet_01v8 L=0.15U W=4.265U AS=1.06625P AD=2.1325P PS=4.765U PD=9.53U
M91 231 229 230 230 sky130_fd_pr__nfet_01v8 L=0.36U W=4.265U AS=1.06625P AD=2.1325P PS=9.03U PD=9.53U
M92 234 232 233 233 sky130_fd_pr__nfet_01v8 L=0.36U W=4.265U AS=1.06625P AD=2.1325P PS=9.03U PD=9.53U
M93 241 237 240 240 sky130_fd_pr__nfet_01v8 L=0.15U W=4.265U AS=1.06625P AD=2.1325P PS=4.765U PD=9.53U
M94 239 235 238 238 sky130_fd_pr__nfet_01v8 L=0.15U W=4.265U AS=1.06625P AD=1.06625P PS=9.03U PD=4.765U
M95 240 236 239 239 sky130_fd_pr__nfet_01v8 L=0.15U W=4.265U AS=1.06625P AD=1.06625P PS=4.765U PD=4.765U
M96 252 250 251 251 sky130_fd_pr__pfet_01v8 L=0.15U W=1.2U AS=0.3P AD=0.6P PS=2.9U PD=3.4U
M97 255 253 254 254 sky130_fd_pr__nfet_01v8 L=0.15U W=0.6U AS=0.15P AD=0.3P PS=1.7U PD=2.2U
M98 258 256 257 257 sky130_fd_pr__pfet_01v8 L=0.15U W=1.2U AS=0.3P AD=0.6P PS=2.9U PD=3.4U
M99 261 259 260 260 sky130_fd_pr__nfet_01v8 L=0.15U W=0.6U AS=0.15P AD=0.3P PS=1.7U PD=2.2U
M100 264 262 263 263 sky130_fd_pr__pfet_01v8 L=0.15U W=1.2U AS=0.3P AD=0.6P PS=2.9U PD=3.4U
M101 267 265 266 266 sky130_fd_pr__nfet_01v8 L=0.15U W=0.6U AS=0.15P AD=0.3P PS=1.7U PD=2.2U
M102 270 268 269 269 sky130_fd_pr__pfet_01v8 L=0.15U W=1.2U AS=0.3P AD=0.6P PS=2.9U PD=3.4U
M103 273 271 272 272 sky130_fd_pr__nfet_01v8 L=0.15U W=0.6U AS=0.15P AD=0.3P PS=1.7U PD=2.2U
M104 276 274 275 275 sky130_fd_pr__pfet_01v8 L=0.15U W=1.2U AS=0.3P AD=0.6P PS=2.9U PD=3.4U
M105 279 277 278 278 sky130_fd_pr__nfet_01v8 L=0.15U W=0.6U AS=0.15P AD=0.3P PS=1.7U PD=2.2U
M106 282 280 281 281 sky130_fd_pr__pfet_01v8 L=0.15U W=1.2U AS=0.3P AD=0.6P PS=2.9U PD=3.4U
M107 285 283 284 284 sky130_fd_pr__nfet_01v8 L=0.15U W=0.6U AS=0.15P AD=0.3P PS=1.7U PD=2.2U
M108 288 286 287 287 sky130_fd_pr__pfet_01v8 L=0.15U W=1.2U AS=0.3P AD=0.6P PS=2.9U PD=3.4U
M109 291 289 290 290 sky130_fd_pr__nfet_01v8 L=0.15U W=0.6U AS=0.15P AD=0.3P PS=1.7U PD=2.2U
M110 294 292 293 293 sky130_fd_pr__pfet_01v8 L=0.15U W=1.2U AS=0.3P AD=0.6P PS=2.9U PD=3.4U
M111 297 295 296 296 sky130_fd_pr__nfet_01v8 L=0.15U W=0.6U AS=0.15P AD=0.3P PS=1.7U PD=2.2U
M112 300 298 299 299 sky130_fd_pr__pfet_01v8 L=0.15U W=1.2U AS=0.3P AD=0.6P PS=2.9U PD=3.4U
M113 303 301 302 302 sky130_fd_pr__nfet_01v8 L=0.15U W=0.6U AS=0.15P AD=0.3P PS=1.7U PD=2.2U
M114 306 304 305 305 sky130_fd_pr__pfet_01v8 L=0.15U W=1.2U AS=0.3P AD=0.6P PS=2.9U PD=3.4U
M115 309 307 308 308 sky130_fd_pr__nfet_01v8 L=0.15U W=0.6U AS=0.15P AD=0.3P PS=1.7U PD=2.2U
M116 312 310 311 311 sky130_fd_pr__pfet_01v8 L=0.15U W=1.2U AS=0.3P AD=0.6P PS=2.9U PD=3.4U
M117 315 313 314 314 sky130_fd_pr__nfet_01v8 L=0.15U W=0.6U AS=0.15P AD=0.3P PS=1.7U PD=2.2U
M118 318 316 317 317 sky130_fd_pr__pfet_01v8 L=0.15U W=1.2U AS=0.3P AD=0.6P PS=2.9U PD=3.4U
M119 321 319 320 320 sky130_fd_pr__nfet_01v8 L=0.15U W=0.6U AS=0.15P AD=0.3P PS=1.7U PD=2.2U
M120 324 322 323 323 sky130_fd_pr__pfet_01v8 L=0.15U W=1.2U AS=0.3P AD=0.6P PS=2.9U PD=3.4U
M121 327 325 326 326 sky130_fd_pr__nfet_01v8 L=0.15U W=0.6U AS=0.15P AD=0.3P PS=1.7U PD=2.2U
M122 330 328 329 329 sky130_fd_pr__pfet_01v8 L=0.15U W=1.2U AS=0.3P AD=0.6P PS=2.9U PD=3.4U
M123 333 331 332 332 sky130_fd_pr__nfet_01v8 L=0.15U W=0.6U AS=0.15P AD=0.3P PS=1.7U PD=2.2U
M124 336 334 335 335 sky130_fd_pr__pfet_01v8 L=0.15U W=1.2U AS=0.3P AD=0.6P PS=2.9U PD=3.4U
M125 339 337 338 338 sky130_fd_pr__nfet_01v8 L=0.15U W=0.6U AS=0.15P AD=0.3P PS=1.7U PD=2.2U
M126 342 340 341 341 sky130_fd_pr__pfet_01v8 L=0.15U W=1.2U AS=0.3P AD=0.6P PS=2.9U PD=3.4U
M127 345 343 344 344 sky130_fd_pr__nfet_01v8 L=0.15U W=0.6U AS=0.15P AD=0.3P PS=1.7U PD=2.2U
M128 348 346 347 347 sky130_fd_pr__pfet_01v8 L=0.15U W=1.2U AS=0.3P AD=0.6P PS=2.9U PD=3.4U
M129 351 349 350 350 sky130_fd_pr__nfet_01v8 L=0.15U W=0.6U AS=0.15P AD=0.3P PS=1.7U PD=2.2U
M130 354 352 353 353 sky130_fd_pr__pfet_01v8 L=0.15U W=1.2U AS=0.3P AD=0.6P PS=2.9U PD=3.4U
M131 357 355 356 356 sky130_fd_pr__nfet_01v8 L=0.15U W=0.6U AS=0.15P AD=0.3P PS=1.7U PD=2.2U
.ENDS kestrel_pll_top
