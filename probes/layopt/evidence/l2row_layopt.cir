* layopt extraction of l2row (sky130)
.SUBCKT l2row
M1 n1 3 VPWR VPWR sky130_fd_pr__pfet_01v8 L=0.15U W=1U AS=0.26P AD=0.26P PS=2.52U PD=2.52U
M2 n1 3 VGND VGND sky130_fd_pr__nfet_01v8 L=0.15U W=0.65U AS=0.169P AD=0.169P PS=1.82U PD=1.82U
M3 VPWR n1 n2 n2 sky130_fd_pr__pfet_01v8 L=0.15U W=1U AS=0.135P AD=0.26P PS=1.27U PD=2.52U
M4 n2 5 VPWR VPWR sky130_fd_pr__pfet_01v8 L=0.15U W=1U AS=0.26P AD=0.135P PS=2.52U PD=1.27U
M5 n2 n1 28 28 sky130_fd_pr__nfet_01v8 L=0.15U W=0.65U AS=0.08775P AD=0.169P PS=0.92U PD=1.82U
M6 28 5 VGND VGND sky130_fd_pr__nfet_01v8 L=0.15U W=0.65U AS=0.169P AD=0.08775P PS=1.82U PD=0.92U
M7 n3 n2 VGND VGND sky130_fd_pr__nfet_01v8 L=0.15U W=1.3U AS=0.338P AD=0.1755P PS=3.64U PD=1.84U
M8 n3 n2 VPWR VPWR sky130_fd_pr__pfet_01v8 L=0.15U W=2U AS=0.52P AD=0.27P PS=5.04U PD=2.54U
M9 q 14 VPWR VPWR sky130_fd_pr__pfet_01v8 L=0.15U W=1U AS=0.135P AD=0.26P PS=1.27U PD=2.52U
M10 VPWR 16 14 14 sky130_fd_pr__pfet_01v8 L=0.15U W=1U AS=0.27P AD=0.135P PS=2.54U PD=1.27U
M11 9 8 VPWR VPWR sky130_fd_pr__pfet_01v8 L=0.15U W=0.64U AS=0.0864P AD=0.1664P PS=0.91U PD=1.8U
M12 VPWR 10 8 8 sky130_fd_pr__pfet_01v8 L=0.15U W=0.64U AS=0.1664P AD=0.0864P PS=1.8U PD=0.91U
M13 9 8 VGND VGND sky130_fd_pr__nfet_01v8 L=0.15U W=0.42U AS=0.0567P AD=0.1092P PS=0.69U PD=1.36U
M14 VGND 10 8 8 sky130_fd_pr__nfet_01v8 L=0.15U W=0.42U AS=0.1092P AD=0.0567P PS=1.36U PD=0.69U
M15 13 12 VPWR VPWR sky130_fd_pr__pfet_01v8 L=0.15U W=0.75U AS=0.32625P AD=0.1875P PS=2.37U PD=2U
M16 VPWR 13 33 33 sky130_fd_pr__pfet_01v8 L=0.15U W=0.42U AS=0.07665P AD=0.0315P PS=0.785U PD=0.99U
M17 11 n3 VPWR VPWR sky130_fd_pr__pfet_01v8 L=0.15U W=0.42U AS=0.1092P AD=0.05775P PS=1.36U PD=0.695U
M18 12 9 11 11 sky130_fd_pr__pfet_01v8 L=0.15U W=0.42U AS=0.05775P AD=0.06825P PS=0.695U PD=0.745U
M19 33 8 12 12 sky130_fd_pr__pfet_01v8 L=0.15U W=0.42U AS=0.06825P AD=0.07665P PS=0.745U PD=0.785U
M20 35 9 16 16 sky130_fd_pr__pfet_01v8 L=0.15U W=0.42U AS=0.0567P AD=0.0882P PS=0.69U PD=0.84U
M21 16 8 13 13 sky130_fd_pr__pfet_01v8 L=0.15U W=0.42U AS=0.0315P AD=0.0567P PS=0.99U PD=0.69U
M22 VPWR 14 35 35 sky130_fd_pr__pfet_01v8 L=0.15U W=0.42U AS=0.0882P AD=0.1113P PS=0.84U PD=1.37U
M23 12 8 11 11 sky130_fd_pr__nfet_01v8 L=0.15U W=0.36U AS=0.0576P AD=0.0621P PS=1.04U PD=0.705U
M24 36 9 12 12 sky130_fd_pr__nfet_01v8 L=0.15U W=0.36U AS=0.0621P AD=0.0342P PS=0.705U PD=0.91U
M25 37 8 16 16 sky130_fd_pr__nfet_01v8 L=0.15U W=0.36U AS=0.0684P AD=0.027P PS=0.74U PD=0.87U
M26 16 9 13 13 sky130_fd_pr__nfet_01v8 L=0.15U W=0.36U AS=0.0378P AD=0.0684P PS=0.93U PD=0.74U
M27 11 n3 VGND VGND sky130_fd_pr__nfet_01v8 L=0.15U W=0.42U AS=0.1092P AD=0.105P PS=1.36U PD=1.34U
M28 VGND 13 36 36 sky130_fd_pr__nfet_01v8 L=0.15U W=0.42U AS=0.105P AD=0.0819P PS=1.34U PD=1.23U
M29 VGND 14 37 37 sky130_fd_pr__nfet_01v8 L=0.15U W=0.42U AS=0.105P AD=0.1092P PS=1.34U PD=1.36U
M30 13 12 VGND VGND sky130_fd_pr__nfet_01v8 L=0.15U W=0.64U AS=0.16P AD=0.16P PS=1.78U PD=1.78U
M31 q 14 VGND VGND sky130_fd_pr__nfet_01v8 L=0.15U W=0.65U AS=0.08775P AD=0.169P PS=0.92U PD=1.82U
M32 VGND 16 14 14 sky130_fd_pr__nfet_01v8 L=0.15U W=0.65U AS=0.169P AD=0.08775P PS=1.82U PD=0.92U
M33 VPWR VGND VPWR VPWR sky130_fd_pr__pfet_01v8 L=1.05U W=1.74U AS=0.4524P AD=0.4524P PS=4.52U PD=4.52U
M34 VGND VPWR VGND VGND sky130_fd_pr__nfet_01v8 L=1.05U W=1.1U AS=0.286P AD=0.286P PS=3.24U PD=3.24U
M35 m1 18 VGND VGND sky130_fd_pr__nfet_01v8 L=0.15U W=0.52U AS=0.0754P AD=0.1352P PS=0.81U PD=1.56U
M36 VGND q 18 18 sky130_fd_pr__nfet_01v8 L=0.15U W=0.52U AS=0.1352P AD=0.0754P PS=1.56U PD=0.81U
M37 m1 18 VPWR VPWR sky130_fd_pr__pfet_01v8 L=0.15U W=0.79U AS=0.11455P AD=0.2054P PS=1.08U PD=2.1U
M38 VPWR q 18 18 sky130_fd_pr__pfet_01v8 L=0.15U W=0.79U AS=0.2054P AD=0.11455P PS=2.1U PD=1.08U
M39 VPWR m1 48 48 sky130_fd_pr__pfet_01v8 L=0.15U W=1U AS=0.105P AD=0.26P PS=1.21U PD=2.52U
M40 48 19 m2 m2 sky130_fd_pr__pfet_01v8 L=0.15U W=1U AS=0.26P AD=0.105P PS=2.52U PD=1.21U
M41 VGND m1 m2 m2 sky130_fd_pr__nfet_01v8 L=0.15U W=0.65U AS=0.08775P AD=0.169P PS=0.92U PD=1.82U
M42 m2 19 VGND VGND sky130_fd_pr__nfet_01v8 L=0.15U W=0.65U AS=0.169P AD=0.08775P PS=1.82U PD=0.92U
M43 VPWR 25 21 21 sky130_fd_pr__pfet_01v8 L=0.15U W=1U AS=0.26P AD=0.26P PS=2.52U PD=2.52U
M44 VPWR m2 23 23 sky130_fd_pr__pfet_01v8 L=0.15U W=1U AS=0.1375P AD=0.14P PS=1.275U PD=1.28U
M45 23 22 VPWR VPWR sky130_fd_pr__pfet_01v8 L=0.15U W=1U AS=0.14P AD=0.265P PS=1.28U PD=2.53U
M46 23 24 25 25 sky130_fd_pr__pfet_01v8 L=0.15U W=1U AS=0.26P AD=0.1375P PS=2.52U PD=1.275U
M47 VGND 25 21 21 sky130_fd_pr__nfet_01v8 L=0.15U W=0.65U AS=0.169P AD=0.25675P PS=1.82U PD=1.44U
M48 50 m2 25 25 sky130_fd_pr__nfet_01v8 L=0.15U W=0.65U AS=0.08937P AD=0.091P PS=0.925U PD=0.93U
M49 VGND 22 50 50 sky130_fd_pr__nfet_01v8 L=0.15U W=0.65U AS=0.091P AD=0.17225P PS=0.93U PD=1.83U
M50 25 24 VGND VGND sky130_fd_pr__nfet_01v8 L=0.15U W=0.65U AS=0.25675P AD=0.08937P PS=1.44U PD=0.925U
M51 27 26 VPWR VPWR sky130_fd_pr__pfet_01v8 L=0.15U W=1U AS=0.26P AD=0.26P PS=2.52U PD=2.52U
M52 27 26 VGND VGND sky130_fd_pr__nfet_01v8 L=0.15U W=0.65U AS=0.169P AD=0.169P PS=1.82U PD=1.82U
.ENDS l2row
