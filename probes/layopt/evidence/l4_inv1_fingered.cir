* layopt extraction of l4 (sky130)
.SUBCKT l4
M1 4 3 VPWR VPWR sky130_fd_pr__pfet_01v8 L=0.15U W=2U AS=0.52P AD=0.27P PS=5.04U PD=2.54U
M2 VGND 3 4 4 sky130_fd_pr__nfet_01v8 L=0.15U W=1.3U AS=0.1755P AD=0.338P PS=1.84U PD=3.64U
M3 VPWR 6 7 7 sky130_fd_pr__pfet_01v8 L=0.15U W=1U AS=0.135P AD=0.26P PS=1.27U PD=2.52U
M4 7 5 VPWR VPWR sky130_fd_pr__pfet_01v8 L=0.15U W=1U AS=0.26P AD=0.135P PS=2.52U PD=1.27U
M5 7 6 9 9 sky130_fd_pr__nfet_01v8 L=0.15U W=0.65U AS=0.08775P AD=0.169P PS=0.92U PD=1.82U
M6 9 5 VGND VGND sky130_fd_pr__nfet_01v8 L=0.15U W=0.65U AS=0.169P AD=0.08775P PS=1.82U PD=0.92U
M7 VPWR VGND VPWR VPWR sky130_fd_pr__pfet_01v8 L=1.05U W=0.87U AS=0.2262P AD=0.2262P PS=2.26U PD=2.26U
M8 VGND VPWR VGND VGND sky130_fd_pr__nfet_01v8 L=1.05U W=0.55U AS=0.143P AD=0.143P PS=1.62U PD=1.62U
.ENDS l4
