* cell gcd
.SUBCKT gcd
* net 1 req_msg[2]
* net 2 req_msg[6]
* net 3 resp_msg[5]
* net 4 req_msg[24]
* net 5 resp_msg[8]
* net 13 dpath.a_lt_b$in1\[2\]
* net 21 dpath.a_lt_b$in0\[8\]
* net 32 clknet_2_0__leaf_clk
* net 33 dpath.b_mux$out\[2\]
* net 35 dpath.a_mux$out\[8\]
* net 37 VDD
* net 51 dpath.a_mux$out\[2\]
* net 57 dpath.a_lt_b$in0\[2\]
* net 61 dpath.b_mux$out\[6\]
* net 62 dpath.a_mux$out\[6\]
* net 63 _004_
* net 64 req_rdy
* net 65 _075_
* net 67 _048_
* net 68 _069_
* net 70 resp_msg[7]
* net 74 dpath.b_mux$out\[8\]
* net 91 _089_
* net 92 _080_
* net 93 resp_msg[6]
* net 94 net1
* net 97 VSS
* net 112 _093_
* net 115 _076_
* net 126 _088_
* net 127 dpath.b_mux$out\[7\]
* net 129 dpath.a_lt_b$in0\[7\]
* net 130 req_msg[7]
* net 133 _087_
* net 135 net6
* net 137 req_msg[8]
* net 157 req_msg[18]
* net 158 net2
* net 159 resp_msg[2]
* net 160 req_msg[22]
* net 161 req_msg[23]
* net 162 dpath.a_lt_b$in1\[8\]
* net 164 req_msg[21]
* net 167 _090_
* net 180 net9
* net 191 dpath.a_lt_b$in0\[6\]
* net 195 dpath.a_lt_b$in1\[7\]
* net 197 dpath.a_mux$out\[7\]
* net 210 _022_
* net 217 _040_
* net 218 dpath.a_lt_b$in1\[6\]
* net 219 net32
* net 220 _023_
* net 256 _041_
* net 259 _047_
* net 260 _070_
* net 262 _027_
* net 264 _030_
* net 266 net11
* net 268 _046_
* net 270 _049_
* net 271 _026_
* net 272 _024_
* net 274 _025_
* net 277 _050_
* net 279 _051_
* net 282 _036_
* net 293 _042_
* net 297 clknet_0_clk
* net 302 ctrl$a_reg_en\[0\]
* net 307 _052_
* net 310 _020_
* net 328 _043_
* net 329 _034_
* net 333 clknet_2_1__leaf_clk
* net 334 _068_
* net 338 _019_
* net 341 _039_
* net 342 _021_
* net 343 dpath.a_lt_b$in0\[9\]
* net 344 dpath.a_lt_b$in1\[9\]
* net 347 resp_msg[9]
* net 352 req_msg[19]
* net 354 _092_
* net 359 resp_msg[3]
* net 362 _103_
* net 372 dpath.a_lt_b$in1\[5\]
* net 374 net52
* net 380 dpath.a_mux$out\[9\]
* net 399 dpath.a_lt_b$in1\[3\]
* net 400 _073_
* net 401 dpath.b_mux$out\[5\]
* net 402 _086_
* net 403 dpath.b_mux$out\[9\]
* net 408 _100_
* net 409 net5
* net 410 dpath.a_mux$out\[3\]
* net 435 _035_
* net 439 _071_
* net 440 _045_
* net 448 req_msg[9]
* net 458 dpath.b_mux$out\[3\]
* net 460 dpath.a_lt_b$in0\[3\]
* net 461 req_msg[25]
* net 463 req_msg[3]
* net 486 _029_
* net 489 req_msg[5]
* net 512 _031_
* net 513 dpath.a_lt_b$in0\[5\]
* net 534 _033_
* net 537 _028_
* net 544 _072_
* net 545 _044_
* net 548 dpath.a_mux$out\[5\]
* net 553 dpath.a_lt_b$in1\[1\]
* net 555 resp_msg[4]
* net 565 _085_
* net 568 dpath.a_lt_b$in1\[10\]
* net 570 dpath.a_mux$out\[10\]
* net 571 resp_msg[10]
* net 577 net8
* net 578 _005_
* net 587 _094_
* net 589 net16
* net 590 resp_msg[1]
* net 591 dpath.a_mux$out\[1\]
* net 593 _037_
* net 594 dpath.a_lt_b$in0\[1\]
* net 595 _032_
* net 597 dpath.a_lt_b$in0\[4\]
* net 599 req_msg[26]
* net 600 _053_
* net 602 _018_
* net 605 _017_
* net 622 req_msg[17]
* net 624 dpath.b_mux$out\[1\]
* net 626 req_msg[1]
* net 628 net12
* net 631 _038_
* net 635 dpath.a_mux$out\[4\]
* net 639 _054_
* net 641 _055_
* net 643 dpath.b_mux$out\[10\]
* net 649 _091_
* net 650 dpath.a_lt_b$in1\[4\]
* net 651 dpath.a_lt_b$in0\[10\]
* net 652 req_msg[10]
* net 661 clk
* net 662 _015_
* net 681 clknet_2_2__leaf_clk
* net 700 _099_
* net 726 req_msg[20]
* net 727 dpath.b_mux$out\[4\]
* net 728 dpath.a_lt_b$in1\[11\]
* net 729 _067_
* net 734 _101_
* net 735 resp_msg[11]
* net 774 dpath.a_mux$out\[11\]
* net 776 _003_
* net 794 req_msg[4]
* net 795 dpath.b_mux$out\[11\]
* net 796 _084_
* net 797 dpath.a_lt_b$in0\[11\]
* net 799 _016_
* net 833 net13
* net 836 dpath.a_lt_b$in1\[0\]
* net 845 _074_
* net 854 net3
* net 867 _095_
* net 868 resp_msg[0]
* net 869 dpath.a_lt_b$in0\[0\]
* net 873 dpath.a_mux$out\[0\]
* net 886 req_msg[16]
* net 888 dpath.b_mux$out\[0\]
* net 893 dpath.a_lt_b$in1\[15\]
* net 896 _102_
* net 897 req_msg[27]
* net 902 dpath.b_mux$out\[12\]
* net 915 req_msg[0]
* net 916 net7
* net 918 _104_
* net 941 net30
* net 943 _056_
* net 946 req_msg[12]
* net 955 dpath.a_lt_b$in0\[12\]
* net 976 _062_
* net 979 clknet_2_3__leaf_clk
* net 980 _014_
* net 983 _012_
* net 985 dpath.a_lt_b$in1\[12\]
* net 986 _013_
* net 993 dpath.a_lt_b$in0\[15\]
* net 994 net4
* net 995 _066_
* net 996 resp_msg[12]
* net 999 _079_
* net 1010 _078_
* net 1015 net10
* net 1017 _059_
* net 1018 resp_msg[14]
* net 1019 _064_
* net 1021 net15
* net 1024 _010_
* net 1025 _083_
* net 1027 dpath.a_mux$out\[12\]
* net 1033 _058_
* net 1039 _057_
* net 1049 ctrl$b_reg_en\[0\]
* net 1051 _063_
* net 1052 _011_
* net 1054 _009_
* net 1058 _060_
* net 1072 _000_
* net 1073 _061_
* net 1075 _077_
* net 1076 _008_
* net 1077 net28
* net 1098 _002_
* net 1099 _105_
* net 1100 _006_
* net 1101 _096_
* net 1104 dpath.a_mux$out\[15\]
* net 1114 dpath.a_lt_b$in0\[14\]
* net 1128 reset
* net 1129 _106_
* net 1130 ctrl.state.out\[2\]
* net 1131 dpath.a_lt_b$in0\[13\]
* net 1132 dpath.a_lt_b$in1\[13\]
* net 1134 dpath.a_lt_b$in1\[14\]
* net 1144 req_val
* net 1145 _097_
* net 1146 _001_
* net 1150 _098_
* net 1154 resp_msg[15]
* net 1168 _065_
* net 1185 _007_
* net 1187 ctrl.state.out\[1\]
* net 1188 req_msg[31]
* net 1189 _081_
* net 1190 dpath.b_mux$out\[14\]
* net 1191 resp_msg[13]
* net 1192 dpath.b_mux$out\[13\]
* net 1200 resp_rdy
* net 1203 net14
* net 1204 dpath.a_mux$out\[14\]
* net 1229 resp_val
* net 1274 dpath.b_mux$out\[15\]
* net 1276 req_msg[11]
* net 1278 _082_
* net 1279 net53
* net 1286 req_msg[30]
* net 1287 req_msg[28]
* net 1289 dpath.a_mux$out\[13\]
* net 1290 req_msg[13]
* net 1315 req_msg[15]
* net 1317 req_msg[14]
* net 1318 req_msg[29]
* device instance $1 r0 *1 5.07,3.165 sky130_fd_pr__nfet_01v8
M$1 97 32 6 6 sky130_fd_pr__nfet_01v8 L=0.15U W=0.42U AS=0.1092P AD=0.0567P
+ PS=1.36U PD=0.69U
* device instance $2 r0 *1 5.49,3.165 sky130_fd_pr__nfet_01v8
M$2 7 6 97 97 sky130_fd_pr__nfet_01v8 L=0.15U W=0.42U AS=0.0567P AD=0.1092P
+ PS=0.69U PD=1.36U
* device instance $3 r0 *1 6.43,3.165 sky130_fd_pr__nfet_01v8
M$3 22 33 8 8 sky130_fd_pr__nfet_01v8 L=0.15U W=0.42U AS=0.1092P AD=0.0441P
+ PS=1.36U PD=0.63U
* device instance $4 r0 *1 6.79,3.165 sky130_fd_pr__nfet_01v8
M$4 97 94 22 22 sky130_fd_pr__nfet_01v8 L=0.15U W=0.42U AS=0.0441P AD=0.1092P
+ PS=0.63U PD=1.36U
* device instance $5 r0 *1 9.59,3.135 sky130_fd_pr__nfet_01v8
M$5 10 6 8 8 sky130_fd_pr__nfet_01v8 L=0.15U W=0.36U AS=0.1446P AD=0.0522P
+ PS=1.18U PD=0.65U
* device instance $6 r0 *1 10.03,3.135 sky130_fd_pr__nfet_01v8
M$6 24 7 10 10 sky130_fd_pr__nfet_01v8 L=0.15U W=0.36U AS=0.0522P AD=0.0759P
+ PS=0.65U PD=0.8U
* device instance $7 r0 *1 7.73,3.165 sky130_fd_pr__nfet_01v8
M$7 97 94 34 34 sky130_fd_pr__nfet_01v8 L=0.15U W=0.42U AS=0.1092P AD=0.0609P
+ PS=1.36U PD=0.71U
* device instance $8 r0 *1 8.17,3.165 sky130_fd_pr__nfet_01v8
M$8 23 34 97 97 sky130_fd_pr__nfet_01v8 L=0.15U W=0.42U AS=0.0609P AD=0.0756P
+ PS=0.71U PD=0.78U
* device instance $9 r0 *1 8.68,3.165 sky130_fd_pr__nfet_01v8
M$9 8 9 23 23 sky130_fd_pr__nfet_01v8 L=0.15U W=0.42U AS=0.0756P AD=0.1446P
+ PS=0.78U PD=1.18U
* device instance $10 r0 *1 10.56,3.165 sky130_fd_pr__nfet_01v8
M$10 97 11 24 24 sky130_fd_pr__nfet_01v8 L=0.15U W=0.42U AS=0.0759P AD=0.12095P
+ PS=0.8U PD=1.085U
* device instance $11 r0 *1 11.155,3.275 sky130_fd_pr__nfet_01v8
M$11 11 10 97 97 sky130_fd_pr__nfet_01v8 L=0.15U W=0.64U AS=0.12095P AD=0.1664P
+ PS=1.085U PD=1.8U
* device instance $12 r0 *1 12.58,3.135 sky130_fd_pr__nfet_01v8
M$12 12 7 25 25 sky130_fd_pr__nfet_01v8 L=0.15U W=0.36U AS=0.0678P AD=0.0684P
+ PS=0.755U PD=0.74U
* device instance $13 r0 *1 13.11,3.135 sky130_fd_pr__nfet_01v8
M$13 27 6 12 12 sky130_fd_pr__nfet_01v8 L=0.15U W=0.36U AS=0.0684P AD=0.066P
+ PS=0.74U PD=0.745U
* device instance $14 r0 *1 12.095,3.165 sky130_fd_pr__nfet_01v8
M$14 25 11 97 97 sky130_fd_pr__nfet_01v8 L=0.15U W=0.42U AS=0.1092P AD=0.0678P
+ PS=1.36U PD=0.755U
* device instance $15 r0 *1 13.585,3.165 sky130_fd_pr__nfet_01v8
M$15 97 9 27 27 sky130_fd_pr__nfet_01v8 L=0.15U W=0.42U AS=0.066P AD=0.1092P
+ PS=0.745U PD=1.36U
* device instance $16 r0 *1 14.525,3.165 sky130_fd_pr__nfet_01v8
M$16 97 12 9 9 sky130_fd_pr__nfet_01v8 L=0.15U W=0.42U AS=0.1092P AD=0.10025P
+ PS=1.36U PD=0.985U
* device instance $17 r0 *1 15.01,3.28 sky130_fd_pr__nfet_01v8
M$17 13 12 97 97 sky130_fd_pr__nfet_01v8 L=0.15U W=0.65U AS=0.10025P AD=0.182P
+ PS=0.985U PD=1.86U
* device instance $18 r0 *1 60.73,3.165 sky130_fd_pr__nfet_01v8
M$18 97 333 14 14 sky130_fd_pr__nfet_01v8 L=0.15U W=0.42U AS=0.1092P AD=0.0567P
+ PS=1.36U PD=0.69U
* device instance $19 r0 *1 61.15,3.165 sky130_fd_pr__nfet_01v8
M$19 15 14 97 97 sky130_fd_pr__nfet_01v8 L=0.15U W=0.42U AS=0.0567P AD=0.1092P
+ PS=0.69U PD=1.36U
* device instance $20 r0 *1 62.09,3.165 sky130_fd_pr__nfet_01v8
M$20 31 35 16 16 sky130_fd_pr__nfet_01v8 L=0.15U W=0.42U AS=0.1092P AD=0.0441P
+ PS=1.36U PD=0.63U
* device instance $21 r0 *1 62.45,3.165 sky130_fd_pr__nfet_01v8
M$21 97 302 31 31 sky130_fd_pr__nfet_01v8 L=0.15U W=0.42U AS=0.0441P AD=0.1092P
+ PS=0.63U PD=1.36U
* device instance $22 r0 *1 65.25,3.135 sky130_fd_pr__nfet_01v8
M$22 18 14 16 16 sky130_fd_pr__nfet_01v8 L=0.15U W=0.36U AS=0.1446P AD=0.0522P
+ PS=1.18U PD=0.65U
* device instance $23 r0 *1 65.69,3.135 sky130_fd_pr__nfet_01v8
M$23 29 15 18 18 sky130_fd_pr__nfet_01v8 L=0.15U W=0.36U AS=0.0522P AD=0.0759P
+ PS=0.65U PD=0.8U
* device instance $24 r0 *1 63.39,3.165 sky130_fd_pr__nfet_01v8
M$24 97 302 36 36 sky130_fd_pr__nfet_01v8 L=0.15U W=0.42U AS=0.1092P AD=0.0609P
+ PS=1.36U PD=0.71U
* device instance $25 r0 *1 63.83,3.165 sky130_fd_pr__nfet_01v8
M$25 30 36 97 97 sky130_fd_pr__nfet_01v8 L=0.15U W=0.42U AS=0.0609P AD=0.0756P
+ PS=0.71U PD=0.78U
* device instance $26 r0 *1 64.34,3.165 sky130_fd_pr__nfet_01v8
M$26 16 17 30 30 sky130_fd_pr__nfet_01v8 L=0.15U W=0.42U AS=0.0756P AD=0.1446P
+ PS=0.78U PD=1.18U
* device instance $27 r0 *1 66.22,3.165 sky130_fd_pr__nfet_01v8
M$27 97 19 29 29 sky130_fd_pr__nfet_01v8 L=0.15U W=0.42U AS=0.0759P AD=0.12095P
+ PS=0.8U PD=1.085U
* device instance $28 r0 *1 66.815,3.275 sky130_fd_pr__nfet_01v8
M$28 19 18 97 97 sky130_fd_pr__nfet_01v8 L=0.15U W=0.64U AS=0.12095P AD=0.1664P
+ PS=1.085U PD=1.8U
* device instance $29 r0 *1 68.24,3.135 sky130_fd_pr__nfet_01v8
M$29 20 15 28 28 sky130_fd_pr__nfet_01v8 L=0.15U W=0.36U AS=0.0678P AD=0.0684P
+ PS=0.755U PD=0.74U
* device instance $30 r0 *1 68.77,3.135 sky130_fd_pr__nfet_01v8
M$30 26 14 20 20 sky130_fd_pr__nfet_01v8 L=0.15U W=0.36U AS=0.0684P AD=0.066P
+ PS=0.74U PD=0.745U
* device instance $31 r0 *1 67.755,3.165 sky130_fd_pr__nfet_01v8
M$31 28 19 97 97 sky130_fd_pr__nfet_01v8 L=0.15U W=0.42U AS=0.1092P AD=0.0678P
+ PS=1.36U PD=0.755U
* device instance $32 r0 *1 69.245,3.165 sky130_fd_pr__nfet_01v8
M$32 97 17 26 26 sky130_fd_pr__nfet_01v8 L=0.15U W=0.42U AS=0.066P AD=0.1092P
+ PS=0.745U PD=1.36U
* device instance $33 r0 *1 70.185,3.165 sky130_fd_pr__nfet_01v8
M$33 97 20 17 17 sky130_fd_pr__nfet_01v8 L=0.15U W=0.42U AS=0.1092P AD=0.10025P
+ PS=1.36U PD=0.985U
* device instance $34 r0 *1 70.67,3.28 sky130_fd_pr__nfet_01v8
M$34 21 20 97 97 sky130_fd_pr__nfet_01v8 L=0.15U W=0.65U AS=0.10025P AD=0.182P
+ PS=0.985U PD=1.86U
* device instance $35 r0 *1 5.53,7.715 sky130_fd_pr__nfet_01v8
M$35 97 32 48 48 sky130_fd_pr__nfet_01v8 L=0.15U W=0.42U AS=0.1092P AD=0.0567P
+ PS=1.36U PD=0.69U
* device instance $36 r0 *1 5.95,7.715 sky130_fd_pr__nfet_01v8
M$36 49 48 97 97 sky130_fd_pr__nfet_01v8 L=0.15U W=0.42U AS=0.0567P AD=0.1092P
+ PS=0.69U PD=1.36U
* device instance $37 r0 *1 6.89,7.715 sky130_fd_pr__nfet_01v8
M$37 99 51 50 50 sky130_fd_pr__nfet_01v8 L=0.15U W=0.42U AS=0.1092P AD=0.0441P
+ PS=1.36U PD=0.63U
* device instance $38 r0 *1 7.25,7.715 sky130_fd_pr__nfet_01v8
M$38 97 302 99 99 sky130_fd_pr__nfet_01v8 L=0.15U W=0.42U AS=0.0441P AD=0.1092P
+ PS=0.63U PD=1.36U
* device instance $39 r0 *1 8.19,7.715 sky130_fd_pr__nfet_01v8
M$39 97 302 52 52 sky130_fd_pr__nfet_01v8 L=0.15U W=0.42U AS=0.1092P AD=0.0609P
+ PS=1.36U PD=0.71U
* device instance $40 r0 *1 8.63,7.715 sky130_fd_pr__nfet_01v8
M$40 101 52 97 97 sky130_fd_pr__nfet_01v8 L=0.15U W=0.42U AS=0.0609P AD=0.0756P
+ PS=0.71U PD=0.78U
* device instance $41 r0 *1 9.14,7.715 sky130_fd_pr__nfet_01v8
M$41 50 56 101 101 sky130_fd_pr__nfet_01v8 L=0.15U W=0.42U AS=0.0756P
+ AD=0.1446P PS=0.78U PD=1.18U
* device instance $42 r0 *1 10.05,7.745 sky130_fd_pr__nfet_01v8
M$42 53 48 50 50 sky130_fd_pr__nfet_01v8 L=0.15U W=0.36U AS=0.1446P AD=0.0522P
+ PS=1.18U PD=0.65U
* device instance $43 r0 *1 10.49,7.745 sky130_fd_pr__nfet_01v8
M$43 53 49 103 103 sky130_fd_pr__nfet_01v8 L=0.15U W=0.36U AS=0.0759P
+ AD=0.0522P PS=0.8U PD=0.65U
* device instance $44 r0 *1 11.02,7.715 sky130_fd_pr__nfet_01v8
M$44 103 54 97 97 sky130_fd_pr__nfet_01v8 L=0.15U W=0.42U AS=0.12095P
+ AD=0.0759P PS=1.085U PD=0.8U
* device instance $45 r0 *1 11.615,7.605 sky130_fd_pr__nfet_01v8
M$45 54 53 97 97 sky130_fd_pr__nfet_01v8 L=0.15U W=0.64U AS=0.12095P AD=0.1664P
+ PS=1.085U PD=1.8U
* device instance $46 r0 *1 12.555,7.715 sky130_fd_pr__nfet_01v8
M$46 105 54 97 97 sky130_fd_pr__nfet_01v8 L=0.15U W=0.42U AS=0.1092P AD=0.0678P
+ PS=1.36U PD=0.755U
* device instance $47 r0 *1 13.04,7.745 sky130_fd_pr__nfet_01v8
M$47 55 49 105 105 sky130_fd_pr__nfet_01v8 L=0.15U W=0.36U AS=0.0678P
+ AD=0.0684P PS=0.755U PD=0.74U
* device instance $48 r0 *1 13.57,7.745 sky130_fd_pr__nfet_01v8
M$48 55 48 106 106 sky130_fd_pr__nfet_01v8 L=0.15U W=0.36U AS=0.066P AD=0.0684P
+ PS=0.745U PD=0.74U
* device instance $49 r0 *1 14.045,7.715 sky130_fd_pr__nfet_01v8
M$49 97 56 106 106 sky130_fd_pr__nfet_01v8 L=0.15U W=0.42U AS=0.066P AD=0.1092P
+ PS=0.745U PD=1.36U
* device instance $50 r0 *1 14.985,7.715 sky130_fd_pr__nfet_01v8
M$50 56 55 97 97 sky130_fd_pr__nfet_01v8 L=0.15U W=0.42U AS=0.10025P AD=0.1092P
+ PS=0.985U PD=1.36U
* device instance $51 r0 *1 15.47,7.6 sky130_fd_pr__nfet_01v8
M$51 57 55 97 97 sky130_fd_pr__nfet_01v8 L=0.15U W=0.65U AS=0.10025P AD=0.182P
+ PS=0.985U PD=1.86U
* device instance $52 r0 *1 23.47,7.6 sky130_fd_pr__nfet_01v8
M$52 97 91 58 58 sky130_fd_pr__nfet_01v8 L=0.15U W=0.65U AS=0.169P AD=0.10725P
+ PS=1.82U PD=0.98U
* device instance $53 r0 *1 23.95,7.6 sky130_fd_pr__nfet_01v8
M$53 110 218 97 97 sky130_fd_pr__nfet_01v8 L=0.15U W=0.65U AS=0.10725P
+ AD=0.06825P PS=0.98U PD=0.86U
* device instance $54 r0 *1 24.31,7.6 sky130_fd_pr__nfet_01v8
M$54 58 92 110 110 sky130_fd_pr__nfet_01v8 L=0.15U W=0.65U AS=0.06825P
+ AD=0.169P PS=0.86U PD=1.82U
* device instance $55 r0 *1 25.25,7.6 sky130_fd_pr__nfet_01v8
M$55 109 158 58 58 sky130_fd_pr__nfet_01v8 L=0.15U W=0.65U AS=0.169P
+ AD=0.10725P PS=1.82U PD=0.98U
* device instance $56 r0 *1 25.73,7.6 sky130_fd_pr__nfet_01v8
M$56 97 93 109 109 sky130_fd_pr__nfet_01v8 L=0.15U W=0.65U AS=0.10725P
+ AD=0.102375P PS=0.98U PD=0.965U
* device instance $57 r0 *1 26.195,7.6 sky130_fd_pr__nfet_01v8
M$57 62 58 97 97 sky130_fd_pr__nfet_01v8 L=0.15U W=0.65U AS=0.102375P AD=0.169P
+ PS=0.965U PD=1.82U
* device instance $58 r0 *1 27.64,7.715 sky130_fd_pr__nfet_01v8
M$58 97 63 96 96 sky130_fd_pr__nfet_01v8 L=0.15U W=0.42U AS=0.1113P AD=0.0588P
+ PS=1.37U PD=0.7U
* device instance $59 r0 *1 28.07,7.715 sky130_fd_pr__nfet_01v8
M$59 96 64 97 97 sky130_fd_pr__nfet_01v8 L=0.15U W=0.42U AS=0.0588P AD=0.0588P
+ PS=0.7U PD=0.7U
* device instance $60 r0 *1 28.5,7.715 sky130_fd_pr__nfet_01v8
M$60 61 65 96 96 sky130_fd_pr__nfet_01v8 L=0.15U W=0.42U AS=0.0588P AD=0.1113P
+ PS=0.7U PD=1.37U
* device instance $61 r0 *1 44.67,7.6 sky130_fd_pr__nfet_01v8
M$61 66 67 97 97 sky130_fd_pr__nfet_01v8 L=0.15U W=0.65U AS=0.169P AD=0.08775P
+ PS=1.82U PD=0.92U
* device instance $62 r0 *1 45.09,7.6 sky130_fd_pr__nfet_01v8
M$62 97 68 66 66 sky130_fd_pr__nfet_01v8 L=0.15U W=0.65U AS=0.08775P
+ AD=0.08775P PS=0.92U PD=0.92U
* device instance $63 r0 *1 45.51,7.6 sky130_fd_pr__nfet_01v8
M$63 108 68 97 97 sky130_fd_pr__nfet_01v8 L=0.15U W=0.65U AS=0.08775P
+ AD=0.08775P PS=0.92U PD=0.92U
* device instance $64 r0 *1 45.93,7.6 sky130_fd_pr__nfet_01v8
M$64 70 67 108 108 sky130_fd_pr__nfet_01v8 L=0.15U W=0.65U AS=0.08775P
+ AD=0.25025P PS=0.92U PD=1.42U
* device instance $65 r0 *1 46.85,7.6 sky130_fd_pr__nfet_01v8
M$65 97 66 70 70 sky130_fd_pr__nfet_01v8 L=0.15U W=0.65U AS=0.25025P AD=0.208P
+ PS=1.42U PD=1.94U
* device instance $66 r0 *1 64.87,7.715 sky130_fd_pr__nfet_01v8
M$66 97 333 71 71 sky130_fd_pr__nfet_01v8 L=0.15U W=0.42U AS=0.1092P AD=0.0567P
+ PS=1.36U PD=0.69U
* device instance $67 r0 *1 65.29,7.715 sky130_fd_pr__nfet_01v8
M$67 72 71 97 97 sky130_fd_pr__nfet_01v8 L=0.15U W=0.42U AS=0.0567P AD=0.1092P
+ PS=0.69U PD=1.36U
* device instance $68 r0 *1 66.23,7.715 sky130_fd_pr__nfet_01v8
M$68 107 74 73 73 sky130_fd_pr__nfet_01v8 L=0.15U W=0.42U AS=0.1092P AD=0.0441P
+ PS=1.36U PD=0.63U
* device instance $69 r0 *1 66.59,7.715 sky130_fd_pr__nfet_01v8
M$69 97 94 107 107 sky130_fd_pr__nfet_01v8 L=0.15U W=0.42U AS=0.0441P
+ AD=0.1092P PS=0.63U PD=1.36U
* device instance $70 r0 *1 67.53,7.715 sky130_fd_pr__nfet_01v8
M$70 97 94 75 75 sky130_fd_pr__nfet_01v8 L=0.15U W=0.42U AS=0.1092P AD=0.0609P
+ PS=1.36U PD=0.71U
* device instance $71 r0 *1 67.97,7.715 sky130_fd_pr__nfet_01v8
M$71 104 75 97 97 sky130_fd_pr__nfet_01v8 L=0.15U W=0.42U AS=0.0609P AD=0.0756P
+ PS=0.71U PD=0.78U
* device instance $72 r0 *1 68.48,7.715 sky130_fd_pr__nfet_01v8
M$72 73 79 104 104 sky130_fd_pr__nfet_01v8 L=0.15U W=0.42U AS=0.0756P
+ AD=0.1446P PS=0.78U PD=1.18U
* device instance $73 r0 *1 69.39,7.745 sky130_fd_pr__nfet_01v8
M$73 76 71 73 73 sky130_fd_pr__nfet_01v8 L=0.15U W=0.36U AS=0.1446P AD=0.0522P
+ PS=1.18U PD=0.65U
* device instance $74 r0 *1 69.83,7.745 sky130_fd_pr__nfet_01v8
M$74 76 72 102 102 sky130_fd_pr__nfet_01v8 L=0.15U W=0.36U AS=0.0759P
+ AD=0.0522P PS=0.8U PD=0.65U
* device instance $75 r0 *1 70.36,7.715 sky130_fd_pr__nfet_01v8
M$75 102 77 97 97 sky130_fd_pr__nfet_01v8 L=0.15U W=0.42U AS=0.12095P
+ AD=0.0759P PS=1.085U PD=0.8U
* device instance $76 r0 *1 70.955,7.605 sky130_fd_pr__nfet_01v8
M$76 77 76 97 97 sky130_fd_pr__nfet_01v8 L=0.15U W=0.64U AS=0.12095P AD=0.1664P
+ PS=1.085U PD=1.8U
* device instance $77 r0 *1 71.895,7.715 sky130_fd_pr__nfet_01v8
M$77 100 77 97 97 sky130_fd_pr__nfet_01v8 L=0.15U W=0.42U AS=0.1092P AD=0.0678P
+ PS=1.36U PD=0.755U
* device instance $78 r0 *1 72.38,7.745 sky130_fd_pr__nfet_01v8
M$78 78 72 100 100 sky130_fd_pr__nfet_01v8 L=0.15U W=0.36U AS=0.0678P
+ AD=0.0684P PS=0.755U PD=0.74U
* device instance $79 r0 *1 72.91,7.745 sky130_fd_pr__nfet_01v8
M$79 78 71 98 98 sky130_fd_pr__nfet_01v8 L=0.15U W=0.36U AS=0.066P AD=0.0684P
+ PS=0.745U PD=0.74U
* device instance $80 r0 *1 73.385,7.715 sky130_fd_pr__nfet_01v8
M$80 97 79 98 98 sky130_fd_pr__nfet_01v8 L=0.15U W=0.42U AS=0.066P AD=0.1092P
+ PS=0.745U PD=1.36U
* device instance $81 r0 *1 74.325,7.715 sky130_fd_pr__nfet_01v8
M$81 79 78 97 97 sky130_fd_pr__nfet_01v8 L=0.15U W=0.42U AS=0.10025P AD=0.1092P
+ PS=0.985U PD=1.36U
* device instance $82 r0 *1 74.81,7.6 sky130_fd_pr__nfet_01v8
M$82 162 78 97 97 sky130_fd_pr__nfet_01v8 L=0.15U W=0.65U AS=0.10025P AD=0.182P
+ PS=0.985U PD=1.86U
* device instance $83 r0 *1 6.98,8.605 sky130_fd_pr__nfet_01v8
M$83 139 157 111 111 sky130_fd_pr__nfet_01v8 L=0.15U W=0.42U AS=0.1113P
+ AD=0.0441P PS=1.37U PD=0.63U
* device instance $84 r0 *1 7.34,8.605 sky130_fd_pr__nfet_01v8
M$84 97 115 139 139 sky130_fd_pr__nfet_01v8 L=0.15U W=0.42U AS=0.0441P
+ AD=0.0966P PS=0.63U PD=0.88U
* device instance $85 r0 *1 7.95,8.605 sky130_fd_pr__nfet_01v8
M$85 112 111 97 97 sky130_fd_pr__nfet_01v8 L=0.15U W=0.42U AS=0.0966P
+ AD=0.1113P PS=0.88U PD=1.37U
* device instance $86 r0 *1 9.21,8.72 sky130_fd_pr__nfet_01v8
M$86 97 112 113 113 sky130_fd_pr__nfet_01v8 L=0.15U W=0.65U AS=0.169P
+ AD=0.10725P PS=1.82U PD=0.98U
* device instance $87 r0 *1 9.69,8.72 sky130_fd_pr__nfet_01v8
M$87 140 13 97 97 sky130_fd_pr__nfet_01v8 L=0.15U W=0.65U AS=0.10725P
+ AD=0.06825P PS=0.98U PD=0.86U
* device instance $88 r0 *1 10.05,8.72 sky130_fd_pr__nfet_01v8
M$88 113 92 140 140 sky130_fd_pr__nfet_01v8 L=0.15U W=0.65U AS=0.06825P
+ AD=0.169P PS=0.86U PD=1.82U
* device instance $89 r0 *1 10.99,8.72 sky130_fd_pr__nfet_01v8
M$89 141 158 113 113 sky130_fd_pr__nfet_01v8 L=0.15U W=0.65U AS=0.169P
+ AD=0.10725P PS=1.82U PD=0.98U
* device instance $90 r0 *1 11.47,8.72 sky130_fd_pr__nfet_01v8
M$90 97 159 141 141 sky130_fd_pr__nfet_01v8 L=0.15U W=0.65U AS=0.10725P
+ AD=0.102375P PS=0.98U PD=0.965U
* device instance $91 r0 *1 11.935,8.72 sky130_fd_pr__nfet_01v8
M$91 51 113 97 97 sky130_fd_pr__nfet_01v8 L=0.15U W=0.65U AS=0.102375P
+ AD=0.169P PS=0.965U PD=1.82U
* device instance $92 r0 *1 23.08,8.605 sky130_fd_pr__nfet_01v8
M$92 142 160 114 114 sky130_fd_pr__nfet_01v8 L=0.15U W=0.42U AS=0.1113P
+ AD=0.0441P PS=1.37U PD=0.63U
* device instance $93 r0 *1 23.44,8.605 sky130_fd_pr__nfet_01v8
M$93 97 115 142 142 sky130_fd_pr__nfet_01v8 L=0.15U W=0.42U AS=0.0441P
+ AD=0.0966P PS=0.63U PD=0.88U
* device instance $94 r0 *1 24.05,8.605 sky130_fd_pr__nfet_01v8
M$94 91 114 97 97 sky130_fd_pr__nfet_01v8 L=0.15U W=0.42U AS=0.0966P AD=0.1113P
+ PS=0.88U PD=1.37U
* device instance $95 r0 *1 25.31,8.605 sky130_fd_pr__nfet_01v8
M$95 97 32 116 116 sky130_fd_pr__nfet_01v8 L=0.15U W=0.42U AS=0.1092P
+ AD=0.0567P PS=1.36U PD=0.69U
* device instance $96 r0 *1 25.73,8.605 sky130_fd_pr__nfet_01v8
M$96 117 116 97 97 sky130_fd_pr__nfet_01v8 L=0.15U W=0.42U AS=0.0567P
+ AD=0.1092P PS=0.69U PD=1.36U
* device instance $97 r0 *1 26.67,8.605 sky130_fd_pr__nfet_01v8
M$97 143 61 118 118 sky130_fd_pr__nfet_01v8 L=0.15U W=0.42U AS=0.1092P
+ AD=0.0441P PS=1.36U PD=0.63U
* device instance $98 r0 *1 27.03,8.605 sky130_fd_pr__nfet_01v8
M$98 97 94 143 143 sky130_fd_pr__nfet_01v8 L=0.15U W=0.42U AS=0.0441P
+ AD=0.1092P PS=0.63U PD=1.36U
* device instance $99 r0 *1 29.83,8.575 sky130_fd_pr__nfet_01v8
M$99 121 116 118 118 sky130_fd_pr__nfet_01v8 L=0.15U W=0.36U AS=0.1446P
+ AD=0.0522P PS=1.18U PD=0.65U
* device instance $100 r0 *1 30.27,8.575 sky130_fd_pr__nfet_01v8
M$100 146 117 121 121 sky130_fd_pr__nfet_01v8 L=0.15U W=0.36U AS=0.0522P
+ AD=0.0759P PS=0.65U PD=0.8U
* device instance $101 r0 *1 27.97,8.605 sky130_fd_pr__nfet_01v8
M$101 97 94 119 119 sky130_fd_pr__nfet_01v8 L=0.15U W=0.42U AS=0.1092P
+ AD=0.0609P PS=1.36U PD=0.71U
* device instance $102 r0 *1 28.41,8.605 sky130_fd_pr__nfet_01v8
M$102 144 119 97 97 sky130_fd_pr__nfet_01v8 L=0.15U W=0.42U AS=0.0609P
+ AD=0.0756P PS=0.71U PD=0.78U
* device instance $103 r0 *1 28.92,8.605 sky130_fd_pr__nfet_01v8
M$103 118 120 144 144 sky130_fd_pr__nfet_01v8 L=0.15U W=0.42U AS=0.0756P
+ AD=0.1446P PS=0.78U PD=1.18U
* device instance $104 r0 *1 30.8,8.605 sky130_fd_pr__nfet_01v8
M$104 97 122 146 146 sky130_fd_pr__nfet_01v8 L=0.15U W=0.42U AS=0.0759P
+ AD=0.12095P PS=0.8U PD=1.085U
* device instance $105 r0 *1 31.395,8.715 sky130_fd_pr__nfet_01v8
M$105 122 121 97 97 sky130_fd_pr__nfet_01v8 L=0.15U W=0.64U AS=0.12095P
+ AD=0.1664P PS=1.085U PD=1.8U
* device instance $106 r0 *1 32.82,8.575 sky130_fd_pr__nfet_01v8
M$106 123 117 148 148 sky130_fd_pr__nfet_01v8 L=0.15U W=0.36U AS=0.0678P
+ AD=0.0684P PS=0.755U PD=0.74U
* device instance $107 r0 *1 33.35,8.575 sky130_fd_pr__nfet_01v8
M$107 149 116 123 123 sky130_fd_pr__nfet_01v8 L=0.15U W=0.36U AS=0.0684P
+ AD=0.066P PS=0.74U PD=0.745U
* device instance $108 r0 *1 32.335,8.605 sky130_fd_pr__nfet_01v8
M$108 148 122 97 97 sky130_fd_pr__nfet_01v8 L=0.15U W=0.42U AS=0.1092P
+ AD=0.0678P PS=1.36U PD=0.755U
* device instance $109 r0 *1 33.825,8.605 sky130_fd_pr__nfet_01v8
M$109 97 120 149 149 sky130_fd_pr__nfet_01v8 L=0.15U W=0.42U AS=0.066P
+ AD=0.1092P PS=0.745U PD=1.36U
* device instance $110 r0 *1 34.765,8.605 sky130_fd_pr__nfet_01v8
M$110 97 123 120 120 sky130_fd_pr__nfet_01v8 L=0.15U W=0.42U AS=0.1092P
+ AD=0.10025P PS=1.36U PD=0.985U
* device instance $111 r0 *1 35.25,8.72 sky130_fd_pr__nfet_01v8
M$111 218 123 97 97 sky130_fd_pr__nfet_01v8 L=0.15U W=0.65U AS=0.10025P
+ AD=0.182P PS=0.985U PD=1.86U
* device instance $112 r0 *1 37.34,8.605 sky130_fd_pr__nfet_01v8
M$112 150 164 124 124 sky130_fd_pr__nfet_01v8 L=0.15U W=0.42U AS=0.1113P
+ AD=0.0441P PS=1.37U PD=0.63U
* device instance $113 r0 *1 37.7,8.605 sky130_fd_pr__nfet_01v8
M$113 97 115 150 150 sky130_fd_pr__nfet_01v8 L=0.15U W=0.42U AS=0.0441P
+ AD=0.0966P PS=0.63U PD=0.88U
* device instance $114 r0 *1 38.31,8.605 sky130_fd_pr__nfet_01v8
M$114 167 124 97 97 sky130_fd_pr__nfet_01v8 L=0.15U W=0.42U AS=0.0966P
+ AD=0.1113P PS=0.88U PD=1.37U
* device instance $115 r0 *1 44.7,8.605 sky130_fd_pr__nfet_01v8
M$115 151 161 125 125 sky130_fd_pr__nfet_01v8 L=0.15U W=0.42U AS=0.1113P
+ AD=0.0441P PS=1.37U PD=0.63U
* device instance $116 r0 *1 45.06,8.605 sky130_fd_pr__nfet_01v8
M$116 97 115 151 151 sky130_fd_pr__nfet_01v8 L=0.15U W=0.42U AS=0.0441P
+ AD=0.0966P PS=0.63U PD=0.88U
* device instance $117 r0 *1 45.67,8.605 sky130_fd_pr__nfet_01v8
M$117 126 125 97 97 sky130_fd_pr__nfet_01v8 L=0.15U W=0.42U AS=0.0966P
+ AD=0.1113P PS=0.88U PD=1.37U
* device instance $118 r0 *1 47.475,8.605 sky130_fd_pr__nfet_01v8
M$118 152 64 97 97 sky130_fd_pr__nfet_01v8 L=0.15U W=0.42U AS=0.11285P
+ AD=0.0693P PS=1.045U PD=0.75U
* device instance $119 r0 *1 47.955,8.605 sky130_fd_pr__nfet_01v8
M$119 128 130 152 152 sky130_fd_pr__nfet_01v8 L=0.15U W=0.42U AS=0.0693P
+ AD=0.09975P PS=0.75U PD=0.895U
* device instance $120 r0 *1 48.58,8.605 sky130_fd_pr__nfet_01v8
M$120 153 129 128 128 sky130_fd_pr__nfet_01v8 L=0.15U W=0.42U AS=0.09975P
+ AD=0.0693P PS=0.895U PD=0.75U
* device instance $121 r0 *1 49.06,8.605 sky130_fd_pr__nfet_01v8
M$121 97 131 153 153 sky130_fd_pr__nfet_01v8 L=0.15U W=0.42U AS=0.0693P
+ AD=0.1449P PS=0.75U PD=1.11U
* device instance $122 r0 *1 49.9,8.605 sky130_fd_pr__nfet_01v8
M$122 131 64 97 97 sky130_fd_pr__nfet_01v8 L=0.15U W=0.42U AS=0.1449P
+ AD=0.1092P PS=1.11U PD=1.36U
* device instance $123 r0 *1 46.93,8.72 sky130_fd_pr__nfet_01v8
M$123 97 128 127 127 sky130_fd_pr__nfet_01v8 L=0.15U W=0.65U AS=0.169P
+ AD=0.11285P PS=1.82U PD=1.045U
* device instance $124 r0 *1 57.58,8.605 sky130_fd_pr__nfet_01v8
M$124 154 4 132 132 sky130_fd_pr__nfet_01v8 L=0.15U W=0.42U AS=0.1113P
+ AD=0.0441P PS=1.37U PD=0.63U
* device instance $125 r0 *1 57.94,8.605 sky130_fd_pr__nfet_01v8
M$125 97 115 154 154 sky130_fd_pr__nfet_01v8 L=0.15U W=0.42U AS=0.0441P
+ AD=0.0966P PS=0.63U PD=0.88U
* device instance $126 r0 *1 58.55,8.605 sky130_fd_pr__nfet_01v8
M$126 133 132 97 97 sky130_fd_pr__nfet_01v8 L=0.15U W=0.42U AS=0.0966P
+ AD=0.1113P PS=0.88U PD=1.37U
* device instance $127 r0 *1 59.81,8.72 sky130_fd_pr__nfet_01v8
M$127 97 133 134 134 sky130_fd_pr__nfet_01v8 L=0.15U W=0.65U AS=0.169P
+ AD=0.10725P PS=1.82U PD=0.98U
* device instance $128 r0 *1 60.29,8.72 sky130_fd_pr__nfet_01v8
M$128 156 162 97 97 sky130_fd_pr__nfet_01v8 L=0.15U W=0.65U AS=0.10725P
+ AD=0.06825P PS=0.98U PD=0.86U
* device instance $129 r0 *1 60.65,8.72 sky130_fd_pr__nfet_01v8
M$129 134 92 156 156 sky130_fd_pr__nfet_01v8 L=0.15U W=0.65U AS=0.06825P
+ AD=0.169P PS=0.86U PD=1.82U
* device instance $130 r0 *1 61.59,8.72 sky130_fd_pr__nfet_01v8
M$130 155 135 134 134 sky130_fd_pr__nfet_01v8 L=0.15U W=0.65U AS=0.169P
+ AD=0.10725P PS=1.82U PD=0.98U
* device instance $131 r0 *1 62.07,8.72 sky130_fd_pr__nfet_01v8
M$131 97 5 155 155 sky130_fd_pr__nfet_01v8 L=0.15U W=0.65U AS=0.10725P
+ AD=0.102375P PS=0.98U PD=0.965U
* device instance $132 r0 *1 62.535,8.72 sky130_fd_pr__nfet_01v8
M$132 35 134 97 97 sky130_fd_pr__nfet_01v8 L=0.15U W=0.65U AS=0.102375P
+ AD=0.169P PS=0.965U PD=1.82U
* device instance $133 r0 *1 68.175,8.605 sky130_fd_pr__nfet_01v8
M$133 147 64 97 97 sky130_fd_pr__nfet_01v8 L=0.15U W=0.42U AS=0.11285P
+ AD=0.0693P PS=1.045U PD=0.75U
* device instance $134 r0 *1 68.655,8.605 sky130_fd_pr__nfet_01v8
M$134 136 137 147 147 sky130_fd_pr__nfet_01v8 L=0.15U W=0.42U AS=0.0693P
+ AD=0.09975P PS=0.75U PD=0.895U
* device instance $135 r0 *1 69.28,8.605 sky130_fd_pr__nfet_01v8
M$135 145 21 136 136 sky130_fd_pr__nfet_01v8 L=0.15U W=0.42U AS=0.09975P
+ AD=0.0693P PS=0.895U PD=0.75U
* device instance $136 r0 *1 69.76,8.605 sky130_fd_pr__nfet_01v8
M$136 97 138 145 145 sky130_fd_pr__nfet_01v8 L=0.15U W=0.42U AS=0.0693P
+ AD=0.1449P PS=0.75U PD=1.11U
* device instance $137 r0 *1 70.6,8.605 sky130_fd_pr__nfet_01v8
M$137 138 64 97 97 sky130_fd_pr__nfet_01v8 L=0.15U W=0.42U AS=0.1449P
+ AD=0.1092P PS=1.11U PD=1.36U
* device instance $138 r0 *1 67.63,8.72 sky130_fd_pr__nfet_01v8
M$138 97 136 74 74 sky130_fd_pr__nfet_01v8 L=0.15U W=0.65U AS=0.169P
+ AD=0.11285P PS=1.82U PD=1.045U
* device instance $139 r0 *1 7.83,13.04 sky130_fd_pr__nfet_01v8
M$139 97 178 33 33 sky130_fd_pr__nfet_01v8 L=0.15U W=0.65U AS=0.169P
+ AD=0.11285P PS=1.82U PD=1.045U
* device instance $140 r0 *1 8.375,13.155 sky130_fd_pr__nfet_01v8
M$140 235 64 97 97 sky130_fd_pr__nfet_01v8 L=0.15U W=0.42U AS=0.11285P
+ AD=0.0693P PS=1.045U PD=0.75U
* device instance $141 r0 *1 8.855,13.155 sky130_fd_pr__nfet_01v8
M$141 178 1 235 235 sky130_fd_pr__nfet_01v8 L=0.15U W=0.42U AS=0.0693P
+ AD=0.09975P PS=0.75U PD=0.895U
* device instance $142 r0 *1 9.48,13.155 sky130_fd_pr__nfet_01v8
M$142 236 57 178 178 sky130_fd_pr__nfet_01v8 L=0.15U W=0.42U AS=0.09975P
+ AD=0.0693P PS=0.895U PD=0.75U
* device instance $143 r0 *1 9.96,13.155 sky130_fd_pr__nfet_01v8
M$143 97 232 236 236 sky130_fd_pr__nfet_01v8 L=0.15U W=0.42U AS=0.0693P
+ AD=0.1449P PS=0.75U PD=1.11U
* device instance $144 r0 *1 10.8,13.155 sky130_fd_pr__nfet_01v8
M$144 232 64 97 97 sky130_fd_pr__nfet_01v8 L=0.15U W=0.42U AS=0.1449P
+ AD=0.1092P PS=1.11U PD=1.36U
* device instance $145 r0 *1 12.53,13.04 sky130_fd_pr__nfet_01v8
M$145 238 217 179 179 sky130_fd_pr__nfet_01v8 L=0.15U W=0.65U AS=0.169P
+ AD=0.06825P PS=1.82U PD=0.86U
* device instance $146 r0 *1 12.89,13.04 sky130_fd_pr__nfet_01v8
M$146 97 180 238 238 sky130_fd_pr__nfet_01v8 L=0.15U W=0.65U AS=0.06825P
+ AD=0.08775P PS=0.86U PD=0.92U
* device instance $147 r0 *1 13.31,13.04 sky130_fd_pr__nfet_01v8
M$147 233 180 97 97 sky130_fd_pr__nfet_01v8 L=0.15U W=0.65U AS=0.08775P
+ AD=0.169P PS=0.92U PD=1.82U
* device instance $148 r0 *1 14.25,13.04 sky130_fd_pr__nfet_01v8
M$148 233 217 97 97 sky130_fd_pr__nfet_01v8 L=0.15U W=0.65U AS=0.169P
+ AD=0.08775P PS=1.82U PD=0.92U
* device instance $149 r0 *1 14.67,13.04 sky130_fd_pr__nfet_01v8
M$149 159 179 233 233 sky130_fd_pr__nfet_01v8 L=0.15U W=0.65U AS=0.08775P
+ AD=0.195P PS=0.92U PD=1.9U
* device instance $150 r0 *1 15.69,13.04 sky130_fd_pr__nfet_01v8
M$150 181 57 97 97 sky130_fd_pr__nfet_01v8 L=0.15U W=0.65U AS=0.169P
+ AD=0.08775P PS=1.82U PD=0.92U
* device instance $151 r0 *1 16.11,13.04 sky130_fd_pr__nfet_01v8
M$151 97 13 181 181 sky130_fd_pr__nfet_01v8 L=0.15U W=0.65U AS=0.08775P
+ AD=0.08775P PS=0.92U PD=0.92U
* device instance $152 r0 *1 16.53,13.04 sky130_fd_pr__nfet_01v8
M$152 240 13 97 97 sky130_fd_pr__nfet_01v8 L=0.15U W=0.65U AS=0.08775P
+ AD=0.08775P PS=0.92U PD=0.92U
* device instance $153 r0 *1 16.95,13.04 sky130_fd_pr__nfet_01v8
M$153 217 57 240 240 sky130_fd_pr__nfet_01v8 L=0.15U W=0.65U AS=0.08775P
+ AD=0.25025P PS=0.92U PD=1.42U
* device instance $154 r0 *1 17.87,13.04 sky130_fd_pr__nfet_01v8
M$154 97 181 217 217 sky130_fd_pr__nfet_01v8 L=0.15U W=0.65U AS=0.25025P
+ AD=0.208P PS=1.42U PD=1.94U
* device instance $155 r0 *1 19.33,13.155 sky130_fd_pr__nfet_01v8
M$155 97 32 183 183 sky130_fd_pr__nfet_01v8 L=0.15U W=0.42U AS=0.1092P
+ AD=0.0567P PS=1.36U PD=0.69U
* device instance $156 r0 *1 19.75,13.155 sky130_fd_pr__nfet_01v8
M$156 184 183 97 97 sky130_fd_pr__nfet_01v8 L=0.15U W=0.42U AS=0.0567P
+ AD=0.1092P PS=0.69U PD=1.36U
* device instance $157 r0 *1 20.69,13.155 sky130_fd_pr__nfet_01v8
M$157 241 62 185 185 sky130_fd_pr__nfet_01v8 L=0.15U W=0.42U AS=0.1092P
+ AD=0.0441P PS=1.36U PD=0.63U
* device instance $158 r0 *1 21.05,13.155 sky130_fd_pr__nfet_01v8
M$158 97 302 241 241 sky130_fd_pr__nfet_01v8 L=0.15U W=0.42U AS=0.0441P
+ AD=0.1092P PS=0.63U PD=1.36U
* device instance $159 r0 *1 21.99,13.155 sky130_fd_pr__nfet_01v8
M$159 97 302 186 186 sky130_fd_pr__nfet_01v8 L=0.15U W=0.42U AS=0.1092P
+ AD=0.0609P PS=1.36U PD=0.71U
* device instance $160 r0 *1 22.43,13.155 sky130_fd_pr__nfet_01v8
M$160 242 186 97 97 sky130_fd_pr__nfet_01v8 L=0.15U W=0.42U AS=0.0609P
+ AD=0.0756P PS=0.71U PD=0.78U
* device instance $161 r0 *1 22.94,13.155 sky130_fd_pr__nfet_01v8
M$161 185 190 242 242 sky130_fd_pr__nfet_01v8 L=0.15U W=0.42U AS=0.0756P
+ AD=0.1446P PS=0.78U PD=1.18U
* device instance $162 r0 *1 23.85,13.185 sky130_fd_pr__nfet_01v8
M$162 187 183 185 185 sky130_fd_pr__nfet_01v8 L=0.15U W=0.36U AS=0.1446P
+ AD=0.0522P PS=1.18U PD=0.65U
* device instance $163 r0 *1 24.29,13.185 sky130_fd_pr__nfet_01v8
M$163 187 184 244 244 sky130_fd_pr__nfet_01v8 L=0.15U W=0.36U AS=0.0759P
+ AD=0.0522P PS=0.8U PD=0.65U
* device instance $164 r0 *1 24.82,13.155 sky130_fd_pr__nfet_01v8
M$164 244 188 97 97 sky130_fd_pr__nfet_01v8 L=0.15U W=0.42U AS=0.12095P
+ AD=0.0759P PS=1.085U PD=0.8U
* device instance $165 r0 *1 25.415,13.045 sky130_fd_pr__nfet_01v8
M$165 188 187 97 97 sky130_fd_pr__nfet_01v8 L=0.15U W=0.64U AS=0.12095P
+ AD=0.1664P PS=1.085U PD=1.8U
* device instance $166 r0 *1 26.355,13.155 sky130_fd_pr__nfet_01v8
M$166 245 188 97 97 sky130_fd_pr__nfet_01v8 L=0.15U W=0.42U AS=0.1092P
+ AD=0.0678P PS=1.36U PD=0.755U
* device instance $167 r0 *1 26.84,13.185 sky130_fd_pr__nfet_01v8
M$167 189 184 245 245 sky130_fd_pr__nfet_01v8 L=0.15U W=0.36U AS=0.0678P
+ AD=0.0684P PS=0.755U PD=0.74U
* device instance $168 r0 *1 27.37,13.185 sky130_fd_pr__nfet_01v8
M$168 189 183 246 246 sky130_fd_pr__nfet_01v8 L=0.15U W=0.36U AS=0.066P
+ AD=0.0684P PS=0.745U PD=0.74U
* device instance $169 r0 *1 27.845,13.155 sky130_fd_pr__nfet_01v8
M$169 97 190 246 246 sky130_fd_pr__nfet_01v8 L=0.15U W=0.42U AS=0.066P
+ AD=0.1092P PS=0.745U PD=1.36U
* device instance $170 r0 *1 28.785,13.155 sky130_fd_pr__nfet_01v8
M$170 190 189 97 97 sky130_fd_pr__nfet_01v8 L=0.15U W=0.42U AS=0.10025P
+ AD=0.1092P PS=0.985U PD=1.36U
* device instance $171 r0 *1 29.27,13.04 sky130_fd_pr__nfet_01v8
M$171 191 189 97 97 sky130_fd_pr__nfet_01v8 L=0.15U W=0.65U AS=0.10025P
+ AD=0.182P PS=0.985U PD=1.86U
* device instance $172 r0 *1 30.85,13.04 sky130_fd_pr__nfet_01v8
M$172 247 2 97 97 sky130_fd_pr__nfet_01v8 L=0.15U W=0.65U AS=0.169P AD=0.08775P
+ PS=1.82U PD=0.92U
* device instance $173 r0 *1 31.27,13.04 sky130_fd_pr__nfet_01v8
M$173 65 64 247 247 sky130_fd_pr__nfet_01v8 L=0.15U W=0.65U AS=0.08775P
+ AD=0.169P PS=0.92U PD=1.82U
* device instance $174 r0 *1 32.625,13.155 sky130_fd_pr__nfet_01v8
M$174 97 191 63 63 sky130_fd_pr__nfet_01v8 L=0.15U W=0.42U AS=0.1092P
+ AD=0.1197P PS=1.36U PD=1.41U
* device instance $175 r0 *1 33.605,13.04 sky130_fd_pr__nfet_01v8
M$175 97 218 234 234 sky130_fd_pr__nfet_01v8 L=0.15U W=1.3U AS=0.299P AD=0.182P
+ PS=2.87U PD=1.86U
* device instance $176 r0 *1 34.035,13.04 sky130_fd_pr__nfet_01v8
M$176 234 63 97 97 sky130_fd_pr__nfet_01v8 L=0.15U W=1.3U AS=0.182P AD=0.21775P
+ PS=1.86U PD=1.97U
* device instance $179 r0 *1 35.435,13.04 sky130_fd_pr__nfet_01v8
M$179 67 259 234 234 sky130_fd_pr__nfet_01v8 L=0.15U W=1.3U AS=0.182P
+ AD=0.26325P PS=1.86U PD=2.76U
* device instance $181 r0 *1 40.95,13.04 sky130_fd_pr__nfet_01v8
M$181 97 126 193 193 sky130_fd_pr__nfet_01v8 L=0.15U W=0.65U AS=0.169P
+ AD=0.10725P PS=1.82U PD=0.98U
* device instance $182 r0 *1 41.43,13.04 sky130_fd_pr__nfet_01v8
M$182 248 195 97 97 sky130_fd_pr__nfet_01v8 L=0.15U W=0.65U AS=0.10725P
+ AD=0.06825P PS=0.98U PD=0.86U
* device instance $183 r0 *1 41.79,13.04 sky130_fd_pr__nfet_01v8
M$183 193 92 248 248 sky130_fd_pr__nfet_01v8 L=0.15U W=0.65U AS=0.06825P
+ AD=0.169P PS=0.86U PD=1.82U
* device instance $184 r0 *1 42.73,13.04 sky130_fd_pr__nfet_01v8
M$184 251 135 193 193 sky130_fd_pr__nfet_01v8 L=0.15U W=0.65U AS=0.169P
+ AD=0.10725P PS=1.82U PD=0.98U
* device instance $185 r0 *1 43.21,13.04 sky130_fd_pr__nfet_01v8
M$185 97 70 251 251 sky130_fd_pr__nfet_01v8 L=0.15U W=0.65U AS=0.10725P
+ AD=0.102375P PS=0.98U PD=0.965U
* device instance $186 r0 *1 43.675,13.04 sky130_fd_pr__nfet_01v8
M$186 197 193 97 97 sky130_fd_pr__nfet_01v8 L=0.15U W=0.65U AS=0.102375P
+ AD=0.169P PS=0.965U PD=1.82U
* device instance $187 r0 *1 46.93,13.155 sky130_fd_pr__nfet_01v8
M$187 97 333 198 198 sky130_fd_pr__nfet_01v8 L=0.15U W=0.42U AS=0.1092P
+ AD=0.0567P PS=1.36U PD=0.69U
* device instance $188 r0 *1 47.35,13.155 sky130_fd_pr__nfet_01v8
M$188 199 198 97 97 sky130_fd_pr__nfet_01v8 L=0.15U W=0.42U AS=0.0567P
+ AD=0.1092P PS=0.69U PD=1.36U
* device instance $189 r0 *1 48.29,13.155 sky130_fd_pr__nfet_01v8
M$189 253 127 200 200 sky130_fd_pr__nfet_01v8 L=0.15U W=0.42U AS=0.1092P
+ AD=0.0441P PS=1.36U PD=0.63U
* device instance $190 r0 *1 48.65,13.155 sky130_fd_pr__nfet_01v8
M$190 97 94 253 253 sky130_fd_pr__nfet_01v8 L=0.15U W=0.42U AS=0.0441P
+ AD=0.1092P PS=0.63U PD=1.36U
* device instance $191 r0 *1 49.59,13.155 sky130_fd_pr__nfet_01v8
M$191 97 94 201 201 sky130_fd_pr__nfet_01v8 L=0.15U W=0.42U AS=0.1092P
+ AD=0.0609P PS=1.36U PD=0.71U
* device instance $192 r0 *1 50.03,13.155 sky130_fd_pr__nfet_01v8
M$192 254 201 97 97 sky130_fd_pr__nfet_01v8 L=0.15U W=0.42U AS=0.0609P
+ AD=0.0756P PS=0.71U PD=0.78U
* device instance $193 r0 *1 50.54,13.155 sky130_fd_pr__nfet_01v8
M$193 200 205 254 254 sky130_fd_pr__nfet_01v8 L=0.15U W=0.42U AS=0.0756P
+ AD=0.1446P PS=0.78U PD=1.18U
* device instance $194 r0 *1 51.45,13.185 sky130_fd_pr__nfet_01v8
M$194 202 198 200 200 sky130_fd_pr__nfet_01v8 L=0.15U W=0.36U AS=0.1446P
+ AD=0.0522P PS=1.18U PD=0.65U
* device instance $195 r0 *1 51.89,13.185 sky130_fd_pr__nfet_01v8
M$195 202 199 252 252 sky130_fd_pr__nfet_01v8 L=0.15U W=0.36U AS=0.0759P
+ AD=0.0522P PS=0.8U PD=0.65U
* device instance $196 r0 *1 52.42,13.155 sky130_fd_pr__nfet_01v8
M$196 252 203 97 97 sky130_fd_pr__nfet_01v8 L=0.15U W=0.42U AS=0.12095P
+ AD=0.0759P PS=1.085U PD=0.8U
* device instance $197 r0 *1 53.015,13.045 sky130_fd_pr__nfet_01v8
M$197 203 202 97 97 sky130_fd_pr__nfet_01v8 L=0.15U W=0.64U AS=0.12095P
+ AD=0.1664P PS=1.085U PD=1.8U
* device instance $198 r0 *1 53.955,13.155 sky130_fd_pr__nfet_01v8
M$198 250 203 97 97 sky130_fd_pr__nfet_01v8 L=0.15U W=0.42U AS=0.1092P
+ AD=0.0678P PS=1.36U PD=0.755U
* device instance $199 r0 *1 54.44,13.185 sky130_fd_pr__nfet_01v8
M$199 204 199 250 250 sky130_fd_pr__nfet_01v8 L=0.15U W=0.36U AS=0.0678P
+ AD=0.0684P PS=0.755U PD=0.74U
* device instance $200 r0 *1 54.97,13.185 sky130_fd_pr__nfet_01v8
M$200 204 198 249 249 sky130_fd_pr__nfet_01v8 L=0.15U W=0.36U AS=0.066P
+ AD=0.0684P PS=0.745U PD=0.74U
* device instance $201 r0 *1 55.445,13.155 sky130_fd_pr__nfet_01v8
M$201 97 205 249 249 sky130_fd_pr__nfet_01v8 L=0.15U W=0.42U AS=0.066P
+ AD=0.1092P PS=0.745U PD=1.36U
* device instance $202 r0 *1 56.385,13.155 sky130_fd_pr__nfet_01v8
M$202 205 204 97 97 sky130_fd_pr__nfet_01v8 L=0.15U W=0.42U AS=0.10025P
+ AD=0.1092P PS=0.985U PD=1.36U
* device instance $203 r0 *1 56.87,13.04 sky130_fd_pr__nfet_01v8
M$203 195 204 97 97 sky130_fd_pr__nfet_01v8 L=0.15U W=0.65U AS=0.10025P
+ AD=0.182P PS=0.985U PD=1.86U
* device instance $204 r0 *1 61.69,13.04 sky130_fd_pr__nfet_01v8
M$204 206 219 97 97 sky130_fd_pr__nfet_01v8 L=0.15U W=0.65U AS=0.169P
+ AD=0.08775P PS=1.82U PD=0.92U
* device instance $205 r0 *1 62.11,13.04 sky130_fd_pr__nfet_01v8
M$205 97 220 206 206 sky130_fd_pr__nfet_01v8 L=0.15U W=0.65U AS=0.08775P
+ AD=0.08775P PS=0.92U PD=0.92U
* device instance $206 r0 *1 62.53,13.04 sky130_fd_pr__nfet_01v8
M$206 243 220 97 97 sky130_fd_pr__nfet_01v8 L=0.15U W=0.65U AS=0.08775P
+ AD=0.08775P PS=0.92U PD=0.92U
* device instance $207 r0 *1 62.95,13.04 sky130_fd_pr__nfet_01v8
M$207 5 219 243 243 sky130_fd_pr__nfet_01v8 L=0.15U W=0.65U AS=0.08775P
+ AD=0.25025P PS=0.92U PD=1.42U
* device instance $208 r0 *1 63.87,13.04 sky130_fd_pr__nfet_01v8
M$208 97 206 5 5 sky130_fd_pr__nfet_01v8 L=0.15U W=0.65U AS=0.25025P AD=0.208P
+ PS=1.42U PD=1.94U
* device instance $209 r0 *1 66.29,13.04 sky130_fd_pr__nfet_01v8
M$209 208 21 97 97 sky130_fd_pr__nfet_01v8 L=0.15U W=0.65U AS=0.169P
+ AD=0.08775P PS=1.82U PD=0.92U
* device instance $210 r0 *1 66.71,13.04 sky130_fd_pr__nfet_01v8
M$210 97 162 208 208 sky130_fd_pr__nfet_01v8 L=0.15U W=0.65U AS=0.08775P
+ AD=0.08775P PS=0.92U PD=0.92U
* device instance $211 r0 *1 67.13,13.04 sky130_fd_pr__nfet_01v8
M$211 239 162 97 97 sky130_fd_pr__nfet_01v8 L=0.15U W=0.65U AS=0.08775P
+ AD=0.08775P PS=0.92U PD=0.92U
* device instance $212 r0 *1 67.55,13.04 sky130_fd_pr__nfet_01v8
M$212 220 21 239 239 sky130_fd_pr__nfet_01v8 L=0.15U W=0.65U AS=0.08775P
+ AD=0.25025P PS=0.92U PD=1.42U
* device instance $213 r0 *1 68.47,13.04 sky130_fd_pr__nfet_01v8
M$213 97 208 220 220 sky130_fd_pr__nfet_01v8 L=0.15U W=0.65U AS=0.25025P
+ AD=0.208P PS=1.42U PD=1.94U
* device instance $214 r0 *1 69.47,12.925 sky130_fd_pr__nfet_01v8
M$214 97 162 221 221 sky130_fd_pr__nfet_01v8 L=0.15U W=0.42U AS=0.1092P
+ AD=0.10025P PS=1.36U PD=0.985U
* device instance $215 r0 *1 69.955,13.04 sky130_fd_pr__nfet_01v8
M$215 237 21 97 97 sky130_fd_pr__nfet_01v8 L=0.15U W=0.65U AS=0.10025P
+ AD=0.08775P PS=0.985U PD=0.92U
* device instance $216 r0 *1 70.375,13.04 sky130_fd_pr__nfet_01v8
M$216 210 221 237 237 sky130_fd_pr__nfet_01v8 L=0.15U W=0.65U AS=0.08775P
+ AD=0.169P PS=0.92U PD=1.82U
* device instance $217 r0 *1 12.665,14.045 sky130_fd_pr__nfet_01v8
M$217 97 57 255 255 sky130_fd_pr__nfet_01v8 L=0.15U W=0.42U AS=0.1092P
+ AD=0.10025P PS=1.36U PD=0.985U
* device instance $218 r0 *1 13.15,14.16 sky130_fd_pr__nfet_01v8
M$218 282 13 97 97 sky130_fd_pr__nfet_01v8 L=0.15U W=0.65U AS=0.10025P
+ AD=0.08775P PS=0.985U PD=0.92U
* device instance $219 r0 *1 13.57,14.16 sky130_fd_pr__nfet_01v8
M$219 97 255 282 282 sky130_fd_pr__nfet_01v8 L=0.15U W=0.65U AS=0.08775P
+ AD=0.169P PS=0.92U PD=1.82U
* device instance $220 r0 *1 13.82,18.48 sky130_fd_pr__nfet_01v8
M$220 97 294 293 293 sky130_fd_pr__nfet_01v8 L=0.15U W=0.65U AS=0.169P
+ AD=0.25675P PS=1.82U PD=1.44U
* device instance $221 r0 *1 14.76,18.48 sky130_fd_pr__nfet_01v8
M$221 294 282 97 97 sky130_fd_pr__nfet_01v8 L=0.15U W=0.65U AS=0.25675P
+ AD=0.089375P PS=1.44U PD=0.925U
* device instance $222 r0 *1 15.185,18.48 sky130_fd_pr__nfet_01v8
M$222 323 180 294 294 sky130_fd_pr__nfet_01v8 L=0.15U W=0.65U AS=0.089375P
+ AD=0.091P PS=0.925U PD=0.93U
* device instance $223 r0 *1 15.615,18.48 sky130_fd_pr__nfet_01v8
M$223 97 256 323 323 sky130_fd_pr__nfet_01v8 L=0.15U W=0.65U AS=0.091P
+ AD=0.17225P PS=0.93U PD=1.83U
* device instance $224 r0 *1 15.145,14.045 sky130_fd_pr__nfet_01v8
M$224 97 217 256 256 sky130_fd_pr__nfet_01v8 L=0.15U W=0.42U AS=0.1092P
+ AD=0.1197P PS=1.36U PD=1.41U
* device instance $225 r0 *1 28.63,14.16 sky130_fd_pr__nfet_01v8
M$225 281 191 257 257 sky130_fd_pr__nfet_01v8 L=0.15U W=0.65U AS=0.169P
+ AD=0.06825P PS=1.82U PD=0.86U
* device instance $226 r0 *1 28.99,14.16 sky130_fd_pr__nfet_01v8
M$226 97 218 281 281 sky130_fd_pr__nfet_01v8 L=0.15U W=0.65U AS=0.06825P
+ AD=0.08775P PS=0.86U PD=0.92U
* device instance $227 r0 *1 29.41,14.16 sky130_fd_pr__nfet_01v8
M$227 258 218 97 97 sky130_fd_pr__nfet_01v8 L=0.15U W=0.65U AS=0.08775P
+ AD=0.169P PS=0.92U PD=1.82U
* device instance $228 r0 *1 30.35,14.16 sky130_fd_pr__nfet_01v8
M$228 258 191 97 97 sky130_fd_pr__nfet_01v8 L=0.15U W=0.65U AS=0.169P
+ AD=0.08775P PS=1.82U PD=0.92U
* device instance $229 r0 *1 30.77,14.16 sky130_fd_pr__nfet_01v8
M$229 262 257 258 258 sky130_fd_pr__nfet_01v8 L=0.15U W=0.65U AS=0.08775P
+ AD=0.195P PS=0.92U PD=1.9U
* device instance $230 r0 *1 31.985,14.045 sky130_fd_pr__nfet_01v8
M$230 97 259 261 261 sky130_fd_pr__nfet_01v8 L=0.15U W=0.42U AS=0.1092P
+ AD=0.10025P PS=1.36U PD=0.985U
* device instance $231 r0 *1 32.47,14.16 sky130_fd_pr__nfet_01v8
M$231 93 260 97 97 sky130_fd_pr__nfet_01v8 L=0.15U W=0.65U AS=0.10025P
+ AD=0.08775P PS=0.985U PD=0.92U
* device instance $232 r0 *1 32.89,14.16 sky130_fd_pr__nfet_01v8
M$232 97 261 93 93 sky130_fd_pr__nfet_01v8 L=0.15U W=0.65U AS=0.08775P
+ AD=0.169P PS=0.92U PD=1.82U
* device instance $233 r0 *1 34.05,14.16 sky130_fd_pr__nfet_01v8
M$233 259 262 263 263 sky130_fd_pr__nfet_01v8 L=0.15U W=1.3U AS=0.25675P
+ AD=0.1755P PS=2.74U PD=1.84U
* device instance $235 r0 *1 34.89,14.16 sky130_fd_pr__nfet_01v8
M$235 265 264 263 263 sky130_fd_pr__nfet_01v8 L=0.15U W=1.3U AS=0.1755P
+ AD=0.25675P PS=1.84U PD=2.74U
* device instance $237 r0 *1 34.07,18.48 sky130_fd_pr__nfet_01v8
M$237 260 262 97 97 sky130_fd_pr__nfet_01v8 L=0.15U W=0.65U AS=0.17225P
+ AD=0.091P PS=1.83U PD=0.93U
* device instance $238 r0 *1 34.5,18.48 sky130_fd_pr__nfet_01v8
M$238 325 264 260 260 sky130_fd_pr__nfet_01v8 L=0.15U W=0.65U AS=0.091P
+ AD=0.095875P PS=0.93U PD=0.945U
* device instance $239 r0 *1 34.945,18.48 sky130_fd_pr__nfet_01v8
M$239 97 266 325 325 sky130_fd_pr__nfet_01v8 L=0.15U W=0.65U AS=0.095875P
+ AD=0.17225P PS=0.945U PD=1.83U
* device instance $240 r0 *1 35.89,18.48 sky130_fd_pr__nfet_01v8
M$240 271 63 97 97 sky130_fd_pr__nfet_01v8 L=0.15U W=0.65U AS=0.169P
+ AD=0.08775P PS=1.82U PD=0.92U
* device instance $241 r0 *1 36.31,18.48 sky130_fd_pr__nfet_01v8
M$241 97 218 271 271 sky130_fd_pr__nfet_01v8 L=0.15U W=0.65U AS=0.08775P
+ AD=0.169P PS=0.92U PD=1.82U
* device instance $242 r0 *1 36.25,14.16 sky130_fd_pr__nfet_01v8
M$242 265 266 97 97 sky130_fd_pr__nfet_01v8 L=0.15U W=1.3U AS=0.25675P
+ AD=0.28925P PS=2.74U PD=2.84U
* device instance $244 r0 *1 37.73,14.16 sky130_fd_pr__nfet_01v8
M$244 97 264 267 267 sky130_fd_pr__nfet_01v8 L=0.15U W=1.3U AS=0.25675P
+ AD=0.1755P PS=2.74U PD=1.84U
* device instance $246 r0 *1 38.57,14.16 sky130_fd_pr__nfet_01v8
M$246 269 268 267 267 sky130_fd_pr__nfet_01v8 L=0.15U W=1.3U AS=0.1755P
+ AD=0.25675P PS=1.84U PD=2.74U
* device instance $248 r0 *1 39.93,14.16 sky130_fd_pr__nfet_01v8
M$248 269 262 270 270 sky130_fd_pr__nfet_01v8 L=0.15U W=1.3U AS=0.25675P
+ AD=0.18525P PS=2.74U PD=1.87U
* device instance $250 r0 *1 40.8,14.16 sky130_fd_pr__nfet_01v8
M$250 97 271 270 270 sky130_fd_pr__nfet_01v8 L=0.15U W=1.3U AS=0.18525P
+ AD=0.25675P PS=1.87U PD=2.09U
* device instance $252 r0 *1 41.89,14.16 sky130_fd_pr__nfet_01v8
M$252 97 272 270 270 sky130_fd_pr__nfet_01v8 L=0.15U W=1.3U AS=0.25675P
+ AD=0.25675P PS=2.09U PD=2.74U
* device instance $254 r0 *1 45.325,14.045 sky130_fd_pr__nfet_01v8
M$254 97 129 273 273 sky130_fd_pr__nfet_01v8 L=0.15U W=0.42U AS=0.1092P
+ AD=0.10025P PS=1.36U PD=0.985U
* device instance $255 r0 *1 45.81,14.16 sky130_fd_pr__nfet_01v8
M$255 272 195 97 97 sky130_fd_pr__nfet_01v8 L=0.15U W=0.65U AS=0.10025P
+ AD=0.08775P PS=0.985U PD=0.92U
* device instance $256 r0 *1 46.23,14.16 sky130_fd_pr__nfet_01v8
M$256 97 273 272 272 sky130_fd_pr__nfet_01v8 L=0.15U W=0.65U AS=0.08775P
+ AD=0.169P PS=0.92U PD=1.82U
* device instance $257 r0 *1 47.39,14.16 sky130_fd_pr__nfet_01v8
M$257 68 274 97 97 sky130_fd_pr__nfet_01v8 L=0.15U W=0.65U AS=0.169P
+ AD=0.08775P PS=1.82U PD=0.92U
* device instance $258 r0 *1 47.81,14.16 sky130_fd_pr__nfet_01v8
M$258 97 272 68 68 sky130_fd_pr__nfet_01v8 L=0.15U W=0.65U AS=0.08775P
+ AD=0.169P PS=0.92U PD=1.82U
* device instance $259 r0 *1 50.385,14.045 sky130_fd_pr__nfet_01v8
M$259 97 195 275 275 sky130_fd_pr__nfet_01v8 L=0.15U W=0.42U AS=0.1092P
+ AD=0.10025P PS=1.36U PD=0.985U
* device instance $260 r0 *1 50.87,14.16 sky130_fd_pr__nfet_01v8
M$260 274 129 97 97 sky130_fd_pr__nfet_01v8 L=0.15U W=0.65U AS=0.10025P
+ AD=0.08775P PS=0.985U PD=0.92U
* device instance $261 r0 *1 51.29,14.16 sky130_fd_pr__nfet_01v8
M$261 97 275 274 274 sky130_fd_pr__nfet_01v8 L=0.15U W=0.65U AS=0.08775P
+ AD=0.169P PS=0.92U PD=1.82U
* device instance $262 r0 *1 53.625,18.595 sky130_fd_pr__nfet_01v8
M$262 306 305 97 97 sky130_fd_pr__nfet_01v8 L=0.15U W=0.42U AS=0.10025P
+ AD=0.1092P PS=0.985U PD=1.36U
* device instance $263 r0 *1 54.11,18.48 sky130_fd_pr__nfet_01v8
M$263 129 305 97 97 sky130_fd_pr__nfet_01v8 L=0.15U W=0.65U AS=0.10025P
+ AD=0.182P PS=0.985U PD=1.86U
* device instance $264 r0 *1 57.655,14.045 sky130_fd_pr__nfet_01v8
M$264 276 274 97 97 sky130_fd_pr__nfet_01v8 L=0.15U W=0.42U AS=0.1092P
+ AD=0.0567P PS=1.36U PD=0.69U
* device instance $265 r0 *1 58.075,14.045 sky130_fd_pr__nfet_01v8
M$265 97 270 276 276 sky130_fd_pr__nfet_01v8 L=0.15U W=0.42U AS=0.0567P
+ AD=0.10025P PS=0.69U PD=0.985U
* device instance $266 r0 *1 58.56,14.16 sky130_fd_pr__nfet_01v8
M$266 277 276 97 97 sky130_fd_pr__nfet_01v8 L=0.15U W=0.65U AS=0.10025P
+ AD=0.169P PS=0.985U PD=1.82U
* device instance $267 r0 *1 59.95,18.48 sky130_fd_pr__nfet_01v8
M$267 97 220 317 317 sky130_fd_pr__nfet_01v8 L=0.15U W=1.3U AS=0.25675P
+ AD=0.1755P PS=2.74U PD=1.84U
* device instance $269 r0 *1 60.79,18.48 sky130_fd_pr__nfet_01v8
M$269 97 270 317 317 sky130_fd_pr__nfet_01v8 L=0.15U W=1.3U AS=0.1755P
+ AD=0.1755P PS=1.84U PD=1.84U
* device instance $271 r0 *1 61.63,18.48 sky130_fd_pr__nfet_01v8
M$271 97 274 317 317 sky130_fd_pr__nfet_01v8 L=0.15U W=1.3U AS=0.3185P
+ AD=0.3185P PS=2.28U PD=2.28U
* device instance $273 r0 *1 62.91,18.48 sky130_fd_pr__nfet_01v8
M$273 318 210 317 317 sky130_fd_pr__nfet_01v8 L=0.15U W=1.3U AS=0.1755P
+ AD=0.26975P PS=1.84U PD=2.78U
* device instance $275 r0 *1 63.52,14.045 sky130_fd_pr__nfet_01v8
M$275 97 220 278 278 sky130_fd_pr__nfet_01v8 L=0.15U W=0.42U AS=0.1113P
+ AD=0.0588P PS=1.37U PD=0.7U
* device instance $276 r0 *1 63.95,14.045 sky130_fd_pr__nfet_01v8
M$276 278 277 97 97 sky130_fd_pr__nfet_01v8 L=0.15U W=0.42U AS=0.0588P
+ AD=0.0588P PS=0.7U PD=0.7U
* device instance $277 r0 *1 64.38,14.045 sky130_fd_pr__nfet_01v8
M$277 279 210 278 278 sky130_fd_pr__nfet_01v8 L=0.15U W=0.42U AS=0.0588P
+ AD=0.1113P PS=0.7U PD=1.37U
* device instance $278 r0 *1 64.31,18.48 sky130_fd_pr__nfet_01v8
M$278 318 310 307 307 sky130_fd_pr__nfet_01v8 L=0.15U W=1.3U AS=0.26975P
+ AD=0.25675P PS=2.78U PD=2.74U
* device instance $280 r0 *1 65.33,14.16 sky130_fd_pr__nfet_01v8
M$280 97 277 280 280 sky130_fd_pr__nfet_01v8 L=0.15U W=0.65U AS=0.169P
+ AD=0.08775P PS=1.82U PD=0.92U
* device instance $281 r0 *1 65.75,14.16 sky130_fd_pr__nfet_01v8
M$281 219 280 97 97 sky130_fd_pr__nfet_01v8 L=0.15U W=2.6U AS=0.351P
+ AD=0.43225P PS=3.68U PD=4.58U
* device instance $285 r0 *1 17.03,19.6 sky130_fd_pr__nfet_01v8
M$285 97 341 326 326 sky130_fd_pr__nfet_01v8 L=0.15U W=0.65U AS=0.169P
+ AD=0.08775P PS=1.82U PD=0.92U
* device instance $286 r0 *1 17.45,19.6 sky130_fd_pr__nfet_01v8
M$286 180 326 97 97 sky130_fd_pr__nfet_01v8 L=0.15U W=2.6U AS=0.351P
+ AD=0.43225P PS=3.68U PD=4.58U
* device instance $290 r0 *1 19.79,19.6 sky130_fd_pr__nfet_01v8
M$290 327 341 97 97 sky130_fd_pr__nfet_01v8 L=0.15U W=2.6U AS=0.43225P
+ AD=0.351P PS=4.58U PD=3.68U
* device instance $293 r0 *1 21.05,19.6 sky130_fd_pr__nfet_01v8
M$293 328 256 327 327 sky130_fd_pr__nfet_01v8 L=0.15U W=2.6U AS=0.351P
+ AD=0.351P PS=3.68U PD=3.68U
* device instance $298 r0 *1 23.15,19.6 sky130_fd_pr__nfet_01v8
M$298 328 329 97 97 sky130_fd_pr__nfet_01v8 L=0.15U W=2.6U AS=0.378625P
+ AD=0.47775P PS=3.765U PD=4.72U
* device instance $301 r0 *1 24.49,19.6 sky130_fd_pr__nfet_01v8
M$301 97 282 328 328 sky130_fd_pr__nfet_01v8 L=0.15U W=2.6U AS=0.352625P
+ AD=0.35425P PS=3.685U PD=3.69U
* device instance $306 r0 *1 27.155,19.485 sky130_fd_pr__nfet_01v8
M$306 330 297 97 97 sky130_fd_pr__nfet_01v8 L=0.15U W=1.68U AS=0.2877P
+ AD=0.2352P PS=3.47U PD=2.8U
* device instance $310 r0 *1 28.875,19.485 sky130_fd_pr__nfet_01v8
M$310 32 330 97 97 sky130_fd_pr__nfet_01v8 L=0.15U W=6.72U AS=0.93975P
+ AD=0.99225P PS=11.195U PD=11.865U
* device instance $326 r0 *1 36.35,19.6 sky130_fd_pr__nfet_01v8
M$326 97 268 331 331 sky130_fd_pr__nfet_01v8 L=0.15U W=0.65U AS=0.169P
+ AD=0.08775P PS=1.82U PD=0.92U
* device instance $327 r0 *1 36.77,19.6 sky130_fd_pr__nfet_01v8
M$327 266 331 97 97 sky130_fd_pr__nfet_01v8 L=0.15U W=2.6U AS=0.351P
+ AD=0.43225P PS=3.68U PD=4.58U
* device instance $331 r0 *1 44.17,18.595 sky130_fd_pr__nfet_01v8
M$331 97 333 298 298 sky130_fd_pr__nfet_01v8 L=0.15U W=0.42U AS=0.1092P
+ AD=0.0567P PS=1.36U PD=0.69U
* device instance $332 r0 *1 44.59,18.595 sky130_fd_pr__nfet_01v8
M$332 299 298 97 97 sky130_fd_pr__nfet_01v8 L=0.15U W=0.42U AS=0.0567P
+ AD=0.1092P PS=0.69U PD=1.36U
* device instance $333 r0 *1 45.53,18.595 sky130_fd_pr__nfet_01v8
M$333 324 197 300 300 sky130_fd_pr__nfet_01v8 L=0.15U W=0.42U AS=0.1092P
+ AD=0.0441P PS=1.36U PD=0.63U
* device instance $334 r0 *1 45.89,18.595 sky130_fd_pr__nfet_01v8
M$334 97 302 324 324 sky130_fd_pr__nfet_01v8 L=0.15U W=0.42U AS=0.0441P
+ AD=0.1092P PS=0.63U PD=1.36U
* device instance $335 r0 *1 46.475,19.485 sky130_fd_pr__nfet_01v8
M$335 332 297 97 97 sky130_fd_pr__nfet_01v8 L=0.15U W=1.68U AS=0.2877P
+ AD=0.2352P PS=3.47U PD=2.8U
* device instance $339 r0 *1 48.195,19.485 sky130_fd_pr__nfet_01v8
M$339 333 332 97 97 sky130_fd_pr__nfet_01v8 L=0.15U W=6.72U AS=0.93975P
+ AD=0.99225P PS=11.195U PD=11.865U
* device instance $355 r0 *1 46.83,18.595 sky130_fd_pr__nfet_01v8
M$355 97 302 301 301 sky130_fd_pr__nfet_01v8 L=0.15U W=0.42U AS=0.1092P
+ AD=0.0609P PS=1.36U PD=0.71U
* device instance $356 r0 *1 47.27,18.595 sky130_fd_pr__nfet_01v8
M$356 322 301 97 97 sky130_fd_pr__nfet_01v8 L=0.15U W=0.42U AS=0.0609P
+ AD=0.0756P PS=0.71U PD=0.78U
* device instance $357 r0 *1 47.78,18.595 sky130_fd_pr__nfet_01v8
M$357 300 306 322 322 sky130_fd_pr__nfet_01v8 L=0.15U W=0.42U AS=0.0756P
+ AD=0.1446P PS=0.78U PD=1.18U
* device instance $358 r0 *1 48.69,18.625 sky130_fd_pr__nfet_01v8
M$358 303 298 300 300 sky130_fd_pr__nfet_01v8 L=0.15U W=0.36U AS=0.1446P
+ AD=0.0522P PS=1.18U PD=0.65U
* device instance $359 r0 *1 49.13,18.625 sky130_fd_pr__nfet_01v8
M$359 303 299 321 321 sky130_fd_pr__nfet_01v8 L=0.15U W=0.36U AS=0.0759P
+ AD=0.0522P PS=0.8U PD=0.65U
* device instance $360 r0 *1 49.66,18.595 sky130_fd_pr__nfet_01v8
M$360 321 304 97 97 sky130_fd_pr__nfet_01v8 L=0.15U W=0.42U AS=0.12095P
+ AD=0.0759P PS=1.085U PD=0.8U
* device instance $361 r0 *1 50.255,18.485 sky130_fd_pr__nfet_01v8
M$361 304 303 97 97 sky130_fd_pr__nfet_01v8 L=0.15U W=0.64U AS=0.12095P
+ AD=0.1664P PS=1.085U PD=1.8U
* device instance $362 r0 *1 51.195,18.595 sky130_fd_pr__nfet_01v8
M$362 320 304 97 97 sky130_fd_pr__nfet_01v8 L=0.15U W=0.42U AS=0.1092P
+ AD=0.0678P PS=1.36U PD=0.755U
* device instance $363 r0 *1 51.68,18.625 sky130_fd_pr__nfet_01v8
M$363 305 299 320 320 sky130_fd_pr__nfet_01v8 L=0.15U W=0.36U AS=0.0678P
+ AD=0.0684P PS=0.755U PD=0.74U
* device instance $364 r0 *1 52.21,18.625 sky130_fd_pr__nfet_01v8
M$364 305 298 319 319 sky130_fd_pr__nfet_01v8 L=0.15U W=0.36U AS=0.066P
+ AD=0.0684P PS=0.745U PD=0.74U
* device instance $365 r0 *1 52.685,18.595 sky130_fd_pr__nfet_01v8
M$365 97 306 319 319 sky130_fd_pr__nfet_01v8 L=0.15U W=0.42U AS=0.066P
+ AD=0.1092P PS=0.745U PD=1.36U
* device instance $366 r0 *1 63.51,19.6 sky130_fd_pr__nfet_01v8
M$366 340 342 97 97 sky130_fd_pr__nfet_01v8 L=0.15U W=0.65U AS=0.169P
+ AD=0.08775P PS=1.82U PD=0.92U
* device instance $367 r0 *1 63.93,19.6 sky130_fd_pr__nfet_01v8
M$367 334 310 340 340 sky130_fd_pr__nfet_01v8 L=0.15U W=0.65U AS=0.08775P
+ AD=0.169P PS=0.92U PD=1.82U
* device instance $368 r0 *1 64.97,19.6 sky130_fd_pr__nfet_01v8
M$368 339 279 335 335 sky130_fd_pr__nfet_01v8 L=0.15U W=0.65U AS=0.169P
+ AD=0.06825P PS=1.82U PD=0.86U
* device instance $369 r0 *1 65.33,19.6 sky130_fd_pr__nfet_01v8
M$369 97 334 339 339 sky130_fd_pr__nfet_01v8 L=0.15U W=0.65U AS=0.06825P
+ AD=0.08775P PS=0.86U PD=0.92U
* device instance $370 r0 *1 65.75,19.6 sky130_fd_pr__nfet_01v8
M$370 336 334 97 97 sky130_fd_pr__nfet_01v8 L=0.15U W=0.65U AS=0.08775P
+ AD=0.169P PS=0.92U PD=1.82U
* device instance $371 r0 *1 66.69,19.6 sky130_fd_pr__nfet_01v8
M$371 336 279 97 97 sky130_fd_pr__nfet_01v8 L=0.15U W=0.65U AS=0.169P
+ AD=0.08775P PS=1.82U PD=0.92U
* device instance $372 r0 *1 67.11,19.6 sky130_fd_pr__nfet_01v8
M$372 347 335 336 336 sky130_fd_pr__nfet_01v8 L=0.15U W=0.65U AS=0.08775P
+ AD=0.195P PS=0.92U PD=1.9U
* device instance $373 r0 *1 68.325,19.485 sky130_fd_pr__nfet_01v8
M$373 97 343 337 337 sky130_fd_pr__nfet_01v8 L=0.15U W=0.42U AS=0.1092P
+ AD=0.10025P PS=1.36U PD=0.985U
* device instance $374 r0 *1 68.81,19.6 sky130_fd_pr__nfet_01v8
M$374 338 344 97 97 sky130_fd_pr__nfet_01v8 L=0.15U W=0.65U AS=0.10025P
+ AD=0.08775P PS=0.985U PD=0.92U
* device instance $375 r0 *1 69.23,19.6 sky130_fd_pr__nfet_01v8
M$375 97 337 338 338 sky130_fd_pr__nfet_01v8 L=0.15U W=0.65U AS=0.08775P
+ AD=0.169P PS=0.92U PD=1.82U
* device instance $376 r0 *1 6.98,24.035 sky130_fd_pr__nfet_01v8
M$376 413 352 353 353 sky130_fd_pr__nfet_01v8 L=0.15U W=0.42U AS=0.1113P
+ AD=0.0441P PS=1.37U PD=0.63U
* device instance $377 r0 *1 7.34,24.035 sky130_fd_pr__nfet_01v8
M$377 97 115 413 413 sky130_fd_pr__nfet_01v8 L=0.15U W=0.42U AS=0.0441P
+ AD=0.0966P PS=0.63U PD=0.88U
* device instance $378 r0 *1 7.95,24.035 sky130_fd_pr__nfet_01v8
M$378 354 353 97 97 sky130_fd_pr__nfet_01v8 L=0.15U W=0.42U AS=0.0966P
+ AD=0.1113P PS=0.88U PD=1.37U
* device instance $379 r0 *1 9.21,23.92 sky130_fd_pr__nfet_01v8
M$379 97 354 355 355 sky130_fd_pr__nfet_01v8 L=0.15U W=0.65U AS=0.169P
+ AD=0.10725P PS=1.82U PD=0.98U
* device instance $380 r0 *1 9.69,23.92 sky130_fd_pr__nfet_01v8
M$380 415 399 97 97 sky130_fd_pr__nfet_01v8 L=0.15U W=0.65U AS=0.10725P
+ AD=0.06825P PS=0.98U PD=0.86U
* device instance $381 r0 *1 10.05,23.92 sky130_fd_pr__nfet_01v8
M$381 355 92 415 415 sky130_fd_pr__nfet_01v8 L=0.15U W=0.65U AS=0.06825P
+ AD=0.169P PS=0.86U PD=1.82U
* device instance $382 r0 *1 10.99,23.92 sky130_fd_pr__nfet_01v8
M$382 416 158 355 355 sky130_fd_pr__nfet_01v8 L=0.15U W=0.65U AS=0.169P
+ AD=0.10725P PS=1.82U PD=0.98U
* device instance $383 r0 *1 11.47,23.92 sky130_fd_pr__nfet_01v8
M$383 97 359 416 416 sky130_fd_pr__nfet_01v8 L=0.15U W=0.65U AS=0.10725P
+ AD=0.102375P PS=0.98U PD=0.965U
* device instance $384 r0 *1 11.935,23.92 sky130_fd_pr__nfet_01v8
M$384 410 355 97 97 sky130_fd_pr__nfet_01v8 L=0.15U W=0.65U AS=0.102375P
+ AD=0.169P PS=0.965U PD=1.82U
* device instance $385 r0 *1 12.93,23.92 sky130_fd_pr__nfet_01v8
M$385 358 400 97 97 sky130_fd_pr__nfet_01v8 L=0.15U W=0.65U AS=0.169P
+ AD=0.08775P PS=1.82U PD=0.92U
* device instance $386 r0 *1 13.35,23.92 sky130_fd_pr__nfet_01v8
M$386 97 293 358 358 sky130_fd_pr__nfet_01v8 L=0.15U W=0.65U AS=0.08775P
+ AD=0.08775P PS=0.92U PD=0.92U
* device instance $387 r0 *1 13.77,23.92 sky130_fd_pr__nfet_01v8
M$387 419 293 97 97 sky130_fd_pr__nfet_01v8 L=0.15U W=0.65U AS=0.08775P
+ AD=0.08775P PS=0.92U PD=0.92U
* device instance $388 r0 *1 14.19,23.92 sky130_fd_pr__nfet_01v8
M$388 359 400 419 419 sky130_fd_pr__nfet_01v8 L=0.15U W=0.65U AS=0.08775P
+ AD=0.25025P PS=0.92U PD=1.42U
* device instance $389 r0 *1 15.11,23.92 sky130_fd_pr__nfet_01v8
M$389 97 358 359 359 sky130_fd_pr__nfet_01v8 L=0.15U W=0.65U AS=0.25025P
+ AD=0.208P PS=1.42U PD=1.94U
* device instance $390 r0 *1 17.49,24.005 sky130_fd_pr__nfet_01v8
M$390 361 589 97 97 sky130_fd_pr__nfet_01v8 L=0.15U W=0.42U AS=0.1092P
+ AD=0.0693P PS=1.36U PD=0.75U
* device instance $391 r0 *1 17.97,24.005 sky130_fd_pr__nfet_01v8
M$391 97 13 361 361 sky130_fd_pr__nfet_01v8 L=0.15U W=0.42U AS=0.0693P
+ AD=0.0567P PS=0.75U PD=0.69U
* device instance $392 r0 *1 18.39,24.005 sky130_fd_pr__nfet_01v8
M$392 361 399 97 97 sky130_fd_pr__nfet_01v8 L=0.15U W=0.42U AS=0.0567P
+ AD=0.0567P PS=0.69U PD=0.69U
* device instance $393 r0 *1 18.81,24.005 sky130_fd_pr__nfet_01v8
M$393 361 218 97 97 sky130_fd_pr__nfet_01v8 L=0.15U W=0.42U AS=0.101875P
+ AD=0.0567P PS=0.99U PD=0.69U
* device instance $394 r0 *1 19.3,23.92 sky130_fd_pr__nfet_01v8
M$394 362 361 97 97 sky130_fd_pr__nfet_01v8 L=0.15U W=0.65U AS=0.101875P
+ AD=0.1755P PS=0.99U PD=1.84U
* device instance $395 r0 *1 27.625,24.035 sky130_fd_pr__nfet_01v8
M$395 363 32 97 97 sky130_fd_pr__nfet_01v8 L=0.15U W=1.68U AS=0.315P AD=0.3423P
+ PS=3.6U PD=3.73U
* device instance $399 r0 *1 41.41,24.035 sky130_fd_pr__nfet_01v8
M$399 97 333 364 364 sky130_fd_pr__nfet_01v8 L=0.15U W=0.42U AS=0.1092P
+ AD=0.0567P PS=1.36U PD=0.69U
* device instance $400 r0 *1 41.83,24.035 sky130_fd_pr__nfet_01v8
M$400 365 364 97 97 sky130_fd_pr__nfet_01v8 L=0.15U W=0.42U AS=0.0567P
+ AD=0.1092P PS=0.69U PD=1.36U
* device instance $401 r0 *1 42.77,24.035 sky130_fd_pr__nfet_01v8
M$401 426 401 366 366 sky130_fd_pr__nfet_01v8 L=0.15U W=0.42U AS=0.1092P
+ AD=0.0441P PS=1.36U PD=0.63U
* device instance $402 r0 *1 43.13,24.035 sky130_fd_pr__nfet_01v8
M$402 97 94 426 426 sky130_fd_pr__nfet_01v8 L=0.15U W=0.42U AS=0.0441P
+ AD=0.1092P PS=0.63U PD=1.36U
* device instance $403 r0 *1 44.07,24.035 sky130_fd_pr__nfet_01v8
M$403 97 94 367 367 sky130_fd_pr__nfet_01v8 L=0.15U W=0.42U AS=0.1092P
+ AD=0.0609P PS=1.36U PD=0.71U
* device instance $404 r0 *1 44.51,24.035 sky130_fd_pr__nfet_01v8
M$404 425 367 97 97 sky130_fd_pr__nfet_01v8 L=0.15U W=0.42U AS=0.0609P
+ AD=0.0756P PS=0.71U PD=0.78U
* device instance $405 r0 *1 45.02,24.035 sky130_fd_pr__nfet_01v8
M$405 366 371 425 425 sky130_fd_pr__nfet_01v8 L=0.15U W=0.42U AS=0.0756P
+ AD=0.1446P PS=0.78U PD=1.18U
* device instance $406 r0 *1 45.93,24.065 sky130_fd_pr__nfet_01v8
M$406 368 364 366 366 sky130_fd_pr__nfet_01v8 L=0.15U W=0.36U AS=0.1446P
+ AD=0.0522P PS=1.18U PD=0.65U
* device instance $407 r0 *1 46.37,24.065 sky130_fd_pr__nfet_01v8
M$407 368 365 424 424 sky130_fd_pr__nfet_01v8 L=0.15U W=0.36U AS=0.0759P
+ AD=0.0522P PS=0.8U PD=0.65U
* device instance $408 r0 *1 46.9,24.035 sky130_fd_pr__nfet_01v8
M$408 424 369 97 97 sky130_fd_pr__nfet_01v8 L=0.15U W=0.42U AS=0.12095P
+ AD=0.0759P PS=1.085U PD=0.8U
* device instance $409 r0 *1 47.495,23.925 sky130_fd_pr__nfet_01v8
M$409 369 368 97 97 sky130_fd_pr__nfet_01v8 L=0.15U W=0.64U AS=0.12095P
+ AD=0.1664P PS=1.085U PD=1.8U
* device instance $410 r0 *1 48.435,24.035 sky130_fd_pr__nfet_01v8
M$410 423 369 97 97 sky130_fd_pr__nfet_01v8 L=0.15U W=0.42U AS=0.1092P
+ AD=0.0678P PS=1.36U PD=0.755U
* device instance $411 r0 *1 48.92,24.065 sky130_fd_pr__nfet_01v8
M$411 370 365 423 423 sky130_fd_pr__nfet_01v8 L=0.15U W=0.36U AS=0.0678P
+ AD=0.0684P PS=0.755U PD=0.74U
* device instance $412 r0 *1 49.45,24.065 sky130_fd_pr__nfet_01v8
M$412 370 364 422 422 sky130_fd_pr__nfet_01v8 L=0.15U W=0.36U AS=0.066P
+ AD=0.0684P PS=0.745U PD=0.74U
* device instance $413 r0 *1 49.925,24.035 sky130_fd_pr__nfet_01v8
M$413 97 371 422 422 sky130_fd_pr__nfet_01v8 L=0.15U W=0.42U AS=0.066P
+ AD=0.1092P PS=0.745U PD=1.36U
* device instance $414 r0 *1 50.865,24.035 sky130_fd_pr__nfet_01v8
M$414 371 370 97 97 sky130_fd_pr__nfet_01v8 L=0.15U W=0.42U AS=0.10025P
+ AD=0.1092P PS=0.985U PD=1.36U
* device instance $415 r0 *1 51.35,23.92 sky130_fd_pr__nfet_01v8
M$415 372 370 97 97 sky130_fd_pr__nfet_01v8 L=0.15U W=0.65U AS=0.10025P
+ AD=0.182P PS=0.985U PD=1.86U
* device instance $416 r0 *1 53.39,23.92 sky130_fd_pr__nfet_01v8
M$416 408 374 97 97 sky130_fd_pr__nfet_01v8 L=0.15U W=1.3U AS=0.26975P
+ AD=0.1755P PS=2.78U PD=1.84U
* device instance $418 r0 *1 54.23,23.92 sky130_fd_pr__nfet_01v8
M$418 408 344 97 97 sky130_fd_pr__nfet_01v8 L=0.15U W=1.3U AS=0.1755P
+ AD=0.26975P PS=1.84U PD=2.78U
* device instance $420 r0 *1 55.63,23.92 sky130_fd_pr__nfet_01v8
M$420 408 162 97 97 sky130_fd_pr__nfet_01v8 L=0.15U W=1.3U AS=0.26975P
+ AD=0.1755P PS=2.78U PD=1.84U
* device instance $422 r0 *1 56.47,23.92 sky130_fd_pr__nfet_01v8
M$422 408 195 97 97 sky130_fd_pr__nfet_01v8 L=0.15U W=1.3U AS=0.1755P
+ AD=0.25675P PS=1.84U PD=2.74U
* device instance $424 r0 *1 60.73,23.92 sky130_fd_pr__nfet_01v8
M$424 97 402 377 377 sky130_fd_pr__nfet_01v8 L=0.15U W=0.65U AS=0.169P
+ AD=0.10725P PS=1.82U PD=0.98U
* device instance $425 r0 *1 61.21,23.92 sky130_fd_pr__nfet_01v8
M$425 421 344 97 97 sky130_fd_pr__nfet_01v8 L=0.15U W=0.65U AS=0.10725P
+ AD=0.06825P PS=0.98U PD=0.86U
* device instance $426 r0 *1 61.57,23.92 sky130_fd_pr__nfet_01v8
M$426 377 92 421 421 sky130_fd_pr__nfet_01v8 L=0.15U W=0.65U AS=0.06825P
+ AD=0.169P PS=0.86U PD=1.82U
* device instance $427 r0 *1 62.51,23.92 sky130_fd_pr__nfet_01v8
M$427 420 135 377 377 sky130_fd_pr__nfet_01v8 L=0.15U W=0.65U AS=0.169P
+ AD=0.10725P PS=1.82U PD=0.98U
* device instance $428 r0 *1 62.99,23.92 sky130_fd_pr__nfet_01v8
M$428 97 347 420 420 sky130_fd_pr__nfet_01v8 L=0.15U W=0.65U AS=0.10725P
+ AD=0.102375P PS=0.98U PD=0.965U
* device instance $429 r0 *1 63.455,23.92 sky130_fd_pr__nfet_01v8
M$429 380 377 97 97 sky130_fd_pr__nfet_01v8 L=0.15U W=0.65U AS=0.102375P
+ AD=0.169P PS=0.965U PD=1.82U
* device instance $430 r0 *1 64.41,24.035 sky130_fd_pr__nfet_01v8
M$430 97 333 381 381 sky130_fd_pr__nfet_01v8 L=0.15U W=0.42U AS=0.1092P
+ AD=0.0567P PS=1.36U PD=0.69U
* device instance $431 r0 *1 64.83,24.035 sky130_fd_pr__nfet_01v8
M$431 382 381 97 97 sky130_fd_pr__nfet_01v8 L=0.15U W=0.42U AS=0.0567P
+ AD=0.1092P PS=0.69U PD=1.36U
* device instance $432 r0 *1 65.77,24.035 sky130_fd_pr__nfet_01v8
M$432 418 403 383 383 sky130_fd_pr__nfet_01v8 L=0.15U W=0.42U AS=0.1092P
+ AD=0.0441P PS=1.36U PD=0.63U
* device instance $433 r0 *1 66.13,24.035 sky130_fd_pr__nfet_01v8
M$433 97 409 418 418 sky130_fd_pr__nfet_01v8 L=0.15U W=0.42U AS=0.0441P
+ AD=0.1092P PS=0.63U PD=1.36U
* device instance $434 r0 *1 67.07,24.035 sky130_fd_pr__nfet_01v8
M$434 97 409 384 384 sky130_fd_pr__nfet_01v8 L=0.15U W=0.42U AS=0.1092P
+ AD=0.0609P PS=1.36U PD=0.71U
* device instance $435 r0 *1 67.51,24.035 sky130_fd_pr__nfet_01v8
M$435 417 384 97 97 sky130_fd_pr__nfet_01v8 L=0.15U W=0.42U AS=0.0609P
+ AD=0.0756P PS=0.71U PD=0.78U
* device instance $436 r0 *1 68.02,24.035 sky130_fd_pr__nfet_01v8
M$436 383 388 417 417 sky130_fd_pr__nfet_01v8 L=0.15U W=0.42U AS=0.0756P
+ AD=0.1446P PS=0.78U PD=1.18U
* device instance $437 r0 *1 68.93,24.065 sky130_fd_pr__nfet_01v8
M$437 385 381 383 383 sky130_fd_pr__nfet_01v8 L=0.15U W=0.36U AS=0.1446P
+ AD=0.0522P PS=1.18U PD=0.65U
* device instance $438 r0 *1 69.37,24.065 sky130_fd_pr__nfet_01v8
M$438 385 382 414 414 sky130_fd_pr__nfet_01v8 L=0.15U W=0.36U AS=0.0759P
+ AD=0.0522P PS=0.8U PD=0.65U
* device instance $439 r0 *1 69.9,24.035 sky130_fd_pr__nfet_01v8
M$439 414 386 97 97 sky130_fd_pr__nfet_01v8 L=0.15U W=0.42U AS=0.12095P
+ AD=0.0759P PS=1.085U PD=0.8U
* device instance $440 r0 *1 70.495,23.925 sky130_fd_pr__nfet_01v8
M$440 386 385 97 97 sky130_fd_pr__nfet_01v8 L=0.15U W=0.64U AS=0.12095P
+ AD=0.1664P PS=1.085U PD=1.8U
* device instance $441 r0 *1 71.435,24.035 sky130_fd_pr__nfet_01v8
M$441 412 386 97 97 sky130_fd_pr__nfet_01v8 L=0.15U W=0.42U AS=0.1092P
+ AD=0.0678P PS=1.36U PD=0.755U
* device instance $442 r0 *1 71.92,24.065 sky130_fd_pr__nfet_01v8
M$442 387 382 412 412 sky130_fd_pr__nfet_01v8 L=0.15U W=0.36U AS=0.0678P
+ AD=0.0684P PS=0.755U PD=0.74U
* device instance $443 r0 *1 72.45,24.065 sky130_fd_pr__nfet_01v8
M$443 387 381 411 411 sky130_fd_pr__nfet_01v8 L=0.15U W=0.36U AS=0.066P
+ AD=0.0684P PS=0.745U PD=0.74U
* device instance $444 r0 *1 72.925,24.035 sky130_fd_pr__nfet_01v8
M$444 97 388 411 411 sky130_fd_pr__nfet_01v8 L=0.15U W=0.42U AS=0.066P
+ AD=0.1092P PS=0.745U PD=1.36U
* device instance $445 r0 *1 73.865,24.035 sky130_fd_pr__nfet_01v8
M$445 388 387 97 97 sky130_fd_pr__nfet_01v8 L=0.15U W=0.42U AS=0.10025P
+ AD=0.1092P PS=0.985U PD=1.36U
* device instance $446 r0 *1 74.35,23.92 sky130_fd_pr__nfet_01v8
M$446 344 387 97 97 sky130_fd_pr__nfet_01v8 L=0.15U W=0.65U AS=0.10025P
+ AD=0.182P PS=0.985U PD=1.86U
* device instance $447 r0 *1 4.61,24.925 sky130_fd_pr__nfet_01v8
M$447 97 32 427 427 sky130_fd_pr__nfet_01v8 L=0.15U W=0.42U AS=0.1092P
+ AD=0.0567P PS=1.36U PD=0.69U
* device instance $448 r0 *1 5.03,24.925 sky130_fd_pr__nfet_01v8
M$448 428 427 97 97 sky130_fd_pr__nfet_01v8 L=0.15U W=0.42U AS=0.0567P
+ AD=0.1092P PS=0.69U PD=1.36U
* device instance $449 r0 *1 5.97,24.925 sky130_fd_pr__nfet_01v8
M$449 450 458 429 429 sky130_fd_pr__nfet_01v8 L=0.15U W=0.42U AS=0.1092P
+ AD=0.0441P PS=1.36U PD=0.63U
* device instance $450 r0 *1 6.33,24.925 sky130_fd_pr__nfet_01v8
M$450 97 94 450 450 sky130_fd_pr__nfet_01v8 L=0.15U W=0.42U AS=0.0441P
+ AD=0.1092P PS=0.63U PD=1.36U
* device instance $451 r0 *1 9.13,24.895 sky130_fd_pr__nfet_01v8
M$451 431 427 429 429 sky130_fd_pr__nfet_01v8 L=0.15U W=0.36U AS=0.1446P
+ AD=0.0522P PS=1.18U PD=0.65U
* device instance $452 r0 *1 9.57,24.895 sky130_fd_pr__nfet_01v8
M$452 452 428 431 431 sky130_fd_pr__nfet_01v8 L=0.15U W=0.36U AS=0.0522P
+ AD=0.0759P PS=0.65U PD=0.8U
* device instance $453 r0 *1 7.27,24.925 sky130_fd_pr__nfet_01v8
M$453 97 94 459 459 sky130_fd_pr__nfet_01v8 L=0.15U W=0.42U AS=0.1092P
+ AD=0.0609P PS=1.36U PD=0.71U
* device instance $454 r0 *1 7.71,24.925 sky130_fd_pr__nfet_01v8
M$454 451 459 97 97 sky130_fd_pr__nfet_01v8 L=0.15U W=0.42U AS=0.0609P
+ AD=0.0756P PS=0.71U PD=0.78U
* device instance $455 r0 *1 8.22,24.925 sky130_fd_pr__nfet_01v8
M$455 429 430 451 451 sky130_fd_pr__nfet_01v8 L=0.15U W=0.42U AS=0.0756P
+ AD=0.1446P PS=0.78U PD=1.18U
* device instance $456 r0 *1 10.1,24.925 sky130_fd_pr__nfet_01v8
M$456 97 432 452 452 sky130_fd_pr__nfet_01v8 L=0.15U W=0.42U AS=0.0759P
+ AD=0.12095P PS=0.8U PD=1.085U
* device instance $457 r0 *1 10.695,25.035 sky130_fd_pr__nfet_01v8
M$457 432 431 97 97 sky130_fd_pr__nfet_01v8 L=0.15U W=0.64U AS=0.12095P
+ AD=0.1664P PS=1.085U PD=1.8U
* device instance $458 r0 *1 12.12,24.895 sky130_fd_pr__nfet_01v8
M$458 433 428 453 453 sky130_fd_pr__nfet_01v8 L=0.15U W=0.36U AS=0.0678P
+ AD=0.0684P PS=0.755U PD=0.74U
* device instance $459 r0 *1 12.65,24.895 sky130_fd_pr__nfet_01v8
M$459 454 427 433 433 sky130_fd_pr__nfet_01v8 L=0.15U W=0.36U AS=0.0684P
+ AD=0.066P PS=0.74U PD=0.745U
* device instance $460 r0 *1 11.635,24.925 sky130_fd_pr__nfet_01v8
M$460 453 432 97 97 sky130_fd_pr__nfet_01v8 L=0.15U W=0.42U AS=0.1092P
+ AD=0.0678P PS=1.36U PD=0.755U
* device instance $461 r0 *1 13.125,24.925 sky130_fd_pr__nfet_01v8
M$461 97 430 454 454 sky130_fd_pr__nfet_01v8 L=0.15U W=0.42U AS=0.066P
+ AD=0.1092P PS=0.745U PD=1.36U
* device instance $462 r0 *1 14.065,24.925 sky130_fd_pr__nfet_01v8
M$462 97 433 430 430 sky130_fd_pr__nfet_01v8 L=0.15U W=0.42U AS=0.1092P
+ AD=0.10025P PS=1.36U PD=0.985U
* device instance $463 r0 *1 14.55,25.04 sky130_fd_pr__nfet_01v8
M$463 399 433 97 97 sky130_fd_pr__nfet_01v8 L=0.15U W=0.65U AS=0.10025P
+ AD=0.182P PS=0.985U PD=1.86U
* device instance $464 r0 *1 18.185,24.925 sky130_fd_pr__nfet_01v8
M$464 97 399 434 434 sky130_fd_pr__nfet_01v8 L=0.15U W=0.42U AS=0.1092P
+ AD=0.10025P PS=1.36U PD=0.985U
* device instance $465 r0 *1 18.67,25.04 sky130_fd_pr__nfet_01v8
M$465 435 460 97 97 sky130_fd_pr__nfet_01v8 L=0.15U W=0.65U AS=0.10025P
+ AD=0.08775P PS=0.985U PD=0.92U
* device instance $466 r0 *1 19.09,25.04 sky130_fd_pr__nfet_01v8
M$466 97 434 435 435 sky130_fd_pr__nfet_01v8 L=0.15U W=0.65U AS=0.08775P
+ AD=0.169P PS=0.92U PD=1.82U
* device instance $467 r0 *1 20.25,25.04 sky130_fd_pr__nfet_01v8
M$467 400 435 97 97 sky130_fd_pr__nfet_01v8 L=0.15U W=0.65U AS=0.169P
+ AD=0.08775P PS=1.82U PD=0.92U
* device instance $468 r0 *1 20.67,25.04 sky130_fd_pr__nfet_01v8
M$468 97 329 400 400 sky130_fd_pr__nfet_01v8 L=0.15U W=0.65U AS=0.08775P
+ AD=0.169P PS=0.92U PD=1.82U
* device instance $469 r0 *1 21.865,24.925 sky130_fd_pr__nfet_01v8
M$469 97 460 436 436 sky130_fd_pr__nfet_01v8 L=0.15U W=0.42U AS=0.1092P
+ AD=0.10025P PS=1.36U PD=0.985U
* device instance $470 r0 *1 22.35,25.04 sky130_fd_pr__nfet_01v8
M$470 329 399 97 97 sky130_fd_pr__nfet_01v8 L=0.15U W=0.65U AS=0.10025P
+ AD=0.08775P PS=0.985U PD=0.92U
* device instance $471 r0 *1 22.77,25.04 sky130_fd_pr__nfet_01v8
M$471 97 436 329 329 sky130_fd_pr__nfet_01v8 L=0.15U W=0.65U AS=0.08775P
+ AD=0.169P PS=0.92U PD=1.82U
* device instance $472 r0 *1 34.985,25.04 sky130_fd_pr__nfet_01v8
M$472 438 439 437 437 sky130_fd_pr__nfet_01v8 L=0.15U W=1.3U AS=0.2665P
+ AD=0.1755P PS=2.77U PD=1.84U
* device instance $474 r0 *1 35.825,25.04 sky130_fd_pr__nfet_01v8
M$474 97 440 437 437 sky130_fd_pr__nfet_01v8 L=0.15U W=1.3U AS=0.1755P
+ AD=0.26975P PS=1.84U PD=2.78U
* device instance $476 r0 *1 37.225,25.04 sky130_fd_pr__nfet_01v8
M$476 441 440 97 97 sky130_fd_pr__nfet_01v8 L=0.15U W=1.3U AS=0.26975P
+ AD=0.1755P PS=2.78U PD=1.84U
* device instance $478 r0 *1 38.065,25.04 sky130_fd_pr__nfet_01v8
M$478 441 439 97 97 sky130_fd_pr__nfet_01v8 L=0.15U W=1.3U AS=0.186875P
+ AD=0.268125P PS=1.875U PD=2.775U
* device instance $480 r0 *1 39.46,25.04 sky130_fd_pr__nfet_01v8
M$480 441 438 3 3 sky130_fd_pr__nfet_01v8 L=0.15U W=1.3U AS=0.25675P
+ AD=0.25675P PS=2.74U PD=2.74U
* device instance $482 r0 *1 46.47,25.04 sky130_fd_pr__nfet_01v8
M$482 97 333 442 442 sky130_fd_pr__nfet_01v8 L=0.15U W=1.95U AS=0.3445P
+ AD=0.26325P PS=3.66U PD=2.76U
* device instance $485 r0 *1 47.73,25.04 sky130_fd_pr__nfet_01v8
M$485 443 442 97 97 sky130_fd_pr__nfet_01v8 L=0.15U W=3.9U AS=0.5265P
+ AD=0.5265P PS=5.52U PD=5.52U
* device instance $491 r0 *1 50.25,25.04 sky130_fd_pr__nfet_01v8
M$491 444 443 97 97 sky130_fd_pr__nfet_01v8 L=0.15U W=10.4U AS=1.404P
+ AD=1.48525P PS=14.72U PD=15.62U
* device instance $507 r0 *1 61.26,24.925 sky130_fd_pr__nfet_01v8
M$507 457 461 445 445 sky130_fd_pr__nfet_01v8 L=0.15U W=0.42U AS=0.1113P
+ AD=0.0441P PS=1.37U PD=0.63U
* device instance $508 r0 *1 61.62,24.925 sky130_fd_pr__nfet_01v8
M$508 97 115 457 457 sky130_fd_pr__nfet_01v8 L=0.15U W=0.42U AS=0.0441P
+ AD=0.0966P PS=0.63U PD=0.88U
* device instance $509 r0 *1 62.23,24.925 sky130_fd_pr__nfet_01v8
M$509 402 445 97 97 sky130_fd_pr__nfet_01v8 L=0.15U W=0.42U AS=0.0966P
+ AD=0.1113P PS=0.88U PD=1.37U
* device instance $510 r0 *1 64.365,24.925 sky130_fd_pr__nfet_01v8
M$510 97 338 310 310 sky130_fd_pr__nfet_01v8 L=0.15U W=0.42U AS=0.1092P
+ AD=0.1197P PS=1.36U PD=1.41U
* device instance $511 r0 *1 65.33,25.155 sky130_fd_pr__nfet_01v8
M$511 446 343 97 97 sky130_fd_pr__nfet_01v8 L=0.15U W=0.42U AS=0.10025P
+ AD=0.1092P PS=0.985U PD=1.36U
* device instance $512 r0 *1 65.815,25.04 sky130_fd_pr__nfet_01v8
M$512 462 344 97 97 sky130_fd_pr__nfet_01v8 L=0.15U W=0.65U AS=0.10025P
+ AD=0.08775P PS=0.985U PD=0.92U
* device instance $513 r0 *1 66.235,25.04 sky130_fd_pr__nfet_01v8
M$513 342 446 462 462 sky130_fd_pr__nfet_01v8 L=0.15U W=0.65U AS=0.08775P
+ AD=0.169P PS=0.92U PD=1.82U
* device instance $514 r0 *1 68.175,24.925 sky130_fd_pr__nfet_01v8
M$514 456 64 97 97 sky130_fd_pr__nfet_01v8 L=0.15U W=0.42U AS=0.11285P
+ AD=0.0693P PS=1.045U PD=0.75U
* device instance $515 r0 *1 68.655,24.925 sky130_fd_pr__nfet_01v8
M$515 447 448 456 456 sky130_fd_pr__nfet_01v8 L=0.15U W=0.42U AS=0.0693P
+ AD=0.09975P PS=0.75U PD=0.895U
* device instance $516 r0 *1 69.28,24.925 sky130_fd_pr__nfet_01v8
M$516 455 343 447 447 sky130_fd_pr__nfet_01v8 L=0.15U W=0.42U AS=0.09975P
+ AD=0.0693P PS=0.895U PD=0.75U
* device instance $517 r0 *1 69.76,24.925 sky130_fd_pr__nfet_01v8
M$517 97 449 455 455 sky130_fd_pr__nfet_01v8 L=0.15U W=0.42U AS=0.0693P
+ AD=0.1449P PS=0.75U PD=1.11U
* device instance $518 r0 *1 70.6,24.925 sky130_fd_pr__nfet_01v8
M$518 449 64 97 97 sky130_fd_pr__nfet_01v8 L=0.15U W=0.42U AS=0.1449P
+ AD=0.1092P PS=1.11U PD=1.36U
* device instance $519 r0 *1 67.63,25.04 sky130_fd_pr__nfet_01v8
M$519 97 447 403 403 sky130_fd_pr__nfet_01v8 L=0.15U W=0.65U AS=0.169P
+ AD=0.11285P PS=1.82U PD=1.045U
* device instance $520 r0 *1 5.07,29.36 sky130_fd_pr__nfet_01v8
M$520 97 475 458 458 sky130_fd_pr__nfet_01v8 L=0.15U W=0.65U AS=0.169P
+ AD=0.11285P PS=1.82U PD=1.045U
* device instance $521 r0 *1 5.615,29.475 sky130_fd_pr__nfet_01v8
M$521 519 64 97 97 sky130_fd_pr__nfet_01v8 L=0.15U W=0.42U AS=0.11285P
+ AD=0.0693P PS=1.045U PD=0.75U
* device instance $522 r0 *1 6.095,29.475 sky130_fd_pr__nfet_01v8
M$522 475 463 519 519 sky130_fd_pr__nfet_01v8 L=0.15U W=0.42U AS=0.0693P
+ AD=0.09975P PS=0.75U PD=0.895U
* device instance $523 r0 *1 6.72,29.475 sky130_fd_pr__nfet_01v8
M$523 521 460 475 475 sky130_fd_pr__nfet_01v8 L=0.15U W=0.42U AS=0.09975P
+ AD=0.0693P PS=0.895U PD=0.75U
* device instance $524 r0 *1 7.2,29.475 sky130_fd_pr__nfet_01v8
M$524 97 514 521 521 sky130_fd_pr__nfet_01v8 L=0.15U W=0.42U AS=0.0693P
+ AD=0.1449P PS=0.75U PD=1.11U
* device instance $525 r0 *1 8.04,29.475 sky130_fd_pr__nfet_01v8
M$525 514 64 97 97 sky130_fd_pr__nfet_01v8 L=0.15U W=0.42U AS=0.1449P
+ AD=0.1092P PS=1.11U PD=1.36U
* device instance $526 r0 *1 9.21,29.475 sky130_fd_pr__nfet_01v8
M$526 97 32 476 476 sky130_fd_pr__nfet_01v8 L=0.15U W=0.42U AS=0.1092P
+ AD=0.0567P PS=1.36U PD=0.69U
* device instance $527 r0 *1 9.63,29.475 sky130_fd_pr__nfet_01v8
M$527 477 476 97 97 sky130_fd_pr__nfet_01v8 L=0.15U W=0.42U AS=0.0567P
+ AD=0.1092P PS=0.69U PD=1.36U
* device instance $528 r0 *1 10.57,29.475 sky130_fd_pr__nfet_01v8
M$528 523 410 478 478 sky130_fd_pr__nfet_01v8 L=0.15U W=0.42U AS=0.1092P
+ AD=0.0441P PS=1.36U PD=0.63U
* device instance $529 r0 *1 10.93,29.475 sky130_fd_pr__nfet_01v8
M$529 97 302 523 523 sky130_fd_pr__nfet_01v8 L=0.15U W=0.42U AS=0.0441P
+ AD=0.1092P PS=0.63U PD=1.36U
* device instance $530 r0 *1 11.87,29.475 sky130_fd_pr__nfet_01v8
M$530 97 302 479 479 sky130_fd_pr__nfet_01v8 L=0.15U W=0.42U AS=0.1092P
+ AD=0.0609P PS=1.36U PD=0.71U
* device instance $531 r0 *1 12.31,29.475 sky130_fd_pr__nfet_01v8
M$531 526 479 97 97 sky130_fd_pr__nfet_01v8 L=0.15U W=0.42U AS=0.0609P
+ AD=0.0756P PS=0.71U PD=0.78U
* device instance $532 r0 *1 12.82,29.475 sky130_fd_pr__nfet_01v8
M$532 478 483 526 526 sky130_fd_pr__nfet_01v8 L=0.15U W=0.42U AS=0.0756P
+ AD=0.1446P PS=0.78U PD=1.18U
* device instance $533 r0 *1 13.73,29.505 sky130_fd_pr__nfet_01v8
M$533 480 476 478 478 sky130_fd_pr__nfet_01v8 L=0.15U W=0.36U AS=0.1446P
+ AD=0.0522P PS=1.18U PD=0.65U
* device instance $534 r0 *1 14.17,29.505 sky130_fd_pr__nfet_01v8
M$534 480 477 527 527 sky130_fd_pr__nfet_01v8 L=0.15U W=0.36U AS=0.0759P
+ AD=0.0522P PS=0.8U PD=0.65U
* device instance $535 r0 *1 14.7,29.475 sky130_fd_pr__nfet_01v8
M$535 527 481 97 97 sky130_fd_pr__nfet_01v8 L=0.15U W=0.42U AS=0.12095P
+ AD=0.0759P PS=1.085U PD=0.8U
* device instance $536 r0 *1 15.295,29.365 sky130_fd_pr__nfet_01v8
M$536 481 480 97 97 sky130_fd_pr__nfet_01v8 L=0.15U W=0.64U AS=0.12095P
+ AD=0.1664P PS=1.085U PD=1.8U
* device instance $537 r0 *1 16.235,29.475 sky130_fd_pr__nfet_01v8
M$537 528 481 97 97 sky130_fd_pr__nfet_01v8 L=0.15U W=0.42U AS=0.1092P
+ AD=0.0678P PS=1.36U PD=0.755U
* device instance $538 r0 *1 16.72,29.505 sky130_fd_pr__nfet_01v8
M$538 482 477 528 528 sky130_fd_pr__nfet_01v8 L=0.15U W=0.36U AS=0.0678P
+ AD=0.0684P PS=0.755U PD=0.74U
* device instance $539 r0 *1 17.25,29.505 sky130_fd_pr__nfet_01v8
M$539 482 476 530 530 sky130_fd_pr__nfet_01v8 L=0.15U W=0.36U AS=0.066P
+ AD=0.0684P PS=0.745U PD=0.74U
* device instance $540 r0 *1 17.725,29.475 sky130_fd_pr__nfet_01v8
M$540 97 483 530 530 sky130_fd_pr__nfet_01v8 L=0.15U W=0.42U AS=0.066P
+ AD=0.1092P PS=0.745U PD=1.36U
* device instance $541 r0 *1 18.665,29.475 sky130_fd_pr__nfet_01v8
M$541 483 482 97 97 sky130_fd_pr__nfet_01v8 L=0.15U W=0.42U AS=0.10025P
+ AD=0.1092P PS=0.985U PD=1.36U
* device instance $542 r0 *1 19.15,29.36 sky130_fd_pr__nfet_01v8
M$542 460 482 97 97 sky130_fd_pr__nfet_01v8 L=0.15U W=0.65U AS=0.10025P
+ AD=0.182P PS=0.985U PD=1.86U
* device instance $543 r0 *1 26.26,30.365 sky130_fd_pr__nfet_01v8
M$543 97 435 533 533 sky130_fd_pr__nfet_01v8 L=0.15U W=0.42U AS=0.1113P
+ AD=0.0588P PS=1.37U PD=0.7U
* device instance $544 r0 *1 26.69,30.365 sky130_fd_pr__nfet_01v8
M$544 533 328 97 97 sky130_fd_pr__nfet_01v8 L=0.15U W=0.42U AS=0.0588P
+ AD=0.0588P PS=0.7U PD=0.7U
* device instance $545 r0 *1 27.12,30.365 sky130_fd_pr__nfet_01v8
M$545 544 534 533 533 sky130_fd_pr__nfet_01v8 L=0.15U W=0.42U AS=0.0588P
+ AD=0.1113P PS=0.7U PD=1.37U
* device instance $546 r0 *1 30.91,29.36 sky130_fd_pr__nfet_01v8
M$546 515 328 97 97 sky130_fd_pr__nfet_01v8 L=0.15U W=2.6U AS=0.44525P
+ AD=0.351P PS=4.62U PD=3.68U
* device instance $550 r0 *1 32.59,29.36 sky130_fd_pr__nfet_01v8
M$550 515 435 97 97 sky130_fd_pr__nfet_01v8 L=0.15U W=2.6U AS=0.351P AD=0.3575P
+ PS=3.68U PD=3.7U
* device instance $554 r0 *1 34.29,29.36 sky130_fd_pr__nfet_01v8
M$554 515 534 97 97 sky130_fd_pr__nfet_01v8 L=0.15U W=2.6U AS=0.3575P
+ AD=0.44525P PS=3.7U PD=4.62U
* device instance $558 r0 *1 31.77,30.48 sky130_fd_pr__nfet_01v8
M$558 540 545 97 97 sky130_fd_pr__nfet_01v8 L=0.15U W=0.65U AS=0.169P
+ AD=0.08775P PS=1.82U PD=0.92U
* device instance $559 r0 *1 32.19,30.48 sky130_fd_pr__nfet_01v8
M$559 440 512 540 540 sky130_fd_pr__nfet_01v8 L=0.15U W=0.65U AS=0.08775P
+ AD=0.169P PS=0.92U PD=1.82U
* device instance $560 r0 *1 35.91,30.48 sky130_fd_pr__nfet_01v8
M$560 541 264 97 97 sky130_fd_pr__nfet_01v8 L=0.15U W=0.65U AS=0.169P
+ AD=0.08775P PS=1.82U PD=0.92U
* device instance $561 r0 *1 36.33,30.48 sky130_fd_pr__nfet_01v8
M$561 439 486 541 541 sky130_fd_pr__nfet_01v8 L=0.15U W=0.65U AS=0.08775P
+ AD=0.169P PS=0.92U PD=1.82U
* device instance $562 r0 *1 36.53,29.36 sky130_fd_pr__nfet_01v8
M$562 515 512 517 517 sky130_fd_pr__nfet_01v8 L=0.15U W=2.6U AS=0.44525P
+ AD=0.351P PS=4.62U PD=3.68U
* device instance $566 r0 *1 38.21,29.36 sky130_fd_pr__nfet_01v8
M$566 268 486 517 517 sky130_fd_pr__nfet_01v8 L=0.15U W=2.6U AS=0.351P
+ AD=0.44525P PS=3.68U PD=4.62U
* device instance $570 r0 *1 38.19,30.48 sky130_fd_pr__nfet_01v8
M$570 97 167 536 536 sky130_fd_pr__nfet_01v8 L=0.15U W=0.65U AS=0.169P
+ AD=0.10725P PS=1.82U PD=0.98U
* device instance $571 r0 *1 38.67,30.48 sky130_fd_pr__nfet_01v8
M$571 542 372 97 97 sky130_fd_pr__nfet_01v8 L=0.15U W=0.65U AS=0.10725P
+ AD=0.06825P PS=0.98U PD=0.86U
* device instance $572 r0 *1 39.03,30.48 sky130_fd_pr__nfet_01v8
M$572 536 92 542 542 sky130_fd_pr__nfet_01v8 L=0.15U W=0.65U AS=0.06825P
+ AD=0.169P PS=0.86U PD=1.82U
* device instance $573 r0 *1 39.97,30.48 sky130_fd_pr__nfet_01v8
M$573 543 135 536 536 sky130_fd_pr__nfet_01v8 L=0.15U W=0.65U AS=0.169P
+ AD=0.10725P PS=1.82U PD=0.98U
* device instance $574 r0 *1 40.45,30.48 sky130_fd_pr__nfet_01v8
M$574 97 3 543 543 sky130_fd_pr__nfet_01v8 L=0.15U W=0.65U AS=0.10725P
+ AD=0.102375P PS=0.98U PD=0.965U
* device instance $575 r0 *1 40.915,30.48 sky130_fd_pr__nfet_01v8
M$575 548 536 97 97 sky130_fd_pr__nfet_01v8 L=0.15U W=0.65U AS=0.102375P
+ AD=0.169P PS=0.965U PD=1.82U
* device instance $576 r0 *1 41.87,29.245 sky130_fd_pr__nfet_01v8
M$576 97 513 487 487 sky130_fd_pr__nfet_01v8 L=0.15U W=0.42U AS=0.1092P
+ AD=0.10025P PS=1.36U PD=0.985U
* device instance $577 r0 *1 42.355,29.36 sky130_fd_pr__nfet_01v8
M$577 532 372 97 97 sky130_fd_pr__nfet_01v8 L=0.15U W=0.65U AS=0.10025P
+ AD=0.08775P PS=0.985U PD=0.92U
* device instance $578 r0 *1 42.775,29.36 sky130_fd_pr__nfet_01v8
M$578 264 487 532 532 sky130_fd_pr__nfet_01v8 L=0.15U W=0.65U AS=0.08775P
+ AD=0.169P PS=0.92U PD=1.82U
* device instance $579 r0 *1 42.285,30.365 sky130_fd_pr__nfet_01v8
M$579 97 537 486 486 sky130_fd_pr__nfet_01v8 L=0.15U W=0.42U AS=0.1092P
+ AD=0.1197P PS=1.36U PD=1.41U
* device instance $580 r0 *1 44.17,29.36 sky130_fd_pr__nfet_01v8
M$580 97 488 401 401 sky130_fd_pr__nfet_01v8 L=0.15U W=0.65U AS=0.169P
+ AD=0.11285P PS=1.82U PD=1.045U
* device instance $581 r0 *1 44.715,29.475 sky130_fd_pr__nfet_01v8
M$581 531 64 97 97 sky130_fd_pr__nfet_01v8 L=0.15U W=0.42U AS=0.11285P
+ AD=0.0693P PS=1.045U PD=0.75U
* device instance $582 r0 *1 45.195,29.475 sky130_fd_pr__nfet_01v8
M$582 488 489 531 531 sky130_fd_pr__nfet_01v8 L=0.15U W=0.42U AS=0.0693P
+ AD=0.09975P PS=0.75U PD=0.895U
* device instance $583 r0 *1 45.82,29.475 sky130_fd_pr__nfet_01v8
M$583 529 513 488 488 sky130_fd_pr__nfet_01v8 L=0.15U W=0.42U AS=0.09975P
+ AD=0.0693P PS=0.895U PD=0.75U
* device instance $584 r0 *1 46.3,29.475 sky130_fd_pr__nfet_01v8
M$584 97 516 529 529 sky130_fd_pr__nfet_01v8 L=0.15U W=0.42U AS=0.0693P
+ AD=0.1449P PS=0.75U PD=1.11U
* device instance $585 r0 *1 47.14,29.475 sky130_fd_pr__nfet_01v8
M$585 516 64 97 97 sky130_fd_pr__nfet_01v8 L=0.15U W=0.42U AS=0.1449P
+ AD=0.1092P PS=1.11U PD=1.36U
* device instance $586 r0 *1 44.865,30.365 sky130_fd_pr__nfet_01v8
M$586 97 513 538 538 sky130_fd_pr__nfet_01v8 L=0.15U W=0.42U AS=0.1092P
+ AD=0.10025P PS=1.36U PD=0.985U
* device instance $587 r0 *1 45.35,30.48 sky130_fd_pr__nfet_01v8
M$587 537 372 97 97 sky130_fd_pr__nfet_01v8 L=0.15U W=0.65U AS=0.10025P
+ AD=0.08775P PS=0.985U PD=0.92U
* device instance $588 r0 *1 45.77,30.48 sky130_fd_pr__nfet_01v8
M$588 97 538 537 537 sky130_fd_pr__nfet_01v8 L=0.15U W=0.65U AS=0.08775P
+ AD=0.169P PS=0.92U PD=1.82U
* device instance $589 r0 *1 47.19,30.48 sky130_fd_pr__nfet_01v8
M$589 539 999 97 97 sky130_fd_pr__nfet_01v8 L=0.15U W=1.3U AS=0.25675P
+ AD=0.1755P PS=2.74U PD=1.84U
* device instance $591 r0 *1 48.03,30.48 sky130_fd_pr__nfet_01v8
M$591 135 539 97 97 sky130_fd_pr__nfet_01v8 L=0.15U W=3.9U AS=0.5265P
+ AD=0.60775P PS=5.52U PD=6.42U
* device instance $597 r0 *1 60.73,29.475 sky130_fd_pr__nfet_01v8
M$597 97 333 490 490 sky130_fd_pr__nfet_01v8 L=0.15U W=0.42U AS=0.1092P
+ AD=0.0567P PS=1.36U PD=0.69U
* device instance $598 r0 *1 61.15,29.475 sky130_fd_pr__nfet_01v8
M$598 491 490 97 97 sky130_fd_pr__nfet_01v8 L=0.15U W=0.42U AS=0.0567P
+ AD=0.1092P PS=0.69U PD=1.36U
* device instance $599 r0 *1 62.09,29.475 sky130_fd_pr__nfet_01v8
M$599 525 380 492 492 sky130_fd_pr__nfet_01v8 L=0.15U W=0.42U AS=0.1092P
+ AD=0.0441P PS=1.36U PD=0.63U
* device instance $600 r0 *1 62.45,29.475 sky130_fd_pr__nfet_01v8
M$600 97 302 525 525 sky130_fd_pr__nfet_01v8 L=0.15U W=0.42U AS=0.0441P
+ AD=0.1092P PS=0.63U PD=1.36U
* device instance $601 r0 *1 63.39,29.475 sky130_fd_pr__nfet_01v8
M$601 97 302 493 493 sky130_fd_pr__nfet_01v8 L=0.15U W=0.42U AS=0.1092P
+ AD=0.0609P PS=1.36U PD=0.71U
* device instance $602 r0 *1 63.83,29.475 sky130_fd_pr__nfet_01v8
M$602 524 493 97 97 sky130_fd_pr__nfet_01v8 L=0.15U W=0.42U AS=0.0609P
+ AD=0.0756P PS=0.71U PD=0.78U
* device instance $603 r0 *1 64.34,29.475 sky130_fd_pr__nfet_01v8
M$603 492 497 524 524 sky130_fd_pr__nfet_01v8 L=0.15U W=0.42U AS=0.0756P
+ AD=0.1446P PS=0.78U PD=1.18U
* device instance $604 r0 *1 65.25,29.505 sky130_fd_pr__nfet_01v8
M$604 494 490 492 492 sky130_fd_pr__nfet_01v8 L=0.15U W=0.36U AS=0.1446P
+ AD=0.0522P PS=1.18U PD=0.65U
* device instance $605 r0 *1 65.69,29.505 sky130_fd_pr__nfet_01v8
M$605 494 491 522 522 sky130_fd_pr__nfet_01v8 L=0.15U W=0.36U AS=0.0759P
+ AD=0.0522P PS=0.8U PD=0.65U
* device instance $606 r0 *1 66.22,29.475 sky130_fd_pr__nfet_01v8
M$606 522 495 97 97 sky130_fd_pr__nfet_01v8 L=0.15U W=0.42U AS=0.12095P
+ AD=0.0759P PS=1.085U PD=0.8U
* device instance $607 r0 *1 66.815,29.365 sky130_fd_pr__nfet_01v8
M$607 495 494 97 97 sky130_fd_pr__nfet_01v8 L=0.15U W=0.64U AS=0.12095P
+ AD=0.1664P PS=1.085U PD=1.8U
* device instance $608 r0 *1 67.755,29.475 sky130_fd_pr__nfet_01v8
M$608 520 495 97 97 sky130_fd_pr__nfet_01v8 L=0.15U W=0.42U AS=0.1092P
+ AD=0.0678P PS=1.36U PD=0.755U
* device instance $609 r0 *1 68.24,29.505 sky130_fd_pr__nfet_01v8
M$609 496 491 520 520 sky130_fd_pr__nfet_01v8 L=0.15U W=0.36U AS=0.0678P
+ AD=0.0684P PS=0.755U PD=0.74U
* device instance $610 r0 *1 68.77,29.505 sky130_fd_pr__nfet_01v8
M$610 496 490 518 518 sky130_fd_pr__nfet_01v8 L=0.15U W=0.36U AS=0.066P
+ AD=0.0684P PS=0.745U PD=0.74U
* device instance $611 r0 *1 69.245,29.475 sky130_fd_pr__nfet_01v8
M$611 97 497 518 518 sky130_fd_pr__nfet_01v8 L=0.15U W=0.42U AS=0.066P
+ AD=0.1092P PS=0.745U PD=1.36U
* device instance $612 r0 *1 70.185,29.475 sky130_fd_pr__nfet_01v8
M$612 497 496 97 97 sky130_fd_pr__nfet_01v8 L=0.15U W=0.42U AS=0.10025P
+ AD=0.1092P PS=0.985U PD=1.36U
* device instance $613 r0 *1 70.67,29.36 sky130_fd_pr__nfet_01v8
M$613 343 496 97 97 sky130_fd_pr__nfet_01v8 L=0.15U W=0.65U AS=0.10025P
+ AD=0.182P PS=0.985U PD=1.86U
* device instance $614 r0 *1 13.765,34.915 sky130_fd_pr__nfet_01v8
M$614 97 553 578 578 sky130_fd_pr__nfet_01v8 L=0.15U W=0.42U AS=0.1092P
+ AD=0.1197P PS=1.36U PD=1.41U
* device instance $615 r0 *1 27.155,34.8 sky130_fd_pr__nfet_01v8
M$615 586 545 554 554 sky130_fd_pr__nfet_01v8 L=0.15U W=0.65U AS=0.17225P
+ AD=0.06825P PS=1.83U PD=0.86U
* device instance $616 r0 *1 27.515,34.8 sky130_fd_pr__nfet_01v8
M$616 97 544 586 586 sky130_fd_pr__nfet_01v8 L=0.15U W=0.65U AS=0.06825P
+ AD=0.138125P PS=0.86U PD=1.075U
* device instance $617 r0 *1 28.09,34.8 sky130_fd_pr__nfet_01v8
M$617 555 554 97 97 sky130_fd_pr__nfet_01v8 L=0.15U W=2.6U AS=0.411125P
+ AD=0.45825P PS=3.865U PD=4.66U
* device instance $621 r0 *1 28.08,30.395 sky130_fd_pr__nfet_01v8
M$621 97 328 535 535 sky130_fd_pr__nfet_01v8 L=0.15U W=0.42U AS=0.1092P
+ AD=0.0567P PS=1.36U PD=0.69U
* device instance $622 r0 *1 28.5,30.395 sky130_fd_pr__nfet_01v8
M$622 535 435 97 97 sky130_fd_pr__nfet_01v8 L=0.15U W=0.42U AS=0.0567P
+ AD=0.0567P PS=0.69U PD=0.69U
* device instance $623 r0 *1 28.92,30.395 sky130_fd_pr__nfet_01v8
M$623 535 534 97 97 sky130_fd_pr__nfet_01v8 L=0.15U W=0.42U AS=0.101875P
+ AD=0.0567P PS=0.99U PD=0.69U
* device instance $624 r0 *1 29.41,30.48 sky130_fd_pr__nfet_01v8
M$624 545 535 97 97 sky130_fd_pr__nfet_01v8 L=0.15U W=0.65U AS=0.101875P
+ AD=0.182P PS=0.99U PD=1.86U
* device instance $625 r0 *1 40.49,34.915 sky130_fd_pr__nfet_01v8
M$625 97 333 556 556 sky130_fd_pr__nfet_01v8 L=0.15U W=0.42U AS=0.1092P
+ AD=0.0567P PS=1.36U PD=0.69U
* device instance $626 r0 *1 40.91,34.915 sky130_fd_pr__nfet_01v8
M$626 557 556 97 97 sky130_fd_pr__nfet_01v8 L=0.15U W=0.42U AS=0.0567P
+ AD=0.1092P PS=0.69U PD=1.36U
* device instance $627 r0 *1 41.85,34.915 sky130_fd_pr__nfet_01v8
M$627 585 548 558 558 sky130_fd_pr__nfet_01v8 L=0.15U W=0.42U AS=0.1092P
+ AD=0.0441P PS=1.36U PD=0.63U
* device instance $628 r0 *1 42.21,34.915 sky130_fd_pr__nfet_01v8
M$628 97 302 585 585 sky130_fd_pr__nfet_01v8 L=0.15U W=0.42U AS=0.0441P
+ AD=0.1092P PS=0.63U PD=1.36U
* device instance $629 r0 *1 43.15,34.915 sky130_fd_pr__nfet_01v8
M$629 97 302 559 559 sky130_fd_pr__nfet_01v8 L=0.15U W=0.42U AS=0.1092P
+ AD=0.0609P PS=1.36U PD=0.71U
* device instance $630 r0 *1 43.59,34.915 sky130_fd_pr__nfet_01v8
M$630 584 559 97 97 sky130_fd_pr__nfet_01v8 L=0.15U W=0.42U AS=0.0609P
+ AD=0.0756P PS=0.71U PD=0.78U
* device instance $631 r0 *1 44.1,34.915 sky130_fd_pr__nfet_01v8
M$631 558 563 584 584 sky130_fd_pr__nfet_01v8 L=0.15U W=0.42U AS=0.0756P
+ AD=0.1446P PS=0.78U PD=1.18U
* device instance $632 r0 *1 45.01,34.945 sky130_fd_pr__nfet_01v8
M$632 560 556 558 558 sky130_fd_pr__nfet_01v8 L=0.15U W=0.36U AS=0.1446P
+ AD=0.0522P PS=1.18U PD=0.65U
* device instance $633 r0 *1 45.45,34.945 sky130_fd_pr__nfet_01v8
M$633 560 557 583 583 sky130_fd_pr__nfet_01v8 L=0.15U W=0.36U AS=0.0759P
+ AD=0.0522P PS=0.8U PD=0.65U
* device instance $634 r0 *1 45.98,34.915 sky130_fd_pr__nfet_01v8
M$634 583 561 97 97 sky130_fd_pr__nfet_01v8 L=0.15U W=0.42U AS=0.12095P
+ AD=0.0759P PS=1.085U PD=0.8U
* device instance $635 r0 *1 46.575,34.805 sky130_fd_pr__nfet_01v8
M$635 561 560 97 97 sky130_fd_pr__nfet_01v8 L=0.15U W=0.64U AS=0.12095P
+ AD=0.1664P PS=1.085U PD=1.8U
* device instance $636 r0 *1 47.515,34.915 sky130_fd_pr__nfet_01v8
M$636 582 561 97 97 sky130_fd_pr__nfet_01v8 L=0.15U W=0.42U AS=0.1092P
+ AD=0.0678P PS=1.36U PD=0.755U
* device instance $637 r0 *1 48,34.945 sky130_fd_pr__nfet_01v8
M$637 562 557 582 582 sky130_fd_pr__nfet_01v8 L=0.15U W=0.36U AS=0.0678P
+ AD=0.0684P PS=0.755U PD=0.74U
* device instance $638 r0 *1 48.53,34.945 sky130_fd_pr__nfet_01v8
M$638 562 556 581 581 sky130_fd_pr__nfet_01v8 L=0.15U W=0.36U AS=0.066P
+ AD=0.0684P PS=0.745U PD=0.74U
* device instance $639 r0 *1 49.005,34.915 sky130_fd_pr__nfet_01v8
M$639 97 563 581 581 sky130_fd_pr__nfet_01v8 L=0.15U W=0.42U AS=0.066P
+ AD=0.1092P PS=0.745U PD=1.36U
* device instance $640 r0 *1 49.945,34.915 sky130_fd_pr__nfet_01v8
M$640 563 562 97 97 sky130_fd_pr__nfet_01v8 L=0.15U W=0.42U AS=0.10025P
+ AD=0.1092P PS=0.985U PD=1.36U
* device instance $641 r0 *1 50.43,34.8 sky130_fd_pr__nfet_01v8
M$641 513 562 97 97 sky130_fd_pr__nfet_01v8 L=0.15U W=0.65U AS=0.10025P
+ AD=0.182P PS=0.985U PD=1.86U
* device instance $642 r0 *1 59.81,34.8 sky130_fd_pr__nfet_01v8
M$642 97 307 564 564 sky130_fd_pr__nfet_01v8 L=0.15U W=0.65U AS=0.169P
+ AD=0.08775P PS=1.82U PD=0.92U
* device instance $643 r0 *1 60.23,34.8 sky130_fd_pr__nfet_01v8
M$643 577 564 97 97 sky130_fd_pr__nfet_01v8 L=0.15U W=2.6U AS=0.351P
+ AD=0.43225P PS=3.68U PD=4.58U
* device instance $647 r0 *1 62.57,34.8 sky130_fd_pr__nfet_01v8
M$647 97 565 566 566 sky130_fd_pr__nfet_01v8 L=0.15U W=0.65U AS=0.169P
+ AD=0.10725P PS=1.82U PD=0.98U
* device instance $648 r0 *1 63.05,34.8 sky130_fd_pr__nfet_01v8
M$648 580 568 97 97 sky130_fd_pr__nfet_01v8 L=0.15U W=0.65U AS=0.10725P
+ AD=0.06825P PS=0.98U PD=0.86U
* device instance $649 r0 *1 63.41,34.8 sky130_fd_pr__nfet_01v8
M$649 566 92 580 580 sky130_fd_pr__nfet_01v8 L=0.15U W=0.65U AS=0.06825P
+ AD=0.169P PS=0.86U PD=1.82U
* device instance $650 r0 *1 64.35,34.8 sky130_fd_pr__nfet_01v8
M$650 579 158 566 566 sky130_fd_pr__nfet_01v8 L=0.15U W=0.65U AS=0.169P
+ AD=0.10725P PS=1.82U PD=0.98U
* device instance $651 r0 *1 64.83,34.8 sky130_fd_pr__nfet_01v8
M$651 97 571 579 579 sky130_fd_pr__nfet_01v8 L=0.15U W=0.65U AS=0.10725P
+ AD=0.102375P PS=0.98U PD=0.965U
* device instance $652 r0 *1 65.295,34.8 sky130_fd_pr__nfet_01v8
M$652 570 566 97 97 sky130_fd_pr__nfet_01v8 L=0.15U W=0.65U AS=0.102375P
+ AD=0.169P PS=0.965U PD=1.82U
* device instance $653 r0 *1 8.75,35.92 sky130_fd_pr__nfet_01v8
M$653 97 587 588 588 sky130_fd_pr__nfet_01v8 L=0.15U W=0.65U AS=0.169P
+ AD=0.10725P PS=1.82U PD=0.98U
* device instance $654 r0 *1 9.23,35.92 sky130_fd_pr__nfet_01v8
M$654 606 589 97 97 sky130_fd_pr__nfet_01v8 L=0.15U W=0.65U AS=0.10725P
+ AD=0.06825P PS=0.98U PD=0.86U
* device instance $655 r0 *1 9.59,35.92 sky130_fd_pr__nfet_01v8
M$655 588 92 606 606 sky130_fd_pr__nfet_01v8 L=0.15U W=0.65U AS=0.06825P
+ AD=0.169P PS=0.86U PD=1.82U
* device instance $656 r0 *1 10.53,35.92 sky130_fd_pr__nfet_01v8
M$656 607 158 588 588 sky130_fd_pr__nfet_01v8 L=0.15U W=0.65U AS=0.169P
+ AD=0.10725P PS=1.82U PD=0.98U
* device instance $657 r0 *1 11.01,35.92 sky130_fd_pr__nfet_01v8
M$657 97 590 607 607 sky130_fd_pr__nfet_01v8 L=0.15U W=0.65U AS=0.10725P
+ AD=0.102375P PS=0.98U PD=0.965U
* device instance $658 r0 *1 11.475,35.92 sky130_fd_pr__nfet_01v8
M$658 591 588 97 97 sky130_fd_pr__nfet_01v8 L=0.15U W=0.65U AS=0.102375P
+ AD=0.169P PS=0.965U PD=1.82U
* device instance $659 r0 *1 12.53,35.805 sky130_fd_pr__nfet_01v8
M$659 608 578 592 592 sky130_fd_pr__nfet_01v8 L=0.15U W=0.42U AS=0.1092P
+ AD=0.0441P PS=1.36U PD=0.63U
* device instance $660 r0 *1 12.89,35.805 sky130_fd_pr__nfet_01v8
M$660 97 593 608 608 sky130_fd_pr__nfet_01v8 L=0.15U W=0.42U AS=0.0441P
+ AD=0.0567P PS=0.63U PD=0.69U
* device instance $661 r0 *1 13.31,35.805 sky130_fd_pr__nfet_01v8
M$661 609 593 97 97 sky130_fd_pr__nfet_01v8 L=0.15U W=0.42U AS=0.0567P
+ AD=0.0441P PS=0.69U PD=0.63U
* device instance $662 r0 *1 13.67,35.805 sky130_fd_pr__nfet_01v8
M$662 592 594 609 609 sky130_fd_pr__nfet_01v8 L=0.15U W=0.42U AS=0.0441P
+ AD=0.0567P PS=0.63U PD=0.69U
* device instance $663 r0 *1 14.09,35.805 sky130_fd_pr__nfet_01v8
M$663 610 594 592 592 sky130_fd_pr__nfet_01v8 L=0.15U W=0.42U AS=0.0567P
+ AD=0.0441P PS=0.69U PD=0.63U
* device instance $664 r0 *1 14.45,35.805 sky130_fd_pr__nfet_01v8
M$664 97 578 610 610 sky130_fd_pr__nfet_01v8 L=0.15U W=0.42U AS=0.0441P
+ AD=0.162225P PS=0.63U PD=1.25U
* device instance $665 r0 *1 15.2,35.92 sky130_fd_pr__nfet_01v8
M$665 341 592 97 97 sky130_fd_pr__nfet_01v8 L=0.15U W=1.3U AS=0.249975P
+ AD=0.26325P PS=2.17U PD=2.76U
* device instance $667 r0 *1 31.705,35.805 sky130_fd_pr__nfet_01v8
M$667 97 595 534 534 sky130_fd_pr__nfet_01v8 L=0.15U W=0.42U AS=0.1092P
+ AD=0.1197P PS=1.36U PD=1.41U
* device instance $668 r0 *1 34.05,36.035 sky130_fd_pr__nfet_01v8
M$668 596 650 97 97 sky130_fd_pr__nfet_01v8 L=0.15U W=0.42U AS=0.10025P
+ AD=0.1092P PS=0.985U PD=1.36U
* device instance $669 r0 *1 34.535,35.92 sky130_fd_pr__nfet_01v8
M$669 611 597 97 97 sky130_fd_pr__nfet_01v8 L=0.15U W=0.65U AS=0.10025P
+ AD=0.08775P PS=0.985U PD=0.92U
* device instance $670 r0 *1 34.955,35.92 sky130_fd_pr__nfet_01v8
M$670 512 596 611 611 sky130_fd_pr__nfet_01v8 L=0.15U W=0.65U AS=0.08775P
+ AD=0.169P PS=0.92U PD=1.82U
* device instance $671 r0 *1 59.42,35.805 sky130_fd_pr__nfet_01v8
M$671 612 599 598 598 sky130_fd_pr__nfet_01v8 L=0.15U W=0.42U AS=0.1113P
+ AD=0.0441P PS=1.37U PD=0.63U
* device instance $672 r0 *1 59.78,35.805 sky130_fd_pr__nfet_01v8
M$672 97 115 612 612 sky130_fd_pr__nfet_01v8 L=0.15U W=0.42U AS=0.0441P
+ AD=0.0966P PS=0.63U PD=0.88U
* device instance $673 r0 *1 60.39,35.805 sky130_fd_pr__nfet_01v8
M$673 565 598 97 97 sky130_fd_pr__nfet_01v8 L=0.15U W=0.42U AS=0.0966P
+ AD=0.1113P PS=0.88U PD=1.37U
* device instance $674 r0 *1 61.67,35.92 sky130_fd_pr__nfet_01v8
M$674 613 577 97 97 sky130_fd_pr__nfet_01v8 L=0.15U W=0.65U AS=0.169P
+ AD=0.08775P PS=1.82U PD=0.92U
* device instance $675 r0 *1 62.09,35.92 sky130_fd_pr__nfet_01v8
M$675 600 342 613 613 sky130_fd_pr__nfet_01v8 L=0.15U W=0.65U AS=0.08775P
+ AD=0.169P PS=0.92U PD=1.82U
* device instance $676 r0 *1 63.13,35.92 sky130_fd_pr__nfet_01v8
M$676 614 600 601 601 sky130_fd_pr__nfet_01v8 L=0.15U W=0.65U AS=0.169P
+ AD=0.06825P PS=1.82U PD=0.86U
* device instance $677 r0 *1 63.49,35.92 sky130_fd_pr__nfet_01v8
M$677 97 602 614 614 sky130_fd_pr__nfet_01v8 L=0.15U W=0.65U AS=0.06825P
+ AD=0.08775P PS=0.86U PD=0.92U
* device instance $678 r0 *1 63.91,35.92 sky130_fd_pr__nfet_01v8
M$678 603 602 97 97 sky130_fd_pr__nfet_01v8 L=0.15U W=0.65U AS=0.08775P
+ AD=0.169P PS=0.92U PD=1.82U
* device instance $679 r0 *1 64.85,35.92 sky130_fd_pr__nfet_01v8
M$679 603 600 97 97 sky130_fd_pr__nfet_01v8 L=0.15U W=0.65U AS=0.169P
+ AD=0.08775P PS=1.82U PD=0.92U
* device instance $680 r0 *1 65.27,35.92 sky130_fd_pr__nfet_01v8
M$680 571 601 603 603 sky130_fd_pr__nfet_01v8 L=0.15U W=0.65U AS=0.08775P
+ AD=0.195P PS=0.92U PD=1.9U
* device instance $681 r0 *1 66.485,35.805 sky130_fd_pr__nfet_01v8
M$681 97 651 604 604 sky130_fd_pr__nfet_01v8 L=0.15U W=0.42U AS=0.1092P
+ AD=0.10025P PS=1.36U PD=0.985U
* device instance $682 r0 *1 66.97,35.92 sky130_fd_pr__nfet_01v8
M$682 605 568 97 97 sky130_fd_pr__nfet_01v8 L=0.15U W=0.65U AS=0.10025P
+ AD=0.08775P PS=0.985U PD=0.92U
* device instance $683 r0 *1 67.39,35.92 sky130_fd_pr__nfet_01v8
M$683 97 604 605 605 sky130_fd_pr__nfet_01v8 L=0.15U W=0.65U AS=0.08775P
+ AD=0.169P PS=0.92U PD=1.82U
* device instance $684 r0 *1 6.91,40.24 sky130_fd_pr__nfet_01v8
M$684 97 625 624 624 sky130_fd_pr__nfet_01v8 L=0.15U W=0.65U AS=0.169P
+ AD=0.11285P PS=1.82U PD=1.045U
* device instance $685 r0 *1 7.455,40.355 sky130_fd_pr__nfet_01v8
M$685 668 64 97 97 sky130_fd_pr__nfet_01v8 L=0.15U W=0.42U AS=0.11285P
+ AD=0.0693P PS=1.045U PD=0.75U
* device instance $686 r0 *1 7.935,40.355 sky130_fd_pr__nfet_01v8
M$686 625 626 668 668 sky130_fd_pr__nfet_01v8 L=0.15U W=0.42U AS=0.0693P
+ AD=0.09975P PS=0.75U PD=0.895U
* device instance $687 r0 *1 8.56,40.355 sky130_fd_pr__nfet_01v8
M$687 669 594 625 625 sky130_fd_pr__nfet_01v8 L=0.15U W=0.42U AS=0.09975P
+ AD=0.0693P PS=0.895U PD=0.75U
* device instance $688 r0 *1 9.04,40.355 sky130_fd_pr__nfet_01v8
M$688 97 658 669 669 sky130_fd_pr__nfet_01v8 L=0.15U W=0.42U AS=0.0693P
+ AD=0.1449P PS=0.75U PD=1.11U
* device instance $689 r0 *1 9.88,40.355 sky130_fd_pr__nfet_01v8
M$689 658 64 97 97 sky130_fd_pr__nfet_01v8 L=0.15U W=0.42U AS=0.1449P
+ AD=0.1092P PS=1.11U PD=1.36U
* device instance $690 r0 *1 11.15,40.24 sky130_fd_pr__nfet_01v8
M$690 670 631 627 627 sky130_fd_pr__nfet_01v8 L=0.15U W=0.65U AS=0.169P
+ AD=0.06825P PS=1.82U PD=0.86U
* device instance $691 r0 *1 11.51,40.24 sky130_fd_pr__nfet_01v8
M$691 97 628 670 670 sky130_fd_pr__nfet_01v8 L=0.15U W=0.65U AS=0.06825P
+ AD=0.08775P PS=0.86U PD=0.92U
* device instance $692 r0 *1 11.93,40.24 sky130_fd_pr__nfet_01v8
M$692 659 628 97 97 sky130_fd_pr__nfet_01v8 L=0.15U W=0.65U AS=0.08775P
+ AD=0.169P PS=0.92U PD=1.82U
* device instance $693 r0 *1 12.87,40.24 sky130_fd_pr__nfet_01v8
M$693 659 631 97 97 sky130_fd_pr__nfet_01v8 L=0.15U W=0.65U AS=0.169P
+ AD=0.08775P PS=1.82U PD=0.92U
* device instance $694 r0 *1 13.29,40.24 sky130_fd_pr__nfet_01v8
M$694 590 627 659 659 sky130_fd_pr__nfet_01v8 L=0.15U W=0.65U AS=0.08775P
+ AD=0.195P PS=0.92U PD=1.9U
* device instance $695 r0 *1 14.31,40.24 sky130_fd_pr__nfet_01v8
M$695 629 594 97 97 sky130_fd_pr__nfet_01v8 L=0.15U W=0.65U AS=0.169P
+ AD=0.08775P PS=1.82U PD=0.92U
* device instance $696 r0 *1 14.73,40.24 sky130_fd_pr__nfet_01v8
M$696 97 589 629 629 sky130_fd_pr__nfet_01v8 L=0.15U W=0.65U AS=0.08775P
+ AD=0.08775P PS=0.92U PD=0.92U
* device instance $697 r0 *1 15.15,40.24 sky130_fd_pr__nfet_01v8
M$697 672 589 97 97 sky130_fd_pr__nfet_01v8 L=0.15U W=0.65U AS=0.08775P
+ AD=0.08775P PS=0.92U PD=0.92U
* device instance $698 r0 *1 15.57,40.24 sky130_fd_pr__nfet_01v8
M$698 631 594 672 672 sky130_fd_pr__nfet_01v8 L=0.15U W=0.65U AS=0.08775P
+ AD=0.25025P PS=0.92U PD=1.42U
* device instance $699 r0 *1 16.49,40.24 sky130_fd_pr__nfet_01v8
M$699 97 629 631 631 sky130_fd_pr__nfet_01v8 L=0.15U W=0.65U AS=0.25025P
+ AD=0.208P PS=1.42U PD=1.94U
* device instance $700 r0 *1 25.77,40.24 sky130_fd_pr__nfet_01v8
M$700 97 649 632 632 sky130_fd_pr__nfet_01v8 L=0.15U W=0.65U AS=0.169P
+ AD=0.10725P PS=1.82U PD=0.98U
* device instance $701 r0 *1 26.25,40.24 sky130_fd_pr__nfet_01v8
M$701 677 650 97 97 sky130_fd_pr__nfet_01v8 L=0.15U W=0.65U AS=0.10725P
+ AD=0.06825P PS=0.98U PD=0.86U
* device instance $702 r0 *1 26.61,40.24 sky130_fd_pr__nfet_01v8
M$702 632 92 677 677 sky130_fd_pr__nfet_01v8 L=0.15U W=0.65U AS=0.06825P
+ AD=0.169P PS=0.86U PD=1.82U
* device instance $703 r0 *1 27.55,40.24 sky130_fd_pr__nfet_01v8
M$703 678 135 632 632 sky130_fd_pr__nfet_01v8 L=0.15U W=0.65U AS=0.169P
+ AD=0.10725P PS=1.82U PD=0.98U
* device instance $704 r0 *1 28.03,40.24 sky130_fd_pr__nfet_01v8
M$704 97 555 678 678 sky130_fd_pr__nfet_01v8 L=0.15U W=0.65U AS=0.10725P
+ AD=0.102375P PS=0.98U PD=0.965U
* device instance $705 r0 *1 28.495,40.24 sky130_fd_pr__nfet_01v8
M$705 635 632 97 97 sky130_fd_pr__nfet_01v8 L=0.15U W=0.65U AS=0.102375P
+ AD=0.169P PS=0.965U PD=1.82U
* device instance $706 r0 *1 30.93,40.24 sky130_fd_pr__nfet_01v8
M$706 679 597 636 636 sky130_fd_pr__nfet_01v8 L=0.15U W=0.65U AS=0.169P
+ AD=0.06825P PS=1.82U PD=0.86U
* device instance $707 r0 *1 31.29,40.24 sky130_fd_pr__nfet_01v8
M$707 97 650 679 679 sky130_fd_pr__nfet_01v8 L=0.15U W=0.65U AS=0.06825P
+ AD=0.08775P PS=0.86U PD=0.92U
* device instance $708 r0 *1 31.71,40.24 sky130_fd_pr__nfet_01v8
M$708 660 650 97 97 sky130_fd_pr__nfet_01v8 L=0.15U W=0.65U AS=0.08775P
+ AD=0.169P PS=0.92U PD=1.82U
* device instance $709 r0 *1 32.65,40.24 sky130_fd_pr__nfet_01v8
M$709 660 597 97 97 sky130_fd_pr__nfet_01v8 L=0.15U W=0.65U AS=0.169P
+ AD=0.08775P PS=1.82U PD=0.92U
* device instance $710 r0 *1 33.07,40.24 sky130_fd_pr__nfet_01v8
M$710 595 636 660 660 sky130_fd_pr__nfet_01v8 L=0.15U W=0.65U AS=0.08775P
+ AD=0.195P PS=0.92U PD=1.9U
* device instance $711 r0 *1 55.67,40.24 sky130_fd_pr__nfet_01v8
M$711 676 577 97 97 sky130_fd_pr__nfet_01v8 L=0.15U W=0.65U AS=0.169P
+ AD=0.06825P PS=1.82U PD=0.86U
* device instance $712 r0 *1 56.03,40.24 sky130_fd_pr__nfet_01v8
M$712 675 342 676 676 sky130_fd_pr__nfet_01v8 L=0.15U W=0.65U AS=0.06825P
+ AD=0.118625P PS=0.86U PD=1.015U
* device instance $713 r0 *1 56.545,40.24 sky130_fd_pr__nfet_01v8
M$713 639 602 675 675 sky130_fd_pr__nfet_01v8 L=0.15U W=0.65U AS=0.118625P
+ AD=0.105625P PS=1.015U PD=0.975U
* device instance $714 r0 *1 57.02,40.24 sky130_fd_pr__nfet_01v8
M$714 97 605 639 639 sky130_fd_pr__nfet_01v8 L=0.15U W=0.65U AS=0.105625P
+ AD=0.1755P PS=0.975U PD=1.84U
* device instance $715 r0 *1 59.35,40.24 sky130_fd_pr__nfet_01v8
M$715 674 342 97 97 sky130_fd_pr__nfet_01v8 L=0.15U W=0.65U AS=0.169P
+ AD=0.089375P PS=1.82U PD=0.925U
* device instance $716 r0 *1 59.775,40.24 sky130_fd_pr__nfet_01v8
M$716 673 307 674 674 sky130_fd_pr__nfet_01v8 L=0.15U W=0.65U AS=0.089375P
+ AD=0.091P PS=0.925U PD=0.93U
* device instance $717 r0 *1 60.205,40.24 sky130_fd_pr__nfet_01v8
M$717 641 602 673 673 sky130_fd_pr__nfet_01v8 L=0.15U W=0.65U AS=0.091P
+ AD=0.115375P PS=0.93U PD=1.005U
* device instance $718 r0 *1 60.71,40.24 sky130_fd_pr__nfet_01v8
M$718 97 605 641 641 sky130_fd_pr__nfet_01v8 L=0.15U W=0.65U AS=0.115375P
+ AD=0.112125P PS=1.005U PD=0.995U
* device instance $719 r0 *1 61.205,40.24 sky130_fd_pr__nfet_01v8
M$719 641 662 97 97 sky130_fd_pr__nfet_01v8 L=0.15U W=0.65U AS=0.112125P
+ AD=0.169P PS=0.995U PD=1.82U
* device instance $720 r0 *1 64.51,40.24 sky130_fd_pr__nfet_01v8
M$720 671 651 642 642 sky130_fd_pr__nfet_01v8 L=0.15U W=0.65U AS=0.169P
+ AD=0.06825P PS=1.82U PD=0.86U
* device instance $721 r0 *1 64.87,40.24 sky130_fd_pr__nfet_01v8
M$721 97 568 671 671 sky130_fd_pr__nfet_01v8 L=0.15U W=0.65U AS=0.06825P
+ AD=0.08775P PS=0.86U PD=0.92U
* device instance $722 r0 *1 65.29,40.24 sky130_fd_pr__nfet_01v8
M$722 663 568 97 97 sky130_fd_pr__nfet_01v8 L=0.15U W=0.65U AS=0.08775P
+ AD=0.169P PS=0.92U PD=1.82U
* device instance $723 r0 *1 66.23,40.24 sky130_fd_pr__nfet_01v8
M$723 663 651 97 97 sky130_fd_pr__nfet_01v8 L=0.15U W=0.65U AS=0.169P
+ AD=0.08775P PS=1.82U PD=0.92U
* device instance $724 r0 *1 66.65,40.24 sky130_fd_pr__nfet_01v8
M$724 602 642 663 663 sky130_fd_pr__nfet_01v8 L=0.15U W=0.65U AS=0.08775P
+ AD=0.195P PS=0.92U PD=1.9U
* device instance $725 r0 *1 68.09,40.24 sky130_fd_pr__nfet_01v8
M$725 97 644 643 643 sky130_fd_pr__nfet_01v8 L=0.15U W=0.65U AS=0.169P
+ AD=0.11285P PS=1.82U PD=1.045U
* device instance $726 r0 *1 68.635,40.355 sky130_fd_pr__nfet_01v8
M$726 667 64 97 97 sky130_fd_pr__nfet_01v8 L=0.15U W=0.42U AS=0.11285P
+ AD=0.0693P PS=1.045U PD=0.75U
* device instance $727 r0 *1 69.115,40.355 sky130_fd_pr__nfet_01v8
M$727 644 652 667 667 sky130_fd_pr__nfet_01v8 L=0.15U W=0.42U AS=0.0693P
+ AD=0.09975P PS=0.75U PD=0.895U
* device instance $728 r0 *1 69.74,40.355 sky130_fd_pr__nfet_01v8
M$728 666 651 644 644 sky130_fd_pr__nfet_01v8 L=0.15U W=0.42U AS=0.09975P
+ AD=0.0693P PS=0.895U PD=0.75U
* device instance $729 r0 *1 70.22,40.355 sky130_fd_pr__nfet_01v8
M$729 97 664 666 666 sky130_fd_pr__nfet_01v8 L=0.15U W=0.42U AS=0.0693P
+ AD=0.1449P PS=0.75U PD=1.11U
* device instance $730 r0 *1 71.06,40.355 sky130_fd_pr__nfet_01v8
M$730 664 64 97 97 sky130_fd_pr__nfet_01v8 L=0.15U W=0.42U AS=0.1449P
+ AD=0.1092P PS=1.11U PD=1.36U
* device instance $731 r0 *1 2.77,41.245 sky130_fd_pr__nfet_01v8
M$731 97 681 680 680 sky130_fd_pr__nfet_01v8 L=0.15U W=0.42U AS=0.1092P
+ AD=0.0567P PS=1.36U PD=0.69U
* device instance $732 r0 *1 3.19,41.245 sky130_fd_pr__nfet_01v8
M$732 682 680 97 97 sky130_fd_pr__nfet_01v8 L=0.15U W=0.42U AS=0.0567P
+ AD=0.1092P PS=0.69U PD=1.36U
* device instance $733 r0 *1 4.13,41.245 sky130_fd_pr__nfet_01v8
M$733 710 624 683 683 sky130_fd_pr__nfet_01v8 L=0.15U W=0.42U AS=0.1092P
+ AD=0.0441P PS=1.36U PD=0.63U
* device instance $734 r0 *1 4.49,41.245 sky130_fd_pr__nfet_01v8
M$734 97 94 710 710 sky130_fd_pr__nfet_01v8 L=0.15U W=0.42U AS=0.0441P
+ AD=0.1092P PS=0.63U PD=1.36U
* device instance $735 r0 *1 4.68,40.355 sky130_fd_pr__nfet_01v8
M$735 665 622 623 623 sky130_fd_pr__nfet_01v8 L=0.15U W=0.42U AS=0.1113P
+ AD=0.0441P PS=1.37U PD=0.63U
* device instance $736 r0 *1 5.04,40.355 sky130_fd_pr__nfet_01v8
M$736 97 115 665 665 sky130_fd_pr__nfet_01v8 L=0.15U W=0.42U AS=0.0441P
+ AD=0.0966P PS=0.63U PD=0.88U
* device instance $737 r0 *1 5.65,40.355 sky130_fd_pr__nfet_01v8
M$737 587 623 97 97 sky130_fd_pr__nfet_01v8 L=0.15U W=0.42U AS=0.0966P
+ AD=0.1113P PS=0.88U PD=1.37U
* device instance $738 r0 *1 7.29,41.215 sky130_fd_pr__nfet_01v8
M$738 686 680 683 683 sky130_fd_pr__nfet_01v8 L=0.15U W=0.36U AS=0.1446P
+ AD=0.0522P PS=1.18U PD=0.65U
* device instance $739 r0 *1 7.73,41.215 sky130_fd_pr__nfet_01v8
M$739 712 682 686 686 sky130_fd_pr__nfet_01v8 L=0.15U W=0.36U AS=0.0522P
+ AD=0.0759P PS=0.65U PD=0.8U
* device instance $740 r0 *1 5.43,41.245 sky130_fd_pr__nfet_01v8
M$740 97 94 684 684 sky130_fd_pr__nfet_01v8 L=0.15U W=0.42U AS=0.1092P
+ AD=0.0609P PS=1.36U PD=0.71U
* device instance $741 r0 *1 5.87,41.245 sky130_fd_pr__nfet_01v8
M$741 711 684 97 97 sky130_fd_pr__nfet_01v8 L=0.15U W=0.42U AS=0.0609P
+ AD=0.0756P PS=0.71U PD=0.78U
* device instance $742 r0 *1 6.38,41.245 sky130_fd_pr__nfet_01v8
M$742 683 685 711 711 sky130_fd_pr__nfet_01v8 L=0.15U W=0.42U AS=0.0756P
+ AD=0.1446P PS=0.78U PD=1.18U
* device instance $743 r0 *1 8.26,41.245 sky130_fd_pr__nfet_01v8
M$743 97 687 712 712 sky130_fd_pr__nfet_01v8 L=0.15U W=0.42U AS=0.0759P
+ AD=0.12095P PS=0.8U PD=1.085U
* device instance $744 r0 *1 8.855,41.355 sky130_fd_pr__nfet_01v8
M$744 687 686 97 97 sky130_fd_pr__nfet_01v8 L=0.15U W=0.64U AS=0.12095P
+ AD=0.1664P PS=1.085U PD=1.8U
* device instance $745 r0 *1 10.28,41.215 sky130_fd_pr__nfet_01v8
M$745 688 682 713 713 sky130_fd_pr__nfet_01v8 L=0.15U W=0.36U AS=0.0678P
+ AD=0.0684P PS=0.755U PD=0.74U
* device instance $746 r0 *1 10.81,41.215 sky130_fd_pr__nfet_01v8
M$746 714 680 688 688 sky130_fd_pr__nfet_01v8 L=0.15U W=0.36U AS=0.0684P
+ AD=0.066P PS=0.74U PD=0.745U
* device instance $747 r0 *1 9.795,41.245 sky130_fd_pr__nfet_01v8
M$747 713 687 97 97 sky130_fd_pr__nfet_01v8 L=0.15U W=0.42U AS=0.1092P
+ AD=0.0678P PS=1.36U PD=0.755U
* device instance $748 r0 *1 11.285,41.245 sky130_fd_pr__nfet_01v8
M$748 97 685 714 714 sky130_fd_pr__nfet_01v8 L=0.15U W=0.42U AS=0.066P
+ AD=0.1092P PS=0.745U PD=1.36U
* device instance $749 r0 *1 12.225,41.245 sky130_fd_pr__nfet_01v8
M$749 97 688 685 685 sky130_fd_pr__nfet_01v8 L=0.15U W=0.42U AS=0.1092P
+ AD=0.10025P PS=1.36U PD=0.985U
* device instance $750 r0 *1 12.71,41.36 sky130_fd_pr__nfet_01v8
M$750 553 688 97 97 sky130_fd_pr__nfet_01v8 L=0.15U W=0.65U AS=0.10025P
+ AD=0.182P PS=0.985U PD=1.86U
* device instance $751 r0 *1 13.81,41.36 sky130_fd_pr__nfet_01v8
M$751 97 553 689 689 sky130_fd_pr__nfet_01v8 L=0.15U W=0.65U AS=0.169P
+ AD=0.08775P PS=1.82U PD=0.92U
* device instance $752 r0 *1 14.23,41.36 sky130_fd_pr__nfet_01v8
M$752 589 689 97 97 sky130_fd_pr__nfet_01v8 L=0.15U W=2.6U AS=0.351P
+ AD=0.43225P PS=3.68U PD=4.58U
* device instance $756 r0 *1 17.03,41.36 sky130_fd_pr__nfet_01v8
M$756 97 593 690 690 sky130_fd_pr__nfet_01v8 L=0.15U W=0.65U AS=0.169P
+ AD=0.08775P PS=1.82U PD=0.92U
* device instance $757 r0 *1 17.45,41.36 sky130_fd_pr__nfet_01v8
M$757 628 690 97 97 sky130_fd_pr__nfet_01v8 L=0.15U W=2.6U AS=0.351P
+ AD=0.43225P PS=3.68U PD=4.58U
* device instance $761 r0 *1 23.08,41.245 sky130_fd_pr__nfet_01v8
M$761 718 726 691 691 sky130_fd_pr__nfet_01v8 L=0.15U W=0.42U AS=0.1113P
+ AD=0.0441P PS=1.37U PD=0.63U
* device instance $762 r0 *1 23.44,41.245 sky130_fd_pr__nfet_01v8
M$762 97 115 718 718 sky130_fd_pr__nfet_01v8 L=0.15U W=0.42U AS=0.0441P
+ AD=0.0966P PS=0.63U PD=0.88U
* device instance $763 r0 *1 24.05,41.245 sky130_fd_pr__nfet_01v8
M$763 649 691 97 97 sky130_fd_pr__nfet_01v8 L=0.15U W=0.42U AS=0.0966P
+ AD=0.1113P PS=0.88U PD=1.37U
* device instance $764 r0 *1 26.23,41.245 sky130_fd_pr__nfet_01v8
M$764 97 681 692 692 sky130_fd_pr__nfet_01v8 L=0.15U W=0.42U AS=0.1092P
+ AD=0.0567P PS=1.36U PD=0.69U
* device instance $765 r0 *1 26.65,41.245 sky130_fd_pr__nfet_01v8
M$765 693 692 97 97 sky130_fd_pr__nfet_01v8 L=0.15U W=0.42U AS=0.0567P
+ AD=0.1092P PS=0.69U PD=1.36U
* device instance $766 r0 *1 27.59,41.245 sky130_fd_pr__nfet_01v8
M$766 720 727 694 694 sky130_fd_pr__nfet_01v8 L=0.15U W=0.42U AS=0.1092P
+ AD=0.0441P PS=1.36U PD=0.63U
* device instance $767 r0 *1 27.95,41.245 sky130_fd_pr__nfet_01v8
M$767 97 94 720 720 sky130_fd_pr__nfet_01v8 L=0.15U W=0.42U AS=0.0441P
+ AD=0.1092P PS=0.63U PD=1.36U
* device instance $768 r0 *1 30.75,41.215 sky130_fd_pr__nfet_01v8
M$768 697 692 694 694 sky130_fd_pr__nfet_01v8 L=0.15U W=0.36U AS=0.1446P
+ AD=0.0522P PS=1.18U PD=0.65U
* device instance $769 r0 *1 31.19,41.215 sky130_fd_pr__nfet_01v8
M$769 723 693 697 697 sky130_fd_pr__nfet_01v8 L=0.15U W=0.36U AS=0.0522P
+ AD=0.0759P PS=0.65U PD=0.8U
* device instance $770 r0 *1 28.89,41.245 sky130_fd_pr__nfet_01v8
M$770 97 94 695 695 sky130_fd_pr__nfet_01v8 L=0.15U W=0.42U AS=0.1092P
+ AD=0.0609P PS=1.36U PD=0.71U
* device instance $771 r0 *1 29.33,41.245 sky130_fd_pr__nfet_01v8
M$771 722 695 97 97 sky130_fd_pr__nfet_01v8 L=0.15U W=0.42U AS=0.0609P
+ AD=0.0756P PS=0.71U PD=0.78U
* device instance $772 r0 *1 29.84,41.245 sky130_fd_pr__nfet_01v8
M$772 694 696 722 722 sky130_fd_pr__nfet_01v8 L=0.15U W=0.42U AS=0.0756P
+ AD=0.1446P PS=0.78U PD=1.18U
* device instance $773 r0 *1 31.72,41.245 sky130_fd_pr__nfet_01v8
M$773 97 698 723 723 sky130_fd_pr__nfet_01v8 L=0.15U W=0.42U AS=0.0759P
+ AD=0.12095P PS=0.8U PD=1.085U
* device instance $774 r0 *1 32.315,41.355 sky130_fd_pr__nfet_01v8
M$774 698 697 97 97 sky130_fd_pr__nfet_01v8 L=0.15U W=0.64U AS=0.12095P
+ AD=0.1664P PS=1.085U PD=1.8U
* device instance $775 r0 *1 33.74,41.215 sky130_fd_pr__nfet_01v8
M$775 699 693 724 724 sky130_fd_pr__nfet_01v8 L=0.15U W=0.36U AS=0.0678P
+ AD=0.0684P PS=0.755U PD=0.74U
* device instance $776 r0 *1 34.27,41.215 sky130_fd_pr__nfet_01v8
M$776 725 692 699 699 sky130_fd_pr__nfet_01v8 L=0.15U W=0.36U AS=0.0684P
+ AD=0.066P PS=0.74U PD=0.745U
* device instance $777 r0 *1 33.255,41.245 sky130_fd_pr__nfet_01v8
M$777 724 698 97 97 sky130_fd_pr__nfet_01v8 L=0.15U W=0.42U AS=0.1092P
+ AD=0.0678P PS=1.36U PD=0.755U
* device instance $778 r0 *1 34.745,41.245 sky130_fd_pr__nfet_01v8
M$778 97 696 725 725 sky130_fd_pr__nfet_01v8 L=0.15U W=0.42U AS=0.066P
+ AD=0.1092P PS=0.745U PD=1.36U
* device instance $779 r0 *1 35.435,40.355 sky130_fd_pr__nfet_01v8
M$779 637 661 97 97 sky130_fd_pr__nfet_01v8 L=0.15U W=1.68U AS=0.2877P
+ AD=0.2352P PS=3.47U PD=2.8U
* device instance $783 r0 *1 37.155,40.355 sky130_fd_pr__nfet_01v8
M$783 297 637 97 97 sky130_fd_pr__nfet_01v8 L=0.15U W=6.72U AS=0.93975P
+ AD=0.99225P PS=11.195U PD=11.865U
* device instance $799 r0 *1 35.685,41.245 sky130_fd_pr__nfet_01v8
M$799 97 699 696 696 sky130_fd_pr__nfet_01v8 L=0.15U W=0.42U AS=0.1092P
+ AD=0.10025P PS=1.36U PD=0.985U
* device instance $800 r0 *1 36.17,41.36 sky130_fd_pr__nfet_01v8
M$800 650 699 97 97 sky130_fd_pr__nfet_01v8 L=0.15U W=0.65U AS=0.10025P
+ AD=0.182P PS=0.985U PD=1.86U
* device instance $801 r0 *1 44.63,41.36 sky130_fd_pr__nfet_01v8
M$801 734 650 97 97 sky130_fd_pr__nfet_01v8 L=0.15U W=0.65U AS=0.169P
+ AD=0.118625P PS=1.82U PD=1.015U
* device instance $802 r0 *1 45.145,41.36 sky130_fd_pr__nfet_01v8
M$802 97 372 734 734 sky130_fd_pr__nfet_01v8 L=0.15U W=0.65U AS=0.118625P
+ AD=0.089375P PS=1.015U PD=0.925U
* device instance $803 r0 *1 45.57,41.36 sky130_fd_pr__nfet_01v8
M$803 734 728 97 97 sky130_fd_pr__nfet_01v8 L=0.15U W=0.65U AS=0.089375P
+ AD=0.08775P PS=0.925U PD=0.92U
* device instance $804 r0 *1 45.99,41.36 sky130_fd_pr__nfet_01v8
M$804 97 1134 734 734 sky130_fd_pr__nfet_01v8 L=0.15U W=0.65U AS=0.08775P
+ AD=0.169P PS=0.92U PD=1.82U
* device instance $805 r0 *1 49.23,41.36 sky130_fd_pr__nfet_01v8
M$805 733 734 97 97 sky130_fd_pr__nfet_01v8 L=0.15U W=0.65U AS=0.169P
+ AD=0.08775P PS=1.82U PD=0.92U
* device instance $806 r0 *1 49.65,41.36 sky130_fd_pr__nfet_01v8
M$806 732 700 733 733 sky130_fd_pr__nfet_01v8 L=0.15U W=0.65U AS=0.08775P
+ AD=0.10725P PS=0.92U PD=0.98U
* device instance $807 r0 *1 50.13,41.36 sky130_fd_pr__nfet_01v8
M$807 896 408 732 732 sky130_fd_pr__nfet_01v8 L=0.15U W=0.65U AS=0.10725P
+ AD=0.169P PS=0.98U PD=1.82U
* device instance $808 r0 *1 57.61,41.36 sky130_fd_pr__nfet_01v8
M$808 731 729 730 730 sky130_fd_pr__nfet_01v8 L=0.15U W=0.65U AS=0.169P
+ AD=0.06825P PS=1.82U PD=0.86U
* device instance $809 r0 *1 57.97,41.36 sky130_fd_pr__nfet_01v8
M$809 97 639 731 731 sky130_fd_pr__nfet_01v8 L=0.15U W=0.65U AS=0.06825P
+ AD=0.08775P PS=0.86U PD=0.92U
* device instance $810 r0 *1 58.39,41.36 sky130_fd_pr__nfet_01v8
M$810 701 639 97 97 sky130_fd_pr__nfet_01v8 L=0.15U W=0.65U AS=0.08775P
+ AD=0.169P PS=0.92U PD=1.82U
* device instance $811 r0 *1 59.33,41.36 sky130_fd_pr__nfet_01v8
M$811 701 729 97 97 sky130_fd_pr__nfet_01v8 L=0.15U W=0.65U AS=0.169P
+ AD=0.08775P PS=1.82U PD=0.92U
* device instance $812 r0 *1 59.75,41.36 sky130_fd_pr__nfet_01v8
M$812 735 730 701 701 sky130_fd_pr__nfet_01v8 L=0.15U W=0.65U AS=0.08775P
+ AD=0.195P PS=0.92U PD=1.9U
* device instance $813 r0 *1 60.73,41.245 sky130_fd_pr__nfet_01v8
M$813 97 979 702 702 sky130_fd_pr__nfet_01v8 L=0.15U W=0.42U AS=0.1092P
+ AD=0.0567P PS=1.36U PD=0.69U
* device instance $814 r0 *1 61.15,41.245 sky130_fd_pr__nfet_01v8
M$814 703 702 97 97 sky130_fd_pr__nfet_01v8 L=0.15U W=0.42U AS=0.0567P
+ AD=0.1092P PS=0.69U PD=1.36U
* device instance $815 r0 *1 62.09,41.245 sky130_fd_pr__nfet_01v8
M$815 721 570 704 704 sky130_fd_pr__nfet_01v8 L=0.15U W=0.42U AS=0.1092P
+ AD=0.0441P PS=1.36U PD=0.63U
* device instance $816 r0 *1 62.45,41.245 sky130_fd_pr__nfet_01v8
M$816 97 302 721 721 sky130_fd_pr__nfet_01v8 L=0.15U W=0.42U AS=0.0441P
+ AD=0.1092P PS=0.63U PD=1.36U
* device instance $817 r0 *1 65.25,41.215 sky130_fd_pr__nfet_01v8
M$817 707 702 704 704 sky130_fd_pr__nfet_01v8 L=0.15U W=0.36U AS=0.1446P
+ AD=0.0522P PS=1.18U PD=0.65U
* device instance $818 r0 *1 65.69,41.215 sky130_fd_pr__nfet_01v8
M$818 717 703 707 707 sky130_fd_pr__nfet_01v8 L=0.15U W=0.36U AS=0.0522P
+ AD=0.0759P PS=0.65U PD=0.8U
* device instance $819 r0 *1 63.39,41.245 sky130_fd_pr__nfet_01v8
M$819 97 302 705 705 sky130_fd_pr__nfet_01v8 L=0.15U W=0.42U AS=0.1092P
+ AD=0.0609P PS=1.36U PD=0.71U
* device instance $820 r0 *1 63.83,41.245 sky130_fd_pr__nfet_01v8
M$820 719 705 97 97 sky130_fd_pr__nfet_01v8 L=0.15U W=0.42U AS=0.0609P
+ AD=0.0756P PS=0.71U PD=0.78U
* device instance $821 r0 *1 64.34,41.245 sky130_fd_pr__nfet_01v8
M$821 704 706 719 719 sky130_fd_pr__nfet_01v8 L=0.15U W=0.42U AS=0.0756P
+ AD=0.1446P PS=0.78U PD=1.18U
* device instance $822 r0 *1 66.22,41.245 sky130_fd_pr__nfet_01v8
M$822 97 708 717 717 sky130_fd_pr__nfet_01v8 L=0.15U W=0.42U AS=0.0759P
+ AD=0.12095P PS=0.8U PD=1.085U
* device instance $823 r0 *1 66.815,41.355 sky130_fd_pr__nfet_01v8
M$823 708 707 97 97 sky130_fd_pr__nfet_01v8 L=0.15U W=0.64U AS=0.12095P
+ AD=0.1664P PS=1.085U PD=1.8U
* device instance $824 r0 *1 68.24,41.215 sky130_fd_pr__nfet_01v8
M$824 709 703 716 716 sky130_fd_pr__nfet_01v8 L=0.15U W=0.36U AS=0.0678P
+ AD=0.0684P PS=0.755U PD=0.74U
* device instance $825 r0 *1 68.77,41.215 sky130_fd_pr__nfet_01v8
M$825 715 702 709 709 sky130_fd_pr__nfet_01v8 L=0.15U W=0.36U AS=0.0684P
+ AD=0.066P PS=0.74U PD=0.745U
* device instance $826 r0 *1 67.755,41.245 sky130_fd_pr__nfet_01v8
M$826 716 708 97 97 sky130_fd_pr__nfet_01v8 L=0.15U W=0.42U AS=0.1092P
+ AD=0.0678P PS=1.36U PD=0.755U
* device instance $827 r0 *1 69.245,41.245 sky130_fd_pr__nfet_01v8
M$827 97 706 715 715 sky130_fd_pr__nfet_01v8 L=0.15U W=0.42U AS=0.066P
+ AD=0.1092P PS=0.745U PD=1.36U
* device instance $828 r0 *1 70.185,41.245 sky130_fd_pr__nfet_01v8
M$828 97 709 706 706 sky130_fd_pr__nfet_01v8 L=0.15U W=0.42U AS=0.1092P
+ AD=0.10025P PS=1.36U PD=0.985U
* device instance $829 r0 *1 70.67,41.36 sky130_fd_pr__nfet_01v8
M$829 651 709 97 97 sky130_fd_pr__nfet_01v8 L=0.15U W=0.65U AS=0.10025P
+ AD=0.182P PS=0.985U PD=1.86U
* device instance $830 r0 *1 7.83,46.8 sky130_fd_pr__nfet_01v8
M$830 97 867 832 832 sky130_fd_pr__nfet_01v8 L=0.15U W=0.65U AS=0.169P
+ AD=0.10725P PS=1.82U PD=0.98U
* device instance $831 r0 *1 8.31,46.8 sky130_fd_pr__nfet_01v8
M$831 855 833 97 97 sky130_fd_pr__nfet_01v8 L=0.15U W=0.65U AS=0.10725P
+ AD=0.06825P PS=0.98U PD=0.86U
* device instance $832 r0 *1 8.67,46.8 sky130_fd_pr__nfet_01v8
M$832 832 92 855 855 sky130_fd_pr__nfet_01v8 L=0.15U W=0.65U AS=0.06825P
+ AD=0.169P PS=0.86U PD=1.82U
* device instance $833 r0 *1 9.21,45.795 sky130_fd_pr__nfet_01v8
M$833 97 681 755 755 sky130_fd_pr__nfet_01v8 L=0.15U W=0.42U AS=0.1092P
+ AD=0.0567P PS=1.36U PD=0.69U
* device instance $834 r0 *1 9.63,45.795 sky130_fd_pr__nfet_01v8
M$834 756 755 97 97 sky130_fd_pr__nfet_01v8 L=0.15U W=0.42U AS=0.0567P
+ AD=0.1092P PS=0.69U PD=1.36U
* device instance $835 r0 *1 9.61,46.8 sky130_fd_pr__nfet_01v8
M$835 856 158 832 832 sky130_fd_pr__nfet_01v8 L=0.15U W=0.65U AS=0.169P
+ AD=0.10725P PS=1.82U PD=0.98U
* device instance $836 r0 *1 10.09,46.8 sky130_fd_pr__nfet_01v8
M$836 97 868 856 856 sky130_fd_pr__nfet_01v8 L=0.15U W=0.65U AS=0.10725P
+ AD=0.102375P PS=0.98U PD=0.965U
* device instance $837 r0 *1 10.555,46.8 sky130_fd_pr__nfet_01v8
M$837 873 832 97 97 sky130_fd_pr__nfet_01v8 L=0.15U W=0.65U AS=0.102375P
+ AD=0.169P PS=0.965U PD=1.82U
* device instance $838 r0 *1 10.57,45.795 sky130_fd_pr__nfet_01v8
M$838 816 591 757 757 sky130_fd_pr__nfet_01v8 L=0.15U W=0.42U AS=0.1092P
+ AD=0.0441P PS=1.36U PD=0.63U
* device instance $839 r0 *1 10.93,45.795 sky130_fd_pr__nfet_01v8
M$839 97 302 816 816 sky130_fd_pr__nfet_01v8 L=0.15U W=0.42U AS=0.0441P
+ AD=0.1092P PS=0.63U PD=1.36U
* device instance $840 r0 *1 11.51,46.8 sky130_fd_pr__nfet_01v8
M$840 97 869 835 835 sky130_fd_pr__nfet_01v8 L=0.15U W=0.65U AS=0.169P
+ AD=0.169P PS=1.82U PD=1.82U
* device instance $841 r0 *1 11.87,45.795 sky130_fd_pr__nfet_01v8
M$841 97 302 758 758 sky130_fd_pr__nfet_01v8 L=0.15U W=0.42U AS=0.1092P
+ AD=0.0609P PS=1.36U PD=0.71U
* device instance $842 r0 *1 12.31,45.795 sky130_fd_pr__nfet_01v8
M$842 818 758 97 97 sky130_fd_pr__nfet_01v8 L=0.15U W=0.42U AS=0.0609P
+ AD=0.0756P PS=0.71U PD=0.78U
* device instance $843 r0 *1 12.82,45.795 sky130_fd_pr__nfet_01v8
M$843 757 762 818 818 sky130_fd_pr__nfet_01v8 L=0.15U W=0.42U AS=0.0756P
+ AD=0.1446P PS=0.78U PD=1.18U
* device instance $844 r0 *1 13.73,45.825 sky130_fd_pr__nfet_01v8
M$844 759 755 757 757 sky130_fd_pr__nfet_01v8 L=0.15U W=0.36U AS=0.1446P
+ AD=0.0522P PS=1.18U PD=0.65U
* device instance $845 r0 *1 14.17,45.825 sky130_fd_pr__nfet_01v8
M$845 759 756 820 820 sky130_fd_pr__nfet_01v8 L=0.15U W=0.36U AS=0.0759P
+ AD=0.0522P PS=0.8U PD=0.65U
* device instance $846 r0 *1 14.7,45.795 sky130_fd_pr__nfet_01v8
M$846 820 760 97 97 sky130_fd_pr__nfet_01v8 L=0.15U W=0.42U AS=0.12095P
+ AD=0.0759P PS=1.085U PD=0.8U
* device instance $847 r0 *1 15.295,45.685 sky130_fd_pr__nfet_01v8
M$847 760 759 97 97 sky130_fd_pr__nfet_01v8 L=0.15U W=0.64U AS=0.12095P
+ AD=0.1664P PS=1.085U PD=1.8U
* device instance $848 r0 *1 12.45,46.8 sky130_fd_pr__nfet_01v8
M$848 593 835 834 834 sky130_fd_pr__nfet_01v8 L=0.15U W=2.6U AS=0.43225P
+ AD=0.355875P PS=4.58U PD=3.695U
* device instance $852 r0 *1 14.145,46.8 sky130_fd_pr__nfet_01v8
M$852 97 836 834 834 sky130_fd_pr__nfet_01v8 L=0.15U W=2.6U AS=0.355875P
+ AD=0.51675P PS=3.695U PD=4.84U
* device instance $856 r0 *1 16.235,45.795 sky130_fd_pr__nfet_01v8
M$856 821 760 97 97 sky130_fd_pr__nfet_01v8 L=0.15U W=0.42U AS=0.1092P
+ AD=0.0678P PS=1.36U PD=0.755U
* device instance $857 r0 *1 16.72,45.825 sky130_fd_pr__nfet_01v8
M$857 761 756 821 821 sky130_fd_pr__nfet_01v8 L=0.15U W=0.36U AS=0.0678P
+ AD=0.0684P PS=0.755U PD=0.74U
* device instance $858 r0 *1 17.25,45.825 sky130_fd_pr__nfet_01v8
M$858 761 755 822 822 sky130_fd_pr__nfet_01v8 L=0.15U W=0.36U AS=0.066P
+ AD=0.0684P PS=0.745U PD=0.74U
* device instance $859 r0 *1 17.725,45.795 sky130_fd_pr__nfet_01v8
M$859 97 762 822 822 sky130_fd_pr__nfet_01v8 L=0.15U W=0.42U AS=0.066P
+ AD=0.1092P PS=0.745U PD=1.36U
* device instance $860 r0 *1 18.665,45.795 sky130_fd_pr__nfet_01v8
M$860 762 761 97 97 sky130_fd_pr__nfet_01v8 L=0.15U W=0.42U AS=0.10025P
+ AD=0.1092P PS=0.985U PD=1.36U
* device instance $861 r0 *1 19.15,45.68 sky130_fd_pr__nfet_01v8
M$861 594 761 97 97 sky130_fd_pr__nfet_01v8 L=0.15U W=0.65U AS=0.10025P
+ AD=0.182P PS=0.985U PD=1.86U
* device instance $862 r0 *1 25.77,46.685 sky130_fd_pr__nfet_01v8
M$862 97 681 837 837 sky130_fd_pr__nfet_01v8 L=0.15U W=0.42U AS=0.1092P
+ AD=0.0567P PS=1.36U PD=0.69U
* device instance $863 r0 *1 26.19,46.685 sky130_fd_pr__nfet_01v8
M$863 870 837 97 97 sky130_fd_pr__nfet_01v8 L=0.15U W=0.42U AS=0.0567P
+ AD=0.1092P PS=0.69U PD=1.36U
* device instance $864 r0 *1 26.23,45.68 sky130_fd_pr__nfet_01v8
M$864 97 763 727 727 sky130_fd_pr__nfet_01v8 L=0.15U W=0.65U AS=0.169P
+ AD=0.11285P PS=1.82U PD=1.045U
* device instance $865 r0 *1 26.775,45.795 sky130_fd_pr__nfet_01v8
M$865 823 64 97 97 sky130_fd_pr__nfet_01v8 L=0.15U W=0.42U AS=0.11285P
+ AD=0.0693P PS=1.045U PD=0.75U
* device instance $866 r0 *1 27.255,45.795 sky130_fd_pr__nfet_01v8
M$866 763 794 823 823 sky130_fd_pr__nfet_01v8 L=0.15U W=0.42U AS=0.0693P
+ AD=0.09975P PS=0.75U PD=0.895U
* device instance $867 r0 *1 27.88,45.795 sky130_fd_pr__nfet_01v8
M$867 824 597 763 763 sky130_fd_pr__nfet_01v8 L=0.15U W=0.42U AS=0.09975P
+ AD=0.0693P PS=0.895U PD=0.75U
* device instance $868 r0 *1 28.36,45.795 sky130_fd_pr__nfet_01v8
M$868 97 812 824 824 sky130_fd_pr__nfet_01v8 L=0.15U W=0.42U AS=0.0693P
+ AD=0.1449P PS=0.75U PD=1.11U
* device instance $869 r0 *1 29.2,45.795 sky130_fd_pr__nfet_01v8
M$869 812 64 97 97 sky130_fd_pr__nfet_01v8 L=0.15U W=0.42U AS=0.1449P
+ AD=0.1092P PS=1.11U PD=1.36U
* device instance $870 r0 *1 27.13,46.685 sky130_fd_pr__nfet_01v8
M$870 857 635 838 838 sky130_fd_pr__nfet_01v8 L=0.15U W=0.42U AS=0.1092P
+ AD=0.0441P PS=1.36U PD=0.63U
* device instance $871 r0 *1 27.49,46.685 sky130_fd_pr__nfet_01v8
M$871 97 302 857 857 sky130_fd_pr__nfet_01v8 L=0.15U W=0.42U AS=0.0441P
+ AD=0.1092P PS=0.63U PD=1.36U
* device instance $872 r0 *1 30.29,46.655 sky130_fd_pr__nfet_01v8
M$872 841 837 838 838 sky130_fd_pr__nfet_01v8 L=0.15U W=0.36U AS=0.1446P
+ AD=0.0522P PS=1.18U PD=0.65U
* device instance $873 r0 *1 30.73,46.655 sky130_fd_pr__nfet_01v8
M$873 859 870 841 841 sky130_fd_pr__nfet_01v8 L=0.15U W=0.36U AS=0.0522P
+ AD=0.0759P PS=0.65U PD=0.8U
* device instance $874 r0 *1 28.43,46.685 sky130_fd_pr__nfet_01v8
M$874 97 302 839 839 sky130_fd_pr__nfet_01v8 L=0.15U W=0.42U AS=0.1092P
+ AD=0.0609P PS=1.36U PD=0.71U
* device instance $875 r0 *1 28.87,46.685 sky130_fd_pr__nfet_01v8
M$875 858 839 97 97 sky130_fd_pr__nfet_01v8 L=0.15U W=0.42U AS=0.0609P
+ AD=0.0756P PS=0.71U PD=0.78U
* device instance $876 r0 *1 29.38,46.685 sky130_fd_pr__nfet_01v8
M$876 838 840 858 858 sky130_fd_pr__nfet_01v8 L=0.15U W=0.42U AS=0.0756P
+ AD=0.1446P PS=0.78U PD=1.18U
* device instance $877 r0 *1 31.26,46.685 sky130_fd_pr__nfet_01v8
M$877 97 842 859 859 sky130_fd_pr__nfet_01v8 L=0.15U W=0.42U AS=0.0759P
+ AD=0.12095P PS=0.8U PD=1.085U
* device instance $878 r0 *1 31.855,46.795 sky130_fd_pr__nfet_01v8
M$878 842 841 97 97 sky130_fd_pr__nfet_01v8 L=0.15U W=0.64U AS=0.12095P
+ AD=0.1664P PS=1.085U PD=1.8U
* device instance $879 r0 *1 33.28,46.655 sky130_fd_pr__nfet_01v8
M$879 843 870 860 860 sky130_fd_pr__nfet_01v8 L=0.15U W=0.36U AS=0.0678P
+ AD=0.0684P PS=0.755U PD=0.74U
* device instance $880 r0 *1 33.81,46.655 sky130_fd_pr__nfet_01v8
M$880 861 837 843 843 sky130_fd_pr__nfet_01v8 L=0.15U W=0.36U AS=0.0684P
+ AD=0.066P PS=0.74U PD=0.745U
* device instance $881 r0 *1 32.795,46.685 sky130_fd_pr__nfet_01v8
M$881 860 842 97 97 sky130_fd_pr__nfet_01v8 L=0.15U W=0.42U AS=0.1092P
+ AD=0.0678P PS=1.36U PD=0.755U
* device instance $882 r0 *1 34.285,46.685 sky130_fd_pr__nfet_01v8
M$882 97 840 861 861 sky130_fd_pr__nfet_01v8 L=0.15U W=0.42U AS=0.066P
+ AD=0.1092P PS=0.745U PD=1.36U
* device instance $883 r0 *1 33.59,45.795 sky130_fd_pr__nfet_01v8
M$883 97 681 764 764 sky130_fd_pr__nfet_01v8 L=0.15U W=0.42U AS=0.1092P
+ AD=0.0567P PS=1.36U PD=0.69U
* device instance $884 r0 *1 34.01,45.795 sky130_fd_pr__nfet_01v8
M$884 765 764 97 97 sky130_fd_pr__nfet_01v8 L=0.15U W=0.42U AS=0.0567P
+ AD=0.1092P PS=0.69U PD=1.36U
* device instance $885 r0 *1 34.95,45.795 sky130_fd_pr__nfet_01v8
M$885 828 795 766 766 sky130_fd_pr__nfet_01v8 L=0.15U W=0.42U AS=0.1092P
+ AD=0.0441P PS=1.36U PD=0.63U
* device instance $886 r0 *1 35.31,45.795 sky130_fd_pr__nfet_01v8
M$886 97 94 828 828 sky130_fd_pr__nfet_01v8 L=0.15U W=0.42U AS=0.0441P
+ AD=0.1092P PS=0.63U PD=1.36U
* device instance $887 r0 *1 35.225,46.685 sky130_fd_pr__nfet_01v8
M$887 97 843 840 840 sky130_fd_pr__nfet_01v8 L=0.15U W=0.42U AS=0.1092P
+ AD=0.10025P PS=1.36U PD=0.985U
* device instance $888 r0 *1 35.71,46.8 sky130_fd_pr__nfet_01v8
M$888 597 843 97 97 sky130_fd_pr__nfet_01v8 L=0.15U W=0.65U AS=0.10025P
+ AD=0.182P PS=0.985U PD=1.86U
* device instance $889 r0 *1 36.25,45.795 sky130_fd_pr__nfet_01v8
M$889 97 94 767 767 sky130_fd_pr__nfet_01v8 L=0.15U W=0.42U AS=0.1092P
+ AD=0.0609P PS=1.36U PD=0.71U
* device instance $890 r0 *1 36.69,45.795 sky130_fd_pr__nfet_01v8
M$890 830 767 97 97 sky130_fd_pr__nfet_01v8 L=0.15U W=0.42U AS=0.0609P
+ AD=0.0756P PS=0.71U PD=0.78U
* device instance $891 r0 *1 37.2,45.795 sky130_fd_pr__nfet_01v8
M$891 766 771 830 830 sky130_fd_pr__nfet_01v8 L=0.15U W=0.42U AS=0.0756P
+ AD=0.1446P PS=0.78U PD=1.18U
* device instance $892 r0 *1 38.11,45.825 sky130_fd_pr__nfet_01v8
M$892 768 764 766 766 sky130_fd_pr__nfet_01v8 L=0.15U W=0.36U AS=0.1446P
+ AD=0.0522P PS=1.18U PD=0.65U
* device instance $893 r0 *1 38.55,45.825 sky130_fd_pr__nfet_01v8
M$893 768 765 831 831 sky130_fd_pr__nfet_01v8 L=0.15U W=0.36U AS=0.0759P
+ AD=0.0522P PS=0.8U PD=0.65U
* device instance $894 r0 *1 39.08,45.795 sky130_fd_pr__nfet_01v8
M$894 831 769 97 97 sky130_fd_pr__nfet_01v8 L=0.15U W=0.42U AS=0.12095P
+ AD=0.0759P PS=1.085U PD=0.8U
* device instance $895 r0 *1 39.675,45.685 sky130_fd_pr__nfet_01v8
M$895 769 768 97 97 sky130_fd_pr__nfet_01v8 L=0.15U W=0.64U AS=0.12095P
+ AD=0.1664P PS=1.085U PD=1.8U
* device instance $896 r0 *1 40.615,45.795 sky130_fd_pr__nfet_01v8
M$896 829 769 97 97 sky130_fd_pr__nfet_01v8 L=0.15U W=0.42U AS=0.1092P
+ AD=0.0678P PS=1.36U PD=0.755U
* device instance $897 r0 *1 41.1,45.825 sky130_fd_pr__nfet_01v8
M$897 770 765 829 829 sky130_fd_pr__nfet_01v8 L=0.15U W=0.36U AS=0.0678P
+ AD=0.0684P PS=0.755U PD=0.74U
* device instance $898 r0 *1 41.63,45.825 sky130_fd_pr__nfet_01v8
M$898 770 764 827 827 sky130_fd_pr__nfet_01v8 L=0.15U W=0.36U AS=0.066P
+ AD=0.0684P PS=0.745U PD=0.74U
* device instance $899 r0 *1 42.105,45.795 sky130_fd_pr__nfet_01v8
M$899 97 771 827 827 sky130_fd_pr__nfet_01v8 L=0.15U W=0.42U AS=0.066P
+ AD=0.1092P PS=0.745U PD=1.36U
* device instance $900 r0 *1 40.98,46.685 sky130_fd_pr__nfet_01v8
M$900 97 776 844 844 sky130_fd_pr__nfet_01v8 L=0.15U W=0.42U AS=0.1113P
+ AD=0.0588P PS=1.37U PD=0.7U
* device instance $901 r0 *1 41.41,46.685 sky130_fd_pr__nfet_01v8
M$901 844 64 97 97 sky130_fd_pr__nfet_01v8 L=0.15U W=0.42U AS=0.0588P
+ AD=0.0588P PS=0.7U PD=0.7U
* device instance $902 r0 *1 41.84,46.685 sky130_fd_pr__nfet_01v8
M$902 795 845 844 844 sky130_fd_pr__nfet_01v8 L=0.15U W=0.42U AS=0.0588P
+ AD=0.1113P PS=0.7U PD=1.37U
* device instance $903 r0 *1 43.045,45.795 sky130_fd_pr__nfet_01v8
M$903 771 770 97 97 sky130_fd_pr__nfet_01v8 L=0.15U W=0.42U AS=0.10025P
+ AD=0.1092P PS=0.985U PD=1.36U
* device instance $904 r0 *1 43.53,45.68 sky130_fd_pr__nfet_01v8
M$904 728 770 97 97 sky130_fd_pr__nfet_01v8 L=0.15U W=0.65U AS=0.10025P
+ AD=0.182P PS=0.985U PD=1.86U
* device instance $905 r0 *1 44.63,46.685 sky130_fd_pr__nfet_01v8
M$905 97 979 846 846 sky130_fd_pr__nfet_01v8 L=0.15U W=0.42U AS=0.1092P
+ AD=0.0567P PS=1.36U PD=0.69U
* device instance $906 r0 *1 45.05,46.685 sky130_fd_pr__nfet_01v8
M$906 871 846 97 97 sky130_fd_pr__nfet_01v8 L=0.15U W=0.42U AS=0.0567P
+ AD=0.1092P PS=0.69U PD=1.36U
* device instance $907 r0 *1 44.63,45.68 sky130_fd_pr__nfet_01v8
M$907 97 796 772 772 sky130_fd_pr__nfet_01v8 L=0.15U W=0.65U AS=0.169P
+ AD=0.10725P PS=1.82U PD=0.98U
* device instance $908 r0 *1 45.11,45.68 sky130_fd_pr__nfet_01v8
M$908 826 728 97 97 sky130_fd_pr__nfet_01v8 L=0.15U W=0.65U AS=0.10725P
+ AD=0.06825P PS=0.98U PD=0.86U
* device instance $909 r0 *1 45.47,45.68 sky130_fd_pr__nfet_01v8
M$909 772 92 826 826 sky130_fd_pr__nfet_01v8 L=0.15U W=0.65U AS=0.06825P
+ AD=0.169P PS=0.86U PD=1.82U
* device instance $910 r0 *1 45.99,46.685 sky130_fd_pr__nfet_01v8
M$910 862 774 847 847 sky130_fd_pr__nfet_01v8 L=0.15U W=0.42U AS=0.1092P
+ AD=0.0441P PS=1.36U PD=0.63U
* device instance $911 r0 *1 46.35,46.685 sky130_fd_pr__nfet_01v8
M$911 97 302 862 862 sky130_fd_pr__nfet_01v8 L=0.15U W=0.42U AS=0.0441P
+ AD=0.1092P PS=0.63U PD=1.36U
* device instance $912 r0 *1 46.41,45.68 sky130_fd_pr__nfet_01v8
M$912 825 135 772 772 sky130_fd_pr__nfet_01v8 L=0.15U W=0.65U AS=0.169P
+ AD=0.10725P PS=1.82U PD=0.98U
* device instance $913 r0 *1 46.89,45.68 sky130_fd_pr__nfet_01v8
M$913 97 735 825 825 sky130_fd_pr__nfet_01v8 L=0.15U W=0.65U AS=0.10725P
+ AD=0.102375P PS=0.98U PD=0.965U
* device instance $914 r0 *1 47.355,45.68 sky130_fd_pr__nfet_01v8
M$914 774 772 97 97 sky130_fd_pr__nfet_01v8 L=0.15U W=0.65U AS=0.102375P
+ AD=0.169P PS=0.965U PD=1.82U
* device instance $915 r0 *1 49.15,46.655 sky130_fd_pr__nfet_01v8
M$915 850 846 847 847 sky130_fd_pr__nfet_01v8 L=0.15U W=0.36U AS=0.1446P
+ AD=0.0522P PS=1.18U PD=0.65U
* device instance $916 r0 *1 49.59,46.655 sky130_fd_pr__nfet_01v8
M$916 864 871 850 850 sky130_fd_pr__nfet_01v8 L=0.15U W=0.36U AS=0.0522P
+ AD=0.0759P PS=0.65U PD=0.8U
* device instance $917 r0 *1 47.29,46.685 sky130_fd_pr__nfet_01v8
M$917 97 302 848 848 sky130_fd_pr__nfet_01v8 L=0.15U W=0.42U AS=0.1092P
+ AD=0.0609P PS=1.36U PD=0.71U
* device instance $918 r0 *1 47.73,46.685 sky130_fd_pr__nfet_01v8
M$918 863 848 97 97 sky130_fd_pr__nfet_01v8 L=0.15U W=0.42U AS=0.0609P
+ AD=0.0756P PS=0.71U PD=0.78U
* device instance $919 r0 *1 48.24,46.685 sky130_fd_pr__nfet_01v8
M$919 847 849 863 863 sky130_fd_pr__nfet_01v8 L=0.15U W=0.42U AS=0.0756P
+ AD=0.1446P PS=0.78U PD=1.18U
* device instance $920 r0 *1 50.12,46.685 sky130_fd_pr__nfet_01v8
M$920 97 851 864 864 sky130_fd_pr__nfet_01v8 L=0.15U W=0.42U AS=0.0759P
+ AD=0.12095P PS=0.8U PD=1.085U
* device instance $921 r0 *1 50.715,46.795 sky130_fd_pr__nfet_01v8
M$921 851 850 97 97 sky130_fd_pr__nfet_01v8 L=0.15U W=0.64U AS=0.12095P
+ AD=0.1664P PS=1.085U PD=1.8U
* device instance $922 r0 *1 48.725,45.795 sky130_fd_pr__nfet_01v8
M$922 97 797 776 776 sky130_fd_pr__nfet_01v8 L=0.15U W=0.42U AS=0.1092P
+ AD=0.1197P PS=1.36U PD=1.41U
* device instance $923 r0 *1 49.69,45.68 sky130_fd_pr__nfet_01v8
M$923 662 776 97 97 sky130_fd_pr__nfet_01v8 L=0.15U W=0.65U AS=0.169P
+ AD=0.08775P PS=1.82U PD=0.92U
* device instance $924 r0 *1 50.11,45.68 sky130_fd_pr__nfet_01v8
M$924 97 728 662 662 sky130_fd_pr__nfet_01v8 L=0.15U W=0.65U AS=0.08775P
+ AD=0.169P PS=0.92U PD=1.82U
* device instance $925 r0 *1 51.305,45.795 sky130_fd_pr__nfet_01v8
M$925 798 728 97 97 sky130_fd_pr__nfet_01v8 L=0.15U W=0.42U AS=0.10025P
+ AD=0.1092P PS=0.985U PD=1.36U
* device instance $926 r0 *1 51.79,45.68 sky130_fd_pr__nfet_01v8
M$926 799 797 97 97 sky130_fd_pr__nfet_01v8 L=0.15U W=0.65U AS=0.10025P
+ AD=0.08775P PS=0.985U PD=0.92U
* device instance $927 r0 *1 52.21,45.68 sky130_fd_pr__nfet_01v8
M$927 97 798 799 799 sky130_fd_pr__nfet_01v8 L=0.15U W=0.65U AS=0.08775P
+ AD=0.169P PS=0.92U PD=1.82U
* device instance $928 r0 *1 52.14,46.655 sky130_fd_pr__nfet_01v8
M$928 852 871 865 865 sky130_fd_pr__nfet_01v8 L=0.15U W=0.36U AS=0.0678P
+ AD=0.0684P PS=0.755U PD=0.74U
* device instance $929 r0 *1 52.67,46.655 sky130_fd_pr__nfet_01v8
M$929 866 846 852 852 sky130_fd_pr__nfet_01v8 L=0.15U W=0.36U AS=0.0684P
+ AD=0.066P PS=0.74U PD=0.745U
* device instance $930 r0 *1 51.655,46.685 sky130_fd_pr__nfet_01v8
M$930 865 851 97 97 sky130_fd_pr__nfet_01v8 L=0.15U W=0.42U AS=0.1092P
+ AD=0.0678P PS=1.36U PD=0.755U
* device instance $931 r0 *1 53.145,46.685 sky130_fd_pr__nfet_01v8
M$931 97 849 866 866 sky130_fd_pr__nfet_01v8 L=0.15U W=0.42U AS=0.066P
+ AD=0.1092P PS=0.745U PD=1.36U
* device instance $932 r0 *1 54.085,46.685 sky130_fd_pr__nfet_01v8
M$932 97 852 849 849 sky130_fd_pr__nfet_01v8 L=0.15U W=0.42U AS=0.1092P
+ AD=0.10025P PS=1.36U PD=0.985U
* device instance $933 r0 *1 54.57,46.8 sky130_fd_pr__nfet_01v8
M$933 797 852 97 97 sky130_fd_pr__nfet_01v8 L=0.15U W=0.65U AS=0.10025P
+ AD=0.182P PS=0.985U PD=1.86U
* device instance $934 r0 *1 56.59,45.68 sky130_fd_pr__nfet_01v8
M$934 729 799 97 97 sky130_fd_pr__nfet_01v8 L=0.15U W=0.65U AS=0.169P
+ AD=0.08775P PS=1.82U PD=0.92U
* device instance $935 r0 *1 57.01,45.68 sky130_fd_pr__nfet_01v8
M$935 97 662 729 729 sky130_fd_pr__nfet_01v8 L=0.15U W=0.65U AS=0.08775P
+ AD=0.169P PS=0.92U PD=1.82U
* device instance $936 r0 *1 61.19,45.68 sky130_fd_pr__nfet_01v8
M$936 700 568 97 97 sky130_fd_pr__nfet_01v8 L=0.15U W=0.65U AS=0.169P
+ AD=0.08775P PS=1.82U PD=0.92U
* device instance $937 r0 *1 61.61,45.68 sky130_fd_pr__nfet_01v8
M$937 97 985 700 700 sky130_fd_pr__nfet_01v8 L=0.15U W=0.65U AS=0.08775P
+ AD=0.169P PS=0.92U PD=1.82U
* device instance $938 r0 *1 61.65,46.8 sky130_fd_pr__nfet_01v8
M$938 97 641 853 853 sky130_fd_pr__nfet_01v8 L=0.15U W=0.65U AS=0.169P
+ AD=0.08775P PS=1.82U PD=0.92U
* device instance $939 r0 *1 62.07,46.8 sky130_fd_pr__nfet_01v8
M$939 854 853 97 97 sky130_fd_pr__nfet_01v8 L=0.15U W=2.6U AS=0.351P
+ AD=0.43225P PS=3.68U PD=4.58U
* device instance $943 r0 *1 64.87,45.795 sky130_fd_pr__nfet_01v8
M$943 97 979 777 777 sky130_fd_pr__nfet_01v8 L=0.15U W=0.42U AS=0.1092P
+ AD=0.0567P PS=1.36U PD=0.69U
* device instance $944 r0 *1 65.29,45.795 sky130_fd_pr__nfet_01v8
M$944 778 777 97 97 sky130_fd_pr__nfet_01v8 L=0.15U W=0.42U AS=0.0567P
+ AD=0.1092P PS=0.69U PD=1.36U
* device instance $945 r0 *1 66.23,45.795 sky130_fd_pr__nfet_01v8
M$945 819 643 779 779 sky130_fd_pr__nfet_01v8 L=0.15U W=0.42U AS=0.1092P
+ AD=0.0441P PS=1.36U PD=0.63U
* device instance $946 r0 *1 66.59,45.795 sky130_fd_pr__nfet_01v8
M$946 97 409 819 819 sky130_fd_pr__nfet_01v8 L=0.15U W=0.42U AS=0.0441P
+ AD=0.1092P PS=0.63U PD=1.36U
* device instance $947 r0 *1 67.53,45.795 sky130_fd_pr__nfet_01v8
M$947 97 409 780 780 sky130_fd_pr__nfet_01v8 L=0.15U W=0.42U AS=0.1092P
+ AD=0.0609P PS=1.36U PD=0.71U
* device instance $948 r0 *1 67.97,45.795 sky130_fd_pr__nfet_01v8
M$948 817 780 97 97 sky130_fd_pr__nfet_01v8 L=0.15U W=0.42U AS=0.0609P
+ AD=0.0756P PS=0.71U PD=0.78U
* device instance $949 r0 *1 68.48,45.795 sky130_fd_pr__nfet_01v8
M$949 779 784 817 817 sky130_fd_pr__nfet_01v8 L=0.15U W=0.42U AS=0.0756P
+ AD=0.1446P PS=0.78U PD=1.18U
* device instance $950 r0 *1 69.39,45.825 sky130_fd_pr__nfet_01v8
M$950 781 777 779 779 sky130_fd_pr__nfet_01v8 L=0.15U W=0.36U AS=0.1446P
+ AD=0.0522P PS=1.18U PD=0.65U
* device instance $951 r0 *1 69.83,45.825 sky130_fd_pr__nfet_01v8
M$951 781 778 815 815 sky130_fd_pr__nfet_01v8 L=0.15U W=0.36U AS=0.0759P
+ AD=0.0522P PS=0.8U PD=0.65U
* device instance $952 r0 *1 70.36,45.795 sky130_fd_pr__nfet_01v8
M$952 815 782 97 97 sky130_fd_pr__nfet_01v8 L=0.15U W=0.42U AS=0.12095P
+ AD=0.0759P PS=1.085U PD=0.8U
* device instance $953 r0 *1 70.955,45.685 sky130_fd_pr__nfet_01v8
M$953 782 781 97 97 sky130_fd_pr__nfet_01v8 L=0.15U W=0.64U AS=0.12095P
+ AD=0.1664P PS=1.085U PD=1.8U
* device instance $954 r0 *1 71.895,45.795 sky130_fd_pr__nfet_01v8
M$954 814 782 97 97 sky130_fd_pr__nfet_01v8 L=0.15U W=0.42U AS=0.1092P
+ AD=0.0678P PS=1.36U PD=0.755U
* device instance $955 r0 *1 72.38,45.825 sky130_fd_pr__nfet_01v8
M$955 783 778 814 814 sky130_fd_pr__nfet_01v8 L=0.15U W=0.36U AS=0.0678P
+ AD=0.0684P PS=0.755U PD=0.74U
* device instance $956 r0 *1 72.91,45.825 sky130_fd_pr__nfet_01v8
M$956 783 777 813 813 sky130_fd_pr__nfet_01v8 L=0.15U W=0.36U AS=0.066P
+ AD=0.0684P PS=0.745U PD=0.74U
* device instance $957 r0 *1 73.385,45.795 sky130_fd_pr__nfet_01v8
M$957 97 784 813 813 sky130_fd_pr__nfet_01v8 L=0.15U W=0.42U AS=0.066P
+ AD=0.1092P PS=0.745U PD=1.36U
* device instance $958 r0 *1 74.325,45.795 sky130_fd_pr__nfet_01v8
M$958 784 783 97 97 sky130_fd_pr__nfet_01v8 L=0.15U W=0.42U AS=0.10025P
+ AD=0.1092P PS=0.985U PD=1.36U
* device instance $959 r0 *1 74.81,45.68 sky130_fd_pr__nfet_01v8
M$959 568 783 97 97 sky130_fd_pr__nfet_01v8 L=0.15U W=0.65U AS=0.10025P
+ AD=0.182P PS=0.985U PD=1.86U
* device instance $960 r0 *1 2.77,52.125 sky130_fd_pr__nfet_01v8
M$960 97 681 930 930 sky130_fd_pr__nfet_01v8 L=0.15U W=0.42U AS=0.1092P
+ AD=0.0567P PS=1.36U PD=0.69U
* device instance $961 r0 *1 3.19,52.125 sky130_fd_pr__nfet_01v8
M$961 931 930 97 97 sky130_fd_pr__nfet_01v8 L=0.15U W=0.42U AS=0.0567P
+ AD=0.1092P PS=0.69U PD=1.36U
* device instance $962 r0 *1 4.13,52.125 sky130_fd_pr__nfet_01v8
M$962 948 888 932 932 sky130_fd_pr__nfet_01v8 L=0.15U W=0.42U AS=0.1092P
+ AD=0.0441P PS=1.36U PD=0.63U
* device instance $963 r0 *1 4.49,52.125 sky130_fd_pr__nfet_01v8
M$963 97 94 948 948 sky130_fd_pr__nfet_01v8 L=0.15U W=0.42U AS=0.0441P
+ AD=0.1092P PS=0.63U PD=1.36U
* device instance $964 r0 *1 4.68,51.235 sky130_fd_pr__nfet_01v8
M$964 920 886 887 887 sky130_fd_pr__nfet_01v8 L=0.15U W=0.42U AS=0.1113P
+ AD=0.0441P PS=1.37U PD=0.63U
* device instance $965 r0 *1 5.04,51.235 sky130_fd_pr__nfet_01v8
M$965 97 115 920 920 sky130_fd_pr__nfet_01v8 L=0.15U W=0.42U AS=0.0441P
+ AD=0.0966P PS=0.63U PD=0.88U
* device instance $966 r0 *1 5.65,51.235 sky130_fd_pr__nfet_01v8
M$966 867 887 97 97 sky130_fd_pr__nfet_01v8 L=0.15U W=0.42U AS=0.0966P
+ AD=0.1113P PS=0.88U PD=1.37U
* device instance $967 r0 *1 7.29,52.095 sky130_fd_pr__nfet_01v8
M$967 935 930 932 932 sky130_fd_pr__nfet_01v8 L=0.15U W=0.36U AS=0.1446P
+ AD=0.0522P PS=1.18U PD=0.65U
* device instance $968 r0 *1 7.73,52.095 sky130_fd_pr__nfet_01v8
M$968 950 931 935 935 sky130_fd_pr__nfet_01v8 L=0.15U W=0.36U AS=0.0522P
+ AD=0.0759P PS=0.65U PD=0.8U
* device instance $969 r0 *1 5.43,52.125 sky130_fd_pr__nfet_01v8
M$969 97 94 933 933 sky130_fd_pr__nfet_01v8 L=0.15U W=0.42U AS=0.1092P
+ AD=0.0609P PS=1.36U PD=0.71U
* device instance $970 r0 *1 5.87,52.125 sky130_fd_pr__nfet_01v8
M$970 949 933 97 97 sky130_fd_pr__nfet_01v8 L=0.15U W=0.42U AS=0.0609P
+ AD=0.0756P PS=0.71U PD=0.78U
* device instance $971 r0 *1 6.38,52.125 sky130_fd_pr__nfet_01v8
M$971 932 934 949 949 sky130_fd_pr__nfet_01v8 L=0.15U W=0.42U AS=0.0756P
+ AD=0.1446P PS=0.78U PD=1.18U
* device instance $972 r0 *1 8.26,52.125 sky130_fd_pr__nfet_01v8
M$972 97 936 950 950 sky130_fd_pr__nfet_01v8 L=0.15U W=0.42U AS=0.0759P
+ AD=0.12095P PS=0.8U PD=1.085U
* device instance $973 r0 *1 8.855,52.235 sky130_fd_pr__nfet_01v8
M$973 936 935 97 97 sky130_fd_pr__nfet_01v8 L=0.15U W=0.64U AS=0.12095P
+ AD=0.1664P PS=1.085U PD=1.8U
* device instance $974 r0 *1 6.91,51.12 sky130_fd_pr__nfet_01v8
M$974 97 889 888 888 sky130_fd_pr__nfet_01v8 L=0.15U W=0.65U AS=0.169P
+ AD=0.11285P PS=1.82U PD=1.045U
* device instance $975 r0 *1 7.455,51.235 sky130_fd_pr__nfet_01v8
M$975 921 64 97 97 sky130_fd_pr__nfet_01v8 L=0.15U W=0.42U AS=0.11285P
+ AD=0.0693P PS=1.045U PD=0.75U
* device instance $976 r0 *1 7.935,51.235 sky130_fd_pr__nfet_01v8
M$976 889 915 921 921 sky130_fd_pr__nfet_01v8 L=0.15U W=0.42U AS=0.0693P
+ AD=0.09975P PS=0.75U PD=0.895U
* device instance $977 r0 *1 8.56,51.235 sky130_fd_pr__nfet_01v8
M$977 922 916 889 889 sky130_fd_pr__nfet_01v8 L=0.15U W=0.42U AS=0.09975P
+ AD=0.0693P PS=0.895U PD=0.75U
* device instance $978 r0 *1 9.04,51.235 sky130_fd_pr__nfet_01v8
M$978 97 917 922 922 sky130_fd_pr__nfet_01v8 L=0.15U W=0.42U AS=0.0693P
+ AD=0.1449P PS=0.75U PD=1.11U
* device instance $979 r0 *1 9.88,51.235 sky130_fd_pr__nfet_01v8
M$979 917 64 97 97 sky130_fd_pr__nfet_01v8 L=0.15U W=0.42U AS=0.1449P
+ AD=0.1092P PS=1.11U PD=1.36U
* device instance $980 r0 *1 10.28,52.095 sky130_fd_pr__nfet_01v8
M$980 937 931 951 951 sky130_fd_pr__nfet_01v8 L=0.15U W=0.36U AS=0.0678P
+ AD=0.0684P PS=0.755U PD=0.74U
* device instance $981 r0 *1 10.81,52.095 sky130_fd_pr__nfet_01v8
M$981 952 930 937 937 sky130_fd_pr__nfet_01v8 L=0.15U W=0.36U AS=0.0684P
+ AD=0.066P PS=0.74U PD=0.745U
* device instance $982 r0 *1 9.795,52.125 sky130_fd_pr__nfet_01v8
M$982 951 936 97 97 sky130_fd_pr__nfet_01v8 L=0.15U W=0.42U AS=0.1092P
+ AD=0.0678P PS=1.36U PD=0.755U
* device instance $983 r0 *1 11.285,52.125 sky130_fd_pr__nfet_01v8
M$983 97 934 952 952 sky130_fd_pr__nfet_01v8 L=0.15U W=0.42U AS=0.066P
+ AD=0.1092P PS=0.745U PD=1.36U
* device instance $984 r0 *1 11.09,51.12 sky130_fd_pr__nfet_01v8
M$984 890 833 97 97 sky130_fd_pr__nfet_01v8 L=0.15U W=0.65U AS=0.169P
+ AD=0.08775P PS=1.82U PD=0.92U
* device instance $985 r0 *1 11.51,51.12 sky130_fd_pr__nfet_01v8
M$985 97 916 890 890 sky130_fd_pr__nfet_01v8 L=0.15U W=0.65U AS=0.08775P
+ AD=0.08775P PS=0.92U PD=0.92U
* device instance $986 r0 *1 11.93,51.12 sky130_fd_pr__nfet_01v8
M$986 924 916 97 97 sky130_fd_pr__nfet_01v8 L=0.15U W=0.65U AS=0.08775P
+ AD=0.08775P PS=0.92U PD=0.92U
* device instance $987 r0 *1 12.35,51.12 sky130_fd_pr__nfet_01v8
M$987 868 833 924 924 sky130_fd_pr__nfet_01v8 L=0.15U W=0.65U AS=0.08775P
+ AD=0.25025P PS=0.92U PD=1.42U
* device instance $988 r0 *1 13.27,51.12 sky130_fd_pr__nfet_01v8
M$988 97 890 868 868 sky130_fd_pr__nfet_01v8 L=0.15U W=0.65U AS=0.25025P
+ AD=0.208P PS=1.42U PD=1.94U
* device instance $989 r0 *1 12.225,52.125 sky130_fd_pr__nfet_01v8
M$989 97 937 934 934 sky130_fd_pr__nfet_01v8 L=0.15U W=0.42U AS=0.1092P
+ AD=0.10025P PS=1.36U PD=0.985U
* device instance $990 r0 *1 12.71,52.24 sky130_fd_pr__nfet_01v8
M$990 836 937 97 97 sky130_fd_pr__nfet_01v8 L=0.15U W=0.65U AS=0.10025P
+ AD=0.182P PS=0.985U PD=1.86U
* device instance $991 r0 *1 13.81,52.24 sky130_fd_pr__nfet_01v8
M$991 97 869 938 938 sky130_fd_pr__nfet_01v8 L=0.15U W=0.65U AS=0.169P
+ AD=0.08775P PS=1.82U PD=0.92U
* device instance $992 r0 *1 14.23,52.24 sky130_fd_pr__nfet_01v8
M$992 916 938 97 97 sky130_fd_pr__nfet_01v8 L=0.15U W=2.6U AS=0.351P
+ AD=0.43225P PS=3.68U PD=4.58U
* device instance $996 r0 *1 17.03,52.24 sky130_fd_pr__nfet_01v8
M$996 97 836 939 939 sky130_fd_pr__nfet_01v8 L=0.15U W=0.65U AS=0.169P
+ AD=0.08775P PS=1.82U PD=0.92U
* device instance $997 r0 *1 17.45,52.24 sky130_fd_pr__nfet_01v8
M$997 833 939 97 97 sky130_fd_pr__nfet_01v8 L=0.15U W=2.6U AS=0.351P
+ AD=0.43225P PS=3.68U PD=4.58U
* device instance $1001 r0 *1 21.19,51.12 sky130_fd_pr__nfet_01v8
M$1001 918 833 97 97 sky130_fd_pr__nfet_01v8 L=0.15U W=2.6U AS=0.44525P
+ AD=0.351P PS=4.62U PD=3.68U
* device instance $1005 r0 *1 22.87,51.12 sky130_fd_pr__nfet_01v8
M$1005 918 893 97 97 sky130_fd_pr__nfet_01v8 L=0.15U W=2.6U AS=0.351P AD=0.52P
+ PS=3.68U PD=4.2U
* device instance $1009 r0 *1 25.07,51.12 sky130_fd_pr__nfet_01v8
M$1009 918 896 97 97 sky130_fd_pr__nfet_01v8 L=0.15U W=2.6U AS=0.52P AD=0.351P
+ PS=4.2U PD=3.68U
* device instance $1013 r0 *1 26.75,51.12 sky130_fd_pr__nfet_01v8
M$1013 918 362 97 97 sky130_fd_pr__nfet_01v8 L=0.15U W=2.6U AS=0.351P
+ AD=0.43225P PS=3.68U PD=4.58U
* device instance $1017 r0 *1 23.935,52.125 sky130_fd_pr__nfet_01v8
M$1017 940 297 97 97 sky130_fd_pr__nfet_01v8 L=0.15U W=1.68U AS=0.2877P
+ AD=0.2352P PS=3.47U PD=2.8U
* device instance $1021 r0 *1 25.655,52.125 sky130_fd_pr__nfet_01v8
M$1021 681 940 97 97 sky130_fd_pr__nfet_01v8 L=0.15U W=6.72U AS=0.93975P
+ AD=0.99225P PS=11.195U PD=11.865U
* device instance $1037 r0 *1 43.32,51.235 sky130_fd_pr__nfet_01v8
M$1037 929 897 898 898 sky130_fd_pr__nfet_01v8 L=0.15U W=0.42U AS=0.1113P
+ AD=0.0441P PS=1.37U PD=0.63U
* device instance $1038 r0 *1 43.68,51.235 sky130_fd_pr__nfet_01v8
M$1038 97 115 929 929 sky130_fd_pr__nfet_01v8 L=0.15U W=0.42U AS=0.0441P
+ AD=0.0966P PS=0.63U PD=0.88U
* device instance $1039 r0 *1 44.29,51.235 sky130_fd_pr__nfet_01v8
M$1039 796 898 97 97 sky130_fd_pr__nfet_01v8 L=0.15U W=0.42U AS=0.0966P
+ AD=0.1113P PS=0.88U PD=1.37U
* device instance $1040 r0 *1 56.13,52.24 sky130_fd_pr__nfet_01v8
M$1040 97 941 942 942 sky130_fd_pr__nfet_01v8 L=0.15U W=0.65U AS=0.169P
+ AD=0.08775P PS=1.82U PD=0.92U
* device instance $1041 r0 *1 56.55,52.24 sky130_fd_pr__nfet_01v8
M$1041 942 799 97 97 sky130_fd_pr__nfet_01v8 L=0.15U W=0.65U AS=0.08775P
+ AD=0.08775P PS=0.92U PD=0.92U
* device instance $1042 r0 *1 56.97,52.24 sky130_fd_pr__nfet_01v8
M$1042 97 980 942 942 sky130_fd_pr__nfet_01v8 L=0.15U W=0.65U AS=0.08775P
+ AD=0.26P PS=0.92U PD=1.45U
* device instance $1043 r0 *1 57.92,52.24 sky130_fd_pr__nfet_01v8
M$1043 943 942 97 97 sky130_fd_pr__nfet_01v8 L=0.15U W=2.6U AS=0.52325P
+ AD=0.468P PS=4.21U PD=4.69U
* device instance $1047 r0 *1 60.27,52.24 sky130_fd_pr__nfet_01v8
M$1047 97 854 944 944 sky130_fd_pr__nfet_01v8 L=0.15U W=0.65U AS=0.169P
+ AD=0.08775P PS=1.82U PD=0.92U
* device instance $1048 r0 *1 60.69,52.24 sky130_fd_pr__nfet_01v8
M$1048 941 944 97 97 sky130_fd_pr__nfet_01v8 L=0.15U W=2.6U AS=0.351P
+ AD=0.43225P PS=3.68U PD=4.58U
* device instance $1052 r0 *1 64.87,51.235 sky130_fd_pr__nfet_01v8
M$1052 97 979 899 899 sky130_fd_pr__nfet_01v8 L=0.15U W=0.42U AS=0.1092P
+ AD=0.0567P PS=1.36U PD=0.69U
* device instance $1053 r0 *1 65.29,51.235 sky130_fd_pr__nfet_01v8
M$1053 900 899 97 97 sky130_fd_pr__nfet_01v8 L=0.15U W=0.42U AS=0.0567P
+ AD=0.1092P PS=0.69U PD=1.36U
* device instance $1054 r0 *1 66.23,51.235 sky130_fd_pr__nfet_01v8
M$1054 928 902 901 901 sky130_fd_pr__nfet_01v8 L=0.15U W=0.42U AS=0.1092P
+ AD=0.0441P PS=1.36U PD=0.63U
* device instance $1055 r0 *1 66.59,51.235 sky130_fd_pr__nfet_01v8
M$1055 97 409 928 928 sky130_fd_pr__nfet_01v8 L=0.15U W=0.42U AS=0.0441P
+ AD=0.1092P PS=0.63U PD=1.36U
* device instance $1056 r0 *1 67.53,51.235 sky130_fd_pr__nfet_01v8
M$1056 97 409 903 903 sky130_fd_pr__nfet_01v8 L=0.15U W=0.42U AS=0.1092P
+ AD=0.0609P PS=1.36U PD=0.71U
* device instance $1057 r0 *1 67.97,51.235 sky130_fd_pr__nfet_01v8
M$1057 927 903 97 97 sky130_fd_pr__nfet_01v8 L=0.15U W=0.42U AS=0.0609P
+ AD=0.0756P PS=0.71U PD=0.78U
* device instance $1058 r0 *1 68.48,51.235 sky130_fd_pr__nfet_01v8
M$1058 901 907 927 927 sky130_fd_pr__nfet_01v8 L=0.15U W=0.42U AS=0.0756P
+ AD=0.1446P PS=0.78U PD=1.18U
* device instance $1059 r0 *1 69.39,51.265 sky130_fd_pr__nfet_01v8
M$1059 904 899 901 901 sky130_fd_pr__nfet_01v8 L=0.15U W=0.36U AS=0.1446P
+ AD=0.0522P PS=1.18U PD=0.65U
* device instance $1060 r0 *1 69.83,51.265 sky130_fd_pr__nfet_01v8
M$1060 904 900 926 926 sky130_fd_pr__nfet_01v8 L=0.15U W=0.36U AS=0.0759P
+ AD=0.0522P PS=0.8U PD=0.65U
* device instance $1061 r0 *1 70.36,51.235 sky130_fd_pr__nfet_01v8
M$1061 926 905 97 97 sky130_fd_pr__nfet_01v8 L=0.15U W=0.42U AS=0.12095P
+ AD=0.0759P PS=1.085U PD=0.8U
* device instance $1062 r0 *1 70.955,51.125 sky130_fd_pr__nfet_01v8
M$1062 905 904 97 97 sky130_fd_pr__nfet_01v8 L=0.15U W=0.64U AS=0.12095P
+ AD=0.1664P PS=1.085U PD=1.8U
* device instance $1063 r0 *1 68.175,52.125 sky130_fd_pr__nfet_01v8
M$1063 954 64 97 97 sky130_fd_pr__nfet_01v8 L=0.15U W=0.42U AS=0.11285P
+ AD=0.0693P PS=1.045U PD=0.75U
* device instance $1064 r0 *1 68.655,52.125 sky130_fd_pr__nfet_01v8
M$1064 945 946 954 954 sky130_fd_pr__nfet_01v8 L=0.15U W=0.42U AS=0.0693P
+ AD=0.09975P PS=0.75U PD=0.895U
* device instance $1065 r0 *1 69.28,52.125 sky130_fd_pr__nfet_01v8
M$1065 953 955 945 945 sky130_fd_pr__nfet_01v8 L=0.15U W=0.42U AS=0.09975P
+ AD=0.0693P PS=0.895U PD=0.75U
* device instance $1066 r0 *1 69.76,52.125 sky130_fd_pr__nfet_01v8
M$1066 97 947 953 953 sky130_fd_pr__nfet_01v8 L=0.15U W=0.42U AS=0.0693P
+ AD=0.1449P PS=0.75U PD=1.11U
* device instance $1067 r0 *1 70.6,52.125 sky130_fd_pr__nfet_01v8
M$1067 947 64 97 97 sky130_fd_pr__nfet_01v8 L=0.15U W=0.42U AS=0.1449P
+ AD=0.1092P PS=1.11U PD=1.36U
* device instance $1068 r0 *1 67.63,52.24 sky130_fd_pr__nfet_01v8
M$1068 97 945 902 902 sky130_fd_pr__nfet_01v8 L=0.15U W=0.65U AS=0.169P
+ AD=0.11285P PS=1.82U PD=1.045U
* device instance $1069 r0 *1 71.895,51.235 sky130_fd_pr__nfet_01v8
M$1069 925 905 97 97 sky130_fd_pr__nfet_01v8 L=0.15U W=0.42U AS=0.1092P
+ AD=0.0678P PS=1.36U PD=0.755U
* device instance $1070 r0 *1 72.38,51.265 sky130_fd_pr__nfet_01v8
M$1070 906 900 925 925 sky130_fd_pr__nfet_01v8 L=0.15U W=0.36U AS=0.0678P
+ AD=0.0684P PS=0.755U PD=0.74U
* device instance $1071 r0 *1 72.91,51.265 sky130_fd_pr__nfet_01v8
M$1071 906 899 923 923 sky130_fd_pr__nfet_01v8 L=0.15U W=0.36U AS=0.066P
+ AD=0.0684P PS=0.745U PD=0.74U
* device instance $1072 r0 *1 73.385,51.235 sky130_fd_pr__nfet_01v8
M$1072 97 907 923 923 sky130_fd_pr__nfet_01v8 L=0.15U W=0.42U AS=0.066P
+ AD=0.1092P PS=0.745U PD=1.36U
* device instance $1073 r0 *1 74.325,51.235 sky130_fd_pr__nfet_01v8
M$1073 907 906 97 97 sky130_fd_pr__nfet_01v8 L=0.15U W=0.42U AS=0.10025P
+ AD=0.1092P PS=0.985U PD=1.36U
* device instance $1074 r0 *1 74.81,51.12 sky130_fd_pr__nfet_01v8
M$1074 985 906 97 97 sky130_fd_pr__nfet_01v8 L=0.15U W=0.65U AS=0.10025P
+ AD=0.182P PS=0.985U PD=1.86U
* device instance $1075 r0 *1 9.21,56.675 sky130_fd_pr__nfet_01v8
M$1075 97 681 965 965 sky130_fd_pr__nfet_01v8 L=0.15U W=0.42U AS=0.1092P
+ AD=0.0567P PS=1.36U PD=0.69U
* device instance $1076 r0 *1 9.63,56.675 sky130_fd_pr__nfet_01v8
M$1076 966 965 97 97 sky130_fd_pr__nfet_01v8 L=0.15U W=0.42U AS=0.0567P
+ AD=0.1092P PS=0.69U PD=1.36U
* device instance $1077 r0 *1 10.57,56.675 sky130_fd_pr__nfet_01v8
M$1077 1004 873 967 967 sky130_fd_pr__nfet_01v8 L=0.15U W=0.42U AS=0.1092P
+ AD=0.0441P PS=1.36U PD=0.63U
* device instance $1078 r0 *1 10.93,56.675 sky130_fd_pr__nfet_01v8
M$1078 97 302 1004 1004 sky130_fd_pr__nfet_01v8 L=0.15U W=0.42U AS=0.0441P
+ AD=0.1092P PS=0.63U PD=1.36U
* device instance $1079 r0 *1 11.87,56.675 sky130_fd_pr__nfet_01v8
M$1079 97 302 968 968 sky130_fd_pr__nfet_01v8 L=0.15U W=0.42U AS=0.1092P
+ AD=0.0609P PS=1.36U PD=0.71U
* device instance $1080 r0 *1 12.31,56.675 sky130_fd_pr__nfet_01v8
M$1080 1005 968 97 97 sky130_fd_pr__nfet_01v8 L=0.15U W=0.42U AS=0.0609P
+ AD=0.0756P PS=0.71U PD=0.78U
* device instance $1081 r0 *1 12.82,56.675 sky130_fd_pr__nfet_01v8
M$1081 967 972 1005 1005 sky130_fd_pr__nfet_01v8 L=0.15U W=0.42U AS=0.0756P
+ AD=0.1446P PS=0.78U PD=1.18U
* device instance $1082 r0 *1 13.73,56.705 sky130_fd_pr__nfet_01v8
M$1082 969 965 967 967 sky130_fd_pr__nfet_01v8 L=0.15U W=0.36U AS=0.1446P
+ AD=0.0522P PS=1.18U PD=0.65U
* device instance $1083 r0 *1 14.17,56.705 sky130_fd_pr__nfet_01v8
M$1083 969 966 1006 1006 sky130_fd_pr__nfet_01v8 L=0.15U W=0.36U AS=0.0759P
+ AD=0.0522P PS=0.8U PD=0.65U
* device instance $1084 r0 *1 14.7,56.675 sky130_fd_pr__nfet_01v8
M$1084 1006 970 97 97 sky130_fd_pr__nfet_01v8 L=0.15U W=0.42U AS=0.12095P
+ AD=0.0759P PS=1.085U PD=0.8U
* device instance $1085 r0 *1 15.295,56.565 sky130_fd_pr__nfet_01v8
M$1085 970 969 97 97 sky130_fd_pr__nfet_01v8 L=0.15U W=0.64U AS=0.12095P
+ AD=0.1664P PS=1.085U PD=1.8U
* device instance $1086 r0 *1 16.235,56.675 sky130_fd_pr__nfet_01v8
M$1086 1008 970 97 97 sky130_fd_pr__nfet_01v8 L=0.15U W=0.42U AS=0.1092P
+ AD=0.0678P PS=1.36U PD=0.755U
* device instance $1087 r0 *1 16.72,56.705 sky130_fd_pr__nfet_01v8
M$1087 971 966 1008 1008 sky130_fd_pr__nfet_01v8 L=0.15U W=0.36U AS=0.0678P
+ AD=0.0684P PS=0.755U PD=0.74U
* device instance $1088 r0 *1 17.25,56.705 sky130_fd_pr__nfet_01v8
M$1088 971 965 1009 1009 sky130_fd_pr__nfet_01v8 L=0.15U W=0.36U AS=0.066P
+ AD=0.0684P PS=0.745U PD=0.74U
* device instance $1089 r0 *1 17.725,56.675 sky130_fd_pr__nfet_01v8
M$1089 97 972 1009 1009 sky130_fd_pr__nfet_01v8 L=0.15U W=0.42U AS=0.066P
+ AD=0.1092P PS=0.745U PD=1.36U
* device instance $1090 r0 *1 18.665,56.675 sky130_fd_pr__nfet_01v8
M$1090 972 971 97 97 sky130_fd_pr__nfet_01v8 L=0.15U W=0.42U AS=0.10025P
+ AD=0.1092P PS=0.985U PD=1.36U
* device instance $1091 r0 *1 19.15,56.56 sky130_fd_pr__nfet_01v8
M$1091 869 971 97 97 sky130_fd_pr__nfet_01v8 L=0.15U W=0.65U AS=0.10025P
+ AD=0.182P PS=0.985U PD=1.86U
* device instance $1092 r0 *1 28.305,56.675 sky130_fd_pr__nfet_01v8
M$1092 973 893 97 97 sky130_fd_pr__nfet_01v8 L=0.15U W=0.42U AS=0.10025P
+ AD=0.1092P PS=0.985U PD=1.36U
* device instance $1093 r0 *1 28.79,56.56 sky130_fd_pr__nfet_01v8
M$1093 976 993 97 97 sky130_fd_pr__nfet_01v8 L=0.15U W=0.65U AS=0.10025P
+ AD=0.08775P PS=0.985U PD=0.92U
* device instance $1094 r0 *1 29.21,56.56 sky130_fd_pr__nfet_01v8
M$1094 97 973 976 976 sky130_fd_pr__nfet_01v8 L=0.15U W=0.65U AS=0.08775P
+ AD=0.169P PS=0.92U PD=1.82U
* device instance $1095 r0 *1 30.85,56.56 sky130_fd_pr__nfet_01v8
M$1095 999 994 97 97 sky130_fd_pr__nfet_01v8 L=0.15U W=2.6U AS=0.44525P
+ AD=0.351P PS=4.62U PD=3.68U
* device instance $1099 r0 *1 32.53,56.56 sky130_fd_pr__nfet_01v8
M$1099 999 115 97 97 sky130_fd_pr__nfet_01v8 L=0.15U W=2.6U AS=0.351P
+ AD=0.43225P PS=3.68U PD=4.58U
* device instance $1102 r0 *1 33.79,56.56 sky130_fd_pr__nfet_01v8
M$1102 97 976 999 999 sky130_fd_pr__nfet_01v8 L=0.15U W=2.6U AS=0.351P
+ AD=0.351P PS=3.68U PD=3.68U
* device instance $1107 r0 *1 43.26,56.675 sky130_fd_pr__nfet_01v8
M$1107 977 979 97 97 sky130_fd_pr__nfet_01v8 L=0.15U W=0.84U AS=0.1701P
+ AD=0.168P PS=2.07U PD=2.06U
* device instance $1109 r0 *1 44.635,56.675 sky130_fd_pr__nfet_01v8
M$1109 978 297 97 97 sky130_fd_pr__nfet_01v8 L=0.15U W=1.68U AS=0.2877P
+ AD=0.2352P PS=3.47U PD=2.8U
* device instance $1113 r0 *1 46.355,56.675 sky130_fd_pr__nfet_01v8
M$1113 979 978 97 97 sky130_fd_pr__nfet_01v8 L=0.15U W=6.72U AS=0.93975P
+ AD=0.99225P PS=11.195U PD=11.865U
* device instance $1129 r0 *1 59.38,56.675 sky130_fd_pr__nfet_01v8
M$1129 97 799 1000 1000 sky130_fd_pr__nfet_01v8 L=0.15U W=0.42U AS=0.1113P
+ AD=0.0588P PS=1.37U PD=0.7U
* device instance $1130 r0 *1 59.81,56.675 sky130_fd_pr__nfet_01v8
M$1130 1000 941 97 97 sky130_fd_pr__nfet_01v8 L=0.15U W=0.42U AS=0.0588P
+ AD=0.0588P PS=0.7U PD=0.7U
* device instance $1131 r0 *1 60.24,56.675 sky130_fd_pr__nfet_01v8
M$1131 995 980 1000 1000 sky130_fd_pr__nfet_01v8 L=0.15U W=0.42U AS=0.0588P
+ AD=0.1113P PS=0.7U PD=1.37U
* device instance $1132 r0 *1 62.115,56.56 sky130_fd_pr__nfet_01v8
M$1132 1007 943 981 981 sky130_fd_pr__nfet_01v8 L=0.15U W=0.65U AS=0.17225P
+ AD=0.06825P PS=1.83U PD=0.86U
* device instance $1133 r0 *1 62.475,56.56 sky130_fd_pr__nfet_01v8
M$1133 97 995 1007 1007 sky130_fd_pr__nfet_01v8 L=0.15U W=0.65U AS=0.06825P
+ AD=0.138125P PS=0.86U PD=1.075U
* device instance $1134 r0 *1 63.05,56.56 sky130_fd_pr__nfet_01v8
M$1134 996 981 97 97 sky130_fd_pr__nfet_01v8 L=0.15U W=2.6U AS=0.411125P
+ AD=0.45825P PS=3.865U PD=4.66U
* device instance $1138 r0 *1 65.745,56.675 sky130_fd_pr__nfet_01v8
M$1138 97 986 980 980 sky130_fd_pr__nfet_01v8 L=0.15U W=0.42U AS=0.1092P
+ AD=0.1197P PS=1.36U PD=1.41U
* device instance $1139 r0 *1 66.71,56.445 sky130_fd_pr__nfet_01v8
M$1139 97 985 982 982 sky130_fd_pr__nfet_01v8 L=0.15U W=0.42U AS=0.1092P
+ AD=0.10025P PS=1.36U PD=0.985U
* device instance $1140 r0 *1 67.195,56.56 sky130_fd_pr__nfet_01v8
M$1140 1003 955 97 97 sky130_fd_pr__nfet_01v8 L=0.15U W=0.65U AS=0.10025P
+ AD=0.08775P PS=0.985U PD=0.92U
* device instance $1141 r0 *1 67.615,56.56 sky130_fd_pr__nfet_01v8
M$1141 983 982 1003 1003 sky130_fd_pr__nfet_01v8 L=0.15U W=0.65U AS=0.08775P
+ AD=0.169P PS=0.92U PD=1.82U
* device instance $1142 r0 *1 69.11,56.56 sky130_fd_pr__nfet_01v8
M$1142 1002 955 984 984 sky130_fd_pr__nfet_01v8 L=0.15U W=0.65U AS=0.169P
+ AD=0.06825P PS=1.82U PD=0.86U
* device instance $1143 r0 *1 69.47,56.56 sky130_fd_pr__nfet_01v8
M$1143 97 985 1002 1002 sky130_fd_pr__nfet_01v8 L=0.15U W=0.65U AS=0.06825P
+ AD=0.08775P PS=0.86U PD=0.92U
* device instance $1144 r0 *1 69.89,56.56 sky130_fd_pr__nfet_01v8
M$1144 1001 985 97 97 sky130_fd_pr__nfet_01v8 L=0.15U W=0.65U AS=0.08775P
+ AD=0.169P PS=0.92U PD=1.82U
* device instance $1145 r0 *1 70.83,56.56 sky130_fd_pr__nfet_01v8
M$1145 1001 955 97 97 sky130_fd_pr__nfet_01v8 L=0.15U W=0.65U AS=0.169P
+ AD=0.08775P PS=1.82U PD=0.92U
* device instance $1146 r0 *1 71.25,56.56 sky130_fd_pr__nfet_01v8
M$1146 986 984 1001 1001 sky130_fd_pr__nfet_01v8 L=0.15U W=0.65U AS=0.08775P
+ AD=0.195P PS=0.92U PD=1.9U
* device instance $1147 r0 *1 15.665,62 sky130_fd_pr__nfet_01v8
M$1147 97 1046 1047 1047 sky130_fd_pr__nfet_01v8 L=0.15U W=0.65U AS=0.169P
+ AD=0.105625P PS=1.82U PD=0.975U
* device instance $1148 r0 *1 16.14,62 sky130_fd_pr__nfet_01v8
M$1148 64 1047 97 97 sky130_fd_pr__nfet_01v8 L=0.15U W=2.6U AS=0.37375P
+ AD=0.453375P PS=3.75U PD=4.645U
* device instance $1152 r0 *1 20.73,62 sky130_fd_pr__nfet_01v8
M$1152 1049 1101 97 97 sky130_fd_pr__nfet_01v8 L=0.15U W=2.6U AS=0.44525P
+ AD=0.351P PS=4.62U PD=3.68U
* device instance $1156 r0 *1 22.41,62 sky130_fd_pr__nfet_01v8
M$1156 1049 1010 97 97 sky130_fd_pr__nfet_01v8 L=0.15U W=2.6U AS=0.351P
+ AD=0.43225P PS=3.68U PD=4.58U
* device instance $1160 r0 *1 24.85,62 sky130_fd_pr__nfet_01v8
M$1160 97 1049 1050 1050 sky130_fd_pr__nfet_01v8 L=0.15U W=1.95U AS=0.3445P
+ AD=0.26325P PS=3.66U PD=2.76U
* device instance $1163 r0 *1 26.11,62 sky130_fd_pr__nfet_01v8
M$1163 94 1050 97 97 sky130_fd_pr__nfet_01v8 L=0.15U W=5.2U AS=0.702P
+ AD=0.78325P PS=7.36U PD=8.26U
* device instance $1171 r0 *1 24.87,57.68 sky130_fd_pr__nfet_01v8
M$1171 1010 64 97 97 sky130_fd_pr__nfet_01v8 L=0.15U W=1.3U AS=0.2665P
+ AD=0.1755P PS=2.77U PD=1.84U
* device instance $1173 r0 *1 25.71,57.68 sky130_fd_pr__nfet_01v8
M$1173 1010 976 97 97 sky130_fd_pr__nfet_01v8 L=0.15U W=1.3U AS=0.1755P
+ AD=0.25675P PS=1.84U PD=2.74U
* device instance $1175 r0 *1 27.09,57.68 sky130_fd_pr__nfet_01v8
M$1175 1010 1015 97 97 sky130_fd_pr__nfet_01v8 L=0.15U W=1.3U AS=0.25675P
+ AD=0.25675P PS=2.74U PD=2.74U
* device instance $1177 r0 *1 28.65,57.68 sky130_fd_pr__nfet_01v8
M$1177 97 115 1012 1012 sky130_fd_pr__nfet_01v8 L=0.15U W=0.65U AS=0.19825P
+ AD=0.08775P PS=1.91U PD=0.92U
* device instance $1178 r0 *1 29.07,57.68 sky130_fd_pr__nfet_01v8
M$1178 92 1011 97 97 sky130_fd_pr__nfet_01v8 L=0.15U W=2.6U AS=0.351P
+ AD=0.43225P PS=3.68U PD=4.58U
* device instance $1182 r0 *1 31.27,57.68 sky130_fd_pr__nfet_01v8
M$1182 1011 1012 1013 1013 sky130_fd_pr__nfet_01v8 L=0.15U W=1.3U AS=0.25675P
+ AD=0.1755P PS=2.74U PD=1.84U
* device instance $1184 r0 *1 32.11,57.68 sky130_fd_pr__nfet_01v8
M$1184 97 1015 1013 1013 sky130_fd_pr__nfet_01v8 L=0.15U W=1.3U AS=0.1755P
+ AD=0.1755P PS=1.84U PD=1.84U
* device instance $1186 r0 *1 32.95,57.68 sky130_fd_pr__nfet_01v8
M$1186 97 976 1013 1013 sky130_fd_pr__nfet_01v8 L=0.15U W=1.3U AS=0.1755P
+ AD=0.26975P PS=1.84U PD=2.78U
* device instance $1188 r0 *1 32.21,62 sky130_fd_pr__nfet_01v8
M$1188 1051 976 97 97 sky130_fd_pr__nfet_01v8 L=0.15U W=0.65U AS=0.169P
+ AD=0.08775P PS=1.82U PD=0.92U
* device instance $1189 r0 *1 32.63,62 sky130_fd_pr__nfet_01v8
M$1189 97 1073 1051 1051 sky130_fd_pr__nfet_01v8 L=0.15U W=0.65U AS=0.08775P
+ AD=0.169P PS=0.92U PD=1.82U
* device instance $1190 r0 *1 33.825,62.115 sky130_fd_pr__nfet_01v8
M$1190 1074 993 97 97 sky130_fd_pr__nfet_01v8 L=0.15U W=0.42U AS=0.10025P
+ AD=0.1092P PS=0.985U PD=1.36U
* device instance $1191 r0 *1 34.31,62 sky130_fd_pr__nfet_01v8
M$1191 1073 893 97 97 sky130_fd_pr__nfet_01v8 L=0.15U W=0.65U AS=0.10025P
+ AD=0.08775P PS=0.985U PD=0.92U
* device instance $1192 r0 *1 34.73,62 sky130_fd_pr__nfet_01v8
M$1192 97 1074 1073 1073 sky130_fd_pr__nfet_01v8 L=0.15U W=0.65U AS=0.08775P
+ AD=0.169P PS=0.92U PD=1.82U
* device instance $1193 r0 *1 34.97,57.68 sky130_fd_pr__nfet_01v8
M$1193 97 994 1014 1014 sky130_fd_pr__nfet_01v8 L=0.15U W=0.65U AS=0.169P
+ AD=0.08775P PS=1.82U PD=0.92U
* device instance $1194 r0 *1 35.39,57.68 sky130_fd_pr__nfet_01v8
M$1194 1015 1014 97 97 sky130_fd_pr__nfet_01v8 L=0.15U W=2.6U AS=0.351P
+ AD=0.43225P PS=3.68U PD=4.58U
* device instance $1198 r0 *1 37.99,57.68 sky130_fd_pr__nfet_01v8
M$1198 1016 999 97 97 sky130_fd_pr__nfet_01v8 L=0.15U W=1.3U AS=0.25675P
+ AD=0.1755P PS=2.74U PD=1.84U
* device instance $1200 r0 *1 38.83,57.68 sky130_fd_pr__nfet_01v8
M$1200 158 1016 97 97 sky130_fd_pr__nfet_01v8 L=0.15U W=3.9U AS=0.5265P
+ AD=0.60775P PS=5.52U PD=6.42U
* device instance $1206 r0 *1 40.03,62 sky130_fd_pr__nfet_01v8
M$1206 97 1052 1083 1083 sky130_fd_pr__nfet_01v8 L=0.15U W=1.3U AS=0.25675P
+ AD=0.1755P PS=2.74U PD=1.84U
* device instance $1208 r0 *1 40.87,62 sky130_fd_pr__nfet_01v8
M$1208 1085 1033 1083 1083 sky130_fd_pr__nfet_01v8 L=0.15U W=1.3U AS=0.1755P
+ AD=0.25675P PS=1.84U PD=2.74U
* device instance $1210 r0 *1 42.23,62 sky130_fd_pr__nfet_01v8
M$1210 1085 1054 1075 1075 sky130_fd_pr__nfet_01v8 L=0.15U W=1.3U AS=0.25675P
+ AD=0.18525P PS=2.74U PD=1.87U
* device instance $1212 r0 *1 43.1,62 sky130_fd_pr__nfet_01v8
M$1212 97 1073 1075 1075 sky130_fd_pr__nfet_01v8 L=0.15U W=1.3U AS=0.18525P
+ AD=0.25675P PS=1.87U PD=2.09U
* device instance $1214 r0 *1 44.19,62 sky130_fd_pr__nfet_01v8
M$1214 97 1076 1075 1075 sky130_fd_pr__nfet_01v8 L=0.15U W=1.3U AS=0.25675P
+ AD=0.25675P PS=2.09U PD=2.74U
* device instance $1216 r0 *1 42.79,57.68 sky130_fd_pr__nfet_01v8
M$1216 1018 1017 97 97 sky130_fd_pr__nfet_01v8 L=0.15U W=0.65U AS=0.169P
+ AD=0.08775P PS=1.82U PD=0.92U
* device instance $1217 r0 *1 43.21,57.68 sky130_fd_pr__nfet_01v8
M$1217 97 1019 1018 1018 sky130_fd_pr__nfet_01v8 L=0.15U W=0.65U AS=0.08775P
+ AD=0.169P PS=0.92U PD=1.82U
* device instance $1218 r0 *1 45.57,62 sky130_fd_pr__nfet_01v8
M$1218 1019 1054 97 97 sky130_fd_pr__nfet_01v8 L=0.15U W=0.65U AS=0.17225P
+ AD=0.091P PS=1.83U PD=0.93U
* device instance $1219 r0 *1 46,62 sky130_fd_pr__nfet_01v8
M$1219 1096 1052 1019 1019 sky130_fd_pr__nfet_01v8 L=0.15U W=0.65U AS=0.091P
+ AD=0.095875P PS=0.93U PD=0.945U
* device instance $1220 r0 *1 46.445,62 sky130_fd_pr__nfet_01v8
M$1220 97 1077 1096 1096 sky130_fd_pr__nfet_01v8 L=0.15U W=0.65U AS=0.095875P
+ AD=0.17225P PS=0.945U PD=1.83U
* device instance $1221 r0 *1 46.47,57.68 sky130_fd_pr__nfet_01v8
M$1221 97 999 1020 1020 sky130_fd_pr__nfet_01v8 L=0.15U W=0.65U AS=0.169P
+ AD=0.08775P PS=1.82U PD=0.92U
* device instance $1222 r0 *1 46.89,57.68 sky130_fd_pr__nfet_01v8
M$1222 1021 1020 97 97 sky130_fd_pr__nfet_01v8 L=0.15U W=2.6U AS=0.351P
+ AD=0.43225P PS=3.68U PD=4.58U
* device instance $1226 r0 *1 49.69,62 sky130_fd_pr__nfet_01v8
M$1226 97 1052 1084 1084 sky130_fd_pr__nfet_01v8 L=0.15U W=1.3U AS=0.25675P
+ AD=0.1755P PS=2.74U PD=1.84U
* device instance $1228 r0 *1 50.53,62 sky130_fd_pr__nfet_01v8
M$1228 1086 1077 1084 1084 sky130_fd_pr__nfet_01v8 L=0.15U W=1.3U AS=0.1755P
+ AD=0.25675P PS=1.84U PD=2.74U
* device instance $1230 r0 *1 51.15,57.68 sky130_fd_pr__nfet_01v8
M$1230 1022 854 97 97 sky130_fd_pr__nfet_01v8 L=0.15U W=2.6U AS=0.44525P
+ AD=0.351P PS=4.62U PD=3.68U
* device instance $1234 r0 *1 52.83,57.68 sky130_fd_pr__nfet_01v8
M$1234 1022 799 97 97 sky130_fd_pr__nfet_01v8 L=0.15U W=2.6U AS=0.351P
+ AD=0.3575P PS=3.68U PD=3.7U
* device instance $1238 r0 *1 54.53,57.68 sky130_fd_pr__nfet_01v8
M$1238 1022 980 97 97 sky130_fd_pr__nfet_01v8 L=0.15U W=2.6U AS=0.3575P
+ AD=0.44525P PS=3.7U PD=4.62U
* device instance $1242 r0 *1 51.89,62 sky130_fd_pr__nfet_01v8
M$1242 1086 1054 1058 1058 sky130_fd_pr__nfet_01v8 L=0.15U W=1.3U AS=0.2665P
+ AD=0.2145P PS=2.77U PD=1.96U
* device instance $1244 r0 *1 52.85,62 sky130_fd_pr__nfet_01v8
M$1244 97 1076 1058 1058 sky130_fd_pr__nfet_01v8 L=0.15U W=1.3U AS=0.23075P
+ AD=0.28275P PS=2.01U PD=2.82U
* device instance $1246 r0 *1 56.77,57.68 sky130_fd_pr__nfet_01v8
M$1246 1022 983 1023 1023 sky130_fd_pr__nfet_01v8 L=0.15U W=2.6U AS=0.44525P
+ AD=0.351P PS=4.62U PD=3.68U
* device instance $1250 r0 *1 58.45,57.68 sky130_fd_pr__nfet_01v8
M$1250 1033 1024 1023 1023 sky130_fd_pr__nfet_01v8 L=0.15U W=2.6U AS=0.351P
+ AD=0.44525P PS=3.68U PD=4.62U
* device instance $1254 r0 *1 60.73,57.68 sky130_fd_pr__nfet_01v8
M$1254 97 1025 1026 1026 sky130_fd_pr__nfet_01v8 L=0.15U W=0.65U AS=0.169P
+ AD=0.10725P PS=1.82U PD=0.98U
* device instance $1255 r0 *1 61.21,57.68 sky130_fd_pr__nfet_01v8
M$1255 1030 985 97 97 sky130_fd_pr__nfet_01v8 L=0.15U W=0.65U AS=0.10725P
+ AD=0.06825P PS=0.98U PD=0.86U
* device instance $1256 r0 *1 61.57,57.68 sky130_fd_pr__nfet_01v8
M$1256 1026 92 1030 1030 sky130_fd_pr__nfet_01v8 L=0.15U W=0.65U AS=0.06825P
+ AD=0.169P PS=0.86U PD=1.82U
* device instance $1257 r0 *1 62.51,57.68 sky130_fd_pr__nfet_01v8
M$1257 1029 1021 1026 1026 sky130_fd_pr__nfet_01v8 L=0.15U W=0.65U AS=0.169P
+ AD=0.10725P PS=1.82U PD=0.98U
* device instance $1258 r0 *1 62.99,57.68 sky130_fd_pr__nfet_01v8
M$1258 97 996 1029 1029 sky130_fd_pr__nfet_01v8 L=0.15U W=0.65U AS=0.10725P
+ AD=0.102375P PS=0.98U PD=0.965U
* device instance $1259 r0 *1 63.455,57.68 sky130_fd_pr__nfet_01v8
M$1259 1027 1026 97 97 sky130_fd_pr__nfet_01v8 L=0.15U W=0.65U AS=0.102375P
+ AD=0.169P PS=0.965U PD=1.82U
* device instance $1260 r0 *1 64.43,57.68 sky130_fd_pr__nfet_01v8
M$1260 1028 943 97 97 sky130_fd_pr__nfet_01v8 L=0.15U W=0.65U AS=0.169P
+ AD=0.08775P PS=1.82U PD=0.92U
* device instance $1261 r0 *1 64.85,57.68 sky130_fd_pr__nfet_01v8
M$1261 1039 983 1028 1028 sky130_fd_pr__nfet_01v8 L=0.15U W=0.65U AS=0.08775P
+ AD=0.169P PS=0.92U PD=1.82U
* device instance $1262 r0 *1 72.945,62.115 sky130_fd_pr__nfet_01v8
M$1262 1066 1065 97 97 sky130_fd_pr__nfet_01v8 L=0.15U W=0.42U AS=0.10025P
+ AD=0.1092P PS=0.985U PD=1.36U
* device instance $1263 r0 *1 73.43,62 sky130_fd_pr__nfet_01v8
M$1263 955 1065 97 97 sky130_fd_pr__nfet_01v8 L=0.15U W=0.65U AS=0.10025P
+ AD=0.182P PS=0.985U PD=1.86U
* device instance $1264 r0 *1 8.245,63.005 sky130_fd_pr__nfet_01v8
M$1264 97 1128 1185 1185 sky130_fd_pr__nfet_01v8 L=0.15U W=0.42U AS=0.1092P
+ AD=0.1197P PS=1.36U PD=1.41U
* device instance $1265 r0 *1 9.21,63.12 sky130_fd_pr__nfet_01v8
M$1265 1098 1129 1097 1097 sky130_fd_pr__nfet_01v8 L=0.15U W=0.65U AS=0.169P
+ AD=0.092625P PS=1.82U PD=0.935U
* device instance $1266 r0 *1 9.645,63.12 sky130_fd_pr__nfet_01v8
M$1266 1097 1128 1098 1098 sky130_fd_pr__nfet_01v8 L=0.15U W=0.65U AS=0.092625P
+ AD=0.115375P PS=0.935U PD=1.005U
* device instance $1267 r0 *1 10.15,63.12 sky130_fd_pr__nfet_01v8
M$1267 97 1099 1097 1097 sky130_fd_pr__nfet_01v8 L=0.15U W=0.65U AS=0.115375P
+ AD=0.08775P PS=1.005U PD=0.92U
* device instance $1268 r0 *1 10.57,63.12 sky130_fd_pr__nfet_01v8
M$1268 1097 918 97 97 sky130_fd_pr__nfet_01v8 L=0.15U W=0.65U AS=0.08775P
+ AD=0.169P PS=0.92U PD=1.82U
* device instance $1269 r0 *1 9.67,62.115 sky130_fd_pr__nfet_01v8
M$1269 97 681 1041 1041 sky130_fd_pr__nfet_01v8 L=0.15U W=0.42U AS=0.1092P
+ AD=0.0567P PS=1.36U PD=0.69U
* device instance $1270 r0 *1 10.09,62.115 sky130_fd_pr__nfet_01v8
M$1270 1042 1041 97 97 sky130_fd_pr__nfet_01v8 L=0.15U W=0.42U AS=0.0567P
+ AD=0.1092P PS=0.69U PD=1.36U
* device instance $1271 r0 *1 11.03,62.115 sky130_fd_pr__nfet_01v8
M$1271 1043 1072 97 97 sky130_fd_pr__nfet_01v8 L=0.15U W=0.42U AS=0.1092P
+ AD=0.066P PS=1.36U PD=0.745U
* device instance $1272 r0 *1 11.505,62.145 sky130_fd_pr__nfet_01v8
M$1272 1044 1041 1043 1043 sky130_fd_pr__nfet_01v8 L=0.15U W=0.36U AS=0.066P
+ AD=0.0594P PS=0.745U PD=0.69U
* device instance $1273 r0 *1 11.985,62.145 sky130_fd_pr__nfet_01v8
M$1273 1044 1042 1090 1090 sky130_fd_pr__nfet_01v8 L=0.15U W=0.36U AS=0.0687P
+ AD=0.0594P PS=0.76U PD=0.69U
* device instance $1274 r0 *1 12.475,62.115 sky130_fd_pr__nfet_01v8
M$1274 1090 1045 97 97 sky130_fd_pr__nfet_01v8 L=0.15U W=0.42U AS=0.1493P
+ AD=0.0687P PS=1.22U PD=0.76U
* device instance $1275 r0 *1 13.205,62.005 sky130_fd_pr__nfet_01v8
M$1275 1045 1044 97 97 sky130_fd_pr__nfet_01v8 L=0.15U W=0.64U AS=0.1493P
+ AD=0.0989P PS=1.22U PD=0.995U
* device instance $1276 r0 *1 13.71,62.145 sky130_fd_pr__nfet_01v8
M$1276 1046 1042 1045 1045 sky130_fd_pr__nfet_01v8 L=0.15U W=0.36U AS=0.0989P
+ AD=0.0657P PS=0.995U PD=0.725U
* device instance $1277 r0 *1 14.225,62.145 sky130_fd_pr__nfet_01v8
M$1277 1046 1041 1092 1092 sky130_fd_pr__nfet_01v8 L=0.15U W=0.36U AS=0.066P
+ AD=0.0657P PS=0.745U PD=0.725U
* device instance $1278 r0 *1 14.7,62.115 sky130_fd_pr__nfet_01v8
M$1278 97 1047 1092 1092 sky130_fd_pr__nfet_01v8 L=0.15U W=0.42U AS=0.066P
+ AD=0.1197P PS=0.745U PD=1.41U
* device instance $1279 r0 *1 11.53,63.12 sky130_fd_pr__nfet_01v8
M$1279 1120 1130 97 97 sky130_fd_pr__nfet_01v8 L=0.15U W=0.65U AS=0.169P
+ AD=0.08775P PS=1.82U PD=0.92U
* device instance $1280 r0 *1 11.95,63.12 sky130_fd_pr__nfet_01v8
M$1280 115 1100 1120 1120 sky130_fd_pr__nfet_01v8 L=0.15U W=0.65U AS=0.08775P
+ AD=0.169P PS=0.92U PD=1.82U
* device instance $1281 r0 *1 13.305,63.005 sky130_fd_pr__nfet_01v8
M$1281 97 64 1100 1100 sky130_fd_pr__nfet_01v8 L=0.15U W=0.42U AS=0.1092P
+ AD=0.1197P PS=1.36U PD=1.41U
* device instance $1282 r0 *1 17.05,63.12 sky130_fd_pr__nfet_01v8
M$1282 1101 1130 97 97 sky130_fd_pr__nfet_01v8 L=0.15U W=2.6U AS=0.44525P
+ AD=0.351P PS=4.62U PD=3.68U
* device instance $1286 r0 *1 18.73,63.12 sky130_fd_pr__nfet_01v8
M$1286 1101 64 97 97 sky130_fd_pr__nfet_01v8 L=0.15U W=2.6U AS=0.351P
+ AD=0.43225P PS=3.68U PD=4.58U
* device instance $1290 r0 *1 22.255,63.12 sky130_fd_pr__nfet_01v8
M$1290 302 1101 97 97 sky130_fd_pr__nfet_01v8 L=0.15U W=5.2U AS=0.78325P
+ AD=0.78325P PS=8.26U PD=8.26U
* device instance $1298 r0 *1 26.49,63.12 sky130_fd_pr__nfet_01v8
M$1298 1102 1049 97 97 sky130_fd_pr__nfet_01v8 L=0.15U W=1.3U AS=0.25675P
+ AD=0.1755P PS=2.74U PD=1.84U
* device instance $1300 r0 *1 27.33,63.12 sky130_fd_pr__nfet_01v8
M$1300 409 1102 97 97 sky130_fd_pr__nfet_01v8 L=0.15U W=3.9U AS=0.5265P
+ AD=0.60775P PS=5.52U PD=6.42U
* device instance $1306 r0 *1 30.37,63.005 sky130_fd_pr__nfet_01v8
M$1306 97 681 1103 1103 sky130_fd_pr__nfet_01v8 L=0.15U W=0.42U AS=0.1092P
+ AD=0.0567P PS=1.36U PD=0.69U
* device instance $1307 r0 *1 30.79,63.005 sky130_fd_pr__nfet_01v8
M$1307 1105 1103 97 97 sky130_fd_pr__nfet_01v8 L=0.15U W=0.42U AS=0.0567P
+ AD=0.1092P PS=0.69U PD=1.36U
* device instance $1308 r0 *1 31.73,63.005 sky130_fd_pr__nfet_01v8
M$1308 1121 1104 1106 1106 sky130_fd_pr__nfet_01v8 L=0.15U W=0.42U AS=0.1092P
+ AD=0.0441P PS=1.36U PD=0.63U
* device instance $1309 r0 *1 32.09,63.005 sky130_fd_pr__nfet_01v8
M$1309 97 302 1121 1121 sky130_fd_pr__nfet_01v8 L=0.15U W=0.42U AS=0.0441P
+ AD=0.1092P PS=0.63U PD=1.36U
* device instance $1310 r0 *1 34.89,62.975 sky130_fd_pr__nfet_01v8
M$1310 1109 1103 1106 1106 sky130_fd_pr__nfet_01v8 L=0.15U W=0.36U AS=0.1446P
+ AD=0.0522P PS=1.18U PD=0.65U
* device instance $1311 r0 *1 35.33,62.975 sky130_fd_pr__nfet_01v8
M$1311 1124 1105 1109 1109 sky130_fd_pr__nfet_01v8 L=0.15U W=0.36U AS=0.0522P
+ AD=0.0759P PS=0.65U PD=0.8U
* device instance $1312 r0 *1 33.03,63.005 sky130_fd_pr__nfet_01v8
M$1312 97 302 1107 1107 sky130_fd_pr__nfet_01v8 L=0.15U W=0.42U AS=0.1092P
+ AD=0.0609P PS=1.36U PD=0.71U
* device instance $1313 r0 *1 33.47,63.005 sky130_fd_pr__nfet_01v8
M$1313 1123 1107 97 97 sky130_fd_pr__nfet_01v8 L=0.15U W=0.42U AS=0.0609P
+ AD=0.0756P PS=0.71U PD=0.78U
* device instance $1314 r0 *1 33.98,63.005 sky130_fd_pr__nfet_01v8
M$1314 1106 1108 1123 1123 sky130_fd_pr__nfet_01v8 L=0.15U W=0.42U AS=0.0756P
+ AD=0.1446P PS=0.78U PD=1.18U
* device instance $1315 r0 *1 35.86,63.005 sky130_fd_pr__nfet_01v8
M$1315 97 1110 1124 1124 sky130_fd_pr__nfet_01v8 L=0.15U W=0.42U AS=0.0759P
+ AD=0.12095P PS=0.8U PD=1.085U
* device instance $1316 r0 *1 36.455,63.115 sky130_fd_pr__nfet_01v8
M$1316 1110 1109 97 97 sky130_fd_pr__nfet_01v8 L=0.15U W=0.64U AS=0.12095P
+ AD=0.1664P PS=1.085U PD=1.8U
* device instance $1317 r0 *1 37.88,62.975 sky130_fd_pr__nfet_01v8
M$1317 1111 1105 1125 1125 sky130_fd_pr__nfet_01v8 L=0.15U W=0.36U AS=0.0678P
+ AD=0.0684P PS=0.755U PD=0.74U
* device instance $1318 r0 *1 38.41,62.975 sky130_fd_pr__nfet_01v8
M$1318 1126 1103 1111 1111 sky130_fd_pr__nfet_01v8 L=0.15U W=0.36U AS=0.0684P
+ AD=0.066P PS=0.74U PD=0.745U
* device instance $1319 r0 *1 37.395,63.005 sky130_fd_pr__nfet_01v8
M$1319 1125 1110 97 97 sky130_fd_pr__nfet_01v8 L=0.15U W=0.42U AS=0.1092P
+ AD=0.0678P PS=1.36U PD=0.755U
* device instance $1320 r0 *1 38.885,63.005 sky130_fd_pr__nfet_01v8
M$1320 97 1108 1126 1126 sky130_fd_pr__nfet_01v8 L=0.15U W=0.42U AS=0.066P
+ AD=0.1092P PS=0.745U PD=1.36U
* device instance $1321 r0 *1 39.825,63.005 sky130_fd_pr__nfet_01v8
M$1321 97 1111 1108 1108 sky130_fd_pr__nfet_01v8 L=0.15U W=0.42U AS=0.1092P
+ AD=0.10025P PS=1.36U PD=0.985U
* device instance $1322 r0 *1 40.31,63.12 sky130_fd_pr__nfet_01v8
M$1322 993 1111 97 97 sky130_fd_pr__nfet_01v8 L=0.15U W=0.65U AS=0.10025P
+ AD=0.182P PS=0.985U PD=1.86U
* device instance $1323 r0 *1 41.41,63.12 sky130_fd_pr__nfet_01v8
M$1323 97 1075 1112 1112 sky130_fd_pr__nfet_01v8 L=0.15U W=0.65U AS=0.169P
+ AD=0.08775P PS=1.82U PD=0.92U
* device instance $1324 r0 *1 41.83,63.12 sky130_fd_pr__nfet_01v8
M$1324 994 1112 97 97 sky130_fd_pr__nfet_01v8 L=0.15U W=2.6U AS=0.351P
+ AD=0.43225P PS=3.68U PD=4.58U
* device instance $1328 r0 *1 45.65,63.12 sky130_fd_pr__nfet_01v8
M$1328 1127 1134 1113 1113 sky130_fd_pr__nfet_01v8 L=0.15U W=0.65U AS=0.169P
+ AD=0.06825P PS=1.82U PD=0.86U
* device instance $1329 r0 *1 46.01,63.12 sky130_fd_pr__nfet_01v8
M$1329 97 1114 1127 1127 sky130_fd_pr__nfet_01v8 L=0.15U W=0.65U AS=0.06825P
+ AD=0.08775P PS=0.86U PD=0.92U
* device instance $1330 r0 *1 46.43,63.12 sky130_fd_pr__nfet_01v8
M$1330 1115 1114 97 97 sky130_fd_pr__nfet_01v8 L=0.15U W=0.65U AS=0.08775P
+ AD=0.169P PS=0.92U PD=1.82U
* device instance $1331 r0 *1 47.37,63.12 sky130_fd_pr__nfet_01v8
M$1331 1115 1134 97 97 sky130_fd_pr__nfet_01v8 L=0.15U W=0.65U AS=0.169P
+ AD=0.08775P PS=1.82U PD=0.92U
* device instance $1332 r0 *1 47.79,63.12 sky130_fd_pr__nfet_01v8
M$1332 1054 1113 1115 1115 sky130_fd_pr__nfet_01v8 L=0.15U W=0.65U AS=0.08775P
+ AD=0.195P PS=0.92U PD=1.9U
* device instance $1333 r0 *1 47.39,62.115 sky130_fd_pr__nfet_01v8
M$1333 1095 1054 1078 1078 sky130_fd_pr__nfet_01v8 L=0.15U W=0.42U AS=0.1092P
+ AD=0.0441P PS=1.36U PD=0.63U
* device instance $1334 r0 *1 47.75,62.115 sky130_fd_pr__nfet_01v8
M$1334 1094 1052 1095 1095 sky130_fd_pr__nfet_01v8 L=0.15U W=0.42U AS=0.0441P
+ AD=0.0441P PS=0.63U PD=0.63U
* device instance $1335 r0 *1 48.11,62.115 sky130_fd_pr__nfet_01v8
M$1335 1094 1077 97 97 sky130_fd_pr__nfet_01v8 L=0.15U W=0.42U AS=0.13165P
+ AD=0.0441P PS=1.14U PD=0.63U
* device instance $1336 r0 *1 48.75,62 sky130_fd_pr__nfet_01v8
M$1336 1017 1078 97 97 sky130_fd_pr__nfet_01v8 L=0.15U W=0.65U AS=0.13165P
+ AD=0.169P PS=1.14U PD=1.82U
* device instance $1337 r0 *1 48.77,63.12 sky130_fd_pr__nfet_01v8
M$1337 97 1033 1116 1116 sky130_fd_pr__nfet_01v8 L=0.15U W=0.65U AS=0.169P
+ AD=0.08775P PS=1.82U PD=0.92U
* device instance $1338 r0 *1 49.19,63.12 sky130_fd_pr__nfet_01v8
M$1338 1077 1116 97 97 sky130_fd_pr__nfet_01v8 L=0.15U W=2.6U AS=0.351P
+ AD=0.43225P PS=3.68U PD=4.58U
* device instance $1342 r0 *1 51.765,63.005 sky130_fd_pr__nfet_01v8
M$1342 97 1114 1117 1117 sky130_fd_pr__nfet_01v8 L=0.15U W=0.42U AS=0.1092P
+ AD=0.10025P PS=1.36U PD=0.985U
* device instance $1343 r0 *1 52.25,63.12 sky130_fd_pr__nfet_01v8
M$1343 1076 1134 97 97 sky130_fd_pr__nfet_01v8 L=0.15U W=0.65U AS=0.10025P
+ AD=0.08775P PS=0.985U PD=0.92U
* device instance $1344 r0 *1 52.67,63.12 sky130_fd_pr__nfet_01v8
M$1344 97 1117 1076 1076 sky130_fd_pr__nfet_01v8 L=0.15U W=0.65U AS=0.08775P
+ AD=0.169P PS=0.92U PD=1.82U
* device instance $1345 r0 *1 63.49,62.115 sky130_fd_pr__nfet_01v8
M$1345 97 979 1059 1059 sky130_fd_pr__nfet_01v8 L=0.15U W=0.42U AS=0.1092P
+ AD=0.0567P PS=1.36U PD=0.69U
* device instance $1346 r0 *1 63.91,62.115 sky130_fd_pr__nfet_01v8
M$1346 1060 1059 97 97 sky130_fd_pr__nfet_01v8 L=0.15U W=0.42U AS=0.0567P
+ AD=0.1092P PS=0.69U PD=1.36U
* device instance $1347 r0 *1 64.85,62.115 sky130_fd_pr__nfet_01v8
M$1347 1093 1027 1061 1061 sky130_fd_pr__nfet_01v8 L=0.15U W=0.42U AS=0.1092P
+ AD=0.0441P PS=1.36U PD=0.63U
* device instance $1348 r0 *1 65.21,62.115 sky130_fd_pr__nfet_01v8
M$1348 97 302 1093 1093 sky130_fd_pr__nfet_01v8 L=0.15U W=0.42U AS=0.0441P
+ AD=0.1092P PS=0.63U PD=1.36U
* device instance $1349 r0 *1 64.41,63.235 sky130_fd_pr__nfet_01v8
M$1349 1118 1131 97 97 sky130_fd_pr__nfet_01v8 L=0.15U W=0.42U AS=0.10025P
+ AD=0.1092P PS=0.985U PD=1.36U
* device instance $1350 r0 *1 64.895,63.12 sky130_fd_pr__nfet_01v8
M$1350 1122 1132 97 97 sky130_fd_pr__nfet_01v8 L=0.15U W=0.65U AS=0.10025P
+ AD=0.08775P PS=0.985U PD=0.92U
* device instance $1351 r0 *1 65.315,63.12 sky130_fd_pr__nfet_01v8
M$1351 1052 1118 1122 1122 sky130_fd_pr__nfet_01v8 L=0.15U W=0.65U AS=0.08775P
+ AD=0.169P PS=0.92U PD=1.82U
* device instance $1352 r0 *1 66.15,62.115 sky130_fd_pr__nfet_01v8
M$1352 97 302 1062 1062 sky130_fd_pr__nfet_01v8 L=0.15U W=0.42U AS=0.1092P
+ AD=0.0609P PS=1.36U PD=0.71U
* device instance $1353 r0 *1 66.59,62.115 sky130_fd_pr__nfet_01v8
M$1353 1091 1062 97 97 sky130_fd_pr__nfet_01v8 L=0.15U W=0.42U AS=0.0609P
+ AD=0.0756P PS=0.71U PD=0.78U
* device instance $1354 r0 *1 67.1,62.115 sky130_fd_pr__nfet_01v8
M$1354 1061 1066 1091 1091 sky130_fd_pr__nfet_01v8 L=0.15U W=0.42U AS=0.0756P
+ AD=0.1446P PS=0.78U PD=1.18U
* device instance $1355 r0 *1 68.01,62.145 sky130_fd_pr__nfet_01v8
M$1355 1063 1059 1061 1061 sky130_fd_pr__nfet_01v8 L=0.15U W=0.36U AS=0.1446P
+ AD=0.0522P PS=1.18U PD=0.65U
* device instance $1356 r0 *1 68.45,62.145 sky130_fd_pr__nfet_01v8
M$1356 1063 1060 1089 1089 sky130_fd_pr__nfet_01v8 L=0.15U W=0.36U AS=0.0759P
+ AD=0.0522P PS=0.8U PD=0.65U
* device instance $1357 r0 *1 68.98,62.115 sky130_fd_pr__nfet_01v8
M$1357 1089 1064 97 97 sky130_fd_pr__nfet_01v8 L=0.15U W=0.42U AS=0.12095P
+ AD=0.0759P PS=1.085U PD=0.8U
* device instance $1358 r0 *1 69.575,62.005 sky130_fd_pr__nfet_01v8
M$1358 1064 1063 97 97 sky130_fd_pr__nfet_01v8 L=0.15U W=0.64U AS=0.12095P
+ AD=0.1664P PS=1.085U PD=1.8U
* device instance $1359 r0 *1 66.71,63.12 sky130_fd_pr__nfet_01v8
M$1359 97 1132 1119 1119 sky130_fd_pr__nfet_01v8 L=0.15U W=0.65U AS=0.169P
+ AD=0.08775P PS=1.82U PD=0.92U
* device instance $1360 r0 *1 67.13,63.12 sky130_fd_pr__nfet_01v8
M$1360 374 1119 97 97 sky130_fd_pr__nfet_01v8 L=0.15U W=2.6U AS=0.351P
+ AD=0.43225P PS=3.68U PD=4.58U
* device instance $1364 r0 *1 70.515,62.115 sky130_fd_pr__nfet_01v8
M$1364 1088 1064 97 97 sky130_fd_pr__nfet_01v8 L=0.15U W=0.42U AS=0.1092P
+ AD=0.0678P PS=1.36U PD=0.755U
* device instance $1365 r0 *1 71,62.145 sky130_fd_pr__nfet_01v8
M$1365 1065 1060 1088 1088 sky130_fd_pr__nfet_01v8 L=0.15U W=0.36U AS=0.0678P
+ AD=0.0684P PS=0.755U PD=0.74U
* device instance $1366 r0 *1 71.53,62.145 sky130_fd_pr__nfet_01v8
M$1366 1065 1059 1087 1087 sky130_fd_pr__nfet_01v8 L=0.15U W=0.36U AS=0.066P
+ AD=0.0684P PS=0.745U PD=0.74U
* device instance $1367 r0 *1 72.005,62.115 sky130_fd_pr__nfet_01v8
M$1367 97 1066 1087 1087 sky130_fd_pr__nfet_01v8 L=0.15U W=0.42U AS=0.066P
+ AD=0.1092P PS=0.745U PD=1.36U
* device instance $1368 r0 *1 5.09,67.44 sky130_fd_pr__nfet_01v8
M$1368 1207 1144 97 97 sky130_fd_pr__nfet_01v8 L=0.15U W=0.65U AS=0.169P
+ AD=0.08775P PS=1.82U PD=0.92U
* device instance $1369 r0 *1 5.51,67.44 sky130_fd_pr__nfet_01v8
M$1369 1129 64 1207 1207 sky130_fd_pr__nfet_01v8 L=0.15U W=0.65U AS=0.08775P
+ AD=0.169P PS=0.92U PD=1.82U
* device instance $1370 r0 *1 8.78,67.555 sky130_fd_pr__nfet_01v8
M$1370 97 1100 1201 1201 sky130_fd_pr__nfet_01v8 L=0.15U W=0.42U AS=0.1113P
+ AD=0.0588P PS=1.37U PD=0.7U
* device instance $1371 r0 *1 9.21,67.555 sky130_fd_pr__nfet_01v8
M$1371 1201 1144 97 97 sky130_fd_pr__nfet_01v8 L=0.15U W=0.42U AS=0.0588P
+ AD=0.0588P PS=0.7U PD=0.7U
* device instance $1372 r0 *1 9.64,67.555 sky130_fd_pr__nfet_01v8
M$1372 1072 1145 1201 1201 sky130_fd_pr__nfet_01v8 L=0.15U W=0.42U AS=0.0588P
+ AD=0.1113P PS=0.7U PD=1.37U
* device instance $1373 r0 *1 10.61,67.44 sky130_fd_pr__nfet_01v8
M$1373 1210 1185 97 97 sky130_fd_pr__nfet_01v8 L=0.15U W=0.65U AS=0.169P
+ AD=0.08775P PS=1.82U PD=0.92U
* device instance $1374 r0 *1 11.03,67.44 sky130_fd_pr__nfet_01v8
M$1374 1099 1130 1210 1210 sky130_fd_pr__nfet_01v8 L=0.15U W=0.65U AS=0.08775P
+ AD=0.169P PS=0.92U PD=1.82U
* device instance $1375 r0 *1 12.04,67.44 sky130_fd_pr__nfet_01v8
M$1375 97 1186 1146 1146 sky130_fd_pr__nfet_01v8 L=0.15U W=0.65U AS=0.2145P
+ AD=0.167375P PS=1.96U PD=1.165U
* device instance $1376 r0 *1 12.705,67.44 sky130_fd_pr__nfet_01v8
M$1376 1212 918 97 97 sky130_fd_pr__nfet_01v8 L=0.15U W=0.65U AS=0.167375P
+ AD=0.0975P PS=1.165U PD=0.95U
* device instance $1377 r0 *1 13.155,67.44 sky130_fd_pr__nfet_01v8
M$1377 1213 1185 1212 1212 sky130_fd_pr__nfet_01v8 L=0.15U W=0.65U AS=0.0975P
+ AD=0.14625P PS=0.95U PD=1.1U
* device instance $1378 r0 *1 13.755,67.44 sky130_fd_pr__nfet_01v8
M$1378 1186 1130 1213 1213 sky130_fd_pr__nfet_01v8 L=0.15U W=0.65U AS=0.14625P
+ AD=0.143P PS=1.1U PD=1.09U
* device instance $1379 r0 *1 14.345,67.44 sky130_fd_pr__nfet_01v8
M$1379 1214 1145 1186 1186 sky130_fd_pr__nfet_01v8 L=0.15U W=0.65U AS=0.143P
+ AD=0.06825P PS=1.09U PD=0.86U
* device instance $1380 r0 *1 14.705,67.44 sky130_fd_pr__nfet_01v8
M$1380 97 1187 1214 1214 sky130_fd_pr__nfet_01v8 L=0.15U W=0.65U AS=0.06825P
+ AD=0.17225P PS=0.86U PD=1.83U
* device instance $1381 r0 *1 15.83,67.415 sky130_fd_pr__nfet_01v8
M$1381 1216 1187 1148 1148 sky130_fd_pr__nfet_01v8 L=0.15U W=0.42U AS=0.1176P
+ AD=0.0567P PS=1.4U PD=0.69U
* device instance $1382 r0 *1 16.25,67.415 sky130_fd_pr__nfet_01v8
M$1382 1216 1101 97 97 sky130_fd_pr__nfet_01v8 L=0.15U W=0.42U AS=0.1118P
+ AD=0.0567P PS=1.04U PD=0.69U
* device instance $1383 r0 *1 16.79,67.44 sky130_fd_pr__nfet_01v8
M$1383 1229 1148 97 97 sky130_fd_pr__nfet_01v8 L=0.15U W=0.65U AS=0.1118P
+ AD=0.182P PS=1.04U PD=1.86U
* device instance $1384 r0 *1 24.46,67.555 sky130_fd_pr__nfet_01v8
M$1384 1220 1188 1149 1149 sky130_fd_pr__nfet_01v8 L=0.15U W=0.42U AS=0.1113P
+ AD=0.0441P PS=1.37U PD=0.63U
* device instance $1385 r0 *1 24.82,67.555 sky130_fd_pr__nfet_01v8
M$1385 97 115 1220 1220 sky130_fd_pr__nfet_01v8 L=0.15U W=0.42U AS=0.0441P
+ AD=0.0966P PS=0.63U PD=0.88U
* device instance $1386 r0 *1 25.43,67.555 sky130_fd_pr__nfet_01v8
M$1386 1150 1149 97 97 sky130_fd_pr__nfet_01v8 L=0.15U W=0.42U AS=0.0966P
+ AD=0.1113P PS=0.88U PD=1.37U
* device instance $1387 r0 *1 26.69,67.44 sky130_fd_pr__nfet_01v8
M$1387 97 1150 1151 1151 sky130_fd_pr__nfet_01v8 L=0.15U W=0.65U AS=0.169P
+ AD=0.10725P PS=1.82U PD=0.98U
* device instance $1388 r0 *1 27.17,67.44 sky130_fd_pr__nfet_01v8
M$1388 1222 893 97 97 sky130_fd_pr__nfet_01v8 L=0.15U W=0.65U AS=0.10725P
+ AD=0.06825P PS=0.98U PD=0.86U
* device instance $1389 r0 *1 27.53,67.44 sky130_fd_pr__nfet_01v8
M$1389 1151 92 1222 1222 sky130_fd_pr__nfet_01v8 L=0.15U W=0.65U AS=0.06825P
+ AD=0.169P PS=0.86U PD=1.82U
* device instance $1390 r0 *1 28.47,67.44 sky130_fd_pr__nfet_01v8
M$1390 1224 1154 1151 1151 sky130_fd_pr__nfet_01v8 L=0.15U W=0.65U AS=0.169P
+ AD=0.10725P PS=1.82U PD=0.98U
* device instance $1391 r0 *1 28.95,67.44 sky130_fd_pr__nfet_01v8
M$1391 97 999 1224 1224 sky130_fd_pr__nfet_01v8 L=0.15U W=0.65U AS=0.10725P
+ AD=0.102375P PS=0.98U PD=0.965U
* device instance $1392 r0 *1 29.415,67.44 sky130_fd_pr__nfet_01v8
M$1392 1104 1151 97 97 sky130_fd_pr__nfet_01v8 L=0.15U W=0.65U AS=0.102375P
+ AD=0.169P PS=0.965U PD=1.82U
* device instance $1393 r0 *1 32.31,67.44 sky130_fd_pr__nfet_01v8
M$1393 1226 1058 1155 1155 sky130_fd_pr__nfet_01v8 L=0.15U W=0.65U AS=0.169P
+ AD=0.06825P PS=1.82U PD=0.86U
* device instance $1394 r0 *1 32.67,67.44 sky130_fd_pr__nfet_01v8
M$1394 97 1051 1226 1226 sky130_fd_pr__nfet_01v8 L=0.15U W=0.65U AS=0.06825P
+ AD=0.08775P PS=0.86U PD=0.92U
* device instance $1395 r0 *1 33.09,67.44 sky130_fd_pr__nfet_01v8
M$1395 1202 1051 97 97 sky130_fd_pr__nfet_01v8 L=0.15U W=0.65U AS=0.08775P
+ AD=0.169P PS=0.92U PD=1.82U
* device instance $1396 r0 *1 34.03,67.44 sky130_fd_pr__nfet_01v8
M$1396 1202 1058 97 97 sky130_fd_pr__nfet_01v8 L=0.15U W=0.65U AS=0.169P
+ AD=0.08775P PS=1.82U PD=0.92U
* device instance $1397 r0 *1 34.45,67.44 sky130_fd_pr__nfet_01v8
M$1397 1154 1155 1202 1202 sky130_fd_pr__nfet_01v8 L=0.15U W=0.65U AS=0.08775P
+ AD=0.195P PS=0.92U PD=1.9U
* device instance $1398 r0 *1 36.81,67.44 sky130_fd_pr__nfet_01v8
M$1398 97 1189 1156 1156 sky130_fd_pr__nfet_01v8 L=0.15U W=0.65U AS=0.169P
+ AD=0.10725P PS=1.82U PD=0.98U
* device instance $1399 r0 *1 37.29,67.44 sky130_fd_pr__nfet_01v8
M$1399 1228 1134 97 97 sky130_fd_pr__nfet_01v8 L=0.15U W=0.65U AS=0.10725P
+ AD=0.06825P PS=0.98U PD=0.86U
* device instance $1400 r0 *1 37.65,67.44 sky130_fd_pr__nfet_01v8
M$1400 1156 92 1228 1228 sky130_fd_pr__nfet_01v8 L=0.15U W=0.65U AS=0.06825P
+ AD=0.169P PS=0.86U PD=1.82U
* device instance $1401 r0 *1 38.59,67.44 sky130_fd_pr__nfet_01v8
M$1401 1227 1203 1156 1156 sky130_fd_pr__nfet_01v8 L=0.15U W=0.65U AS=0.169P
+ AD=0.10725P PS=1.82U PD=0.98U
* device instance $1402 r0 *1 39.07,67.44 sky130_fd_pr__nfet_01v8
M$1402 97 1018 1227 1227 sky130_fd_pr__nfet_01v8 L=0.15U W=0.65U AS=0.10725P
+ AD=0.102375P PS=0.98U PD=0.965U
* device instance $1403 r0 *1 39.535,67.44 sky130_fd_pr__nfet_01v8
M$1403 1204 1156 97 97 sky130_fd_pr__nfet_01v8 L=0.15U W=0.65U AS=0.102375P
+ AD=0.169P PS=0.965U PD=1.82U
* device instance $1404 r0 *1 40.49,67.555 sky130_fd_pr__nfet_01v8
M$1404 97 979 1159 1159 sky130_fd_pr__nfet_01v8 L=0.15U W=0.42U AS=0.1092P
+ AD=0.0567P PS=1.36U PD=0.69U
* device instance $1405 r0 *1 40.91,67.555 sky130_fd_pr__nfet_01v8
M$1405 1160 1159 97 97 sky130_fd_pr__nfet_01v8 L=0.15U W=0.42U AS=0.0567P
+ AD=0.1092P PS=0.69U PD=1.36U
* device instance $1406 r0 *1 41.85,67.555 sky130_fd_pr__nfet_01v8
M$1406 1225 1190 1161 1161 sky130_fd_pr__nfet_01v8 L=0.15U W=0.42U AS=0.1092P
+ AD=0.0441P PS=1.36U PD=0.63U
* device instance $1407 r0 *1 42.21,67.555 sky130_fd_pr__nfet_01v8
M$1407 97 409 1225 1225 sky130_fd_pr__nfet_01v8 L=0.15U W=0.42U AS=0.0441P
+ AD=0.1092P PS=0.63U PD=1.36U
* device instance $1408 r0 *1 43.15,67.555 sky130_fd_pr__nfet_01v8
M$1408 97 409 1162 1162 sky130_fd_pr__nfet_01v8 L=0.15U W=0.42U AS=0.1092P
+ AD=0.0609P PS=1.36U PD=0.71U
* device instance $1409 r0 *1 43.59,67.555 sky130_fd_pr__nfet_01v8
M$1409 1223 1162 97 97 sky130_fd_pr__nfet_01v8 L=0.15U W=0.42U AS=0.0609P
+ AD=0.0756P PS=0.71U PD=0.78U
* device instance $1410 r0 *1 44.1,67.555 sky130_fd_pr__nfet_01v8
M$1410 1161 1166 1223 1223 sky130_fd_pr__nfet_01v8 L=0.15U W=0.42U AS=0.0756P
+ AD=0.1446P PS=0.78U PD=1.18U
* device instance $1411 r0 *1 45.01,67.585 sky130_fd_pr__nfet_01v8
M$1411 1163 1159 1161 1161 sky130_fd_pr__nfet_01v8 L=0.15U W=0.36U AS=0.1446P
+ AD=0.0522P PS=1.18U PD=0.65U
* device instance $1412 r0 *1 45.45,67.585 sky130_fd_pr__nfet_01v8
M$1412 1163 1160 1221 1221 sky130_fd_pr__nfet_01v8 L=0.15U W=0.36U AS=0.0759P
+ AD=0.0522P PS=0.8U PD=0.65U
* device instance $1413 r0 *1 45.98,67.555 sky130_fd_pr__nfet_01v8
M$1413 1221 1164 97 97 sky130_fd_pr__nfet_01v8 L=0.15U W=0.42U AS=0.12095P
+ AD=0.0759P PS=1.085U PD=0.8U
* device instance $1414 r0 *1 46.575,67.445 sky130_fd_pr__nfet_01v8
M$1414 1164 1163 97 97 sky130_fd_pr__nfet_01v8 L=0.15U W=0.64U AS=0.12095P
+ AD=0.1664P PS=1.085U PD=1.8U
* device instance $1415 r0 *1 47.515,67.555 sky130_fd_pr__nfet_01v8
M$1415 1219 1164 97 97 sky130_fd_pr__nfet_01v8 L=0.15U W=0.42U AS=0.1092P
+ AD=0.0678P PS=1.36U PD=0.755U
* device instance $1416 r0 *1 48,67.585 sky130_fd_pr__nfet_01v8
M$1416 1165 1160 1219 1219 sky130_fd_pr__nfet_01v8 L=0.15U W=0.36U AS=0.0678P
+ AD=0.0684P PS=0.755U PD=0.74U
* device instance $1417 r0 *1 48.53,67.585 sky130_fd_pr__nfet_01v8
M$1417 1165 1159 1218 1218 sky130_fd_pr__nfet_01v8 L=0.15U W=0.36U AS=0.066P
+ AD=0.0684P PS=0.745U PD=0.74U
* device instance $1418 r0 *1 49.005,67.555 sky130_fd_pr__nfet_01v8
M$1418 97 1166 1218 1218 sky130_fd_pr__nfet_01v8 L=0.15U W=0.42U AS=0.066P
+ AD=0.1092P PS=0.745U PD=1.36U
* device instance $1419 r0 *1 49.945,67.555 sky130_fd_pr__nfet_01v8
M$1419 1166 1165 97 97 sky130_fd_pr__nfet_01v8 L=0.15U W=0.42U AS=0.10025P
+ AD=0.1092P PS=0.985U PD=1.36U
* device instance $1420 r0 *1 50.43,67.44 sky130_fd_pr__nfet_01v8
M$1420 1134 1165 97 97 sky130_fd_pr__nfet_01v8 L=0.15U W=0.65U AS=0.10025P
+ AD=0.182P PS=0.985U PD=1.86U
* device instance $1421 r0 *1 60.34,67.555 sky130_fd_pr__nfet_01v8
M$1421 1217 1024 1167 1167 sky130_fd_pr__nfet_01v8 L=0.15U W=0.42U AS=0.1113P
+ AD=0.0441P PS=1.37U PD=0.63U
* device instance $1422 r0 *1 60.7,67.555 sky130_fd_pr__nfet_01v8
M$1422 97 1052 1217 1217 sky130_fd_pr__nfet_01v8 L=0.15U W=0.42U AS=0.0441P
+ AD=0.0966P PS=0.63U PD=0.88U
* device instance $1423 r0 *1 61.31,67.555 sky130_fd_pr__nfet_01v8
M$1423 1168 1167 97 97 sky130_fd_pr__nfet_01v8 L=0.15U W=0.42U AS=0.0966P
+ AD=0.1113P PS=0.88U PD=1.37U
* device instance $1424 r0 *1 62.61,67.44 sky130_fd_pr__nfet_01v8
M$1424 1169 1039 97 97 sky130_fd_pr__nfet_01v8 L=0.15U W=0.65U AS=0.169P
+ AD=0.08775P PS=1.82U PD=0.92U
* device instance $1425 r0 *1 63.03,67.44 sky130_fd_pr__nfet_01v8
M$1425 97 1168 1169 1169 sky130_fd_pr__nfet_01v8 L=0.15U W=0.65U AS=0.08775P
+ AD=0.08775P PS=0.92U PD=0.92U
* device instance $1426 r0 *1 63.45,67.44 sky130_fd_pr__nfet_01v8
M$1426 1215 1168 97 97 sky130_fd_pr__nfet_01v8 L=0.15U W=0.65U AS=0.08775P
+ AD=0.08775P PS=0.92U PD=0.92U
* device instance $1427 r0 *1 63.87,67.44 sky130_fd_pr__nfet_01v8
M$1427 1191 1039 1215 1215 sky130_fd_pr__nfet_01v8 L=0.15U W=0.65U AS=0.08775P
+ AD=0.25025P PS=0.92U PD=1.42U
* device instance $1428 r0 *1 64.79,67.44 sky130_fd_pr__nfet_01v8
M$1428 97 1169 1191 1191 sky130_fd_pr__nfet_01v8 L=0.15U W=0.65U AS=0.25025P
+ AD=0.208P PS=1.42U PD=1.94U
* device instance $1429 r0 *1 65.79,67.555 sky130_fd_pr__nfet_01v8
M$1429 97 979 1171 1171 sky130_fd_pr__nfet_01v8 L=0.15U W=0.42U AS=0.1092P
+ AD=0.0567P PS=1.36U PD=0.69U
* device instance $1430 r0 *1 66.21,67.555 sky130_fd_pr__nfet_01v8
M$1430 1172 1171 97 97 sky130_fd_pr__nfet_01v8 L=0.15U W=0.42U AS=0.0567P
+ AD=0.1092P PS=0.69U PD=1.36U
* device instance $1431 r0 *1 67.15,67.555 sky130_fd_pr__nfet_01v8
M$1431 1211 1192 1173 1173 sky130_fd_pr__nfet_01v8 L=0.15U W=0.42U AS=0.1092P
+ AD=0.0441P PS=1.36U PD=0.63U
* device instance $1432 r0 *1 67.51,67.555 sky130_fd_pr__nfet_01v8
M$1432 97 409 1211 1211 sky130_fd_pr__nfet_01v8 L=0.15U W=0.42U AS=0.0441P
+ AD=0.1092P PS=0.63U PD=1.36U
* device instance $1433 r0 *1 68.45,67.555 sky130_fd_pr__nfet_01v8
M$1433 97 409 1174 1174 sky130_fd_pr__nfet_01v8 L=0.15U W=0.42U AS=0.1092P
+ AD=0.0609P PS=1.36U PD=0.71U
* device instance $1434 r0 *1 68.89,67.555 sky130_fd_pr__nfet_01v8
M$1434 1209 1174 97 97 sky130_fd_pr__nfet_01v8 L=0.15U W=0.42U AS=0.0609P
+ AD=0.0756P PS=0.71U PD=0.78U
* device instance $1435 r0 *1 69.4,67.555 sky130_fd_pr__nfet_01v8
M$1435 1173 1178 1209 1209 sky130_fd_pr__nfet_01v8 L=0.15U W=0.42U AS=0.0756P
+ AD=0.1446P PS=0.78U PD=1.18U
* device instance $1436 r0 *1 70.31,67.585 sky130_fd_pr__nfet_01v8
M$1436 1175 1171 1173 1173 sky130_fd_pr__nfet_01v8 L=0.15U W=0.36U AS=0.1446P
+ AD=0.0522P PS=1.18U PD=0.65U
* device instance $1437 r0 *1 70.75,67.585 sky130_fd_pr__nfet_01v8
M$1437 1175 1172 1208 1208 sky130_fd_pr__nfet_01v8 L=0.15U W=0.36U AS=0.0759P
+ AD=0.0522P PS=0.8U PD=0.65U
* device instance $1438 r0 *1 71.28,67.555 sky130_fd_pr__nfet_01v8
M$1438 1208 1176 97 97 sky130_fd_pr__nfet_01v8 L=0.15U W=0.42U AS=0.12095P
+ AD=0.0759P PS=1.085U PD=0.8U
* device instance $1439 r0 *1 71.875,67.445 sky130_fd_pr__nfet_01v8
M$1439 1176 1175 97 97 sky130_fd_pr__nfet_01v8 L=0.15U W=0.64U AS=0.12095P
+ AD=0.1664P PS=1.085U PD=1.8U
* device instance $1440 r0 *1 72.815,67.555 sky130_fd_pr__nfet_01v8
M$1440 1206 1176 97 97 sky130_fd_pr__nfet_01v8 L=0.15U W=0.42U AS=0.1092P
+ AD=0.0678P PS=1.36U PD=0.755U
* device instance $1441 r0 *1 73.3,67.585 sky130_fd_pr__nfet_01v8
M$1441 1177 1172 1206 1206 sky130_fd_pr__nfet_01v8 L=0.15U W=0.36U AS=0.0678P
+ AD=0.0684P PS=0.755U PD=0.74U
* device instance $1442 r0 *1 73.83,67.585 sky130_fd_pr__nfet_01v8
M$1442 1177 1171 1205 1205 sky130_fd_pr__nfet_01v8 L=0.15U W=0.36U AS=0.066P
+ AD=0.0684P PS=0.745U PD=0.74U
* device instance $1443 r0 *1 74.305,67.555 sky130_fd_pr__nfet_01v8
M$1443 97 1178 1205 1205 sky130_fd_pr__nfet_01v8 L=0.15U W=0.42U AS=0.066P
+ AD=0.1092P PS=0.745U PD=1.36U
* device instance $1444 r0 *1 75.245,67.555 sky130_fd_pr__nfet_01v8
M$1444 1178 1177 97 97 sky130_fd_pr__nfet_01v8 L=0.15U W=0.42U AS=0.10025P
+ AD=0.1092P PS=0.985U PD=1.36U
* device instance $1445 r0 *1 75.73,67.44 sky130_fd_pr__nfet_01v8
M$1445 1132 1177 97 97 sky130_fd_pr__nfet_01v8 L=0.15U W=0.65U AS=0.10025P
+ AD=0.182P PS=0.985U PD=1.86U
* device instance $1446 r0 *1 5.555,68.56 sky130_fd_pr__nfet_01v8
M$1446 1280 1200 97 97 sky130_fd_pr__nfet_01v8 L=0.15U W=0.65U AS=0.18525P
+ AD=0.089375P PS=1.87U PD=0.925U
* device instance $1447 r0 *1 5.98,68.56 sky130_fd_pr__nfet_01v8
M$1447 1145 1229 1280 1280 sky130_fd_pr__nfet_01v8 L=0.15U W=0.65U AS=0.089375P
+ AD=0.091P PS=0.925U PD=0.93U
* device instance $1448 r0 *1 6.41,68.56 sky130_fd_pr__nfet_01v8
M$1448 1282 1229 1145 1145 sky130_fd_pr__nfet_01v8 L=0.15U W=0.65U AS=0.091P
+ AD=0.06825P PS=0.93U PD=0.86U
* device instance $1449 r0 *1 6.77,68.56 sky130_fd_pr__nfet_01v8
M$1449 97 1200 1282 1282 sky130_fd_pr__nfet_01v8 L=0.15U W=0.65U AS=0.06825P
+ AD=0.10725P PS=0.86U PD=0.98U
* device instance $1450 r0 *1 7.25,68.56 sky130_fd_pr__nfet_01v8
M$1450 1145 1128 97 97 sky130_fd_pr__nfet_01v8 L=0.15U W=1.3U AS=0.195P
+ AD=0.34775P PS=1.9U PD=3.02U
* device instance $1452 r0 *1 8.75,68.445 sky130_fd_pr__nfet_01v8
M$1452 97 681 1230 1230 sky130_fd_pr__nfet_01v8 L=0.15U W=0.42U AS=0.1092P
+ AD=0.0567P PS=1.36U PD=0.69U
* device instance $1453 r0 *1 9.17,68.445 sky130_fd_pr__nfet_01v8
M$1453 1231 1230 97 97 sky130_fd_pr__nfet_01v8 L=0.15U W=0.42U AS=0.0567P
+ AD=0.1092P PS=0.69U PD=1.36U
* device instance $1454 r0 *1 10.67,68.415 sky130_fd_pr__nfet_01v8
M$1454 1233 1230 1232 1232 sky130_fd_pr__nfet_01v8 L=0.15U W=0.36U AS=0.0813P
+ AD=0.0621P PS=0.83U PD=0.705U
* device instance $1455 r0 *1 11.165,68.415 sky130_fd_pr__nfet_01v8
M$1455 1258 1231 1233 1233 sky130_fd_pr__nfet_01v8 L=0.15U W=0.36U AS=0.0621P
+ AD=0.0696P PS=0.705U PD=0.765U
* device instance $1456 r0 *1 12.76,68.415 sky130_fd_pr__nfet_01v8
M$1456 1235 1231 1234 1234 sky130_fd_pr__nfet_01v8 L=0.15U W=0.36U AS=0.0989P
+ AD=0.0684P PS=0.995U PD=0.74U
* device instance $1457 r0 *1 13.29,68.415 sky130_fd_pr__nfet_01v8
M$1457 1259 1230 1235 1235 sky130_fd_pr__nfet_01v8 L=0.15U W=0.36U AS=0.0684P
+ AD=0.066P PS=0.74U PD=0.745U
* device instance $1458 r0 *1 10.11,68.445 sky130_fd_pr__nfet_01v8
M$1458 1232 1146 97 97 sky130_fd_pr__nfet_01v8 L=0.15U W=0.42U AS=0.1092P
+ AD=0.0813P PS=1.36U PD=0.83U
* device instance $1459 r0 *1 11.66,68.445 sky130_fd_pr__nfet_01v8
M$1459 97 1234 1258 1258 sky130_fd_pr__nfet_01v8 L=0.15U W=0.42U AS=0.0696P
+ AD=0.12095P PS=0.765U PD=1.085U
* device instance $1460 r0 *1 13.765,68.445 sky130_fd_pr__nfet_01v8
M$1460 97 1236 1259 1259 sky130_fd_pr__nfet_01v8 L=0.15U W=0.42U AS=0.066P
+ AD=0.1092P PS=0.745U PD=1.36U
* device instance $1461 r0 *1 12.255,68.555 sky130_fd_pr__nfet_01v8
M$1461 1234 1233 97 97 sky130_fd_pr__nfet_01v8 L=0.15U W=0.64U AS=0.12095P
+ AD=0.0989P PS=1.085U PD=0.995U
* device instance $1462 r0 *1 14.71,68.56 sky130_fd_pr__nfet_01v8
M$1462 97 1235 1236 1236 sky130_fd_pr__nfet_01v8 L=0.15U W=0.65U AS=0.169P
+ AD=0.08775P PS=1.82U PD=0.92U
* device instance $1463 r0 *1 15.13,68.56 sky130_fd_pr__nfet_01v8
M$1463 1187 1236 97 97 sky130_fd_pr__nfet_01v8 L=0.15U W=0.65U AS=0.08775P
+ AD=0.169P PS=0.92U PD=1.82U
* device instance $1464 r0 *1 22.09,68.445 sky130_fd_pr__nfet_01v8
M$1464 97 681 1237 1237 sky130_fd_pr__nfet_01v8 L=0.15U W=0.42U AS=0.1092P
+ AD=0.0567P PS=1.36U PD=0.69U
* device instance $1465 r0 *1 22.51,68.445 sky130_fd_pr__nfet_01v8
M$1465 1238 1237 97 97 sky130_fd_pr__nfet_01v8 L=0.15U W=0.42U AS=0.0567P
+ AD=0.1092P PS=0.69U PD=1.36U
* device instance $1466 r0 *1 23.45,68.445 sky130_fd_pr__nfet_01v8
M$1466 1262 1274 1239 1239 sky130_fd_pr__nfet_01v8 L=0.15U W=0.42U AS=0.1092P
+ AD=0.0441P PS=1.36U PD=0.63U
* device instance $1467 r0 *1 23.81,68.445 sky130_fd_pr__nfet_01v8
M$1467 97 409 1262 1262 sky130_fd_pr__nfet_01v8 L=0.15U W=0.42U AS=0.0441P
+ AD=0.1092P PS=0.63U PD=1.36U
* device instance $1468 r0 *1 26.61,68.415 sky130_fd_pr__nfet_01v8
M$1468 1241 1237 1239 1239 sky130_fd_pr__nfet_01v8 L=0.15U W=0.36U AS=0.1446P
+ AD=0.0522P PS=1.18U PD=0.65U
* device instance $1469 r0 *1 27.05,68.415 sky130_fd_pr__nfet_01v8
M$1469 1264 1238 1241 1241 sky130_fd_pr__nfet_01v8 L=0.15U W=0.36U AS=0.0522P
+ AD=0.0759P PS=0.65U PD=0.8U
* device instance $1470 r0 *1 24.75,68.445 sky130_fd_pr__nfet_01v8
M$1470 97 409 1240 1240 sky130_fd_pr__nfet_01v8 L=0.15U W=0.42U AS=0.1092P
+ AD=0.0609P PS=1.36U PD=0.71U
* device instance $1471 r0 *1 25.19,68.445 sky130_fd_pr__nfet_01v8
M$1471 1263 1240 97 97 sky130_fd_pr__nfet_01v8 L=0.15U W=0.42U AS=0.0609P
+ AD=0.0756P PS=0.71U PD=0.78U
* device instance $1472 r0 *1 25.7,68.445 sky130_fd_pr__nfet_01v8
M$1472 1239 1275 1263 1263 sky130_fd_pr__nfet_01v8 L=0.15U W=0.42U AS=0.0756P
+ AD=0.1446P PS=0.78U PD=1.18U
* device instance $1473 r0 *1 27.58,68.445 sky130_fd_pr__nfet_01v8
M$1473 97 1242 1264 1264 sky130_fd_pr__nfet_01v8 L=0.15U W=0.42U AS=0.0759P
+ AD=0.12095P PS=0.8U PD=1.085U
* device instance $1474 r0 *1 28.175,68.555 sky130_fd_pr__nfet_01v8
M$1474 1242 1241 97 97 sky130_fd_pr__nfet_01v8 L=0.15U W=0.64U AS=0.12095P
+ AD=0.1664P PS=1.085U PD=1.8U
* device instance $1475 r0 *1 29.6,68.415 sky130_fd_pr__nfet_01v8
M$1475 1243 1238 1265 1265 sky130_fd_pr__nfet_01v8 L=0.15U W=0.36U AS=0.0678P
+ AD=0.0684P PS=0.755U PD=0.74U
* device instance $1476 r0 *1 30.13,68.415 sky130_fd_pr__nfet_01v8
M$1476 1266 1237 1243 1243 sky130_fd_pr__nfet_01v8 L=0.15U W=0.36U AS=0.0684P
+ AD=0.066P PS=0.74U PD=0.745U
* device instance $1477 r0 *1 29.115,68.445 sky130_fd_pr__nfet_01v8
M$1477 1265 1242 97 97 sky130_fd_pr__nfet_01v8 L=0.15U W=0.42U AS=0.1092P
+ AD=0.0678P PS=1.36U PD=0.755U
* device instance $1478 r0 *1 30.605,68.445 sky130_fd_pr__nfet_01v8
M$1478 97 1275 1266 1266 sky130_fd_pr__nfet_01v8 L=0.15U W=0.42U AS=0.066P
+ AD=0.1092P PS=0.745U PD=1.36U
* device instance $1479 r0 *1 31.545,68.445 sky130_fd_pr__nfet_01v8
M$1479 97 1243 1275 1275 sky130_fd_pr__nfet_01v8 L=0.15U W=0.42U AS=0.1092P
+ AD=0.10025P PS=1.36U PD=0.985U
* device instance $1480 r0 *1 32.03,68.56 sky130_fd_pr__nfet_01v8
M$1480 893 1243 97 97 sky130_fd_pr__nfet_01v8 L=0.15U W=0.65U AS=0.10025P
+ AD=0.182P PS=0.985U PD=1.86U
* device instance $1481 r0 *1 33.13,68.56 sky130_fd_pr__nfet_01v8
M$1481 97 999 1244 1244 sky130_fd_pr__nfet_01v8 L=0.15U W=0.65U AS=0.169P
+ AD=0.08775P PS=1.82U PD=0.92U
* device instance $1482 r0 *1 33.55,68.56 sky130_fd_pr__nfet_01v8
M$1482 1203 1244 97 97 sky130_fd_pr__nfet_01v8 L=0.15U W=2.6U AS=0.351P
+ AD=0.43225P PS=3.68U PD=4.58U
* device instance $1486 r0 *1 40.51,68.56 sky130_fd_pr__nfet_01v8
M$1486 1285 1276 97 97 sky130_fd_pr__nfet_01v8 L=0.15U W=0.65U AS=0.169P
+ AD=0.08775P PS=1.82U PD=0.92U
* device instance $1487 r0 *1 40.93,68.56 sky130_fd_pr__nfet_01v8
M$1487 845 64 1285 1285 sky130_fd_pr__nfet_01v8 L=0.15U W=0.65U AS=0.08775P
+ AD=0.169P PS=0.92U PD=1.82U
* device instance $1488 r0 *1 41.94,68.445 sky130_fd_pr__nfet_01v8
M$1488 1267 1286 1245 1245 sky130_fd_pr__nfet_01v8 L=0.15U W=0.42U AS=0.1113P
+ AD=0.0441P PS=1.37U PD=0.63U
* device instance $1489 r0 *1 42.3,68.445 sky130_fd_pr__nfet_01v8
M$1489 97 115 1267 1267 sky130_fd_pr__nfet_01v8 L=0.15U W=0.42U AS=0.0441P
+ AD=0.0966P PS=0.63U PD=0.88U
* device instance $1490 r0 *1 42.91,68.445 sky130_fd_pr__nfet_01v8
M$1490 1189 1245 97 97 sky130_fd_pr__nfet_01v8 L=0.15U W=0.42U AS=0.0966P
+ AD=0.1113P PS=0.88U PD=1.37U
* device instance $1491 r0 *1 44.63,68.445 sky130_fd_pr__nfet_01v8
M$1491 97 979 1246 1246 sky130_fd_pr__nfet_01v8 L=0.15U W=0.42U AS=0.1092P
+ AD=0.0567P PS=1.36U PD=0.69U
* device instance $1492 r0 *1 45.05,68.445 sky130_fd_pr__nfet_01v8
M$1492 1247 1246 97 97 sky130_fd_pr__nfet_01v8 L=0.15U W=0.42U AS=0.0567P
+ AD=0.1092P PS=0.69U PD=1.36U
* device instance $1493 r0 *1 45.99,68.445 sky130_fd_pr__nfet_01v8
M$1493 1269 1204 1248 1248 sky130_fd_pr__nfet_01v8 L=0.15U W=0.42U AS=0.1092P
+ AD=0.0441P PS=1.36U PD=0.63U
* device instance $1494 r0 *1 46.35,68.445 sky130_fd_pr__nfet_01v8
M$1494 97 302 1269 1269 sky130_fd_pr__nfet_01v8 L=0.15U W=0.42U AS=0.0441P
+ AD=0.1092P PS=0.63U PD=1.36U
* device instance $1495 r0 *1 49.15,68.415 sky130_fd_pr__nfet_01v8
M$1495 1250 1246 1248 1248 sky130_fd_pr__nfet_01v8 L=0.15U W=0.36U AS=0.1446P
+ AD=0.0522P PS=1.18U PD=0.65U
* device instance $1496 r0 *1 49.59,68.415 sky130_fd_pr__nfet_01v8
M$1496 1271 1247 1250 1250 sky130_fd_pr__nfet_01v8 L=0.15U W=0.36U AS=0.0522P
+ AD=0.0759P PS=0.65U PD=0.8U
* device instance $1497 r0 *1 47.29,68.445 sky130_fd_pr__nfet_01v8
M$1497 97 302 1249 1249 sky130_fd_pr__nfet_01v8 L=0.15U W=0.42U AS=0.1092P
+ AD=0.0609P PS=1.36U PD=0.71U
* device instance $1498 r0 *1 47.73,68.445 sky130_fd_pr__nfet_01v8
M$1498 1270 1249 97 97 sky130_fd_pr__nfet_01v8 L=0.15U W=0.42U AS=0.0609P
+ AD=0.0756P PS=0.71U PD=0.78U
* device instance $1499 r0 *1 48.24,68.445 sky130_fd_pr__nfet_01v8
M$1499 1248 1277 1270 1270 sky130_fd_pr__nfet_01v8 L=0.15U W=0.42U AS=0.0756P
+ AD=0.1446P PS=0.78U PD=1.18U
* device instance $1500 r0 *1 50.12,68.445 sky130_fd_pr__nfet_01v8
M$1500 97 1251 1271 1271 sky130_fd_pr__nfet_01v8 L=0.15U W=0.42U AS=0.0759P
+ AD=0.12095P PS=0.8U PD=1.085U
* device instance $1501 r0 *1 50.715,68.555 sky130_fd_pr__nfet_01v8
M$1501 1251 1250 97 97 sky130_fd_pr__nfet_01v8 L=0.15U W=0.64U AS=0.12095P
+ AD=0.1664P PS=1.085U PD=1.8U
* device instance $1502 r0 *1 52.14,68.415 sky130_fd_pr__nfet_01v8
M$1502 1252 1247 1273 1273 sky130_fd_pr__nfet_01v8 L=0.15U W=0.36U AS=0.0678P
+ AD=0.0684P PS=0.755U PD=0.74U
* device instance $1503 r0 *1 52.67,68.415 sky130_fd_pr__nfet_01v8
M$1503 1272 1246 1252 1252 sky130_fd_pr__nfet_01v8 L=0.15U W=0.36U AS=0.0684P
+ AD=0.066P PS=0.74U PD=0.745U
* device instance $1504 r0 *1 51.655,68.445 sky130_fd_pr__nfet_01v8
M$1504 1273 1251 97 97 sky130_fd_pr__nfet_01v8 L=0.15U W=0.42U AS=0.1092P
+ AD=0.0678P PS=1.36U PD=0.755U
* device instance $1505 r0 *1 53.145,68.445 sky130_fd_pr__nfet_01v8
M$1505 97 1277 1272 1272 sky130_fd_pr__nfet_01v8 L=0.15U W=0.42U AS=0.066P
+ AD=0.1092P PS=0.745U PD=1.36U
* device instance $1506 r0 *1 54.085,68.445 sky130_fd_pr__nfet_01v8
M$1506 97 1252 1277 1277 sky130_fd_pr__nfet_01v8 L=0.15U W=0.42U AS=0.1092P
+ AD=0.10025P PS=1.36U PD=0.985U
* device instance $1507 r0 *1 54.57,68.56 sky130_fd_pr__nfet_01v8
M$1507 1114 1252 97 97 sky130_fd_pr__nfet_01v8 L=0.15U W=0.65U AS=0.10025P
+ AD=0.182P PS=0.985U PD=1.86U
* device instance $1508 r0 *1 57.12,68.445 sky130_fd_pr__nfet_01v8
M$1508 1268 1287 1253 1253 sky130_fd_pr__nfet_01v8 L=0.15U W=0.42U AS=0.1113P
+ AD=0.0441P PS=1.37U PD=0.63U
* device instance $1509 r0 *1 57.48,68.445 sky130_fd_pr__nfet_01v8
M$1509 97 115 1268 1268 sky130_fd_pr__nfet_01v8 L=0.15U W=0.42U AS=0.0441P
+ AD=0.0966P PS=0.63U PD=0.88U
* device instance $1510 r0 *1 58.09,68.445 sky130_fd_pr__nfet_01v8
M$1510 1025 1253 97 97 sky130_fd_pr__nfet_01v8 L=0.15U W=0.42U AS=0.0966P
+ AD=0.1113P PS=0.88U PD=1.37U
* device instance $1511 r0 *1 60.27,68.56 sky130_fd_pr__nfet_01v8
M$1511 97 1278 1254 1254 sky130_fd_pr__nfet_01v8 L=0.15U W=0.65U AS=0.169P
+ AD=0.10725P PS=1.82U PD=0.98U
* device instance $1512 r0 *1 60.75,68.56 sky130_fd_pr__nfet_01v8
M$1512 1284 1279 97 97 sky130_fd_pr__nfet_01v8 L=0.15U W=0.65U AS=0.10725P
+ AD=0.06825P PS=0.98U PD=0.86U
* device instance $1513 r0 *1 61.11,68.56 sky130_fd_pr__nfet_01v8
M$1513 1254 92 1284 1284 sky130_fd_pr__nfet_01v8 L=0.15U W=0.65U AS=0.06825P
+ AD=0.169P PS=0.86U PD=1.82U
* device instance $1514 r0 *1 62.05,68.56 sky130_fd_pr__nfet_01v8
M$1514 1283 1021 1254 1254 sky130_fd_pr__nfet_01v8 L=0.15U W=0.65U AS=0.169P
+ AD=0.10725P PS=1.82U PD=0.98U
* device instance $1515 r0 *1 62.53,68.56 sky130_fd_pr__nfet_01v8
M$1515 97 1191 1283 1283 sky130_fd_pr__nfet_01v8 L=0.15U W=0.65U AS=0.10725P
+ AD=0.102375P PS=0.98U PD=0.965U
* device instance $1516 r0 *1 62.995,68.56 sky130_fd_pr__nfet_01v8
M$1516 1289 1254 97 97 sky130_fd_pr__nfet_01v8 L=0.15U W=0.65U AS=0.102375P
+ AD=0.169P PS=0.965U PD=1.82U
* device instance $1517 r0 *1 63.95,68.675 sky130_fd_pr__nfet_01v8
M$1517 1255 1132 97 97 sky130_fd_pr__nfet_01v8 L=0.15U W=0.42U AS=0.10025P
+ AD=0.1092P PS=0.985U PD=1.36U
* device instance $1518 r0 *1 64.435,68.56 sky130_fd_pr__nfet_01v8
M$1518 1281 1131 97 97 sky130_fd_pr__nfet_01v8 L=0.15U W=0.65U AS=0.10025P
+ AD=0.08775P PS=0.985U PD=0.92U
* device instance $1519 r0 *1 64.855,68.56 sky130_fd_pr__nfet_01v8
M$1519 1024 1255 1281 1281 sky130_fd_pr__nfet_01v8 L=0.15U W=0.65U AS=0.08775P
+ AD=0.169P PS=0.92U PD=1.82U
* device instance $1520 r0 *1 68.175,68.445 sky130_fd_pr__nfet_01v8
M$1520 1261 64 97 97 sky130_fd_pr__nfet_01v8 L=0.15U W=0.42U AS=0.11285P
+ AD=0.0693P PS=1.045U PD=0.75U
* device instance $1521 r0 *1 68.655,68.445 sky130_fd_pr__nfet_01v8
M$1521 1256 1290 1261 1261 sky130_fd_pr__nfet_01v8 L=0.15U W=0.42U AS=0.0693P
+ AD=0.09975P PS=0.75U PD=0.895U
* device instance $1522 r0 *1 69.28,68.445 sky130_fd_pr__nfet_01v8
M$1522 1260 1131 1256 1256 sky130_fd_pr__nfet_01v8 L=0.15U W=0.42U AS=0.09975P
+ AD=0.0693P PS=0.895U PD=0.75U
* device instance $1523 r0 *1 69.76,68.445 sky130_fd_pr__nfet_01v8
M$1523 97 1257 1260 1260 sky130_fd_pr__nfet_01v8 L=0.15U W=0.42U AS=0.0693P
+ AD=0.1449P PS=0.75U PD=1.11U
* device instance $1524 r0 *1 70.6,68.445 sky130_fd_pr__nfet_01v8
M$1524 1257 64 97 97 sky130_fd_pr__nfet_01v8 L=0.15U W=0.42U AS=0.1449P
+ AD=0.1092P PS=1.11U PD=1.36U
* device instance $1525 r0 *1 67.63,68.56 sky130_fd_pr__nfet_01v8
M$1525 97 1256 1192 1192 sky130_fd_pr__nfet_01v8 L=0.15U W=0.65U AS=0.169P
+ AD=0.11285P PS=1.82U PD=1.045U
* device instance $1526 r0 *1 8.29,72.995 sky130_fd_pr__nfet_01v8
M$1526 97 681 1307 1307 sky130_fd_pr__nfet_01v8 L=0.15U W=0.42U AS=0.1092P
+ AD=0.0567P PS=1.36U PD=0.69U
* device instance $1527 r0 *1 8.71,72.995 sky130_fd_pr__nfet_01v8
M$1527 1308 1307 97 97 sky130_fd_pr__nfet_01v8 L=0.15U W=0.42U AS=0.0567P
+ AD=0.1092P PS=0.69U PD=1.36U
* device instance $1528 r0 *1 9.65,72.995 sky130_fd_pr__nfet_01v8
M$1528 1309 1098 97 97 sky130_fd_pr__nfet_01v8 L=0.15U W=0.42U AS=0.1092P
+ AD=0.0813P PS=1.36U PD=0.83U
* device instance $1529 r0 *1 10.21,73.025 sky130_fd_pr__nfet_01v8
M$1529 1310 1307 1309 1309 sky130_fd_pr__nfet_01v8 L=0.15U W=0.36U AS=0.0813P
+ AD=0.0621P PS=0.83U PD=0.705U
* device instance $1530 r0 *1 10.705,73.025 sky130_fd_pr__nfet_01v8
M$1530 1310 1308 1344 1344 sky130_fd_pr__nfet_01v8 L=0.15U W=0.36U AS=0.0696P
+ AD=0.0621P PS=0.765U PD=0.705U
* device instance $1531 r0 *1 11.2,72.995 sky130_fd_pr__nfet_01v8
M$1531 1344 1311 97 97 sky130_fd_pr__nfet_01v8 L=0.15U W=0.42U AS=0.12095P
+ AD=0.0696P PS=1.085U PD=0.765U
* device instance $1532 r0 *1 11.795,72.885 sky130_fd_pr__nfet_01v8
M$1532 1311 1310 97 97 sky130_fd_pr__nfet_01v8 L=0.15U W=0.64U AS=0.12095P
+ AD=0.0989P PS=1.085U PD=0.995U
* device instance $1533 r0 *1 12.3,73.025 sky130_fd_pr__nfet_01v8
M$1533 1312 1308 1311 1311 sky130_fd_pr__nfet_01v8 L=0.15U W=0.36U AS=0.0989P
+ AD=0.0684P PS=0.995U PD=0.74U
* device instance $1534 r0 *1 12.83,73.025 sky130_fd_pr__nfet_01v8
M$1534 1312 1307 1346 1346 sky130_fd_pr__nfet_01v8 L=0.15U W=0.36U AS=0.066P
+ AD=0.0684P PS=0.745U PD=0.74U
* device instance $1535 r0 *1 13.305,72.995 sky130_fd_pr__nfet_01v8
M$1535 97 1313 1346 1346 sky130_fd_pr__nfet_01v8 L=0.15U W=0.42U AS=0.066P
+ AD=0.1092P PS=0.745U PD=1.36U
* device instance $1536 r0 *1 14.25,72.88 sky130_fd_pr__nfet_01v8
M$1536 97 1312 1313 1313 sky130_fd_pr__nfet_01v8 L=0.15U W=0.65U AS=0.169P
+ AD=0.08775P PS=1.82U PD=0.92U
* device instance $1537 r0 *1 14.67,72.88 sky130_fd_pr__nfet_01v8
M$1537 1130 1313 97 97 sky130_fd_pr__nfet_01v8 L=0.15U W=0.65U AS=0.08775P
+ AD=0.169P PS=0.92U PD=1.82U
* device instance $1538 r0 *1 26.23,72.88 sky130_fd_pr__nfet_01v8
M$1538 97 1314 1274 1274 sky130_fd_pr__nfet_01v8 L=0.15U W=0.65U AS=0.169P
+ AD=0.11285P PS=1.82U PD=1.045U
* device instance $1539 r0 *1 26.775,72.995 sky130_fd_pr__nfet_01v8
M$1539 1351 64 97 97 sky130_fd_pr__nfet_01v8 L=0.15U W=0.42U AS=0.11285P
+ AD=0.0693P PS=1.045U PD=0.75U
* device instance $1540 r0 *1 27.255,72.995 sky130_fd_pr__nfet_01v8
M$1540 1314 1315 1351 1351 sky130_fd_pr__nfet_01v8 L=0.15U W=0.42U AS=0.0693P
+ AD=0.09975P PS=0.75U PD=0.895U
* device instance $1541 r0 *1 27.88,72.995 sky130_fd_pr__nfet_01v8
M$1541 1352 993 1314 1314 sky130_fd_pr__nfet_01v8 L=0.15U W=0.42U AS=0.09975P
+ AD=0.0693P PS=0.895U PD=0.75U
* device instance $1542 r0 *1 28.36,72.995 sky130_fd_pr__nfet_01v8
M$1542 97 1339 1352 1352 sky130_fd_pr__nfet_01v8 L=0.15U W=0.42U AS=0.0693P
+ AD=0.1449P PS=0.75U PD=1.11U
* device instance $1543 r0 *1 29.2,72.995 sky130_fd_pr__nfet_01v8
M$1543 1339 64 97 97 sky130_fd_pr__nfet_01v8 L=0.15U W=0.42U AS=0.1449P
+ AD=0.1092P PS=1.11U PD=1.36U
* device instance $1544 r0 *1 44.63,72.88 sky130_fd_pr__nfet_01v8
M$1544 97 1316 1190 1190 sky130_fd_pr__nfet_01v8 L=0.15U W=0.65U AS=0.169P
+ AD=0.11285P PS=1.82U PD=1.045U
* device instance $1545 r0 *1 45.175,72.995 sky130_fd_pr__nfet_01v8
M$1545 1350 64 97 97 sky130_fd_pr__nfet_01v8 L=0.15U W=0.42U AS=0.11285P
+ AD=0.0693P PS=1.045U PD=0.75U
* device instance $1546 r0 *1 45.655,72.995 sky130_fd_pr__nfet_01v8
M$1546 1316 1317 1350 1350 sky130_fd_pr__nfet_01v8 L=0.15U W=0.42U AS=0.0693P
+ AD=0.09975P PS=0.75U PD=0.895U
* device instance $1547 r0 *1 46.28,72.995 sky130_fd_pr__nfet_01v8
M$1547 1349 1114 1316 1316 sky130_fd_pr__nfet_01v8 L=0.15U W=0.42U AS=0.09975P
+ AD=0.0693P PS=0.895U PD=0.75U
* device instance $1548 r0 *1 46.76,72.995 sky130_fd_pr__nfet_01v8
M$1548 97 1340 1349 1349 sky130_fd_pr__nfet_01v8 L=0.15U W=0.42U AS=0.0693P
+ AD=0.1449P PS=0.75U PD=1.11U
* device instance $1549 r0 *1 47.6,72.995 sky130_fd_pr__nfet_01v8
M$1549 1340 64 97 97 sky130_fd_pr__nfet_01v8 L=0.15U W=0.42U AS=0.1449P
+ AD=0.1092P PS=1.11U PD=1.36U
* device instance $1550 r0 *1 58.5,72.995 sky130_fd_pr__nfet_01v8
M$1550 1348 1318 1319 1319 sky130_fd_pr__nfet_01v8 L=0.15U W=0.42U AS=0.1113P
+ AD=0.0441P PS=1.37U PD=0.63U
* device instance $1551 r0 *1 58.86,72.995 sky130_fd_pr__nfet_01v8
M$1551 97 115 1348 1348 sky130_fd_pr__nfet_01v8 L=0.15U W=0.42U AS=0.0441P
+ AD=0.0966P PS=0.63U PD=0.88U
* device instance $1552 r0 *1 59.47,72.995 sky130_fd_pr__nfet_01v8
M$1552 1278 1319 97 97 sky130_fd_pr__nfet_01v8 L=0.15U W=0.42U AS=0.0966P
+ AD=0.1113P PS=0.88U PD=1.37U
* device instance $1553 r0 *1 60.73,72.995 sky130_fd_pr__nfet_01v8
M$1553 97 979 1320 1320 sky130_fd_pr__nfet_01v8 L=0.15U W=0.42U AS=0.1092P
+ AD=0.0567P PS=1.36U PD=0.69U
* device instance $1554 r0 *1 61.15,72.995 sky130_fd_pr__nfet_01v8
M$1554 1321 1320 97 97 sky130_fd_pr__nfet_01v8 L=0.15U W=0.42U AS=0.0567P
+ AD=0.1092P PS=0.69U PD=1.36U
* device instance $1555 r0 *1 62.09,72.995 sky130_fd_pr__nfet_01v8
M$1555 1347 1289 1322 1322 sky130_fd_pr__nfet_01v8 L=0.15U W=0.42U AS=0.1092P
+ AD=0.0441P PS=1.36U PD=0.63U
* device instance $1556 r0 *1 62.45,72.995 sky130_fd_pr__nfet_01v8
M$1556 97 302 1347 1347 sky130_fd_pr__nfet_01v8 L=0.15U W=0.42U AS=0.0441P
+ AD=0.1092P PS=0.63U PD=1.36U
* device instance $1557 r0 *1 63.39,72.995 sky130_fd_pr__nfet_01v8
M$1557 97 302 1323 1323 sky130_fd_pr__nfet_01v8 L=0.15U W=0.42U AS=0.1092P
+ AD=0.0609P PS=1.36U PD=0.71U
* device instance $1558 r0 *1 63.83,72.995 sky130_fd_pr__nfet_01v8
M$1558 1345 1323 97 97 sky130_fd_pr__nfet_01v8 L=0.15U W=0.42U AS=0.0609P
+ AD=0.0756P PS=0.71U PD=0.78U
* device instance $1559 r0 *1 64.34,72.995 sky130_fd_pr__nfet_01v8
M$1559 1322 1327 1345 1345 sky130_fd_pr__nfet_01v8 L=0.15U W=0.42U AS=0.0756P
+ AD=0.1446P PS=0.78U PD=1.18U
* device instance $1560 r0 *1 65.25,73.025 sky130_fd_pr__nfet_01v8
M$1560 1324 1320 1322 1322 sky130_fd_pr__nfet_01v8 L=0.15U W=0.36U AS=0.1446P
+ AD=0.0522P PS=1.18U PD=0.65U
* device instance $1561 r0 *1 65.69,73.025 sky130_fd_pr__nfet_01v8
M$1561 1324 1321 1343 1343 sky130_fd_pr__nfet_01v8 L=0.15U W=0.36U AS=0.0759P
+ AD=0.0522P PS=0.8U PD=0.65U
* device instance $1562 r0 *1 66.22,72.995 sky130_fd_pr__nfet_01v8
M$1562 1343 1325 97 97 sky130_fd_pr__nfet_01v8 L=0.15U W=0.42U AS=0.12095P
+ AD=0.0759P PS=1.085U PD=0.8U
* device instance $1563 r0 *1 66.815,72.885 sky130_fd_pr__nfet_01v8
M$1563 1325 1324 97 97 sky130_fd_pr__nfet_01v8 L=0.15U W=0.64U AS=0.12095P
+ AD=0.1664P PS=1.085U PD=1.8U
* device instance $1564 r0 *1 65.79,74 sky130_fd_pr__nfet_01v8
M$1564 97 1132 1353 1353 sky130_fd_pr__nfet_01v8 L=0.15U W=0.65U AS=0.169P
+ AD=0.08775P PS=1.82U PD=0.92U
* device instance $1565 r0 *1 66.21,74 sky130_fd_pr__nfet_01v8
M$1565 1279 1353 97 97 sky130_fd_pr__nfet_01v8 L=0.15U W=2.6U AS=0.351P
+ AD=0.43225P PS=3.68U PD=4.58U
* device instance $1569 r0 *1 67.755,72.995 sky130_fd_pr__nfet_01v8
M$1569 1342 1325 97 97 sky130_fd_pr__nfet_01v8 L=0.15U W=0.42U AS=0.1092P
+ AD=0.0678P PS=1.36U PD=0.755U
* device instance $1570 r0 *1 68.24,73.025 sky130_fd_pr__nfet_01v8
M$1570 1326 1321 1342 1342 sky130_fd_pr__nfet_01v8 L=0.15U W=0.36U AS=0.0678P
+ AD=0.0684P PS=0.755U PD=0.74U
* device instance $1571 r0 *1 68.77,73.025 sky130_fd_pr__nfet_01v8
M$1571 1326 1320 1341 1341 sky130_fd_pr__nfet_01v8 L=0.15U W=0.36U AS=0.066P
+ AD=0.0684P PS=0.745U PD=0.74U
* device instance $1572 r0 *1 69.245,72.995 sky130_fd_pr__nfet_01v8
M$1572 97 1327 1341 1341 sky130_fd_pr__nfet_01v8 L=0.15U W=0.42U AS=0.066P
+ AD=0.1092P PS=0.745U PD=1.36U
* device instance $1573 r0 *1 70.185,72.995 sky130_fd_pr__nfet_01v8
M$1573 1327 1326 97 97 sky130_fd_pr__nfet_01v8 L=0.15U W=0.42U AS=0.10025P
+ AD=0.1092P PS=0.985U PD=1.36U
* device instance $1574 r0 *1 70.67,72.88 sky130_fd_pr__nfet_01v8
M$1574 1131 1326 97 97 sky130_fd_pr__nfet_01v8 L=0.15U W=0.65U AS=0.10025P
+ AD=0.182P PS=0.985U PD=1.86U
* device instance $1575 r0 *1 14.525,4.885 sky130_fd_pr__pfet_01v8
M$1575 9 12 37 37 sky130_fd_pr__pfet_01v8 L=0.15U W=0.64U AS=0.154P AD=0.1728P
+ PS=1.335U PD=1.82U
* device instance $1576 r0 *1 15.01,4.705 sky130_fd_pr__pfet_01v8
M$1576 13 12 37 37 sky130_fd_pr__pfet_01v8 L=0.15U W=1U AS=0.154P AD=0.28P
+ PS=1.335U PD=2.56U
* device instance $1577 r0 *1 70.185,4.885 sky130_fd_pr__pfet_01v8
M$1577 17 20 37 37 sky130_fd_pr__pfet_01v8 L=0.15U W=0.64U AS=0.154P AD=0.1728P
+ PS=1.335U PD=1.82U
* device instance $1578 r0 *1 70.67,4.705 sky130_fd_pr__pfet_01v8
M$1578 21 20 37 37 sky130_fd_pr__pfet_01v8 L=0.15U W=1U AS=0.154P AD=0.28P
+ PS=1.335U PD=2.56U
* device instance $1579 r0 *1 5.07,4.855 sky130_fd_pr__pfet_01v8
M$1579 37 32 6 6 sky130_fd_pr__pfet_01v8 L=0.15U W=0.64U AS=0.1664P AD=0.0864P
+ PS=1.8U PD=0.91U
* device instance $1580 r0 *1 5.49,4.855 sky130_fd_pr__pfet_01v8
M$1580 7 6 37 37 sky130_fd_pr__pfet_01v8 L=0.15U W=0.64U AS=0.0864P AD=0.1664P
+ PS=0.91U PD=1.8U
* device instance $1581 r0 *1 6.43,4.885 sky130_fd_pr__pfet_01v8
M$1581 38 33 8 8 sky130_fd_pr__pfet_01v8 L=0.15U W=0.64U AS=0.1664P AD=0.0672P
+ PS=1.8U PD=0.85U
* device instance $1582 r0 *1 6.79,4.885 sky130_fd_pr__pfet_01v8
M$1582 37 34 38 38 sky130_fd_pr__pfet_01v8 L=0.15U W=0.64U AS=0.0672P
+ AD=0.1664P PS=0.85U PD=1.8U
* device instance $1583 r0 *1 7.73,4.885 sky130_fd_pr__pfet_01v8
M$1583 37 94 34 34 sky130_fd_pr__pfet_01v8 L=0.15U W=0.64U AS=0.1664P
+ AD=0.0928P PS=1.8U PD=0.93U
* device instance $1584 r0 *1 8.17,4.885 sky130_fd_pr__pfet_01v8
M$1584 41 94 37 37 sky130_fd_pr__pfet_01v8 L=0.15U W=0.64U AS=0.0928P
+ AD=0.1152P PS=0.93U PD=1U
* device instance $1585 r0 *1 8.68,4.885 sky130_fd_pr__pfet_01v8
M$1585 8 9 41 41 sky130_fd_pr__pfet_01v8 L=0.15U W=0.64U AS=0.1152P AD=0.15985P
+ PS=1U PD=1.265U
* device instance $1586 r0 *1 9.455,4.995 sky130_fd_pr__pfet_01v8
M$1586 10 7 8 8 sky130_fd_pr__pfet_01v8 L=0.15U W=0.42U AS=0.15985P AD=0.06405P
+ PS=1.265U PD=0.725U
* device instance $1587 r0 *1 9.91,4.995 sky130_fd_pr__pfet_01v8
M$1587 42 6 10 10 sky130_fd_pr__pfet_01v8 L=0.15U W=0.42U AS=0.06405P
+ AD=0.07665P PS=0.725U PD=0.785U
* device instance $1588 r0 *1 10.425,4.995 sky130_fd_pr__pfet_01v8
M$1588 42 11 37 37 sky130_fd_pr__pfet_01v8 L=0.15U W=0.42U AS=0.178875P
+ AD=0.07665P PS=1.26U PD=0.785U
* device instance $1589 r0 *1 11.085,4.83 sky130_fd_pr__pfet_01v8
M$1589 11 10 37 37 sky130_fd_pr__pfet_01v8 L=0.15U W=0.75U AS=0.178875P
+ AD=0.195P PS=1.26U PD=2.02U
* device instance $1590 r0 *1 60.73,4.855 sky130_fd_pr__pfet_01v8
M$1590 37 333 14 14 sky130_fd_pr__pfet_01v8 L=0.15U W=0.64U AS=0.1664P
+ AD=0.0864P PS=1.8U PD=0.91U
* device instance $1591 r0 *1 61.15,4.855 sky130_fd_pr__pfet_01v8
M$1591 15 14 37 37 sky130_fd_pr__pfet_01v8 L=0.15U W=0.64U AS=0.0864P
+ AD=0.1664P PS=0.91U PD=1.8U
* device instance $1592 r0 *1 62.09,4.885 sky130_fd_pr__pfet_01v8
M$1592 47 35 16 16 sky130_fd_pr__pfet_01v8 L=0.15U W=0.64U AS=0.1664P
+ AD=0.0672P PS=1.8U PD=0.85U
* device instance $1593 r0 *1 62.45,4.885 sky130_fd_pr__pfet_01v8
M$1593 37 36 47 47 sky130_fd_pr__pfet_01v8 L=0.15U W=0.64U AS=0.0672P
+ AD=0.1664P PS=0.85U PD=1.8U
* device instance $1594 r0 *1 63.39,4.885 sky130_fd_pr__pfet_01v8
M$1594 37 302 36 36 sky130_fd_pr__pfet_01v8 L=0.15U W=0.64U AS=0.1664P
+ AD=0.0928P PS=1.8U PD=0.93U
* device instance $1595 r0 *1 63.83,4.885 sky130_fd_pr__pfet_01v8
M$1595 45 302 37 37 sky130_fd_pr__pfet_01v8 L=0.15U W=0.64U AS=0.0928P
+ AD=0.1152P PS=0.93U PD=1U
* device instance $1596 r0 *1 64.34,4.885 sky130_fd_pr__pfet_01v8
M$1596 16 17 45 45 sky130_fd_pr__pfet_01v8 L=0.15U W=0.64U AS=0.1152P
+ AD=0.15985P PS=1U PD=1.265U
* device instance $1597 r0 *1 65.115,4.995 sky130_fd_pr__pfet_01v8
M$1597 18 15 16 16 sky130_fd_pr__pfet_01v8 L=0.15U W=0.42U AS=0.15985P
+ AD=0.06405P PS=1.265U PD=0.725U
* device instance $1598 r0 *1 65.57,4.995 sky130_fd_pr__pfet_01v8
M$1598 43 14 18 18 sky130_fd_pr__pfet_01v8 L=0.15U W=0.42U AS=0.06405P
+ AD=0.07665P PS=0.725U PD=0.785U
* device instance $1599 r0 *1 66.085,4.995 sky130_fd_pr__pfet_01v8
M$1599 43 19 37 37 sky130_fd_pr__pfet_01v8 L=0.15U W=0.42U AS=0.178875P
+ AD=0.07665P PS=1.26U PD=0.785U
* device instance $1600 r0 *1 66.745,4.83 sky130_fd_pr__pfet_01v8
M$1600 19 18 37 37 sky130_fd_pr__pfet_01v8 L=0.15U W=0.75U AS=0.178875P
+ AD=0.195P PS=1.26U PD=2.02U
* device instance $1601 r0 *1 6.89,5.995 sky130_fd_pr__pfet_01v8
M$1601 80 51 50 50 sky130_fd_pr__pfet_01v8 L=0.15U W=0.64U AS=0.1664P
+ AD=0.0672P PS=1.8U PD=0.85U
* device instance $1602 r0 *1 7.25,5.995 sky130_fd_pr__pfet_01v8
M$1602 37 52 80 80 sky130_fd_pr__pfet_01v8 L=0.15U W=0.64U AS=0.0672P
+ AD=0.1664P PS=0.85U PD=1.8U
* device instance $1603 r0 *1 9.915,5.885 sky130_fd_pr__pfet_01v8
M$1603 53 49 50 50 sky130_fd_pr__pfet_01v8 L=0.15U W=0.42U AS=0.15985P
+ AD=0.06405P PS=1.265U PD=0.725U
* device instance $1604 r0 *1 10.37,5.885 sky130_fd_pr__pfet_01v8
M$1604 84 48 53 53 sky130_fd_pr__pfet_01v8 L=0.15U W=0.42U AS=0.06405P
+ AD=0.07665P PS=0.725U PD=0.785U
* device instance $1605 r0 *1 10.885,5.885 sky130_fd_pr__pfet_01v8
M$1605 37 54 84 84 sky130_fd_pr__pfet_01v8 L=0.15U W=0.42U AS=0.07665P
+ AD=0.178875P PS=0.785U PD=1.26U
* device instance $1606 r0 *1 8.19,5.995 sky130_fd_pr__pfet_01v8
M$1606 37 302 52 52 sky130_fd_pr__pfet_01v8 L=0.15U W=0.64U AS=0.1664P
+ AD=0.0928P PS=1.8U PD=0.93U
* device instance $1607 r0 *1 8.63,5.995 sky130_fd_pr__pfet_01v8
M$1607 82 302 37 37 sky130_fd_pr__pfet_01v8 L=0.15U W=0.64U AS=0.0928P
+ AD=0.1152P PS=0.93U PD=1U
* device instance $1608 r0 *1 9.14,5.995 sky130_fd_pr__pfet_01v8
M$1608 50 56 82 82 sky130_fd_pr__pfet_01v8 L=0.15U W=0.64U AS=0.1152P
+ AD=0.15985P PS=1U PD=1.265U
* device instance $1609 r0 *1 11.545,6.05 sky130_fd_pr__pfet_01v8
M$1609 54 53 37 37 sky130_fd_pr__pfet_01v8 L=0.15U W=0.75U AS=0.178875P
+ AD=0.195P PS=1.26U PD=2.02U
* device instance $1610 r0 *1 12.025,4.995 sky130_fd_pr__pfet_01v8
M$1610 44 11 37 37 sky130_fd_pr__pfet_01v8 L=0.15U W=0.42U AS=0.1092P
+ AD=0.06405P PS=1.36U PD=0.725U
* device instance $1611 r0 *1 12.48,4.995 sky130_fd_pr__pfet_01v8
M$1611 12 6 44 44 sky130_fd_pr__pfet_01v8 L=0.15U W=0.42U AS=0.06405P
+ AD=0.0567P PS=0.725U PD=0.69U
* device instance $1612 r0 *1 12.9,4.995 sky130_fd_pr__pfet_01v8
M$1612 46 7 12 12 sky130_fd_pr__pfet_01v8 L=0.15U W=0.42U AS=0.0567P AD=0.0882P
+ PS=0.69U PD=0.84U
* device instance $1613 r0 *1 13.47,4.995 sky130_fd_pr__pfet_01v8
M$1613 37 9 46 46 sky130_fd_pr__pfet_01v8 L=0.15U W=0.42U AS=0.0882P AD=0.1113P
+ PS=0.84U PD=1.37U
* device instance $1614 r0 *1 12.485,5.885 sky130_fd_pr__pfet_01v8
M$1614 85 54 37 37 sky130_fd_pr__pfet_01v8 L=0.15U W=0.42U AS=0.1092P
+ AD=0.06405P PS=1.36U PD=0.725U
* device instance $1615 r0 *1 12.94,5.885 sky130_fd_pr__pfet_01v8
M$1615 55 48 85 85 sky130_fd_pr__pfet_01v8 L=0.15U W=0.42U AS=0.06405P
+ AD=0.0567P PS=0.725U PD=0.69U
* device instance $1616 r0 *1 13.36,5.885 sky130_fd_pr__pfet_01v8
M$1616 86 49 55 55 sky130_fd_pr__pfet_01v8 L=0.15U W=0.42U AS=0.0567P
+ AD=0.0882P PS=0.69U PD=0.84U
* device instance $1617 r0 *1 13.93,5.885 sky130_fd_pr__pfet_01v8
M$1617 37 56 86 86 sky130_fd_pr__pfet_01v8 L=0.15U W=0.42U AS=0.0882P
+ AD=0.1113P PS=0.84U PD=1.37U
* device instance $1618 r0 *1 14.985,5.995 sky130_fd_pr__pfet_01v8
M$1618 37 55 56 56 sky130_fd_pr__pfet_01v8 L=0.15U W=0.64U AS=0.1728P AD=0.154P
+ PS=1.82U PD=1.335U
* device instance $1619 r0 *1 15.47,6.175 sky130_fd_pr__pfet_01v8
M$1619 57 55 37 37 sky130_fd_pr__pfet_01v8 L=0.15U W=1U AS=0.154P AD=0.28P
+ PS=1.335U PD=2.56U
* device instance $1620 r0 *1 23.47,6.175 sky130_fd_pr__pfet_01v8
M$1620 59 91 58 58 sky130_fd_pr__pfet_01v8 L=0.15U W=1U AS=0.26P AD=0.135P
+ PS=2.52U PD=1.27U
* device instance $1621 r0 *1 23.89,6.175 sky130_fd_pr__pfet_01v8
M$1621 60 218 59 59 sky130_fd_pr__pfet_01v8 L=0.15U W=1U AS=0.135P AD=0.135P
+ PS=1.27U PD=1.27U
* device instance $1622 r0 *1 24.31,6.175 sky130_fd_pr__pfet_01v8
M$1622 59 92 60 60 sky130_fd_pr__pfet_01v8 L=0.15U W=1U AS=0.135P AD=0.26P
+ PS=1.27U PD=2.52U
* device instance $1623 r0 *1 25.25,6.175 sky130_fd_pr__pfet_01v8
M$1623 60 158 37 37 sky130_fd_pr__pfet_01v8 L=0.15U W=1U AS=0.26P AD=0.165P
+ PS=2.52U PD=1.33U
* device instance $1624 r0 *1 25.73,6.175 sky130_fd_pr__pfet_01v8
M$1624 37 93 60 60 sky130_fd_pr__pfet_01v8 L=0.15U W=1U AS=0.165P AD=0.1575P
+ PS=1.33U PD=1.315U
* device instance $1625 r0 *1 26.195,6.175 sky130_fd_pr__pfet_01v8
M$1625 62 58 37 37 sky130_fd_pr__pfet_01v8 L=0.15U W=1U AS=0.1575P AD=0.26P
+ PS=1.315U PD=2.52U
* device instance $1626 r0 *1 27.665,5.995 sky130_fd_pr__pfet_01v8
M$1626 90 63 37 37 sky130_fd_pr__pfet_01v8 L=0.15U W=0.64U AS=0.1696P
+ AD=0.0768P PS=1.81U PD=0.88U
* device instance $1627 r0 *1 28.055,5.995 sky130_fd_pr__pfet_01v8
M$1627 61 64 90 90 sky130_fd_pr__pfet_01v8 L=0.15U W=0.64U AS=0.0768P
+ AD=0.0896P PS=0.88U PD=0.92U
* device instance $1628 r0 *1 28.485,5.995 sky130_fd_pr__pfet_01v8
M$1628 37 65 61 61 sky130_fd_pr__pfet_01v8 L=0.15U W=0.64U AS=0.0896P
+ AD=0.1824P PS=0.92U PD=1.85U
* device instance $1629 r0 *1 44.67,6.175 sky130_fd_pr__pfet_01v8
M$1629 95 67 66 66 sky130_fd_pr__pfet_01v8 L=0.15U W=1U AS=0.26P AD=0.135P
+ PS=2.52U PD=1.27U
* device instance $1630 r0 *1 45.09,6.175 sky130_fd_pr__pfet_01v8
M$1630 37 68 95 95 sky130_fd_pr__pfet_01v8 L=0.15U W=1U AS=0.135P AD=0.135P
+ PS=1.27U PD=1.27U
* device instance $1631 r0 *1 45.51,6.175 sky130_fd_pr__pfet_01v8
M$1631 69 68 37 37 sky130_fd_pr__pfet_01v8 L=0.15U W=1U AS=0.135P AD=0.135P
+ PS=1.27U PD=1.27U
* device instance $1632 r0 *1 45.93,6.175 sky130_fd_pr__pfet_01v8
M$1632 37 67 69 69 sky130_fd_pr__pfet_01v8 L=0.15U W=1U AS=0.135P AD=0.26P
+ PS=1.27U PD=2.52U
* device instance $1633 r0 *1 46.87,6.175 sky130_fd_pr__pfet_01v8
M$1633 70 66 69 69 sky130_fd_pr__pfet_01v8 L=0.15U W=1U AS=0.26P AD=0.3P
+ PS=2.52U PD=2.6U
* device instance $1634 r0 *1 66.23,5.995 sky130_fd_pr__pfet_01v8
M$1634 89 74 73 73 sky130_fd_pr__pfet_01v8 L=0.15U W=0.64U AS=0.1664P
+ AD=0.0672P PS=1.8U PD=0.85U
* device instance $1635 r0 *1 66.59,5.995 sky130_fd_pr__pfet_01v8
M$1635 37 75 89 89 sky130_fd_pr__pfet_01v8 L=0.15U W=0.64U AS=0.0672P
+ AD=0.1664P PS=0.85U PD=1.8U
* device instance $1636 r0 *1 69.255,5.885 sky130_fd_pr__pfet_01v8
M$1636 76 72 73 73 sky130_fd_pr__pfet_01v8 L=0.15U W=0.42U AS=0.15985P
+ AD=0.06405P PS=1.265U PD=0.725U
* device instance $1637 r0 *1 69.71,5.885 sky130_fd_pr__pfet_01v8
M$1637 87 71 76 76 sky130_fd_pr__pfet_01v8 L=0.15U W=0.42U AS=0.06405P
+ AD=0.07665P PS=0.725U PD=0.785U
* device instance $1638 r0 *1 70.225,5.885 sky130_fd_pr__pfet_01v8
M$1638 37 77 87 87 sky130_fd_pr__pfet_01v8 L=0.15U W=0.42U AS=0.07665P
+ AD=0.178875P PS=0.785U PD=1.26U
* device instance $1639 r0 *1 67.53,5.995 sky130_fd_pr__pfet_01v8
M$1639 37 94 75 75 sky130_fd_pr__pfet_01v8 L=0.15U W=0.64U AS=0.1664P
+ AD=0.0928P PS=1.8U PD=0.93U
* device instance $1640 r0 *1 67.97,5.995 sky130_fd_pr__pfet_01v8
M$1640 88 94 37 37 sky130_fd_pr__pfet_01v8 L=0.15U W=0.64U AS=0.0928P
+ AD=0.1152P PS=0.93U PD=1U
* device instance $1641 r0 *1 68.48,5.995 sky130_fd_pr__pfet_01v8
M$1641 73 79 88 88 sky130_fd_pr__pfet_01v8 L=0.15U W=0.64U AS=0.1152P
+ AD=0.15985P PS=1U PD=1.265U
* device instance $1642 r0 *1 70.885,6.05 sky130_fd_pr__pfet_01v8
M$1642 77 76 37 37 sky130_fd_pr__pfet_01v8 L=0.15U W=0.75U AS=0.178875P
+ AD=0.195P PS=1.26U PD=2.02U
* device instance $1643 r0 *1 67.685,4.995 sky130_fd_pr__pfet_01v8
M$1643 40 19 37 37 sky130_fd_pr__pfet_01v8 L=0.15U W=0.42U AS=0.1092P
+ AD=0.06405P PS=1.36U PD=0.725U
* device instance $1644 r0 *1 68.14,4.995 sky130_fd_pr__pfet_01v8
M$1644 20 14 40 40 sky130_fd_pr__pfet_01v8 L=0.15U W=0.42U AS=0.06405P
+ AD=0.0567P PS=0.725U PD=0.69U
* device instance $1645 r0 *1 68.56,4.995 sky130_fd_pr__pfet_01v8
M$1645 39 15 20 20 sky130_fd_pr__pfet_01v8 L=0.15U W=0.42U AS=0.0567P
+ AD=0.0882P PS=0.69U PD=0.84U
* device instance $1646 r0 *1 69.13,4.995 sky130_fd_pr__pfet_01v8
M$1646 37 17 39 39 sky130_fd_pr__pfet_01v8 L=0.15U W=0.42U AS=0.0882P
+ AD=0.1113P PS=0.84U PD=1.37U
* device instance $1647 r0 *1 71.825,5.885 sky130_fd_pr__pfet_01v8
M$1647 83 77 37 37 sky130_fd_pr__pfet_01v8 L=0.15U W=0.42U AS=0.1092P
+ AD=0.06405P PS=1.36U PD=0.725U
* device instance $1648 r0 *1 72.28,5.885 sky130_fd_pr__pfet_01v8
M$1648 78 71 83 83 sky130_fd_pr__pfet_01v8 L=0.15U W=0.42U AS=0.06405P
+ AD=0.0567P PS=0.725U PD=0.69U
* device instance $1649 r0 *1 72.7,5.885 sky130_fd_pr__pfet_01v8
M$1649 81 72 78 78 sky130_fd_pr__pfet_01v8 L=0.15U W=0.42U AS=0.0567P
+ AD=0.0882P PS=0.69U PD=0.84U
* device instance $1650 r0 *1 73.27,5.885 sky130_fd_pr__pfet_01v8
M$1650 37 79 81 81 sky130_fd_pr__pfet_01v8 L=0.15U W=0.42U AS=0.0882P
+ AD=0.1113P PS=0.84U PD=1.37U
* device instance $1651 r0 *1 74.325,5.995 sky130_fd_pr__pfet_01v8
M$1651 37 78 79 79 sky130_fd_pr__pfet_01v8 L=0.15U W=0.64U AS=0.1728P AD=0.154P
+ PS=1.82U PD=1.335U
* device instance $1652 r0 *1 74.81,6.175 sky130_fd_pr__pfet_01v8
M$1652 162 78 37 37 sky130_fd_pr__pfet_01v8 L=0.15U W=1U AS=0.154P AD=0.28P
+ PS=1.335U PD=2.56U
* device instance $1653 r0 *1 5.53,6.025 sky130_fd_pr__pfet_01v8
M$1653 37 32 48 48 sky130_fd_pr__pfet_01v8 L=0.15U W=0.64U AS=0.1664P
+ AD=0.0864P PS=1.8U PD=0.91U
* device instance $1654 r0 *1 5.95,6.025 sky130_fd_pr__pfet_01v8
M$1654 49 48 37 37 sky130_fd_pr__pfet_01v8 L=0.15U W=0.64U AS=0.0864P
+ AD=0.1664P PS=0.91U PD=1.8U
* device instance $1655 r0 *1 9.21,10.145 sky130_fd_pr__pfet_01v8
M$1655 166 112 113 113 sky130_fd_pr__pfet_01v8 L=0.15U W=1U AS=0.26P AD=0.135P
+ PS=2.52U PD=1.27U
* device instance $1656 r0 *1 9.63,10.145 sky130_fd_pr__pfet_01v8
M$1656 163 13 166 166 sky130_fd_pr__pfet_01v8 L=0.15U W=1U AS=0.135P AD=0.135P
+ PS=1.27U PD=1.27U
* device instance $1657 r0 *1 10.05,10.145 sky130_fd_pr__pfet_01v8
M$1657 166 92 163 163 sky130_fd_pr__pfet_01v8 L=0.15U W=1U AS=0.135P AD=0.26P
+ PS=1.27U PD=2.52U
* device instance $1658 r0 *1 10.99,10.145 sky130_fd_pr__pfet_01v8
M$1658 163 158 37 37 sky130_fd_pr__pfet_01v8 L=0.15U W=1U AS=0.26P AD=0.165P
+ PS=2.52U PD=1.33U
* device instance $1659 r0 *1 11.47,10.145 sky130_fd_pr__pfet_01v8
M$1659 37 159 163 163 sky130_fd_pr__pfet_01v8 L=0.15U W=1U AS=0.165P AD=0.1575P
+ PS=1.33U PD=1.315U
* device instance $1660 r0 *1 11.935,10.145 sky130_fd_pr__pfet_01v8
M$1660 51 113 37 37 sky130_fd_pr__pfet_01v8 L=0.15U W=1U AS=0.1575P AD=0.26P
+ PS=1.315U PD=2.52U
* device instance $1661 r0 *1 25.31,10.295 sky130_fd_pr__pfet_01v8
M$1661 37 32 116 116 sky130_fd_pr__pfet_01v8 L=0.15U W=0.64U AS=0.1664P
+ AD=0.0864P PS=1.8U PD=0.91U
* device instance $1662 r0 *1 25.73,10.295 sky130_fd_pr__pfet_01v8
M$1662 117 116 37 37 sky130_fd_pr__pfet_01v8 L=0.15U W=0.64U AS=0.0864P
+ AD=0.1664P PS=0.91U PD=1.8U
* device instance $1663 r0 *1 26.67,10.325 sky130_fd_pr__pfet_01v8
M$1663 173 61 118 118 sky130_fd_pr__pfet_01v8 L=0.15U W=0.64U AS=0.1664P
+ AD=0.0672P PS=1.8U PD=0.85U
* device instance $1664 r0 *1 27.03,10.325 sky130_fd_pr__pfet_01v8
M$1664 37 119 173 173 sky130_fd_pr__pfet_01v8 L=0.15U W=0.64U AS=0.0672P
+ AD=0.1664P PS=0.85U PD=1.8U
* device instance $1665 r0 *1 27.97,10.325 sky130_fd_pr__pfet_01v8
M$1665 37 94 119 119 sky130_fd_pr__pfet_01v8 L=0.15U W=0.64U AS=0.1664P
+ AD=0.0928P PS=1.8U PD=0.93U
* device instance $1666 r0 *1 28.41,10.325 sky130_fd_pr__pfet_01v8
M$1666 174 94 37 37 sky130_fd_pr__pfet_01v8 L=0.15U W=0.64U AS=0.0928P
+ AD=0.1152P PS=0.93U PD=1U
* device instance $1667 r0 *1 28.92,10.325 sky130_fd_pr__pfet_01v8
M$1667 118 120 174 174 sky130_fd_pr__pfet_01v8 L=0.15U W=0.64U AS=0.1152P
+ AD=0.15985P PS=1U PD=1.265U
* device instance $1668 r0 *1 29.695,10.435 sky130_fd_pr__pfet_01v8
M$1668 121 117 118 118 sky130_fd_pr__pfet_01v8 L=0.15U W=0.42U AS=0.15985P
+ AD=0.06405P PS=1.265U PD=0.725U
* device instance $1669 r0 *1 30.15,10.435 sky130_fd_pr__pfet_01v8
M$1669 177 116 121 121 sky130_fd_pr__pfet_01v8 L=0.15U W=0.42U AS=0.06405P
+ AD=0.07665P PS=0.725U PD=0.785U
* device instance $1670 r0 *1 30.665,10.435 sky130_fd_pr__pfet_01v8
M$1670 177 122 37 37 sky130_fd_pr__pfet_01v8 L=0.15U W=0.42U AS=0.178875P
+ AD=0.07665P PS=1.26U PD=0.785U
* device instance $1671 r0 *1 31.325,10.27 sky130_fd_pr__pfet_01v8
M$1671 122 121 37 37 sky130_fd_pr__pfet_01v8 L=0.15U W=0.75U AS=0.178875P
+ AD=0.195P PS=1.26U PD=2.02U
* device instance $1672 r0 *1 34.765,10.325 sky130_fd_pr__pfet_01v8
M$1672 120 123 37 37 sky130_fd_pr__pfet_01v8 L=0.15U W=0.64U AS=0.154P
+ AD=0.1728P PS=1.335U PD=1.82U
* device instance $1673 r0 *1 35.25,10.145 sky130_fd_pr__pfet_01v8
M$1673 218 123 37 37 sky130_fd_pr__pfet_01v8 L=0.15U W=1U AS=0.154P AD=0.28P
+ PS=1.335U PD=2.56U
* device instance $1674 r0 *1 47.475,10.24 sky130_fd_pr__pfet_01v8
M$1674 172 64 37 37 sky130_fd_pr__pfet_01v8 L=0.15U W=0.42U AS=0.15835P
+ AD=0.07665P PS=1.395U PD=0.785U
* device instance $1675 r0 *1 47.99,10.24 sky130_fd_pr__pfet_01v8
M$1675 128 129 172 172 sky130_fd_pr__pfet_01v8 L=0.15U W=0.42U AS=0.07665P
+ AD=0.1932P PS=0.785U PD=1.34U
* device instance $1676 r0 *1 49.06,10.24 sky130_fd_pr__pfet_01v8
M$1676 171 130 128 128 sky130_fd_pr__pfet_01v8 L=0.15U W=0.42U AS=0.1932P
+ AD=0.0441P PS=1.34U PD=0.63U
* device instance $1677 r0 *1 49.42,10.24 sky130_fd_pr__pfet_01v8
M$1677 37 131 171 171 sky130_fd_pr__pfet_01v8 L=0.15U W=0.42U AS=0.0441P
+ AD=0.0693P PS=0.63U PD=0.75U
* device instance $1678 r0 *1 49.9,10.24 sky130_fd_pr__pfet_01v8
M$1678 131 64 37 37 sky130_fd_pr__pfet_01v8 L=0.15U W=0.42U AS=0.0693P
+ AD=0.1176P PS=0.75U PD=1.4U
* device instance $1679 r0 *1 46.93,10.145 sky130_fd_pr__pfet_01v8
M$1679 37 128 127 127 sky130_fd_pr__pfet_01v8 L=0.15U W=1U AS=0.26P AD=0.15835P
+ PS=2.52U PD=1.395U
* device instance $1680 r0 *1 59.81,10.145 sky130_fd_pr__pfet_01v8
M$1680 168 133 134 134 sky130_fd_pr__pfet_01v8 L=0.15U W=1U AS=0.26P AD=0.135P
+ PS=2.52U PD=1.27U
* device instance $1681 r0 *1 60.23,10.145 sky130_fd_pr__pfet_01v8
M$1681 165 162 168 168 sky130_fd_pr__pfet_01v8 L=0.15U W=1U AS=0.135P AD=0.135P
+ PS=1.27U PD=1.27U
* device instance $1682 r0 *1 60.65,10.145 sky130_fd_pr__pfet_01v8
M$1682 168 92 165 165 sky130_fd_pr__pfet_01v8 L=0.15U W=1U AS=0.135P AD=0.26P
+ PS=1.27U PD=2.52U
* device instance $1683 r0 *1 61.59,10.145 sky130_fd_pr__pfet_01v8
M$1683 165 135 37 37 sky130_fd_pr__pfet_01v8 L=0.15U W=1U AS=0.26P AD=0.165P
+ PS=2.52U PD=1.33U
* device instance $1684 r0 *1 62.07,10.145 sky130_fd_pr__pfet_01v8
M$1684 37 5 165 165 sky130_fd_pr__pfet_01v8 L=0.15U W=1U AS=0.165P AD=0.1575P
+ PS=1.33U PD=1.315U
* device instance $1685 r0 *1 62.535,10.145 sky130_fd_pr__pfet_01v8
M$1685 35 134 37 37 sky130_fd_pr__pfet_01v8 L=0.15U W=1U AS=0.1575P AD=0.26P
+ PS=1.315U PD=2.52U
* device instance $1686 r0 *1 64.87,6.025 sky130_fd_pr__pfet_01v8
M$1686 37 333 71 71 sky130_fd_pr__pfet_01v8 L=0.15U W=0.64U AS=0.1664P
+ AD=0.0864P PS=1.8U PD=0.91U
* device instance $1687 r0 *1 65.29,6.025 sky130_fd_pr__pfet_01v8
M$1687 72 71 37 37 sky130_fd_pr__pfet_01v8 L=0.15U W=0.64U AS=0.0864P
+ AD=0.1664P PS=0.91U PD=1.8U
* device instance $1688 r0 *1 68.175,10.24 sky130_fd_pr__pfet_01v8
M$1688 170 64 37 37 sky130_fd_pr__pfet_01v8 L=0.15U W=0.42U AS=0.15835P
+ AD=0.07665P PS=1.395U PD=0.785U
* device instance $1689 r0 *1 68.69,10.24 sky130_fd_pr__pfet_01v8
M$1689 136 21 170 170 sky130_fd_pr__pfet_01v8 L=0.15U W=0.42U AS=0.07665P
+ AD=0.1932P PS=0.785U PD=1.34U
* device instance $1690 r0 *1 69.76,10.24 sky130_fd_pr__pfet_01v8
M$1690 169 137 136 136 sky130_fd_pr__pfet_01v8 L=0.15U W=0.42U AS=0.1932P
+ AD=0.0441P PS=1.34U PD=0.63U
* device instance $1691 r0 *1 70.12,10.24 sky130_fd_pr__pfet_01v8
M$1691 37 138 169 169 sky130_fd_pr__pfet_01v8 L=0.15U W=0.42U AS=0.0441P
+ AD=0.0693P PS=0.63U PD=0.75U
* device instance $1692 r0 *1 70.6,10.24 sky130_fd_pr__pfet_01v8
M$1692 138 64 37 37 sky130_fd_pr__pfet_01v8 L=0.15U W=0.42U AS=0.0693P
+ AD=0.1176P PS=0.75U PD=1.4U
* device instance $1693 r0 *1 67.63,10.145 sky130_fd_pr__pfet_01v8
M$1693 37 136 74 74 sky130_fd_pr__pfet_01v8 L=0.15U W=1U AS=0.26P AD=0.15835P
+ PS=2.52U PD=1.395U
* device instance $1694 r0 *1 6.98,10.435 sky130_fd_pr__pfet_01v8
M$1694 111 157 37 37 sky130_fd_pr__pfet_01v8 L=0.15U W=0.42U AS=0.1113P
+ AD=0.0609P PS=1.37U PD=0.71U
* device instance $1695 r0 *1 7.42,10.435 sky130_fd_pr__pfet_01v8
M$1695 111 115 37 37 sky130_fd_pr__pfet_01v8 L=0.15U W=0.42U AS=0.1841P
+ AD=0.0609P PS=1.26U PD=0.71U
* device instance $1696 r0 *1 8.19,10.325 sky130_fd_pr__pfet_01v8
M$1696 112 111 37 37 sky130_fd_pr__pfet_01v8 L=0.15U W=0.64U AS=0.1841P
+ AD=0.1696P PS=1.26U PD=1.81U
* device instance $1697 r0 *1 8.375,11.52 sky130_fd_pr__pfet_01v8
M$1697 222 64 37 37 sky130_fd_pr__pfet_01v8 L=0.15U W=0.42U AS=0.15835P
+ AD=0.07665P PS=1.395U PD=0.785U
* device instance $1698 r0 *1 8.89,11.52 sky130_fd_pr__pfet_01v8
M$1698 178 57 222 222 sky130_fd_pr__pfet_01v8 L=0.15U W=0.42U AS=0.07665P
+ AD=0.1932P PS=0.785U PD=1.34U
* device instance $1699 r0 *1 9.96,11.52 sky130_fd_pr__pfet_01v8
M$1699 223 1 178 178 sky130_fd_pr__pfet_01v8 L=0.15U W=0.42U AS=0.1932P
+ AD=0.0441P PS=1.34U PD=0.63U
* device instance $1700 r0 *1 10.32,11.52 sky130_fd_pr__pfet_01v8
M$1700 37 232 223 223 sky130_fd_pr__pfet_01v8 L=0.15U W=0.42U AS=0.0441P
+ AD=0.0693P PS=0.63U PD=0.75U
* device instance $1701 r0 *1 10.8,11.52 sky130_fd_pr__pfet_01v8
M$1701 232 64 37 37 sky130_fd_pr__pfet_01v8 L=0.15U W=0.42U AS=0.0693P
+ AD=0.1176P PS=0.75U PD=1.4U
* device instance $1702 r0 *1 7.83,11.615 sky130_fd_pr__pfet_01v8
M$1702 37 178 33 33 sky130_fd_pr__pfet_01v8 L=0.15U W=1U AS=0.26P AD=0.15835P
+ PS=2.52U PD=1.395U
* device instance $1703 r0 *1 12.47,11.615 sky130_fd_pr__pfet_01v8
M$1703 179 217 37 37 sky130_fd_pr__pfet_01v8 L=0.15U W=1U AS=0.3P AD=0.135P
+ PS=2.6U PD=1.27U
* device instance $1704 r0 *1 12.89,11.615 sky130_fd_pr__pfet_01v8
M$1704 37 180 179 179 sky130_fd_pr__pfet_01v8 L=0.15U W=1U AS=0.135P AD=0.365P
+ PS=1.27U PD=1.73U
* device instance $1705 r0 *1 13.77,11.615 sky130_fd_pr__pfet_01v8
M$1705 224 180 37 37 sky130_fd_pr__pfet_01v8 L=0.15U W=1U AS=0.365P AD=0.105P
+ PS=1.73U PD=1.21U
* device instance $1706 r0 *1 14.13,11.615 sky130_fd_pr__pfet_01v8
M$1706 159 217 224 224 sky130_fd_pr__pfet_01v8 L=0.15U W=1U AS=0.105P AD=0.165P
+ PS=1.21U PD=1.33U
* device instance $1707 r0 *1 14.61,11.615 sky130_fd_pr__pfet_01v8
M$1707 37 179 159 159 sky130_fd_pr__pfet_01v8 L=0.15U W=1U AS=0.165P AD=0.36P
+ PS=1.33U PD=2.72U
* device instance $1708 r0 *1 15.69,11.615 sky130_fd_pr__pfet_01v8
M$1708 225 57 181 181 sky130_fd_pr__pfet_01v8 L=0.15U W=1U AS=0.26P AD=0.135P
+ PS=2.52U PD=1.27U
* device instance $1709 r0 *1 16.11,11.615 sky130_fd_pr__pfet_01v8
M$1709 37 13 225 225 sky130_fd_pr__pfet_01v8 L=0.15U W=1U AS=0.135P AD=0.135P
+ PS=1.27U PD=1.27U
* device instance $1710 r0 *1 16.53,11.615 sky130_fd_pr__pfet_01v8
M$1710 182 13 37 37 sky130_fd_pr__pfet_01v8 L=0.15U W=1U AS=0.135P AD=0.135P
+ PS=1.27U PD=1.27U
* device instance $1711 r0 *1 16.95,11.615 sky130_fd_pr__pfet_01v8
M$1711 37 57 182 182 sky130_fd_pr__pfet_01v8 L=0.15U W=1U AS=0.135P AD=0.26P
+ PS=1.27U PD=2.52U
* device instance $1712 r0 *1 17.89,11.615 sky130_fd_pr__pfet_01v8
M$1712 217 181 182 182 sky130_fd_pr__pfet_01v8 L=0.15U W=1U AS=0.26P AD=0.3P
+ PS=2.52U PD=2.6U
* device instance $1713 r0 *1 20.69,11.435 sky130_fd_pr__pfet_01v8
M$1713 227 62 185 185 sky130_fd_pr__pfet_01v8 L=0.15U W=0.64U AS=0.1664P
+ AD=0.0672P PS=1.8U PD=0.85U
* device instance $1714 r0 *1 21.05,11.435 sky130_fd_pr__pfet_01v8
M$1714 37 186 227 227 sky130_fd_pr__pfet_01v8 L=0.15U W=0.64U AS=0.0672P
+ AD=0.1664P PS=0.85U PD=1.8U
* device instance $1715 r0 *1 23.715,11.325 sky130_fd_pr__pfet_01v8
M$1715 187 184 185 185 sky130_fd_pr__pfet_01v8 L=0.15U W=0.42U AS=0.15985P
+ AD=0.06405P PS=1.265U PD=0.725U
* device instance $1716 r0 *1 24.17,11.325 sky130_fd_pr__pfet_01v8
M$1716 211 183 187 187 sky130_fd_pr__pfet_01v8 L=0.15U W=0.42U AS=0.06405P
+ AD=0.07665P PS=0.725U PD=0.785U
* device instance $1717 r0 *1 24.685,11.325 sky130_fd_pr__pfet_01v8
M$1717 37 188 211 211 sky130_fd_pr__pfet_01v8 L=0.15U W=0.42U AS=0.07665P
+ AD=0.178875P PS=0.785U PD=1.26U
* device instance $1718 r0 *1 21.99,11.435 sky130_fd_pr__pfet_01v8
M$1718 37 302 186 186 sky130_fd_pr__pfet_01v8 L=0.15U W=0.64U AS=0.1664P
+ AD=0.0928P PS=1.8U PD=0.93U
* device instance $1719 r0 *1 22.43,11.435 sky130_fd_pr__pfet_01v8
M$1719 228 302 37 37 sky130_fd_pr__pfet_01v8 L=0.15U W=0.64U AS=0.0928P
+ AD=0.1152P PS=0.93U PD=1U
* device instance $1720 r0 *1 22.94,11.435 sky130_fd_pr__pfet_01v8
M$1720 185 190 228 228 sky130_fd_pr__pfet_01v8 L=0.15U W=0.64U AS=0.1152P
+ AD=0.15985P PS=1U PD=1.265U
* device instance $1721 r0 *1 25.345,11.49 sky130_fd_pr__pfet_01v8
M$1721 188 187 37 37 sky130_fd_pr__pfet_01v8 L=0.15U W=0.75U AS=0.178875P
+ AD=0.195P PS=1.26U PD=2.02U
* device instance $1722 r0 *1 23.08,10.435 sky130_fd_pr__pfet_01v8
M$1722 114 160 37 37 sky130_fd_pr__pfet_01v8 L=0.15U W=0.42U AS=0.1113P
+ AD=0.0609P PS=1.37U PD=0.71U
* device instance $1723 r0 *1 23.52,10.435 sky130_fd_pr__pfet_01v8
M$1723 114 115 37 37 sky130_fd_pr__pfet_01v8 L=0.15U W=0.42U AS=0.1841P
+ AD=0.0609P PS=1.26U PD=0.71U
* device instance $1724 r0 *1 24.29,10.325 sky130_fd_pr__pfet_01v8
M$1724 91 114 37 37 sky130_fd_pr__pfet_01v8 L=0.15U W=0.64U AS=0.1841P
+ AD=0.1696P PS=1.26U PD=1.81U
* device instance $1725 r0 *1 26.285,11.325 sky130_fd_pr__pfet_01v8
M$1725 212 188 37 37 sky130_fd_pr__pfet_01v8 L=0.15U W=0.42U AS=0.1092P
+ AD=0.06405P PS=1.36U PD=0.725U
* device instance $1726 r0 *1 26.74,11.325 sky130_fd_pr__pfet_01v8
M$1726 189 183 212 212 sky130_fd_pr__pfet_01v8 L=0.15U W=0.42U AS=0.06405P
+ AD=0.0567P PS=0.725U PD=0.69U
* device instance $1727 r0 *1 27.16,11.325 sky130_fd_pr__pfet_01v8
M$1727 213 184 189 189 sky130_fd_pr__pfet_01v8 L=0.15U W=0.42U AS=0.0567P
+ AD=0.0882P PS=0.69U PD=0.84U
* device instance $1728 r0 *1 27.73,11.325 sky130_fd_pr__pfet_01v8
M$1728 37 190 213 213 sky130_fd_pr__pfet_01v8 L=0.15U W=0.42U AS=0.0882P
+ AD=0.1113P PS=0.84U PD=1.37U
* device instance $1729 r0 *1 28.785,11.435 sky130_fd_pr__pfet_01v8
M$1729 37 189 190 190 sky130_fd_pr__pfet_01v8 L=0.15U W=0.64U AS=0.1728P
+ AD=0.154P PS=1.82U PD=1.335U
* device instance $1730 r0 *1 29.27,11.615 sky130_fd_pr__pfet_01v8
M$1730 191 189 37 37 sky130_fd_pr__pfet_01v8 L=0.15U W=1U AS=0.154P AD=0.28P
+ PS=1.335U PD=2.56U
* device instance $1731 r0 *1 30.85,11.615 sky130_fd_pr__pfet_01v8
M$1731 65 2 37 37 sky130_fd_pr__pfet_01v8 L=0.15U W=1U AS=0.26P AD=0.135P
+ PS=2.52U PD=1.27U
* device instance $1732 r0 *1 31.27,11.615 sky130_fd_pr__pfet_01v8
M$1732 37 64 65 65 sky130_fd_pr__pfet_01v8 L=0.15U W=1U AS=0.135P AD=0.26P
+ PS=1.27U PD=2.52U
* device instance $1733 r0 *1 32.21,11.535 sky130_fd_pr__pfet_01v8
M$1733 63 191 37 37 sky130_fd_pr__pfet_01v8 L=0.15U W=1.68U AS=0.3318P
+ AD=0.3486P PS=3.31U PD=3.35U
* device instance $1735 r0 *1 32.265,10.435 sky130_fd_pr__pfet_01v8
M$1735 176 122 37 37 sky130_fd_pr__pfet_01v8 L=0.15U W=0.42U AS=0.1092P
+ AD=0.06405P PS=1.36U PD=0.725U
* device instance $1736 r0 *1 32.72,10.435 sky130_fd_pr__pfet_01v8
M$1736 123 116 176 176 sky130_fd_pr__pfet_01v8 L=0.15U W=0.42U AS=0.06405P
+ AD=0.0567P PS=0.725U PD=0.69U
* device instance $1737 r0 *1 33.14,10.435 sky130_fd_pr__pfet_01v8
M$1737 175 117 123 123 sky130_fd_pr__pfet_01v8 L=0.15U W=0.42U AS=0.0567P
+ AD=0.0882P PS=0.69U PD=0.84U
* device instance $1738 r0 *1 33.71,10.435 sky130_fd_pr__pfet_01v8
M$1738 37 120 175 175 sky130_fd_pr__pfet_01v8 L=0.15U W=0.42U AS=0.0882P
+ AD=0.1113P PS=0.84U PD=1.37U
* device instance $1739 r0 *1 33.605,11.615 sky130_fd_pr__pfet_01v8
M$1739 192 218 37 37 sky130_fd_pr__pfet_01v8 L=0.15U W=2U AS=0.44P AD=0.3P
+ PS=3.88U PD=2.6U
* device instance $1740 r0 *1 34.035,11.615 sky130_fd_pr__pfet_01v8
M$1740 67 63 192 192 sky130_fd_pr__pfet_01v8 L=0.15U W=2U AS=0.28P AD=0.315P
+ PS=2.56U PD=2.63U
* device instance $1743 r0 *1 35.435,11.615 sky130_fd_pr__pfet_01v8
M$1743 67 259 37 37 sky130_fd_pr__pfet_01v8 L=0.15U W=2U AS=0.3P AD=0.405P
+ PS=2.6U PD=3.81U
* device instance $1745 r0 *1 37.34,10.435 sky130_fd_pr__pfet_01v8
M$1745 124 164 37 37 sky130_fd_pr__pfet_01v8 L=0.15U W=0.42U AS=0.1113P
+ AD=0.0609P PS=1.37U PD=0.71U
* device instance $1746 r0 *1 37.78,10.435 sky130_fd_pr__pfet_01v8
M$1746 124 115 37 37 sky130_fd_pr__pfet_01v8 L=0.15U W=0.42U AS=0.1841P
+ AD=0.0609P PS=1.26U PD=0.71U
* device instance $1747 r0 *1 38.55,10.325 sky130_fd_pr__pfet_01v8
M$1747 167 124 37 37 sky130_fd_pr__pfet_01v8 L=0.15U W=0.64U AS=0.1841P
+ AD=0.1696P PS=1.26U PD=1.81U
* device instance $1748 r0 *1 40.95,11.615 sky130_fd_pr__pfet_01v8
M$1748 194 126 193 193 sky130_fd_pr__pfet_01v8 L=0.15U W=1U AS=0.26P AD=0.135P
+ PS=2.52U PD=1.27U
* device instance $1749 r0 *1 41.37,11.615 sky130_fd_pr__pfet_01v8
M$1749 196 195 194 194 sky130_fd_pr__pfet_01v8 L=0.15U W=1U AS=0.135P AD=0.135P
+ PS=1.27U PD=1.27U
* device instance $1750 r0 *1 41.79,11.615 sky130_fd_pr__pfet_01v8
M$1750 194 92 196 196 sky130_fd_pr__pfet_01v8 L=0.15U W=1U AS=0.135P AD=0.26P
+ PS=1.27U PD=2.52U
* device instance $1751 r0 *1 42.73,11.615 sky130_fd_pr__pfet_01v8
M$1751 196 135 37 37 sky130_fd_pr__pfet_01v8 L=0.15U W=1U AS=0.26P AD=0.165P
+ PS=2.52U PD=1.33U
* device instance $1752 r0 *1 43.21,11.615 sky130_fd_pr__pfet_01v8
M$1752 37 70 196 196 sky130_fd_pr__pfet_01v8 L=0.15U W=1U AS=0.165P AD=0.1575P
+ PS=1.33U PD=1.315U
* device instance $1753 r0 *1 43.675,11.615 sky130_fd_pr__pfet_01v8
M$1753 197 193 37 37 sky130_fd_pr__pfet_01v8 L=0.15U W=1U AS=0.1575P AD=0.26P
+ PS=1.315U PD=2.52U
* device instance $1754 r0 *1 44.7,10.435 sky130_fd_pr__pfet_01v8
M$1754 125 161 37 37 sky130_fd_pr__pfet_01v8 L=0.15U W=0.42U AS=0.1113P
+ AD=0.0609P PS=1.37U PD=0.71U
* device instance $1755 r0 *1 45.14,10.435 sky130_fd_pr__pfet_01v8
M$1755 125 115 37 37 sky130_fd_pr__pfet_01v8 L=0.15U W=0.42U AS=0.1841P
+ AD=0.0609P PS=1.26U PD=0.71U
* device instance $1756 r0 *1 45.91,10.325 sky130_fd_pr__pfet_01v8
M$1756 126 125 37 37 sky130_fd_pr__pfet_01v8 L=0.15U W=0.64U AS=0.1841P
+ AD=0.1696P PS=1.26U PD=1.81U
* device instance $1757 r0 *1 48.29,11.435 sky130_fd_pr__pfet_01v8
M$1757 231 127 200 200 sky130_fd_pr__pfet_01v8 L=0.15U W=0.64U AS=0.1664P
+ AD=0.0672P PS=1.8U PD=0.85U
* device instance $1758 r0 *1 48.65,11.435 sky130_fd_pr__pfet_01v8
M$1758 37 201 231 231 sky130_fd_pr__pfet_01v8 L=0.15U W=0.64U AS=0.0672P
+ AD=0.1664P PS=0.85U PD=1.8U
* device instance $1759 r0 *1 51.315,11.325 sky130_fd_pr__pfet_01v8
M$1759 202 199 200 200 sky130_fd_pr__pfet_01v8 L=0.15U W=0.42U AS=0.15985P
+ AD=0.06405P PS=1.265U PD=0.725U
* device instance $1760 r0 *1 51.77,11.325 sky130_fd_pr__pfet_01v8
M$1760 216 198 202 202 sky130_fd_pr__pfet_01v8 L=0.15U W=0.42U AS=0.06405P
+ AD=0.07665P PS=0.725U PD=0.785U
* device instance $1761 r0 *1 52.285,11.325 sky130_fd_pr__pfet_01v8
M$1761 37 203 216 216 sky130_fd_pr__pfet_01v8 L=0.15U W=0.42U AS=0.07665P
+ AD=0.178875P PS=0.785U PD=1.26U
* device instance $1762 r0 *1 49.59,11.435 sky130_fd_pr__pfet_01v8
M$1762 37 94 201 201 sky130_fd_pr__pfet_01v8 L=0.15U W=0.64U AS=0.1664P
+ AD=0.0928P PS=1.8U PD=0.93U
* device instance $1763 r0 *1 50.03,11.435 sky130_fd_pr__pfet_01v8
M$1763 230 94 37 37 sky130_fd_pr__pfet_01v8 L=0.15U W=0.64U AS=0.0928P
+ AD=0.1152P PS=0.93U PD=1U
* device instance $1764 r0 *1 50.54,11.435 sky130_fd_pr__pfet_01v8
M$1764 200 205 230 230 sky130_fd_pr__pfet_01v8 L=0.15U W=0.64U AS=0.1152P
+ AD=0.15985P PS=1U PD=1.265U
* device instance $1765 r0 *1 52.945,11.49 sky130_fd_pr__pfet_01v8
M$1765 203 202 37 37 sky130_fd_pr__pfet_01v8 L=0.15U W=0.75U AS=0.178875P
+ AD=0.195P PS=1.26U PD=2.02U
* device instance $1766 r0 *1 53.885,11.325 sky130_fd_pr__pfet_01v8
M$1766 215 203 37 37 sky130_fd_pr__pfet_01v8 L=0.15U W=0.42U AS=0.1092P
+ AD=0.06405P PS=1.36U PD=0.725U
* device instance $1767 r0 *1 54.34,11.325 sky130_fd_pr__pfet_01v8
M$1767 204 198 215 215 sky130_fd_pr__pfet_01v8 L=0.15U W=0.42U AS=0.06405P
+ AD=0.0567P PS=0.725U PD=0.69U
* device instance $1768 r0 *1 54.76,11.325 sky130_fd_pr__pfet_01v8
M$1768 214 199 204 204 sky130_fd_pr__pfet_01v8 L=0.15U W=0.42U AS=0.0567P
+ AD=0.0882P PS=0.69U PD=0.84U
* device instance $1769 r0 *1 55.33,11.325 sky130_fd_pr__pfet_01v8
M$1769 37 205 214 214 sky130_fd_pr__pfet_01v8 L=0.15U W=0.42U AS=0.0882P
+ AD=0.1113P PS=0.84U PD=1.37U
* device instance $1770 r0 *1 56.385,11.435 sky130_fd_pr__pfet_01v8
M$1770 37 204 205 205 sky130_fd_pr__pfet_01v8 L=0.15U W=0.64U AS=0.1728P
+ AD=0.154P PS=1.82U PD=1.335U
* device instance $1771 r0 *1 56.87,11.615 sky130_fd_pr__pfet_01v8
M$1771 195 204 37 37 sky130_fd_pr__pfet_01v8 L=0.15U W=1U AS=0.154P AD=0.28P
+ PS=1.335U PD=2.56U
* device instance $1772 r0 *1 57.58,10.435 sky130_fd_pr__pfet_01v8
M$1772 132 4 37 37 sky130_fd_pr__pfet_01v8 L=0.15U W=0.42U AS=0.1113P
+ AD=0.0609P PS=1.37U PD=0.71U
* device instance $1773 r0 *1 58.02,10.435 sky130_fd_pr__pfet_01v8
M$1773 132 115 37 37 sky130_fd_pr__pfet_01v8 L=0.15U W=0.42U AS=0.1841P
+ AD=0.0609P PS=1.26U PD=0.71U
* device instance $1774 r0 *1 58.79,10.325 sky130_fd_pr__pfet_01v8
M$1774 133 132 37 37 sky130_fd_pr__pfet_01v8 L=0.15U W=0.64U AS=0.1841P
+ AD=0.1696P PS=1.26U PD=1.81U
* device instance $1775 r0 *1 61.69,11.615 sky130_fd_pr__pfet_01v8
M$1775 229 219 206 206 sky130_fd_pr__pfet_01v8 L=0.15U W=1U AS=0.26P AD=0.135P
+ PS=2.52U PD=1.27U
* device instance $1776 r0 *1 62.11,11.615 sky130_fd_pr__pfet_01v8
M$1776 37 220 229 229 sky130_fd_pr__pfet_01v8 L=0.15U W=1U AS=0.135P AD=0.135P
+ PS=1.27U PD=1.27U
* device instance $1777 r0 *1 62.53,11.615 sky130_fd_pr__pfet_01v8
M$1777 207 220 37 37 sky130_fd_pr__pfet_01v8 L=0.15U W=1U AS=0.135P AD=0.135P
+ PS=1.27U PD=1.27U
* device instance $1778 r0 *1 62.95,11.615 sky130_fd_pr__pfet_01v8
M$1778 37 219 207 207 sky130_fd_pr__pfet_01v8 L=0.15U W=1U AS=0.135P AD=0.26P
+ PS=1.27U PD=2.52U
* device instance $1779 r0 *1 63.89,11.615 sky130_fd_pr__pfet_01v8
M$1779 5 206 207 207 sky130_fd_pr__pfet_01v8 L=0.15U W=1U AS=0.26P AD=0.3P
+ PS=2.52U PD=2.6U
* device instance $1780 r0 *1 66.29,11.615 sky130_fd_pr__pfet_01v8
M$1780 226 21 208 208 sky130_fd_pr__pfet_01v8 L=0.15U W=1U AS=0.26P AD=0.135P
+ PS=2.52U PD=1.27U
* device instance $1781 r0 *1 66.71,11.615 sky130_fd_pr__pfet_01v8
M$1781 37 162 226 226 sky130_fd_pr__pfet_01v8 L=0.15U W=1U AS=0.135P AD=0.135P
+ PS=1.27U PD=1.27U
* device instance $1782 r0 *1 67.13,11.615 sky130_fd_pr__pfet_01v8
M$1782 209 162 37 37 sky130_fd_pr__pfet_01v8 L=0.15U W=1U AS=0.135P AD=0.135P
+ PS=1.27U PD=1.27U
* device instance $1783 r0 *1 67.55,11.615 sky130_fd_pr__pfet_01v8
M$1783 37 21 209 209 sky130_fd_pr__pfet_01v8 L=0.15U W=1U AS=0.135P AD=0.26P
+ PS=1.27U PD=2.52U
* device instance $1784 r0 *1 68.49,11.615 sky130_fd_pr__pfet_01v8
M$1784 220 208 209 209 sky130_fd_pr__pfet_01v8 L=0.15U W=1U AS=0.26P AD=0.3P
+ PS=2.52U PD=2.6U
* device instance $1785 r0 *1 69.47,11.905 sky130_fd_pr__pfet_01v8
M$1785 221 162 37 37 sky130_fd_pr__pfet_01v8 L=0.15U W=0.42U AS=0.14575P
+ AD=0.1092P PS=1.335U PD=1.36U
* device instance $1786 r0 *1 69.955,11.615 sky130_fd_pr__pfet_01v8
M$1786 210 21 37 37 sky130_fd_pr__pfet_01v8 L=0.15U W=1U AS=0.14575P AD=0.135P
+ PS=1.335U PD=1.27U
* device instance $1787 r0 *1 70.375,11.615 sky130_fd_pr__pfet_01v8
M$1787 37 221 210 210 sky130_fd_pr__pfet_01v8 L=0.15U W=1U AS=0.135P AD=0.265P
+ PS=1.27U PD=2.53U
* device instance $1788 r0 *1 12.67,15.295 sky130_fd_pr__pfet_01v8
M$1788 37 57 255 255 sky130_fd_pr__pfet_01v8 L=0.15U W=0.42U AS=0.1092P
+ AD=0.1573P PS=1.36U PD=1.39U
* device instance $1789 r0 *1 13.21,15.585 sky130_fd_pr__pfet_01v8
M$1789 285 13 37 37 sky130_fd_pr__pfet_01v8 L=0.15U W=1U AS=0.1573P AD=0.105P
+ PS=1.39U PD=1.21U
* device instance $1790 r0 *1 13.57,15.585 sky130_fd_pr__pfet_01v8
M$1790 282 255 285 285 sky130_fd_pr__pfet_01v8 L=0.15U W=1U AS=0.105P AD=0.26P
+ PS=1.21U PD=2.52U
* device instance $1791 r0 *1 13.82,17.055 sky130_fd_pr__pfet_01v8
M$1791 37 294 293 293 sky130_fd_pr__pfet_01v8 L=0.15U W=1U AS=0.26P AD=0.26P
+ PS=2.52U PD=2.52U
* device instance $1792 r0 *1 14.73,15.665 sky130_fd_pr__pfet_01v8
M$1792 256 217 37 37 sky130_fd_pr__pfet_01v8 L=0.15U W=1.68U AS=0.3318P
+ AD=0.3486P PS=3.31U PD=3.35U
* device instance $1794 r0 *1 14.76,17.055 sky130_fd_pr__pfet_01v8
M$1794 295 282 294 294 sky130_fd_pr__pfet_01v8 L=0.15U W=1U AS=0.26P AD=0.1375P
+ PS=2.52U PD=1.275U
* device instance $1795 r0 *1 15.185,17.055 sky130_fd_pr__pfet_01v8
M$1795 37 180 295 295 sky130_fd_pr__pfet_01v8 L=0.15U W=1U AS=0.1375P AD=0.14P
+ PS=1.275U PD=1.28U
* device instance $1796 r0 *1 15.615,17.055 sky130_fd_pr__pfet_01v8
M$1796 295 256 37 37 sky130_fd_pr__pfet_01v8 L=0.15U W=1U AS=0.14P AD=0.265P
+ PS=1.28U PD=2.53U
* device instance $1797 r0 *1 19.33,11.465 sky130_fd_pr__pfet_01v8
M$1797 37 32 183 183 sky130_fd_pr__pfet_01v8 L=0.15U W=0.64U AS=0.1664P
+ AD=0.0864P PS=1.8U PD=0.91U
* device instance $1798 r0 *1 19.75,11.465 sky130_fd_pr__pfet_01v8
M$1798 184 183 37 37 sky130_fd_pr__pfet_01v8 L=0.15U W=0.64U AS=0.0864P
+ AD=0.1664P PS=0.91U PD=1.8U
* device instance $1799 r0 *1 28.57,15.585 sky130_fd_pr__pfet_01v8
M$1799 257 191 37 37 sky130_fd_pr__pfet_01v8 L=0.15U W=1U AS=0.3P AD=0.135P
+ PS=2.6U PD=1.27U
* device instance $1800 r0 *1 28.99,15.585 sky130_fd_pr__pfet_01v8
M$1800 37 218 257 257 sky130_fd_pr__pfet_01v8 L=0.15U W=1U AS=0.135P AD=0.365P
+ PS=1.27U PD=1.73U
* device instance $1801 r0 *1 29.87,15.585 sky130_fd_pr__pfet_01v8
M$1801 286 218 37 37 sky130_fd_pr__pfet_01v8 L=0.15U W=1U AS=0.365P AD=0.105P
+ PS=1.73U PD=1.21U
* device instance $1802 r0 *1 30.23,15.585 sky130_fd_pr__pfet_01v8
M$1802 262 191 286 286 sky130_fd_pr__pfet_01v8 L=0.15U W=1U AS=0.105P AD=0.165P
+ PS=1.21U PD=1.33U
* device instance $1803 r0 *1 30.71,15.585 sky130_fd_pr__pfet_01v8
M$1803 37 257 262 262 sky130_fd_pr__pfet_01v8 L=0.15U W=1U AS=0.165P AD=0.36P
+ PS=1.33U PD=2.72U
* device instance $1804 r0 *1 31.99,15.295 sky130_fd_pr__pfet_01v8
M$1804 37 259 261 261 sky130_fd_pr__pfet_01v8 L=0.15U W=0.42U AS=0.1092P
+ AD=0.1573P PS=1.36U PD=1.39U
* device instance $1805 r0 *1 32.53,15.585 sky130_fd_pr__pfet_01v8
M$1805 287 260 37 37 sky130_fd_pr__pfet_01v8 L=0.15U W=1U AS=0.1573P AD=0.105P
+ PS=1.39U PD=1.21U
* device instance $1806 r0 *1 32.89,15.585 sky130_fd_pr__pfet_01v8
M$1806 93 261 287 287 sky130_fd_pr__pfet_01v8 L=0.15U W=1U AS=0.105P AD=0.26P
+ PS=1.21U PD=2.52U
* device instance $1807 r0 *1 34.05,15.585 sky130_fd_pr__pfet_01v8
M$1807 259 262 37 37 sky130_fd_pr__pfet_01v8 L=0.15U W=2U AS=0.395P AD=0.27P
+ PS=3.79U PD=2.54U
* device instance $1809 r0 *1 34.89,15.585 sky130_fd_pr__pfet_01v8
M$1809 259 264 37 37 sky130_fd_pr__pfet_01v8 L=0.15U W=2U AS=0.27P AD=0.395P
+ PS=2.54U PD=3.79U
* device instance $1811 r0 *1 34.07,17.055 sky130_fd_pr__pfet_01v8
M$1811 296 262 260 260 sky130_fd_pr__pfet_01v8 L=0.15U W=1U AS=0.265P AD=0.14P
+ PS=2.53U PD=1.28U
* device instance $1812 r0 *1 34.5,17.055 sky130_fd_pr__pfet_01v8
M$1812 37 264 296 296 sky130_fd_pr__pfet_01v8 L=0.15U W=1U AS=0.14P AD=0.1475P
+ PS=1.28U PD=1.295U
* device instance $1813 r0 *1 34.945,17.055 sky130_fd_pr__pfet_01v8
M$1813 296 266 37 37 sky130_fd_pr__pfet_01v8 L=0.15U W=1U AS=0.1475P AD=0.265P
+ PS=1.295U PD=2.53U
* device instance $1814 r0 *1 35.89,17.055 sky130_fd_pr__pfet_01v8
M$1814 311 63 271 271 sky130_fd_pr__pfet_01v8 L=0.15U W=1U AS=0.26P AD=0.105P
+ PS=2.52U PD=1.21U
* device instance $1815 r0 *1 36.25,17.055 sky130_fd_pr__pfet_01v8
M$1815 37 218 311 311 sky130_fd_pr__pfet_01v8 L=0.15U W=1U AS=0.105P AD=0.26P
+ PS=1.21U PD=2.52U
* device instance $1816 r0 *1 36.25,15.585 sky130_fd_pr__pfet_01v8
M$1816 259 266 37 37 sky130_fd_pr__pfet_01v8 L=0.15U W=2U AS=0.395P AD=0.445P
+ PS=3.79U PD=3.89U
* device instance $1818 r0 *1 37.73,15.585 sky130_fd_pr__pfet_01v8
M$1818 283 264 37 37 sky130_fd_pr__pfet_01v8 L=0.15U W=2U AS=0.395P AD=0.27P
+ PS=3.79U PD=2.54U
* device instance $1820 r0 *1 38.57,15.585 sky130_fd_pr__pfet_01v8
M$1820 283 268 37 37 sky130_fd_pr__pfet_01v8 L=0.15U W=2U AS=0.275P AD=0.285P
+ PS=2.55U PD=2.57U
* device instance $1822 r0 *1 39.44,15.585 sky130_fd_pr__pfet_01v8
M$1822 283 262 37 37 sky130_fd_pr__pfet_01v8 L=0.15U W=2U AS=0.28P AD=0.395P
+ PS=2.56U PD=3.79U
* device instance $1824 r0 *1 40.8,15.585 sky130_fd_pr__pfet_01v8
M$1824 283 271 284 284 sky130_fd_pr__pfet_01v8 L=0.15U W=2U AS=0.395P AD=0.395P
+ PS=3.79U PD=2.79U
* device instance $1826 r0 *1 41.89,15.585 sky130_fd_pr__pfet_01v8
M$1826 270 272 284 284 sky130_fd_pr__pfet_01v8 L=0.15U W=2U AS=0.395P AD=0.395P
+ PS=2.79U PD=3.79U
* device instance $1828 r0 *1 45.33,15.295 sky130_fd_pr__pfet_01v8
M$1828 37 129 273 273 sky130_fd_pr__pfet_01v8 L=0.15U W=0.42U AS=0.1092P
+ AD=0.1573P PS=1.36U PD=1.39U
* device instance $1829 r0 *1 45.87,15.585 sky130_fd_pr__pfet_01v8
M$1829 290 195 37 37 sky130_fd_pr__pfet_01v8 L=0.15U W=1U AS=0.1573P AD=0.105P
+ PS=1.39U PD=1.21U
* device instance $1830 r0 *1 46.23,15.585 sky130_fd_pr__pfet_01v8
M$1830 272 273 290 290 sky130_fd_pr__pfet_01v8 L=0.15U W=1U AS=0.105P AD=0.26P
+ PS=1.21U PD=2.52U
* device instance $1831 r0 *1 45.53,16.875 sky130_fd_pr__pfet_01v8
M$1831 312 197 300 300 sky130_fd_pr__pfet_01v8 L=0.15U W=0.64U AS=0.1664P
+ AD=0.0672P PS=1.8U PD=0.85U
* device instance $1832 r0 *1 45.89,16.875 sky130_fd_pr__pfet_01v8
M$1832 37 301 312 312 sky130_fd_pr__pfet_01v8 L=0.15U W=0.64U AS=0.0672P
+ AD=0.1664P PS=0.85U PD=1.8U
* device instance $1833 r0 *1 48.555,16.765 sky130_fd_pr__pfet_01v8
M$1833 303 299 300 300 sky130_fd_pr__pfet_01v8 L=0.15U W=0.42U AS=0.15985P
+ AD=0.06405P PS=1.265U PD=0.725U
* device instance $1834 r0 *1 49.01,16.765 sky130_fd_pr__pfet_01v8
M$1834 314 298 303 303 sky130_fd_pr__pfet_01v8 L=0.15U W=0.42U AS=0.06405P
+ AD=0.07665P PS=0.725U PD=0.785U
* device instance $1835 r0 *1 49.525,16.765 sky130_fd_pr__pfet_01v8
M$1835 37 304 314 314 sky130_fd_pr__pfet_01v8 L=0.15U W=0.42U AS=0.07665P
+ AD=0.178875P PS=0.785U PD=1.26U
* device instance $1836 r0 *1 46.83,16.875 sky130_fd_pr__pfet_01v8
M$1836 37 302 301 301 sky130_fd_pr__pfet_01v8 L=0.15U W=0.64U AS=0.1664P
+ AD=0.0928P PS=1.8U PD=0.93U
* device instance $1837 r0 *1 47.27,16.875 sky130_fd_pr__pfet_01v8
M$1837 313 302 37 37 sky130_fd_pr__pfet_01v8 L=0.15U W=0.64U AS=0.0928P
+ AD=0.1152P PS=0.93U PD=1U
* device instance $1838 r0 *1 47.78,16.875 sky130_fd_pr__pfet_01v8
M$1838 300 306 313 313 sky130_fd_pr__pfet_01v8 L=0.15U W=0.64U AS=0.1152P
+ AD=0.15985P PS=1U PD=1.265U
* device instance $1839 r0 *1 50.185,16.93 sky130_fd_pr__pfet_01v8
M$1839 304 303 37 37 sky130_fd_pr__pfet_01v8 L=0.15U W=0.75U AS=0.178875P
+ AD=0.195P PS=1.26U PD=2.02U
* device instance $1840 r0 *1 46.93,11.465 sky130_fd_pr__pfet_01v8
M$1840 37 333 198 198 sky130_fd_pr__pfet_01v8 L=0.15U W=0.64U AS=0.1664P
+ AD=0.0864P PS=1.8U PD=0.91U
* device instance $1841 r0 *1 47.35,11.465 sky130_fd_pr__pfet_01v8
M$1841 199 198 37 37 sky130_fd_pr__pfet_01v8 L=0.15U W=0.64U AS=0.0864P
+ AD=0.1664P PS=0.91U PD=1.8U
* device instance $1842 r0 *1 47.39,15.585 sky130_fd_pr__pfet_01v8
M$1842 291 274 68 68 sky130_fd_pr__pfet_01v8 L=0.15U W=1U AS=0.26P AD=0.105P
+ PS=2.52U PD=1.21U
* device instance $1843 r0 *1 47.75,15.585 sky130_fd_pr__pfet_01v8
M$1843 37 272 291 291 sky130_fd_pr__pfet_01v8 L=0.15U W=1U AS=0.105P AD=0.26P
+ PS=1.21U PD=2.52U
* device instance $1844 r0 *1 50.39,15.295 sky130_fd_pr__pfet_01v8
M$1844 37 195 275 275 sky130_fd_pr__pfet_01v8 L=0.15U W=0.42U AS=0.1092P
+ AD=0.1573P PS=1.36U PD=1.39U
* device instance $1845 r0 *1 50.93,15.585 sky130_fd_pr__pfet_01v8
M$1845 292 129 37 37 sky130_fd_pr__pfet_01v8 L=0.15U W=1U AS=0.1573P AD=0.105P
+ PS=1.39U PD=1.21U
* device instance $1846 r0 *1 51.29,15.585 sky130_fd_pr__pfet_01v8
M$1846 274 275 292 292 sky130_fd_pr__pfet_01v8 L=0.15U W=1U AS=0.105P AD=0.26P
+ PS=1.21U PD=2.52U
* device instance $1847 r0 *1 51.125,16.765 sky130_fd_pr__pfet_01v8
M$1847 315 304 37 37 sky130_fd_pr__pfet_01v8 L=0.15U W=0.42U AS=0.1092P
+ AD=0.06405P PS=1.36U PD=0.725U
* device instance $1848 r0 *1 51.58,16.765 sky130_fd_pr__pfet_01v8
M$1848 305 298 315 315 sky130_fd_pr__pfet_01v8 L=0.15U W=0.42U AS=0.06405P
+ AD=0.0567P PS=0.725U PD=0.69U
* device instance $1849 r0 *1 52,16.765 sky130_fd_pr__pfet_01v8
M$1849 316 299 305 305 sky130_fd_pr__pfet_01v8 L=0.15U W=0.42U AS=0.0567P
+ AD=0.0882P PS=0.69U PD=0.84U
* device instance $1850 r0 *1 52.57,16.765 sky130_fd_pr__pfet_01v8
M$1850 37 306 316 316 sky130_fd_pr__pfet_01v8 L=0.15U W=0.42U AS=0.0882P
+ AD=0.1113P PS=0.84U PD=1.37U
* device instance $1851 r0 *1 53.625,16.875 sky130_fd_pr__pfet_01v8
M$1851 37 305 306 306 sky130_fd_pr__pfet_01v8 L=0.15U W=0.64U AS=0.1728P
+ AD=0.154P PS=1.82U PD=1.335U
* device instance $1852 r0 *1 54.11,17.055 sky130_fd_pr__pfet_01v8
M$1852 129 305 37 37 sky130_fd_pr__pfet_01v8 L=0.15U W=1U AS=0.154P AD=0.28P
+ PS=1.335U PD=2.56U
* device instance $1853 r0 *1 57.715,15.295 sky130_fd_pr__pfet_01v8
M$1853 289 274 276 276 sky130_fd_pr__pfet_01v8 L=0.15U W=0.42U AS=0.1092P
+ AD=0.0441P PS=1.36U PD=0.63U
* device instance $1854 r0 *1 58.075,15.295 sky130_fd_pr__pfet_01v8
M$1854 37 270 289 289 sky130_fd_pr__pfet_01v8 L=0.15U W=0.42U AS=0.0441P
+ AD=0.14575P PS=0.63U PD=1.335U
* device instance $1855 r0 *1 58.56,15.585 sky130_fd_pr__pfet_01v8
M$1855 277 276 37 37 sky130_fd_pr__pfet_01v8 L=0.15U W=1U AS=0.14575P AD=0.34P
+ PS=1.335U PD=2.68U
* device instance $1856 r0 *1 59.93,17.055 sky130_fd_pr__pfet_01v8
M$1856 37 220 308 308 sky130_fd_pr__pfet_01v8 L=0.15U W=2U AS=0.395P AD=0.27P
+ PS=3.79U PD=2.54U
* device instance $1858 r0 *1 60.77,17.055 sky130_fd_pr__pfet_01v8
M$1858 309 270 308 308 sky130_fd_pr__pfet_01v8 L=0.15U W=2U AS=0.27P AD=0.395P
+ PS=2.54U PD=3.79U
* device instance $1860 r0 *1 62.13,17.055 sky130_fd_pr__pfet_01v8
M$1860 309 274 307 307 sky130_fd_pr__pfet_01v8 L=0.15U W=2U AS=0.395P AD=0.27P
+ PS=3.79U PD=2.54U
* device instance $1862 r0 *1 62.97,17.055 sky130_fd_pr__pfet_01v8
M$1862 37 210 307 307 sky130_fd_pr__pfet_01v8 L=0.15U W=2U AS=0.44P AD=0.51P
+ PS=2.88U PD=3.02U
* device instance $1864 r0 *1 64.29,17.055 sky130_fd_pr__pfet_01v8
M$1864 37 310 307 307 sky130_fd_pr__pfet_01v8 L=0.15U W=2U AS=0.34P AD=0.395P
+ PS=2.68U PD=3.79U
* device instance $1866 r0 *1 63.545,15.765 sky130_fd_pr__pfet_01v8
M$1866 288 220 37 37 sky130_fd_pr__pfet_01v8 L=0.15U W=0.64U AS=0.1696P
+ AD=0.0768P PS=1.81U PD=0.88U
* device instance $1867 r0 *1 63.935,15.765 sky130_fd_pr__pfet_01v8
M$1867 279 277 288 288 sky130_fd_pr__pfet_01v8 L=0.15U W=0.64U AS=0.0768P
+ AD=0.0896P PS=0.88U PD=0.92U
* device instance $1868 r0 *1 64.365,15.765 sky130_fd_pr__pfet_01v8
M$1868 37 210 279 279 sky130_fd_pr__pfet_01v8 L=0.15U W=0.64U AS=0.0896P
+ AD=0.1824P PS=0.92U PD=1.85U
* device instance $1869 r0 *1 65.33,15.585 sky130_fd_pr__pfet_01v8
M$1869 37 277 280 280 sky130_fd_pr__pfet_01v8 L=0.15U W=1U AS=0.26P AD=0.135P
+ PS=2.52U PD=1.27U
* device instance $1870 r0 *1 65.75,15.585 sky130_fd_pr__pfet_01v8
M$1870 219 280 37 37 sky130_fd_pr__pfet_01v8 L=0.15U W=4U AS=0.54P AD=0.665P
+ PS=5.08U PD=6.33U
* device instance $1874 r0 *1 17.03,21.025 sky130_fd_pr__pfet_01v8
M$1874 37 341 326 326 sky130_fd_pr__pfet_01v8 L=0.15U W=1U AS=0.26P AD=0.135P
+ PS=2.52U PD=1.27U
* device instance $1875 r0 *1 17.45,21.025 sky130_fd_pr__pfet_01v8
M$1875 180 326 37 37 sky130_fd_pr__pfet_01v8 L=0.15U W=4U AS=0.54P AD=0.665P
+ PS=5.08U PD=6.33U
* device instance $1879 r0 *1 19.79,21.025 sky130_fd_pr__pfet_01v8
M$1879 37 341 345 345 sky130_fd_pr__pfet_01v8 L=0.15U W=4U AS=0.665P AD=0.54P
+ PS=6.33U PD=5.08U
* device instance $1882 r0 *1 21.05,21.025 sky130_fd_pr__pfet_01v8
M$1882 345 256 37 37 sky130_fd_pr__pfet_01v8 L=0.15U W=4U AS=0.54P AD=0.54P
+ PS=5.08U PD=5.08U
* device instance $1887 r0 *1 23.15,21.025 sky130_fd_pr__pfet_01v8
M$1887 346 329 345 345 sky130_fd_pr__pfet_01v8 L=0.15U W=2U AS=0.27P AD=0.27P
+ PS=2.54U PD=2.54U
* device instance $1889 r0 *1 23.99,21.025 sky130_fd_pr__pfet_01v8
M$1889 349 329 345 345 sky130_fd_pr__pfet_01v8 L=0.15U W=1U AS=0.135P AD=0.15P
+ PS=1.27U PD=1.3U
* device instance $1890 r0 *1 24.44,21.025 sky130_fd_pr__pfet_01v8
M$1890 328 282 349 349 sky130_fd_pr__pfet_01v8 L=0.15U W=1U AS=0.15P AD=0.14P
+ PS=1.3U PD=1.28U
* device instance $1891 r0 *1 24.87,21.025 sky130_fd_pr__pfet_01v8
M$1891 346 282 328 328 sky130_fd_pr__pfet_01v8 L=0.15U W=2U AS=0.28P AD=0.29P
+ PS=2.56U PD=2.58U
* device instance $1893 r0 *1 25.75,21.025 sky130_fd_pr__pfet_01v8
M$1893 350 282 328 328 sky130_fd_pr__pfet_01v8 L=0.15U W=1U AS=0.15P AD=0.155P
+ PS=1.3U PD=1.31U
* device instance $1894 r0 *1 26.21,21.025 sky130_fd_pr__pfet_01v8
M$1894 345 329 350 350 sky130_fd_pr__pfet_01v8 L=0.15U W=1U AS=0.155P AD=0.26P
+ PS=1.31U PD=2.52U
* device instance $1895 r0 *1 27.155,21.025 sky130_fd_pr__pfet_01v8
M$1895 330 297 37 37 sky130_fd_pr__pfet_01v8 L=0.15U W=4U AS=0.685P AD=0.56P
+ PS=6.37U PD=5.12U
* device instance $1899 r0 *1 28.875,21.025 sky130_fd_pr__pfet_01v8
M$1899 32 330 37 37 sky130_fd_pr__pfet_01v8 L=0.15U W=16U AS=2.2375P AD=2.3625P
+ PS=20.475U PD=21.725U
* device instance $1915 r0 *1 36.35,21.025 sky130_fd_pr__pfet_01v8
M$1915 37 268 331 331 sky130_fd_pr__pfet_01v8 L=0.15U W=1U AS=0.26P AD=0.135P
+ PS=2.52U PD=1.27U
* device instance $1916 r0 *1 36.77,21.025 sky130_fd_pr__pfet_01v8
M$1916 266 331 37 37 sky130_fd_pr__pfet_01v8 L=0.15U W=4U AS=0.54P AD=0.665P
+ PS=5.08U PD=6.33U
* device instance $1920 r0 *1 44.17,16.905 sky130_fd_pr__pfet_01v8
M$1920 37 333 298 298 sky130_fd_pr__pfet_01v8 L=0.15U W=0.64U AS=0.1664P
+ AD=0.0864P PS=1.8U PD=0.91U
* device instance $1921 r0 *1 44.59,16.905 sky130_fd_pr__pfet_01v8
M$1921 299 298 37 37 sky130_fd_pr__pfet_01v8 L=0.15U W=0.64U AS=0.0864P
+ AD=0.1664P PS=0.91U PD=1.8U
* device instance $1922 r0 *1 46.475,21.025 sky130_fd_pr__pfet_01v8
M$1922 332 297 37 37 sky130_fd_pr__pfet_01v8 L=0.15U W=4U AS=0.685P AD=0.56P
+ PS=6.37U PD=5.12U
* device instance $1926 r0 *1 48.195,21.025 sky130_fd_pr__pfet_01v8
M$1926 333 332 37 37 sky130_fd_pr__pfet_01v8 L=0.15U W=16U AS=2.2375P
+ AD=2.3625P PS=20.475U PD=21.725U
* device instance $1942 r0 *1 63.51,21.025 sky130_fd_pr__pfet_01v8
M$1942 334 342 37 37 sky130_fd_pr__pfet_01v8 L=0.15U W=1U AS=0.26P AD=0.135P
+ PS=2.52U PD=1.27U
* device instance $1943 r0 *1 63.93,21.025 sky130_fd_pr__pfet_01v8
M$1943 37 310 334 334 sky130_fd_pr__pfet_01v8 L=0.15U W=1U AS=0.135P AD=0.26P
+ PS=1.27U PD=2.52U
* device instance $1944 r0 *1 64.91,21.025 sky130_fd_pr__pfet_01v8
M$1944 335 279 37 37 sky130_fd_pr__pfet_01v8 L=0.15U W=1U AS=0.3P AD=0.135P
+ PS=2.6U PD=1.27U
* device instance $1945 r0 *1 65.33,21.025 sky130_fd_pr__pfet_01v8
M$1945 37 334 335 335 sky130_fd_pr__pfet_01v8 L=0.15U W=1U AS=0.135P AD=0.365P
+ PS=1.27U PD=1.73U
* device instance $1946 r0 *1 66.21,21.025 sky130_fd_pr__pfet_01v8
M$1946 351 334 37 37 sky130_fd_pr__pfet_01v8 L=0.15U W=1U AS=0.365P AD=0.105P
+ PS=1.73U PD=1.21U
* device instance $1947 r0 *1 66.57,21.025 sky130_fd_pr__pfet_01v8
M$1947 347 279 351 351 sky130_fd_pr__pfet_01v8 L=0.15U W=1U AS=0.105P AD=0.165P
+ PS=1.21U PD=1.33U
* device instance $1948 r0 *1 67.05,21.025 sky130_fd_pr__pfet_01v8
M$1948 37 335 347 347 sky130_fd_pr__pfet_01v8 L=0.15U W=1U AS=0.165P AD=0.36P
+ PS=1.33U PD=2.72U
* device instance $1949 r0 *1 68.33,20.735 sky130_fd_pr__pfet_01v8
M$1949 37 343 337 337 sky130_fd_pr__pfet_01v8 L=0.15U W=0.42U AS=0.1092P
+ AD=0.1573P PS=1.36U PD=1.39U
* device instance $1950 r0 *1 68.87,21.025 sky130_fd_pr__pfet_01v8
M$1950 348 344 37 37 sky130_fd_pr__pfet_01v8 L=0.15U W=1U AS=0.1573P AD=0.105P
+ PS=1.39U PD=1.21U
* device instance $1951 r0 *1 69.23,21.025 sky130_fd_pr__pfet_01v8
M$1951 338 337 348 348 sky130_fd_pr__pfet_01v8 L=0.15U W=1U AS=0.105P AD=0.26P
+ PS=1.21U PD=2.52U
* device instance $1952 r0 *1 6.98,22.205 sky130_fd_pr__pfet_01v8
M$1952 353 352 37 37 sky130_fd_pr__pfet_01v8 L=0.15U W=0.42U AS=0.1113P
+ AD=0.0609P PS=1.37U PD=0.71U
* device instance $1953 r0 *1 7.42,22.205 sky130_fd_pr__pfet_01v8
M$1953 37 115 353 353 sky130_fd_pr__pfet_01v8 L=0.15U W=0.42U AS=0.0609P
+ AD=0.1841P PS=0.71U PD=1.26U
* device instance $1954 r0 *1 8.19,22.315 sky130_fd_pr__pfet_01v8
M$1954 354 353 37 37 sky130_fd_pr__pfet_01v8 L=0.15U W=0.64U AS=0.1841P
+ AD=0.1696P PS=1.26U PD=1.81U
* device instance $1955 r0 *1 9.21,22.495 sky130_fd_pr__pfet_01v8
M$1955 356 354 355 355 sky130_fd_pr__pfet_01v8 L=0.15U W=1U AS=0.26P AD=0.135P
+ PS=2.52U PD=1.27U
* device instance $1956 r0 *1 9.63,22.495 sky130_fd_pr__pfet_01v8
M$1956 357 399 356 356 sky130_fd_pr__pfet_01v8 L=0.15U W=1U AS=0.135P AD=0.135P
+ PS=1.27U PD=1.27U
* device instance $1957 r0 *1 10.05,22.495 sky130_fd_pr__pfet_01v8
M$1957 356 92 357 357 sky130_fd_pr__pfet_01v8 L=0.15U W=1U AS=0.135P AD=0.26P
+ PS=1.27U PD=2.52U
* device instance $1958 r0 *1 10.99,22.495 sky130_fd_pr__pfet_01v8
M$1958 357 158 37 37 sky130_fd_pr__pfet_01v8 L=0.15U W=1U AS=0.26P AD=0.165P
+ PS=2.52U PD=1.33U
* device instance $1959 r0 *1 11.47,22.495 sky130_fd_pr__pfet_01v8
M$1959 37 359 357 357 sky130_fd_pr__pfet_01v8 L=0.15U W=1U AS=0.165P AD=0.1575P
+ PS=1.33U PD=1.315U
* device instance $1960 r0 *1 11.935,22.495 sky130_fd_pr__pfet_01v8
M$1960 410 355 37 37 sky130_fd_pr__pfet_01v8 L=0.15U W=1U AS=0.1575P AD=0.26P
+ PS=1.315U PD=2.52U
* device instance $1961 r0 *1 12.93,22.495 sky130_fd_pr__pfet_01v8
M$1961 404 400 358 358 sky130_fd_pr__pfet_01v8 L=0.15U W=1U AS=0.26P AD=0.135P
+ PS=2.52U PD=1.27U
* device instance $1962 r0 *1 13.35,22.495 sky130_fd_pr__pfet_01v8
M$1962 37 293 404 404 sky130_fd_pr__pfet_01v8 L=0.15U W=1U AS=0.135P AD=0.135P
+ PS=1.27U PD=1.27U
* device instance $1963 r0 *1 13.77,22.495 sky130_fd_pr__pfet_01v8
M$1963 360 293 37 37 sky130_fd_pr__pfet_01v8 L=0.15U W=1U AS=0.135P AD=0.135P
+ PS=1.27U PD=1.27U
* device instance $1964 r0 *1 14.19,22.495 sky130_fd_pr__pfet_01v8
M$1964 37 400 360 360 sky130_fd_pr__pfet_01v8 L=0.15U W=1U AS=0.135P AD=0.26P
+ PS=1.27U PD=2.52U
* device instance $1965 r0 *1 15.13,22.495 sky130_fd_pr__pfet_01v8
M$1965 359 358 360 360 sky130_fd_pr__pfet_01v8 L=0.15U W=1U AS=0.26P AD=0.3P
+ PS=2.52U PD=2.6U
* device instance $1966 r0 *1 17.49,22.785 sky130_fd_pr__pfet_01v8
M$1966 405 589 361 361 sky130_fd_pr__pfet_01v8 L=0.15U W=0.42U AS=0.1092P
+ AD=0.0693P PS=1.36U PD=0.75U
* device instance $1967 r0 *1 17.97,22.785 sky130_fd_pr__pfet_01v8
M$1967 406 13 405 405 sky130_fd_pr__pfet_01v8 L=0.15U W=0.42U AS=0.0693P
+ AD=0.0441P PS=0.75U PD=0.63U
* device instance $1968 r0 *1 18.33,22.785 sky130_fd_pr__pfet_01v8
M$1968 407 399 406 406 sky130_fd_pr__pfet_01v8 L=0.15U W=0.42U AS=0.0441P
+ AD=0.0693P PS=0.63U PD=0.75U
* device instance $1969 r0 *1 18.81,22.785 sky130_fd_pr__pfet_01v8
M$1969 407 218 37 37 sky130_fd_pr__pfet_01v8 L=0.15U W=0.42U AS=0.14825P
+ AD=0.0693P PS=1.34U PD=0.75U
* device instance $1970 r0 *1 19.3,22.495 sky130_fd_pr__pfet_01v8
M$1970 362 361 37 37 sky130_fd_pr__pfet_01v8 L=0.15U W=1U AS=0.14825P AD=0.27P
+ PS=1.34U PD=2.54U
* device instance $1971 r0 *1 27.195,22.495 sky130_fd_pr__pfet_01v8
M$1971 363 32 37 37 sky130_fd_pr__pfet_01v8 L=0.15U W=6U AS=1.005P AD=1.045P
+ PS=9.01U PD=9.09U
* device instance $1977 r0 *1 41.41,22.345 sky130_fd_pr__pfet_01v8
M$1977 37 333 364 364 sky130_fd_pr__pfet_01v8 L=0.15U W=0.64U AS=0.1664P
+ AD=0.0864P PS=1.8U PD=0.91U
* device instance $1978 r0 *1 41.83,22.345 sky130_fd_pr__pfet_01v8
M$1978 365 364 37 37 sky130_fd_pr__pfet_01v8 L=0.15U W=0.64U AS=0.0864P
+ AD=0.1664P PS=0.91U PD=1.8U
* device instance $1979 r0 *1 42.77,22.315 sky130_fd_pr__pfet_01v8
M$1979 392 401 366 366 sky130_fd_pr__pfet_01v8 L=0.15U W=0.64U AS=0.1664P
+ AD=0.0672P PS=1.8U PD=0.85U
* device instance $1980 r0 *1 43.13,22.315 sky130_fd_pr__pfet_01v8
M$1980 37 367 392 392 sky130_fd_pr__pfet_01v8 L=0.15U W=0.64U AS=0.0672P
+ AD=0.1664P PS=0.85U PD=1.8U
* device instance $1981 r0 *1 45.795,22.205 sky130_fd_pr__pfet_01v8
M$1981 368 365 366 366 sky130_fd_pr__pfet_01v8 L=0.15U W=0.42U AS=0.15985P
+ AD=0.06405P PS=1.265U PD=0.725U
* device instance $1982 r0 *1 46.25,22.205 sky130_fd_pr__pfet_01v8
M$1982 395 364 368 368 sky130_fd_pr__pfet_01v8 L=0.15U W=0.42U AS=0.06405P
+ AD=0.07665P PS=0.725U PD=0.785U
* device instance $1983 r0 *1 46.765,22.205 sky130_fd_pr__pfet_01v8
M$1983 37 369 395 395 sky130_fd_pr__pfet_01v8 L=0.15U W=0.42U AS=0.07665P
+ AD=0.178875P PS=0.785U PD=1.26U
* device instance $1984 r0 *1 44.07,22.315 sky130_fd_pr__pfet_01v8
M$1984 37 94 367 367 sky130_fd_pr__pfet_01v8 L=0.15U W=0.64U AS=0.1664P
+ AD=0.0928P PS=1.8U PD=0.93U
* device instance $1985 r0 *1 44.51,22.315 sky130_fd_pr__pfet_01v8
M$1985 394 94 37 37 sky130_fd_pr__pfet_01v8 L=0.15U W=0.64U AS=0.0928P
+ AD=0.1152P PS=0.93U PD=1U
* device instance $1986 r0 *1 45.02,22.315 sky130_fd_pr__pfet_01v8
M$1986 366 371 394 394 sky130_fd_pr__pfet_01v8 L=0.15U W=0.64U AS=0.1152P
+ AD=0.15985P PS=1U PD=1.265U
* device instance $1987 r0 *1 47.425,22.37 sky130_fd_pr__pfet_01v8
M$1987 369 368 37 37 sky130_fd_pr__pfet_01v8 L=0.15U W=0.75U AS=0.178875P
+ AD=0.195P PS=1.26U PD=2.02U
* device instance $1988 r0 *1 48.365,22.205 sky130_fd_pr__pfet_01v8
M$1988 397 369 37 37 sky130_fd_pr__pfet_01v8 L=0.15U W=0.42U AS=0.1092P
+ AD=0.06405P PS=1.36U PD=0.725U
* device instance $1989 r0 *1 48.82,22.205 sky130_fd_pr__pfet_01v8
M$1989 370 364 397 397 sky130_fd_pr__pfet_01v8 L=0.15U W=0.42U AS=0.06405P
+ AD=0.0567P PS=0.725U PD=0.69U
* device instance $1990 r0 *1 49.24,22.205 sky130_fd_pr__pfet_01v8
M$1990 398 365 370 370 sky130_fd_pr__pfet_01v8 L=0.15U W=0.42U AS=0.0567P
+ AD=0.0882P PS=0.69U PD=0.84U
* device instance $1991 r0 *1 49.81,22.205 sky130_fd_pr__pfet_01v8
M$1991 37 371 398 398 sky130_fd_pr__pfet_01v8 L=0.15U W=0.42U AS=0.0882P
+ AD=0.1113P PS=0.84U PD=1.37U
* device instance $1992 r0 *1 50.865,22.315 sky130_fd_pr__pfet_01v8
M$1992 37 370 371 371 sky130_fd_pr__pfet_01v8 L=0.15U W=0.64U AS=0.1728P
+ AD=0.154P PS=1.82U PD=1.335U
* device instance $1993 r0 *1 51.35,22.495 sky130_fd_pr__pfet_01v8
M$1993 372 370 37 37 sky130_fd_pr__pfet_01v8 L=0.15U W=1U AS=0.154P AD=0.28P
+ PS=1.335U PD=2.56U
* device instance $1994 r0 *1 53.39,22.495 sky130_fd_pr__pfet_01v8
M$1994 37 374 373 373 sky130_fd_pr__pfet_01v8 L=0.15U W=2U AS=0.415P AD=0.27P
+ PS=3.83U PD=2.54U
* device instance $1996 r0 *1 54.23,22.495 sky130_fd_pr__pfet_01v8
M$1996 375 344 373 373 sky130_fd_pr__pfet_01v8 L=0.15U W=2U AS=0.27P AD=0.415P
+ PS=2.54U PD=3.83U
* device instance $1998 r0 *1 55.63,22.495 sky130_fd_pr__pfet_01v8
M$1998 375 162 376 376 sky130_fd_pr__pfet_01v8 L=0.15U W=2U AS=0.415P AD=0.27P
+ PS=3.83U PD=2.54U
* device instance $2000 r0 *1 56.47,22.495 sky130_fd_pr__pfet_01v8
M$2000 408 195 376 376 sky130_fd_pr__pfet_01v8 L=0.15U W=2U AS=0.27P AD=0.395P
+ PS=2.54U PD=3.79U
* device instance $2002 r0 *1 60.73,22.495 sky130_fd_pr__pfet_01v8
M$2002 378 402 377 377 sky130_fd_pr__pfet_01v8 L=0.15U W=1U AS=0.26P AD=0.135P
+ PS=2.52U PD=1.27U
* device instance $2003 r0 *1 61.15,22.495 sky130_fd_pr__pfet_01v8
M$2003 379 344 378 378 sky130_fd_pr__pfet_01v8 L=0.15U W=1U AS=0.135P AD=0.135P
+ PS=1.27U PD=1.27U
* device instance $2004 r0 *1 61.57,22.495 sky130_fd_pr__pfet_01v8
M$2004 378 92 379 379 sky130_fd_pr__pfet_01v8 L=0.15U W=1U AS=0.135P AD=0.26P
+ PS=1.27U PD=2.52U
* device instance $2005 r0 *1 62.51,22.495 sky130_fd_pr__pfet_01v8
M$2005 379 135 37 37 sky130_fd_pr__pfet_01v8 L=0.15U W=1U AS=0.26P AD=0.165P
+ PS=2.52U PD=1.33U
* device instance $2006 r0 *1 62.99,22.495 sky130_fd_pr__pfet_01v8
M$2006 37 347 379 379 sky130_fd_pr__pfet_01v8 L=0.15U W=1U AS=0.165P AD=0.1575P
+ PS=1.33U PD=1.315U
* device instance $2007 r0 *1 63.455,22.495 sky130_fd_pr__pfet_01v8
M$2007 380 377 37 37 sky130_fd_pr__pfet_01v8 L=0.15U W=1U AS=0.1575P AD=0.26P
+ PS=1.315U PD=2.52U
* device instance $2008 r0 *1 64.41,22.345 sky130_fd_pr__pfet_01v8
M$2008 37 333 381 381 sky130_fd_pr__pfet_01v8 L=0.15U W=0.64U AS=0.1664P
+ AD=0.0864P PS=1.8U PD=0.91U
* device instance $2009 r0 *1 64.83,22.345 sky130_fd_pr__pfet_01v8
M$2009 382 381 37 37 sky130_fd_pr__pfet_01v8 L=0.15U W=0.64U AS=0.0864P
+ AD=0.1664P PS=0.91U PD=1.8U
* device instance $2010 r0 *1 65.77,22.315 sky130_fd_pr__pfet_01v8
M$2010 396 403 383 383 sky130_fd_pr__pfet_01v8 L=0.15U W=0.64U AS=0.1664P
+ AD=0.0672P PS=1.8U PD=0.85U
* device instance $2011 r0 *1 66.13,22.315 sky130_fd_pr__pfet_01v8
M$2011 37 384 396 396 sky130_fd_pr__pfet_01v8 L=0.15U W=0.64U AS=0.0672P
+ AD=0.1664P PS=0.85U PD=1.8U
* device instance $2012 r0 *1 68.795,22.205 sky130_fd_pr__pfet_01v8
M$2012 385 382 383 383 sky130_fd_pr__pfet_01v8 L=0.15U W=0.42U AS=0.15985P
+ AD=0.06405P PS=1.265U PD=0.725U
* device instance $2013 r0 *1 69.25,22.205 sky130_fd_pr__pfet_01v8
M$2013 391 381 385 385 sky130_fd_pr__pfet_01v8 L=0.15U W=0.42U AS=0.06405P
+ AD=0.07665P PS=0.725U PD=0.785U
* device instance $2014 r0 *1 69.765,22.205 sky130_fd_pr__pfet_01v8
M$2014 37 386 391 391 sky130_fd_pr__pfet_01v8 L=0.15U W=0.42U AS=0.07665P
+ AD=0.178875P PS=0.785U PD=1.26U
* device instance $2015 r0 *1 67.07,22.315 sky130_fd_pr__pfet_01v8
M$2015 37 409 384 384 sky130_fd_pr__pfet_01v8 L=0.15U W=0.64U AS=0.1664P
+ AD=0.0928P PS=1.8U PD=0.93U
* device instance $2016 r0 *1 67.51,22.315 sky130_fd_pr__pfet_01v8
M$2016 393 409 37 37 sky130_fd_pr__pfet_01v8 L=0.15U W=0.64U AS=0.0928P
+ AD=0.1152P PS=0.93U PD=1U
* device instance $2017 r0 *1 68.02,22.315 sky130_fd_pr__pfet_01v8
M$2017 383 388 393 393 sky130_fd_pr__pfet_01v8 L=0.15U W=0.64U AS=0.1152P
+ AD=0.15985P PS=1U PD=1.265U
* device instance $2018 r0 *1 70.425,22.37 sky130_fd_pr__pfet_01v8
M$2018 386 385 37 37 sky130_fd_pr__pfet_01v8 L=0.15U W=0.75U AS=0.178875P
+ AD=0.195P PS=1.26U PD=2.02U
* device instance $2019 r0 *1 71.365,22.205 sky130_fd_pr__pfet_01v8
M$2019 390 386 37 37 sky130_fd_pr__pfet_01v8 L=0.15U W=0.42U AS=0.1092P
+ AD=0.06405P PS=1.36U PD=0.725U
* device instance $2020 r0 *1 71.82,22.205 sky130_fd_pr__pfet_01v8
M$2020 387 381 390 390 sky130_fd_pr__pfet_01v8 L=0.15U W=0.42U AS=0.06405P
+ AD=0.0567P PS=0.725U PD=0.69U
* device instance $2021 r0 *1 72.24,22.205 sky130_fd_pr__pfet_01v8
M$2021 389 382 387 387 sky130_fd_pr__pfet_01v8 L=0.15U W=0.42U AS=0.0567P
+ AD=0.0882P PS=0.69U PD=0.84U
* device instance $2022 r0 *1 72.81,22.205 sky130_fd_pr__pfet_01v8
M$2022 37 388 389 389 sky130_fd_pr__pfet_01v8 L=0.15U W=0.42U AS=0.0882P
+ AD=0.1113P PS=0.84U PD=1.37U
* device instance $2023 r0 *1 73.865,22.315 sky130_fd_pr__pfet_01v8
M$2023 37 387 388 388 sky130_fd_pr__pfet_01v8 L=0.15U W=0.64U AS=0.1728P
+ AD=0.154P PS=1.82U PD=1.335U
* device instance $2024 r0 *1 74.35,22.495 sky130_fd_pr__pfet_01v8
M$2024 344 387 37 37 sky130_fd_pr__pfet_01v8 L=0.15U W=1U AS=0.154P AD=0.28P
+ PS=1.335U PD=2.56U
* device instance $2025 r0 *1 4.61,26.615 sky130_fd_pr__pfet_01v8
M$2025 37 32 427 427 sky130_fd_pr__pfet_01v8 L=0.15U W=0.64U AS=0.1664P
+ AD=0.0864P PS=1.8U PD=0.91U
* device instance $2026 r0 *1 5.03,26.615 sky130_fd_pr__pfet_01v8
M$2026 428 427 37 37 sky130_fd_pr__pfet_01v8 L=0.15U W=0.64U AS=0.0864P
+ AD=0.1664P PS=0.91U PD=1.8U
* device instance $2027 r0 *1 5.97,26.645 sky130_fd_pr__pfet_01v8
M$2027 466 458 429 429 sky130_fd_pr__pfet_01v8 L=0.15U W=0.64U AS=0.1664P
+ AD=0.0672P PS=1.8U PD=0.85U
* device instance $2028 r0 *1 6.33,26.645 sky130_fd_pr__pfet_01v8
M$2028 37 459 466 466 sky130_fd_pr__pfet_01v8 L=0.15U W=0.64U AS=0.0672P
+ AD=0.1664P PS=0.85U PD=1.8U
* device instance $2029 r0 *1 7.27,26.645 sky130_fd_pr__pfet_01v8
M$2029 37 94 459 459 sky130_fd_pr__pfet_01v8 L=0.15U W=0.64U AS=0.1664P
+ AD=0.0928P PS=1.8U PD=0.93U
* device instance $2030 r0 *1 7.71,26.645 sky130_fd_pr__pfet_01v8
M$2030 468 94 37 37 sky130_fd_pr__pfet_01v8 L=0.15U W=0.64U AS=0.0928P
+ AD=0.1152P PS=0.93U PD=1U
* device instance $2031 r0 *1 8.22,26.645 sky130_fd_pr__pfet_01v8
M$2031 429 430 468 468 sky130_fd_pr__pfet_01v8 L=0.15U W=0.64U AS=0.1152P
+ AD=0.15985P PS=1U PD=1.265U
* device instance $2032 r0 *1 8.995,26.755 sky130_fd_pr__pfet_01v8
M$2032 431 428 429 429 sky130_fd_pr__pfet_01v8 L=0.15U W=0.42U AS=0.15985P
+ AD=0.06405P PS=1.265U PD=0.725U
* device instance $2033 r0 *1 9.45,26.755 sky130_fd_pr__pfet_01v8
M$2033 469 427 431 431 sky130_fd_pr__pfet_01v8 L=0.15U W=0.42U AS=0.06405P
+ AD=0.07665P PS=0.725U PD=0.785U
* device instance $2034 r0 *1 9.965,26.755 sky130_fd_pr__pfet_01v8
M$2034 469 432 37 37 sky130_fd_pr__pfet_01v8 L=0.15U W=0.42U AS=0.178875P
+ AD=0.07665P PS=1.26U PD=0.785U
* device instance $2035 r0 *1 10.625,26.59 sky130_fd_pr__pfet_01v8
M$2035 432 431 37 37 sky130_fd_pr__pfet_01v8 L=0.15U W=0.75U AS=0.178875P
+ AD=0.195P PS=1.26U PD=2.02U
* device instance $2036 r0 *1 14.065,26.645 sky130_fd_pr__pfet_01v8
M$2036 430 433 37 37 sky130_fd_pr__pfet_01v8 L=0.15U W=0.64U AS=0.154P
+ AD=0.1728P PS=1.335U PD=1.82U
* device instance $2037 r0 *1 14.55,26.465 sky130_fd_pr__pfet_01v8
M$2037 399 433 37 37 sky130_fd_pr__pfet_01v8 L=0.15U W=1U AS=0.154P AD=0.28P
+ PS=1.335U PD=2.56U
* device instance $2038 r0 *1 18.19,26.175 sky130_fd_pr__pfet_01v8
M$2038 37 399 434 434 sky130_fd_pr__pfet_01v8 L=0.15U W=0.42U AS=0.1092P
+ AD=0.1573P PS=1.36U PD=1.39U
* device instance $2039 r0 *1 18.73,26.465 sky130_fd_pr__pfet_01v8
M$2039 472 460 37 37 sky130_fd_pr__pfet_01v8 L=0.15U W=1U AS=0.1573P AD=0.105P
+ PS=1.39U PD=1.21U
* device instance $2040 r0 *1 19.09,26.465 sky130_fd_pr__pfet_01v8
M$2040 435 434 472 472 sky130_fd_pr__pfet_01v8 L=0.15U W=1U AS=0.105P AD=0.26P
+ PS=1.21U PD=2.52U
* device instance $2041 r0 *1 20.25,26.465 sky130_fd_pr__pfet_01v8
M$2041 473 435 400 400 sky130_fd_pr__pfet_01v8 L=0.15U W=1U AS=0.26P AD=0.105P
+ PS=2.52U PD=1.21U
* device instance $2042 r0 *1 20.61,26.465 sky130_fd_pr__pfet_01v8
M$2042 37 329 473 473 sky130_fd_pr__pfet_01v8 L=0.15U W=1U AS=0.105P AD=0.26P
+ PS=1.21U PD=2.52U
* device instance $2043 r0 *1 21.87,26.175 sky130_fd_pr__pfet_01v8
M$2043 37 460 436 436 sky130_fd_pr__pfet_01v8 L=0.15U W=0.42U AS=0.1092P
+ AD=0.1573P PS=1.36U PD=1.39U
* device instance $2044 r0 *1 22.41,26.465 sky130_fd_pr__pfet_01v8
M$2044 474 399 37 37 sky130_fd_pr__pfet_01v8 L=0.15U W=1U AS=0.1573P AD=0.105P
+ PS=1.39U PD=1.21U
* device instance $2045 r0 *1 22.77,26.465 sky130_fd_pr__pfet_01v8
M$2045 329 436 474 474 sky130_fd_pr__pfet_01v8 L=0.15U W=1U AS=0.105P AD=0.26P
+ PS=1.21U PD=2.52U
* device instance $2046 r0 *1 34.985,26.465 sky130_fd_pr__pfet_01v8
M$2046 37 439 438 438 sky130_fd_pr__pfet_01v8 L=0.15U W=2U AS=0.41P AD=0.27P
+ PS=3.82U PD=2.54U
* device instance $2048 r0 *1 35.825,26.465 sky130_fd_pr__pfet_01v8
M$2048 37 440 438 438 sky130_fd_pr__pfet_01v8 L=0.15U W=2U AS=0.27P AD=0.415P
+ PS=2.54U PD=3.83U
* device instance $2050 r0 *1 37.225,26.465 sky130_fd_pr__pfet_01v8
M$2050 37 440 464 464 sky130_fd_pr__pfet_01v8 L=0.15U W=2U AS=0.415P AD=0.27P
+ PS=3.83U PD=2.54U
* device instance $2052 r0 *1 38.065,26.465 sky130_fd_pr__pfet_01v8
M$2052 3 439 464 464 sky130_fd_pr__pfet_01v8 L=0.15U W=2U AS=0.2875P AD=0.4125P
+ PS=2.575U PD=3.825U
* device instance $2054 r0 *1 39.46,26.465 sky130_fd_pr__pfet_01v8
M$2054 3 438 37 37 sky130_fd_pr__pfet_01v8 L=0.15U W=2U AS=0.395P AD=0.415P
+ PS=3.79U PD=3.83U
* device instance $2056 r0 *1 46.47,26.465 sky130_fd_pr__pfet_01v8
M$2056 37 333 442 442 sky130_fd_pr__pfet_01v8 L=0.15U W=3U AS=0.53P AD=0.405P
+ PS=5.06U PD=3.81U
* device instance $2059 r0 *1 47.73,26.465 sky130_fd_pr__pfet_01v8
M$2059 443 442 37 37 sky130_fd_pr__pfet_01v8 L=0.15U W=6U AS=0.81P AD=0.81P
+ PS=7.62U PD=7.62U
* device instance $2065 r0 *1 50.25,26.465 sky130_fd_pr__pfet_01v8
M$2065 444 443 37 37 sky130_fd_pr__pfet_01v8 L=0.15U W=16U AS=2.16P AD=2.285P
+ PS=20.32U PD=21.57U
* device instance $2081 r0 *1 63.95,26.545 sky130_fd_pr__pfet_01v8
M$2081 310 338 37 37 sky130_fd_pr__pfet_01v8 L=0.15U W=1.68U AS=0.3318P
+ AD=0.3486P PS=3.31U PD=3.35U
* device instance $2083 r0 *1 65.33,26.175 sky130_fd_pr__pfet_01v8
M$2083 37 343 446 446 sky130_fd_pr__pfet_01v8 L=0.15U W=0.42U AS=0.1092P
+ AD=0.14575P PS=1.36U PD=1.335U
* device instance $2084 r0 *1 65.815,26.465 sky130_fd_pr__pfet_01v8
M$2084 342 344 37 37 sky130_fd_pr__pfet_01v8 L=0.15U W=1U AS=0.14575P AD=0.135P
+ PS=1.335U PD=1.27U
* device instance $2085 r0 *1 66.235,26.465 sky130_fd_pr__pfet_01v8
M$2085 37 446 342 342 sky130_fd_pr__pfet_01v8 L=0.15U W=1U AS=0.135P AD=0.265P
+ PS=1.27U PD=2.53U
* device instance $2086 r0 *1 68.175,26.56 sky130_fd_pr__pfet_01v8
M$2086 467 64 37 37 sky130_fd_pr__pfet_01v8 L=0.15U W=0.42U AS=0.15835P
+ AD=0.07665P PS=1.395U PD=0.785U
* device instance $2087 r0 *1 68.69,26.56 sky130_fd_pr__pfet_01v8
M$2087 447 343 467 467 sky130_fd_pr__pfet_01v8 L=0.15U W=0.42U AS=0.07665P
+ AD=0.1932P PS=0.785U PD=1.34U
* device instance $2088 r0 *1 69.76,26.56 sky130_fd_pr__pfet_01v8
M$2088 465 448 447 447 sky130_fd_pr__pfet_01v8 L=0.15U W=0.42U AS=0.1932P
+ AD=0.0441P PS=1.34U PD=0.63U
* device instance $2089 r0 *1 70.12,26.56 sky130_fd_pr__pfet_01v8
M$2089 37 449 465 465 sky130_fd_pr__pfet_01v8 L=0.15U W=0.42U AS=0.0441P
+ AD=0.0693P PS=0.63U PD=0.75U
* device instance $2090 r0 *1 70.6,26.56 sky130_fd_pr__pfet_01v8
M$2090 449 64 37 37 sky130_fd_pr__pfet_01v8 L=0.15U W=0.42U AS=0.0693P
+ AD=0.1176P PS=0.75U PD=1.4U
* device instance $2091 r0 *1 67.63,26.465 sky130_fd_pr__pfet_01v8
M$2091 37 447 403 403 sky130_fd_pr__pfet_01v8 L=0.15U W=1U AS=0.26P AD=0.15835P
+ PS=2.52U PD=1.395U
* device instance $2092 r0 *1 5.615,27.84 sky130_fd_pr__pfet_01v8
M$2092 498 64 37 37 sky130_fd_pr__pfet_01v8 L=0.15U W=0.42U AS=0.15835P
+ AD=0.07665P PS=1.395U PD=0.785U
* device instance $2093 r0 *1 6.13,27.84 sky130_fd_pr__pfet_01v8
M$2093 475 460 498 498 sky130_fd_pr__pfet_01v8 L=0.15U W=0.42U AS=0.07665P
+ AD=0.1932P PS=0.785U PD=1.34U
* device instance $2094 r0 *1 7.2,27.84 sky130_fd_pr__pfet_01v8
M$2094 499 463 475 475 sky130_fd_pr__pfet_01v8 L=0.15U W=0.42U AS=0.1932P
+ AD=0.0441P PS=1.34U PD=0.63U
* device instance $2095 r0 *1 7.56,27.84 sky130_fd_pr__pfet_01v8
M$2095 37 514 499 499 sky130_fd_pr__pfet_01v8 L=0.15U W=0.42U AS=0.0441P
+ AD=0.0693P PS=0.63U PD=0.75U
* device instance $2096 r0 *1 8.04,27.84 sky130_fd_pr__pfet_01v8
M$2096 514 64 37 37 sky130_fd_pr__pfet_01v8 L=0.15U W=0.42U AS=0.0693P
+ AD=0.1176P PS=0.75U PD=1.4U
* device instance $2097 r0 *1 5.07,27.935 sky130_fd_pr__pfet_01v8
M$2097 37 475 458 458 sky130_fd_pr__pfet_01v8 L=0.15U W=1U AS=0.26P AD=0.15835P
+ PS=2.52U PD=1.395U
* device instance $2098 r0 *1 10.57,27.755 sky130_fd_pr__pfet_01v8
M$2098 500 410 478 478 sky130_fd_pr__pfet_01v8 L=0.15U W=0.64U AS=0.1664P
+ AD=0.0672P PS=1.8U PD=0.85U
* device instance $2099 r0 *1 10.93,27.755 sky130_fd_pr__pfet_01v8
M$2099 37 479 500 500 sky130_fd_pr__pfet_01v8 L=0.15U W=0.64U AS=0.0672P
+ AD=0.1664P PS=0.85U PD=1.8U
* device instance $2100 r0 *1 11.565,26.755 sky130_fd_pr__pfet_01v8
M$2100 470 432 37 37 sky130_fd_pr__pfet_01v8 L=0.15U W=0.42U AS=0.1092P
+ AD=0.06405P PS=1.36U PD=0.725U
* device instance $2101 r0 *1 12.02,26.755 sky130_fd_pr__pfet_01v8
M$2101 433 427 470 470 sky130_fd_pr__pfet_01v8 L=0.15U W=0.42U AS=0.06405P
+ AD=0.0567P PS=0.725U PD=0.69U
* device instance $2102 r0 *1 12.44,26.755 sky130_fd_pr__pfet_01v8
M$2102 471 428 433 433 sky130_fd_pr__pfet_01v8 L=0.15U W=0.42U AS=0.0567P
+ AD=0.0882P PS=0.69U PD=0.84U
* device instance $2103 r0 *1 13.01,26.755 sky130_fd_pr__pfet_01v8
M$2103 37 430 471 471 sky130_fd_pr__pfet_01v8 L=0.15U W=0.42U AS=0.0882P
+ AD=0.1113P PS=0.84U PD=1.37U
* device instance $2104 r0 *1 13.595,27.645 sky130_fd_pr__pfet_01v8
M$2104 480 477 478 478 sky130_fd_pr__pfet_01v8 L=0.15U W=0.42U AS=0.15985P
+ AD=0.06405P PS=1.265U PD=0.725U
* device instance $2105 r0 *1 14.05,27.645 sky130_fd_pr__pfet_01v8
M$2105 502 476 480 480 sky130_fd_pr__pfet_01v8 L=0.15U W=0.42U AS=0.06405P
+ AD=0.07665P PS=0.725U PD=0.785U
* device instance $2106 r0 *1 14.565,27.645 sky130_fd_pr__pfet_01v8
M$2106 37 481 502 502 sky130_fd_pr__pfet_01v8 L=0.15U W=0.42U AS=0.07665P
+ AD=0.178875P PS=0.785U PD=1.26U
* device instance $2107 r0 *1 11.87,27.755 sky130_fd_pr__pfet_01v8
M$2107 37 302 479 479 sky130_fd_pr__pfet_01v8 L=0.15U W=0.64U AS=0.1664P
+ AD=0.0928P PS=1.8U PD=0.93U
* device instance $2108 r0 *1 12.31,27.755 sky130_fd_pr__pfet_01v8
M$2108 501 302 37 37 sky130_fd_pr__pfet_01v8 L=0.15U W=0.64U AS=0.0928P
+ AD=0.1152P PS=0.93U PD=1U
* device instance $2109 r0 *1 12.82,27.755 sky130_fd_pr__pfet_01v8
M$2109 478 483 501 501 sky130_fd_pr__pfet_01v8 L=0.15U W=0.64U AS=0.1152P
+ AD=0.15985P PS=1U PD=1.265U
* device instance $2110 r0 *1 15.225,27.81 sky130_fd_pr__pfet_01v8
M$2110 481 480 37 37 sky130_fd_pr__pfet_01v8 L=0.15U W=0.75U AS=0.178875P
+ AD=0.195P PS=1.26U PD=2.02U
* device instance $2111 r0 *1 16.165,27.645 sky130_fd_pr__pfet_01v8
M$2111 503 481 37 37 sky130_fd_pr__pfet_01v8 L=0.15U W=0.42U AS=0.1092P
+ AD=0.06405P PS=1.36U PD=0.725U
* device instance $2112 r0 *1 16.62,27.645 sky130_fd_pr__pfet_01v8
M$2112 482 476 503 503 sky130_fd_pr__pfet_01v8 L=0.15U W=0.42U AS=0.06405P
+ AD=0.0567P PS=0.725U PD=0.69U
* device instance $2113 r0 *1 17.04,27.645 sky130_fd_pr__pfet_01v8
M$2113 505 477 482 482 sky130_fd_pr__pfet_01v8 L=0.15U W=0.42U AS=0.0567P
+ AD=0.0882P PS=0.69U PD=0.84U
* device instance $2114 r0 *1 17.61,27.645 sky130_fd_pr__pfet_01v8
M$2114 37 483 505 505 sky130_fd_pr__pfet_01v8 L=0.15U W=0.42U AS=0.0882P
+ AD=0.1113P PS=0.84U PD=1.37U
* device instance $2115 r0 *1 18.665,27.755 sky130_fd_pr__pfet_01v8
M$2115 37 482 483 483 sky130_fd_pr__pfet_01v8 L=0.15U W=0.64U AS=0.1728P
+ AD=0.154P PS=1.82U PD=1.335U
* device instance $2116 r0 *1 19.15,27.935 sky130_fd_pr__pfet_01v8
M$2116 460 482 37 37 sky130_fd_pr__pfet_01v8 L=0.15U W=1U AS=0.154P AD=0.28P
+ PS=1.335U PD=2.56U
* device instance $2117 r0 *1 30.91,27.935 sky130_fd_pr__pfet_01v8
M$2117 37 328 484 484 sky130_fd_pr__pfet_01v8 L=0.15U W=4U AS=0.685P AD=0.54P
+ PS=6.37U PD=5.08U
* device instance $2121 r0 *1 32.59,27.935 sky130_fd_pr__pfet_01v8
M$2121 485 435 484 484 sky130_fd_pr__pfet_01v8 L=0.15U W=4U AS=0.54P AD=0.665P
+ PS=5.08U PD=6.33U
* device instance $2125 r0 *1 34.79,27.935 sky130_fd_pr__pfet_01v8
M$2125 485 534 268 268 sky130_fd_pr__pfet_01v8 L=0.15U W=4U AS=0.665P AD=0.55P
+ PS=6.33U PD=5.1U
* device instance $2129 r0 *1 36.49,27.935 sky130_fd_pr__pfet_01v8
M$2129 37 512 268 268 sky130_fd_pr__pfet_01v8 L=0.15U W=4U AS=0.55P AD=0.54P
+ PS=5.1U PD=5.08U
* device instance $2133 r0 *1 38.17,27.935 sky130_fd_pr__pfet_01v8
M$2133 37 486 268 268 sky130_fd_pr__pfet_01v8 L=0.15U W=4U AS=0.54P AD=0.665P
+ PS=5.08U PD=6.33U
* device instance $2137 r0 *1 41.87,28.225 sky130_fd_pr__pfet_01v8
M$2137 487 513 37 37 sky130_fd_pr__pfet_01v8 L=0.15U W=0.42U AS=0.14575P
+ AD=0.1092P PS=1.335U PD=1.36U
* device instance $2138 r0 *1 42.355,27.935 sky130_fd_pr__pfet_01v8
M$2138 264 372 37 37 sky130_fd_pr__pfet_01v8 L=0.15U W=1U AS=0.14575P AD=0.135P
+ PS=1.335U PD=1.27U
* device instance $2139 r0 *1 42.775,27.935 sky130_fd_pr__pfet_01v8
M$2139 37 487 264 264 sky130_fd_pr__pfet_01v8 L=0.15U W=1U AS=0.135P AD=0.265P
+ PS=1.27U PD=2.53U
* device instance $2140 r0 *1 44.715,27.84 sky130_fd_pr__pfet_01v8
M$2140 510 64 37 37 sky130_fd_pr__pfet_01v8 L=0.15U W=0.42U AS=0.15835P
+ AD=0.07665P PS=1.395U PD=0.785U
* device instance $2141 r0 *1 45.23,27.84 sky130_fd_pr__pfet_01v8
M$2141 488 513 510 510 sky130_fd_pr__pfet_01v8 L=0.15U W=0.42U AS=0.07665P
+ AD=0.1932P PS=0.785U PD=1.34U
* device instance $2142 r0 *1 46.3,27.84 sky130_fd_pr__pfet_01v8
M$2142 511 489 488 488 sky130_fd_pr__pfet_01v8 L=0.15U W=0.42U AS=0.1932P
+ AD=0.0441P PS=1.34U PD=0.63U
* device instance $2143 r0 *1 46.66,27.84 sky130_fd_pr__pfet_01v8
M$2143 37 516 511 511 sky130_fd_pr__pfet_01v8 L=0.15U W=0.42U AS=0.0441P
+ AD=0.0693P PS=0.63U PD=0.75U
* device instance $2144 r0 *1 47.14,27.84 sky130_fd_pr__pfet_01v8
M$2144 516 64 37 37 sky130_fd_pr__pfet_01v8 L=0.15U W=0.42U AS=0.0693P
+ AD=0.1176P PS=0.75U PD=1.4U
* device instance $2145 r0 *1 44.17,27.935 sky130_fd_pr__pfet_01v8
M$2145 37 488 401 401 sky130_fd_pr__pfet_01v8 L=0.15U W=1U AS=0.26P AD=0.15835P
+ PS=2.52U PD=1.395U
* device instance $2146 r0 *1 61.26,26.755 sky130_fd_pr__pfet_01v8
M$2146 445 461 37 37 sky130_fd_pr__pfet_01v8 L=0.15U W=0.42U AS=0.1113P
+ AD=0.0609P PS=1.37U PD=0.71U
* device instance $2147 r0 *1 61.7,26.755 sky130_fd_pr__pfet_01v8
M$2147 445 115 37 37 sky130_fd_pr__pfet_01v8 L=0.15U W=0.42U AS=0.1841P
+ AD=0.0609P PS=1.26U PD=0.71U
* device instance $2148 r0 *1 62.47,26.645 sky130_fd_pr__pfet_01v8
M$2148 402 445 37 37 sky130_fd_pr__pfet_01v8 L=0.15U W=0.64U AS=0.1841P
+ AD=0.1696P PS=1.26U PD=1.81U
* device instance $2149 r0 *1 62.09,27.755 sky130_fd_pr__pfet_01v8
M$2149 509 380 492 492 sky130_fd_pr__pfet_01v8 L=0.15U W=0.64U AS=0.1664P
+ AD=0.0672P PS=1.8U PD=0.85U
* device instance $2150 r0 *1 62.45,27.755 sky130_fd_pr__pfet_01v8
M$2150 37 493 509 509 sky130_fd_pr__pfet_01v8 L=0.15U W=0.64U AS=0.0672P
+ AD=0.1664P PS=0.85U PD=1.8U
* device instance $2151 r0 *1 65.115,27.645 sky130_fd_pr__pfet_01v8
M$2151 494 491 492 492 sky130_fd_pr__pfet_01v8 L=0.15U W=0.42U AS=0.15985P
+ AD=0.06405P PS=1.265U PD=0.725U
* device instance $2152 r0 *1 65.57,27.645 sky130_fd_pr__pfet_01v8
M$2152 507 490 494 494 sky130_fd_pr__pfet_01v8 L=0.15U W=0.42U AS=0.06405P
+ AD=0.07665P PS=0.725U PD=0.785U
* device instance $2153 r0 *1 66.085,27.645 sky130_fd_pr__pfet_01v8
M$2153 37 495 507 507 sky130_fd_pr__pfet_01v8 L=0.15U W=0.42U AS=0.07665P
+ AD=0.178875P PS=0.785U PD=1.26U
* device instance $2154 r0 *1 63.39,27.755 sky130_fd_pr__pfet_01v8
M$2154 37 302 493 493 sky130_fd_pr__pfet_01v8 L=0.15U W=0.64U AS=0.1664P
+ AD=0.0928P PS=1.8U PD=0.93U
* device instance $2155 r0 *1 63.83,27.755 sky130_fd_pr__pfet_01v8
M$2155 508 302 37 37 sky130_fd_pr__pfet_01v8 L=0.15U W=0.64U AS=0.0928P
+ AD=0.1152P PS=0.93U PD=1U
* device instance $2156 r0 *1 64.34,27.755 sky130_fd_pr__pfet_01v8
M$2156 492 497 508 508 sky130_fd_pr__pfet_01v8 L=0.15U W=0.64U AS=0.1152P
+ AD=0.15985P PS=1U PD=1.265U
* device instance $2157 r0 *1 66.745,27.81 sky130_fd_pr__pfet_01v8
M$2157 495 494 37 37 sky130_fd_pr__pfet_01v8 L=0.15U W=0.75U AS=0.178875P
+ AD=0.195P PS=1.26U PD=2.02U
* device instance $2158 r0 *1 67.685,27.645 sky130_fd_pr__pfet_01v8
M$2158 506 495 37 37 sky130_fd_pr__pfet_01v8 L=0.15U W=0.42U AS=0.1092P
+ AD=0.06405P PS=1.36U PD=0.725U
* device instance $2159 r0 *1 68.14,27.645 sky130_fd_pr__pfet_01v8
M$2159 496 490 506 506 sky130_fd_pr__pfet_01v8 L=0.15U W=0.42U AS=0.06405P
+ AD=0.0567P PS=0.725U PD=0.69U
* device instance $2160 r0 *1 68.56,27.645 sky130_fd_pr__pfet_01v8
M$2160 504 491 496 496 sky130_fd_pr__pfet_01v8 L=0.15U W=0.42U AS=0.0567P
+ AD=0.0882P PS=0.69U PD=0.84U
* device instance $2161 r0 *1 69.13,27.645 sky130_fd_pr__pfet_01v8
M$2161 37 497 504 504 sky130_fd_pr__pfet_01v8 L=0.15U W=0.42U AS=0.0882P
+ AD=0.1113P PS=0.84U PD=1.37U
* device instance $2162 r0 *1 70.185,27.755 sky130_fd_pr__pfet_01v8
M$2162 37 496 497 497 sky130_fd_pr__pfet_01v8 L=0.15U W=0.64U AS=0.1728P
+ AD=0.154P PS=1.82U PD=1.335U
* device instance $2163 r0 *1 70.67,27.935 sky130_fd_pr__pfet_01v8
M$2163 343 496 37 37 sky130_fd_pr__pfet_01v8 L=0.15U W=1U AS=0.154P AD=0.28P
+ PS=1.335U PD=2.56U
* device instance $2164 r0 *1 9.21,27.785 sky130_fd_pr__pfet_01v8
M$2164 37 32 476 476 sky130_fd_pr__pfet_01v8 L=0.15U W=0.64U AS=0.1664P
+ AD=0.0864P PS=1.8U PD=0.91U
* device instance $2165 r0 *1 9.63,27.785 sky130_fd_pr__pfet_01v8
M$2165 477 476 37 37 sky130_fd_pr__pfet_01v8 L=0.15U W=0.64U AS=0.0864P
+ AD=0.1664P PS=0.91U PD=1.8U
* device instance $2166 r0 *1 13.35,33.295 sky130_fd_pr__pfet_01v8
M$2166 578 553 37 37 sky130_fd_pr__pfet_01v8 L=0.15U W=1.68U AS=0.3318P
+ AD=0.3486P PS=3.31U PD=3.35U
* device instance $2168 r0 *1 26.285,32.085 sky130_fd_pr__pfet_01v8
M$2168 552 435 37 37 sky130_fd_pr__pfet_01v8 L=0.15U W=0.64U AS=0.1696P
+ AD=0.0768P PS=1.81U PD=0.88U
* device instance $2169 r0 *1 26.675,32.085 sky130_fd_pr__pfet_01v8
M$2169 544 328 552 552 sky130_fd_pr__pfet_01v8 L=0.15U W=0.64U AS=0.0768P
+ AD=0.0896P PS=0.88U PD=0.92U
* device instance $2170 r0 *1 27.105,32.085 sky130_fd_pr__pfet_01v8
M$2170 37 534 544 544 sky130_fd_pr__pfet_01v8 L=0.15U W=0.64U AS=0.0896P
+ AD=0.1824P PS=0.92U PD=1.85U
* device instance $2171 r0 *1 27.155,33.375 sky130_fd_pr__pfet_01v8
M$2171 554 545 37 37 sky130_fd_pr__pfet_01v8 L=0.15U W=1U AS=0.265P AD=0.14P
+ PS=2.53U PD=1.28U
* device instance $2172 r0 *1 27.585,33.375 sky130_fd_pr__pfet_01v8
M$2172 37 544 554 554 sky130_fd_pr__pfet_01v8 L=0.15U W=1U AS=0.14P AD=0.1775P
+ PS=1.28U PD=1.355U
* device instance $2173 r0 *1 28.09,33.375 sky130_fd_pr__pfet_01v8
M$2173 555 554 37 37 sky130_fd_pr__pfet_01v8 L=0.15U W=4U AS=0.5975P AD=0.705P
+ PS=5.195U PD=6.41U
* device instance $2177 r0 *1 28.08,31.615 sky130_fd_pr__pfet_01v8
M$2177 549 328 535 535 sky130_fd_pr__pfet_01v8 L=0.15U W=0.42U AS=0.1092P
+ AD=0.0441P PS=1.36U PD=0.63U
* device instance $2178 r0 *1 28.44,31.615 sky130_fd_pr__pfet_01v8
M$2178 550 435 549 549 sky130_fd_pr__pfet_01v8 L=0.15U W=0.42U AS=0.0441P
+ AD=0.0693P PS=0.63U PD=0.75U
* device instance $2179 r0 *1 28.92,31.615 sky130_fd_pr__pfet_01v8
M$2179 37 534 550 550 sky130_fd_pr__pfet_01v8 L=0.15U W=0.42U AS=0.0693P
+ AD=0.14825P PS=0.75U PD=1.34U
* device instance $2180 r0 *1 29.41,31.905 sky130_fd_pr__pfet_01v8
M$2180 545 535 37 37 sky130_fd_pr__pfet_01v8 L=0.15U W=1U AS=0.14825P AD=0.28P
+ PS=1.34U PD=2.56U
* device instance $2181 r0 *1 31.77,31.905 sky130_fd_pr__pfet_01v8
M$2181 440 545 37 37 sky130_fd_pr__pfet_01v8 L=0.15U W=1U AS=0.26P AD=0.135P
+ PS=2.52U PD=1.27U
* device instance $2182 r0 *1 32.19,31.905 sky130_fd_pr__pfet_01v8
M$2182 37 512 440 440 sky130_fd_pr__pfet_01v8 L=0.15U W=1U AS=0.135P AD=0.26P
+ PS=1.27U PD=2.52U
* device instance $2183 r0 *1 35.91,31.905 sky130_fd_pr__pfet_01v8
M$2183 439 264 37 37 sky130_fd_pr__pfet_01v8 L=0.15U W=1U AS=0.26P AD=0.135P
+ PS=2.52U PD=1.27U
* device instance $2184 r0 *1 36.33,31.905 sky130_fd_pr__pfet_01v8
M$2184 37 486 439 439 sky130_fd_pr__pfet_01v8 L=0.15U W=1U AS=0.135P AD=0.26P
+ PS=1.27U PD=2.52U
* device instance $2185 r0 *1 38.19,31.905 sky130_fd_pr__pfet_01v8
M$2185 546 167 536 536 sky130_fd_pr__pfet_01v8 L=0.15U W=1U AS=0.26P AD=0.135P
+ PS=2.52U PD=1.27U
* device instance $2186 r0 *1 38.61,31.905 sky130_fd_pr__pfet_01v8
M$2186 547 372 546 546 sky130_fd_pr__pfet_01v8 L=0.15U W=1U AS=0.135P AD=0.135P
+ PS=1.27U PD=1.27U
* device instance $2187 r0 *1 39.03,31.905 sky130_fd_pr__pfet_01v8
M$2187 546 92 547 547 sky130_fd_pr__pfet_01v8 L=0.15U W=1U AS=0.135P AD=0.26P
+ PS=1.27U PD=2.52U
* device instance $2188 r0 *1 39.97,31.905 sky130_fd_pr__pfet_01v8
M$2188 547 135 37 37 sky130_fd_pr__pfet_01v8 L=0.15U W=1U AS=0.26P AD=0.165P
+ PS=2.52U PD=1.33U
* device instance $2189 r0 *1 40.45,31.905 sky130_fd_pr__pfet_01v8
M$2189 37 3 547 547 sky130_fd_pr__pfet_01v8 L=0.15U W=1U AS=0.165P AD=0.1575P
+ PS=1.33U PD=1.315U
* device instance $2190 r0 *1 40.915,31.905 sky130_fd_pr__pfet_01v8
M$2190 548 536 37 37 sky130_fd_pr__pfet_01v8 L=0.15U W=1U AS=0.1575P AD=0.26P
+ PS=1.315U PD=2.52U
* device instance $2191 r0 *1 41.85,33.195 sky130_fd_pr__pfet_01v8
M$2191 572 548 558 558 sky130_fd_pr__pfet_01v8 L=0.15U W=0.64U AS=0.1664P
+ AD=0.0672P PS=1.8U PD=0.85U
* device instance $2192 r0 *1 42.21,33.195 sky130_fd_pr__pfet_01v8
M$2192 37 559 572 572 sky130_fd_pr__pfet_01v8 L=0.15U W=0.64U AS=0.0672P
+ AD=0.1664P PS=0.85U PD=1.8U
* device instance $2193 r0 *1 41.87,31.985 sky130_fd_pr__pfet_01v8
M$2193 486 537 37 37 sky130_fd_pr__pfet_01v8 L=0.15U W=1.68U AS=0.3318P
+ AD=0.3486P PS=3.31U PD=3.35U
* device instance $2195 r0 *1 44.875,33.085 sky130_fd_pr__pfet_01v8
M$2195 560 557 558 558 sky130_fd_pr__pfet_01v8 L=0.15U W=0.42U AS=0.15985P
+ AD=0.06405P PS=1.265U PD=0.725U
* device instance $2196 r0 *1 45.33,33.085 sky130_fd_pr__pfet_01v8
M$2196 574 556 560 560 sky130_fd_pr__pfet_01v8 L=0.15U W=0.42U AS=0.06405P
+ AD=0.07665P PS=0.725U PD=0.785U
* device instance $2197 r0 *1 45.845,33.085 sky130_fd_pr__pfet_01v8
M$2197 37 561 574 574 sky130_fd_pr__pfet_01v8 L=0.15U W=0.42U AS=0.07665P
+ AD=0.178875P PS=0.785U PD=1.26U
* device instance $2198 r0 *1 43.15,33.195 sky130_fd_pr__pfet_01v8
M$2198 37 302 559 559 sky130_fd_pr__pfet_01v8 L=0.15U W=0.64U AS=0.1664P
+ AD=0.0928P PS=1.8U PD=0.93U
* device instance $2199 r0 *1 43.59,33.195 sky130_fd_pr__pfet_01v8
M$2199 573 302 37 37 sky130_fd_pr__pfet_01v8 L=0.15U W=0.64U AS=0.0928P
+ AD=0.1152P PS=0.93U PD=1U
* device instance $2200 r0 *1 44.1,33.195 sky130_fd_pr__pfet_01v8
M$2200 558 563 573 573 sky130_fd_pr__pfet_01v8 L=0.15U W=0.64U AS=0.1152P
+ AD=0.15985P PS=1U PD=1.265U
* device instance $2201 r0 *1 46.505,33.25 sky130_fd_pr__pfet_01v8
M$2201 561 560 37 37 sky130_fd_pr__pfet_01v8 L=0.15U W=0.75U AS=0.178875P
+ AD=0.195P PS=1.26U PD=2.02U
* device instance $2202 r0 *1 44.87,31.615 sky130_fd_pr__pfet_01v8
M$2202 37 513 538 538 sky130_fd_pr__pfet_01v8 L=0.15U W=0.42U AS=0.1092P
+ AD=0.1573P PS=1.36U PD=1.39U
* device instance $2203 r0 *1 45.41,31.905 sky130_fd_pr__pfet_01v8
M$2203 551 372 37 37 sky130_fd_pr__pfet_01v8 L=0.15U W=1U AS=0.1573P AD=0.105P
+ PS=1.39U PD=1.21U
* device instance $2204 r0 *1 45.77,31.905 sky130_fd_pr__pfet_01v8
M$2204 537 538 551 551 sky130_fd_pr__pfet_01v8 L=0.15U W=1U AS=0.105P AD=0.26P
+ PS=1.21U PD=2.52U
* device instance $2205 r0 *1 47.19,31.905 sky130_fd_pr__pfet_01v8
M$2205 539 999 37 37 sky130_fd_pr__pfet_01v8 L=0.15U W=2U AS=0.395P AD=0.27P
+ PS=3.79U PD=2.54U
* device instance $2207 r0 *1 48.03,31.905 sky130_fd_pr__pfet_01v8
M$2207 135 539 37 37 sky130_fd_pr__pfet_01v8 L=0.15U W=6U AS=0.81P AD=0.935P
+ PS=7.62U PD=8.87U
* device instance $2213 r0 *1 47.445,33.085 sky130_fd_pr__pfet_01v8
M$2213 575 561 37 37 sky130_fd_pr__pfet_01v8 L=0.15U W=0.42U AS=0.1092P
+ AD=0.06405P PS=1.36U PD=0.725U
* device instance $2214 r0 *1 47.9,33.085 sky130_fd_pr__pfet_01v8
M$2214 562 556 575 575 sky130_fd_pr__pfet_01v8 L=0.15U W=0.42U AS=0.06405P
+ AD=0.0567P PS=0.725U PD=0.69U
* device instance $2215 r0 *1 48.32,33.085 sky130_fd_pr__pfet_01v8
M$2215 576 557 562 562 sky130_fd_pr__pfet_01v8 L=0.15U W=0.42U AS=0.0567P
+ AD=0.0882P PS=0.69U PD=0.84U
* device instance $2216 r0 *1 48.89,33.085 sky130_fd_pr__pfet_01v8
M$2216 37 563 576 576 sky130_fd_pr__pfet_01v8 L=0.15U W=0.42U AS=0.0882P
+ AD=0.1113P PS=0.84U PD=1.37U
* device instance $2217 r0 *1 49.945,33.195 sky130_fd_pr__pfet_01v8
M$2217 37 562 563 563 sky130_fd_pr__pfet_01v8 L=0.15U W=0.64U AS=0.1728P
+ AD=0.154P PS=1.82U PD=1.335U
* device instance $2218 r0 *1 50.43,33.375 sky130_fd_pr__pfet_01v8
M$2218 513 562 37 37 sky130_fd_pr__pfet_01v8 L=0.15U W=1U AS=0.154P AD=0.28P
+ PS=1.335U PD=2.56U
* device instance $2219 r0 *1 59.81,33.375 sky130_fd_pr__pfet_01v8
M$2219 37 307 564 564 sky130_fd_pr__pfet_01v8 L=0.15U W=1U AS=0.26P AD=0.135P
+ PS=2.52U PD=1.27U
* device instance $2220 r0 *1 60.23,33.375 sky130_fd_pr__pfet_01v8
M$2220 577 564 37 37 sky130_fd_pr__pfet_01v8 L=0.15U W=4U AS=0.54P AD=0.665P
+ PS=5.08U PD=6.33U
* device instance $2224 r0 *1 60.73,27.785 sky130_fd_pr__pfet_01v8
M$2224 37 333 490 490 sky130_fd_pr__pfet_01v8 L=0.15U W=0.64U AS=0.1664P
+ AD=0.0864P PS=1.8U PD=0.91U
* device instance $2225 r0 *1 61.15,27.785 sky130_fd_pr__pfet_01v8
M$2225 491 490 37 37 sky130_fd_pr__pfet_01v8 L=0.15U W=0.64U AS=0.0864P
+ AD=0.1664P PS=0.91U PD=1.8U
* device instance $2226 r0 *1 62.57,33.375 sky130_fd_pr__pfet_01v8
M$2226 567 565 566 566 sky130_fd_pr__pfet_01v8 L=0.15U W=1U AS=0.26P AD=0.135P
+ PS=2.52U PD=1.27U
* device instance $2227 r0 *1 62.99,33.375 sky130_fd_pr__pfet_01v8
M$2227 569 568 567 567 sky130_fd_pr__pfet_01v8 L=0.15U W=1U AS=0.135P AD=0.135P
+ PS=1.27U PD=1.27U
* device instance $2228 r0 *1 63.41,33.375 sky130_fd_pr__pfet_01v8
M$2228 567 92 569 569 sky130_fd_pr__pfet_01v8 L=0.15U W=1U AS=0.135P AD=0.26P
+ PS=1.27U PD=2.52U
* device instance $2229 r0 *1 64.35,33.375 sky130_fd_pr__pfet_01v8
M$2229 569 158 37 37 sky130_fd_pr__pfet_01v8 L=0.15U W=1U AS=0.26P AD=0.165P
+ PS=2.52U PD=1.33U
* device instance $2230 r0 *1 64.83,33.375 sky130_fd_pr__pfet_01v8
M$2230 37 571 569 569 sky130_fd_pr__pfet_01v8 L=0.15U W=1U AS=0.165P AD=0.1575P
+ PS=1.33U PD=1.315U
* device instance $2231 r0 *1 65.295,33.375 sky130_fd_pr__pfet_01v8
M$2231 570 566 37 37 sky130_fd_pr__pfet_01v8 L=0.15U W=1U AS=0.1575P AD=0.26P
+ PS=1.315U PD=2.52U
* device instance $2232 r0 *1 8.75,37.345 sky130_fd_pr__pfet_01v8
M$2232 615 587 588 588 sky130_fd_pr__pfet_01v8 L=0.15U W=1U AS=0.26P AD=0.135P
+ PS=2.52U PD=1.27U
* device instance $2233 r0 *1 9.17,37.345 sky130_fd_pr__pfet_01v8
M$2233 616 589 615 615 sky130_fd_pr__pfet_01v8 L=0.15U W=1U AS=0.135P AD=0.135P
+ PS=1.27U PD=1.27U
* device instance $2234 r0 *1 9.59,37.345 sky130_fd_pr__pfet_01v8
M$2234 615 92 616 616 sky130_fd_pr__pfet_01v8 L=0.15U W=1U AS=0.135P AD=0.26P
+ PS=1.27U PD=2.52U
* device instance $2235 r0 *1 10.53,37.345 sky130_fd_pr__pfet_01v8
M$2235 616 158 37 37 sky130_fd_pr__pfet_01v8 L=0.15U W=1U AS=0.26P AD=0.165P
+ PS=2.52U PD=1.33U
* device instance $2236 r0 *1 11.01,37.345 sky130_fd_pr__pfet_01v8
M$2236 37 590 616 616 sky130_fd_pr__pfet_01v8 L=0.15U W=1U AS=0.165P AD=0.1575P
+ PS=1.33U PD=1.315U
* device instance $2237 r0 *1 11.475,37.345 sky130_fd_pr__pfet_01v8
M$2237 591 588 37 37 sky130_fd_pr__pfet_01v8 L=0.15U W=1U AS=0.1575P AD=0.26P
+ PS=1.315U PD=2.52U
* device instance $2238 r0 *1 12.53,37.525 sky130_fd_pr__pfet_01v8
M$2238 619 578 592 592 sky130_fd_pr__pfet_01v8 L=0.15U W=0.64U AS=0.1664P
+ AD=0.0672P PS=1.8U PD=0.85U
* device instance $2239 r0 *1 12.89,37.525 sky130_fd_pr__pfet_01v8
M$2239 37 593 619 619 sky130_fd_pr__pfet_01v8 L=0.15U W=0.64U AS=0.0672P
+ AD=0.0864P PS=0.85U PD=0.91U
* device instance $2240 r0 *1 13.31,37.525 sky130_fd_pr__pfet_01v8
M$2240 620 593 37 37 sky130_fd_pr__pfet_01v8 L=0.15U W=0.64U AS=0.0864P
+ AD=0.0672P PS=0.91U PD=0.85U
* device instance $2241 r0 *1 13.67,37.525 sky130_fd_pr__pfet_01v8
M$2241 592 594 620 620 sky130_fd_pr__pfet_01v8 L=0.15U W=0.64U AS=0.0672P
+ AD=0.0864P PS=0.85U PD=0.91U
* device instance $2242 r0 *1 14.09,37.525 sky130_fd_pr__pfet_01v8
M$2242 621 594 592 592 sky130_fd_pr__pfet_01v8 L=0.15U W=0.64U AS=0.0864P
+ AD=0.0672P PS=0.91U PD=0.85U
* device instance $2243 r0 *1 14.45,37.525 sky130_fd_pr__pfet_01v8
M$2243 621 578 37 37 sky130_fd_pr__pfet_01v8 L=0.15U W=0.64U AS=0.237P
+ AD=0.0672P PS=1.6U PD=0.85U
* device instance $2244 r0 *1 15.2,37.345 sky130_fd_pr__pfet_01v8
M$2244 341 592 37 37 sky130_fd_pr__pfet_01v8 L=0.15U W=2U AS=0.372P AD=0.405P
+ PS=2.87U PD=3.81U
* device instance $2246 r0 *1 31.29,37.425 sky130_fd_pr__pfet_01v8
M$2246 534 595 37 37 sky130_fd_pr__pfet_01v8 L=0.15U W=1.68U AS=0.3318P
+ AD=0.3486P PS=3.31U PD=3.35U
* device instance $2248 r0 *1 34.05,37.055 sky130_fd_pr__pfet_01v8
M$2248 37 650 596 596 sky130_fd_pr__pfet_01v8 L=0.15U W=0.42U AS=0.1092P
+ AD=0.14575P PS=1.36U PD=1.335U
* device instance $2249 r0 *1 34.535,37.345 sky130_fd_pr__pfet_01v8
M$2249 512 597 37 37 sky130_fd_pr__pfet_01v8 L=0.15U W=1U AS=0.14575P AD=0.135P
+ PS=1.335U PD=1.27U
* device instance $2250 r0 *1 34.955,37.345 sky130_fd_pr__pfet_01v8
M$2250 37 596 512 512 sky130_fd_pr__pfet_01v8 L=0.15U W=1U AS=0.135P AD=0.265P
+ PS=1.27U PD=2.53U
* device instance $2251 r0 *1 40.49,33.225 sky130_fd_pr__pfet_01v8
M$2251 37 333 556 556 sky130_fd_pr__pfet_01v8 L=0.15U W=0.64U AS=0.1664P
+ AD=0.0864P PS=1.8U PD=0.91U
* device instance $2252 r0 *1 40.91,33.225 sky130_fd_pr__pfet_01v8
M$2252 557 556 37 37 sky130_fd_pr__pfet_01v8 L=0.15U W=0.64U AS=0.0864P
+ AD=0.1664P PS=0.91U PD=1.8U
* device instance $2253 r0 *1 59.42,37.635 sky130_fd_pr__pfet_01v8
M$2253 598 599 37 37 sky130_fd_pr__pfet_01v8 L=0.15U W=0.42U AS=0.1113P
+ AD=0.0609P PS=1.37U PD=0.71U
* device instance $2254 r0 *1 59.86,37.635 sky130_fd_pr__pfet_01v8
M$2254 598 115 37 37 sky130_fd_pr__pfet_01v8 L=0.15U W=0.42U AS=0.1841P
+ AD=0.0609P PS=1.26U PD=0.71U
* device instance $2255 r0 *1 60.63,37.525 sky130_fd_pr__pfet_01v8
M$2255 565 598 37 37 sky130_fd_pr__pfet_01v8 L=0.15U W=0.64U AS=0.1841P
+ AD=0.1696P PS=1.26U PD=1.81U
* device instance $2256 r0 *1 61.67,37.345 sky130_fd_pr__pfet_01v8
M$2256 600 577 37 37 sky130_fd_pr__pfet_01v8 L=0.15U W=1U AS=0.26P AD=0.135P
+ PS=2.52U PD=1.27U
* device instance $2257 r0 *1 62.09,37.345 sky130_fd_pr__pfet_01v8
M$2257 37 342 600 600 sky130_fd_pr__pfet_01v8 L=0.15U W=1U AS=0.135P AD=0.26P
+ PS=1.27U PD=2.52U
* device instance $2258 r0 *1 63.07,37.345 sky130_fd_pr__pfet_01v8
M$2258 601 600 37 37 sky130_fd_pr__pfet_01v8 L=0.15U W=1U AS=0.3P AD=0.135P
+ PS=2.6U PD=1.27U
* device instance $2259 r0 *1 63.49,37.345 sky130_fd_pr__pfet_01v8
M$2259 37 602 601 601 sky130_fd_pr__pfet_01v8 L=0.15U W=1U AS=0.135P AD=0.365P
+ PS=1.27U PD=1.73U
* device instance $2260 r0 *1 64.37,37.345 sky130_fd_pr__pfet_01v8
M$2260 618 602 37 37 sky130_fd_pr__pfet_01v8 L=0.15U W=1U AS=0.365P AD=0.105P
+ PS=1.73U PD=1.21U
* device instance $2261 r0 *1 64.73,37.345 sky130_fd_pr__pfet_01v8
M$2261 571 600 618 618 sky130_fd_pr__pfet_01v8 L=0.15U W=1U AS=0.105P AD=0.165P
+ PS=1.21U PD=1.33U
* device instance $2262 r0 *1 65.21,37.345 sky130_fd_pr__pfet_01v8
M$2262 37 601 571 571 sky130_fd_pr__pfet_01v8 L=0.15U W=1U AS=0.165P AD=0.36P
+ PS=1.33U PD=2.72U
* device instance $2263 r0 *1 66.49,37.055 sky130_fd_pr__pfet_01v8
M$2263 37 651 604 604 sky130_fd_pr__pfet_01v8 L=0.15U W=0.42U AS=0.1092P
+ AD=0.1573P PS=1.36U PD=1.39U
* device instance $2264 r0 *1 67.03,37.345 sky130_fd_pr__pfet_01v8
M$2264 617 568 37 37 sky130_fd_pr__pfet_01v8 L=0.15U W=1U AS=0.1573P AD=0.105P
+ PS=1.39U PD=1.21U
* device instance $2265 r0 *1 67.39,37.345 sky130_fd_pr__pfet_01v8
M$2265 605 604 617 617 sky130_fd_pr__pfet_01v8 L=0.15U W=1U AS=0.105P AD=0.26P
+ PS=1.21U PD=2.52U
* device instance $2266 r0 *1 4.68,38.525 sky130_fd_pr__pfet_01v8
M$2266 623 622 37 37 sky130_fd_pr__pfet_01v8 L=0.15U W=0.42U AS=0.1113P
+ AD=0.0609P PS=1.37U PD=0.71U
* device instance $2267 r0 *1 5.12,38.525 sky130_fd_pr__pfet_01v8
M$2267 37 115 623 623 sky130_fd_pr__pfet_01v8 L=0.15U W=0.42U AS=0.0609P
+ AD=0.1841P PS=0.71U PD=1.26U
* device instance $2268 r0 *1 5.89,38.635 sky130_fd_pr__pfet_01v8
M$2268 587 623 37 37 sky130_fd_pr__pfet_01v8 L=0.15U W=0.64U AS=0.1841P
+ AD=0.1696P PS=1.26U PD=1.81U
* device instance $2269 r0 *1 7.455,38.72 sky130_fd_pr__pfet_01v8
M$2269 645 64 37 37 sky130_fd_pr__pfet_01v8 L=0.15U W=0.42U AS=0.15835P
+ AD=0.07665P PS=1.395U PD=0.785U
* device instance $2270 r0 *1 7.97,38.72 sky130_fd_pr__pfet_01v8
M$2270 625 594 645 645 sky130_fd_pr__pfet_01v8 L=0.15U W=0.42U AS=0.07665P
+ AD=0.1932P PS=0.785U PD=1.34U
* device instance $2271 r0 *1 9.04,38.72 sky130_fd_pr__pfet_01v8
M$2271 646 626 625 625 sky130_fd_pr__pfet_01v8 L=0.15U W=0.42U AS=0.1932P
+ AD=0.0441P PS=1.34U PD=0.63U
* device instance $2272 r0 *1 9.4,38.72 sky130_fd_pr__pfet_01v8
M$2272 37 658 646 646 sky130_fd_pr__pfet_01v8 L=0.15U W=0.42U AS=0.0441P
+ AD=0.0693P PS=0.63U PD=0.75U
* device instance $2273 r0 *1 9.88,38.72 sky130_fd_pr__pfet_01v8
M$2273 658 64 37 37 sky130_fd_pr__pfet_01v8 L=0.15U W=0.42U AS=0.0693P
+ AD=0.1176P PS=0.75U PD=1.4U
* device instance $2274 r0 *1 6.91,38.815 sky130_fd_pr__pfet_01v8
M$2274 37 625 624 624 sky130_fd_pr__pfet_01v8 L=0.15U W=1U AS=0.26P AD=0.15835P
+ PS=2.52U PD=1.395U
* device instance $2275 r0 *1 11.09,38.815 sky130_fd_pr__pfet_01v8
M$2275 627 631 37 37 sky130_fd_pr__pfet_01v8 L=0.15U W=1U AS=0.3P AD=0.135P
+ PS=2.6U PD=1.27U
* device instance $2276 r0 *1 11.51,38.815 sky130_fd_pr__pfet_01v8
M$2276 37 628 627 627 sky130_fd_pr__pfet_01v8 L=0.15U W=1U AS=0.135P AD=0.365P
+ PS=1.27U PD=1.73U
* device instance $2277 r0 *1 12.39,38.815 sky130_fd_pr__pfet_01v8
M$2277 655 628 37 37 sky130_fd_pr__pfet_01v8 L=0.15U W=1U AS=0.365P AD=0.105P
+ PS=1.73U PD=1.21U
* device instance $2278 r0 *1 12.75,38.815 sky130_fd_pr__pfet_01v8
M$2278 590 631 655 655 sky130_fd_pr__pfet_01v8 L=0.15U W=1U AS=0.105P AD=0.165P
+ PS=1.21U PD=1.33U
* device instance $2279 r0 *1 13.23,38.815 sky130_fd_pr__pfet_01v8
M$2279 37 627 590 590 sky130_fd_pr__pfet_01v8 L=0.15U W=1U AS=0.165P AD=0.36P
+ PS=1.33U PD=2.72U
* device instance $2280 r0 *1 14.31,38.815 sky130_fd_pr__pfet_01v8
M$2280 656 594 629 629 sky130_fd_pr__pfet_01v8 L=0.15U W=1U AS=0.26P AD=0.135P
+ PS=2.52U PD=1.27U
* device instance $2281 r0 *1 14.73,38.815 sky130_fd_pr__pfet_01v8
M$2281 37 589 656 656 sky130_fd_pr__pfet_01v8 L=0.15U W=1U AS=0.135P AD=0.135P
+ PS=1.27U PD=1.27U
* device instance $2282 r0 *1 15.15,38.815 sky130_fd_pr__pfet_01v8
M$2282 630 589 37 37 sky130_fd_pr__pfet_01v8 L=0.15U W=1U AS=0.135P AD=0.135P
+ PS=1.27U PD=1.27U
* device instance $2283 r0 *1 15.57,38.815 sky130_fd_pr__pfet_01v8
M$2283 37 594 630 630 sky130_fd_pr__pfet_01v8 L=0.15U W=1U AS=0.135P AD=0.26P
+ PS=1.27U PD=2.52U
* device instance $2284 r0 *1 16.51,38.815 sky130_fd_pr__pfet_01v8
M$2284 631 629 630 630 sky130_fd_pr__pfet_01v8 L=0.15U W=1U AS=0.26P AD=0.3P
+ PS=2.52U PD=2.6U
* device instance $2285 r0 *1 25.77,38.815 sky130_fd_pr__pfet_01v8
M$2285 633 649 632 632 sky130_fd_pr__pfet_01v8 L=0.15U W=1U AS=0.26P AD=0.135P
+ PS=2.52U PD=1.27U
* device instance $2286 r0 *1 26.19,38.815 sky130_fd_pr__pfet_01v8
M$2286 634 650 633 633 sky130_fd_pr__pfet_01v8 L=0.15U W=1U AS=0.135P AD=0.135P
+ PS=1.27U PD=1.27U
* device instance $2287 r0 *1 26.61,38.815 sky130_fd_pr__pfet_01v8
M$2287 633 92 634 634 sky130_fd_pr__pfet_01v8 L=0.15U W=1U AS=0.135P AD=0.26P
+ PS=1.27U PD=2.52U
* device instance $2288 r0 *1 27.55,38.815 sky130_fd_pr__pfet_01v8
M$2288 634 135 37 37 sky130_fd_pr__pfet_01v8 L=0.15U W=1U AS=0.26P AD=0.165P
+ PS=2.52U PD=1.33U
* device instance $2289 r0 *1 28.03,38.815 sky130_fd_pr__pfet_01v8
M$2289 37 555 634 634 sky130_fd_pr__pfet_01v8 L=0.15U W=1U AS=0.165P AD=0.1575P
+ PS=1.33U PD=1.315U
* device instance $2290 r0 *1 28.495,38.815 sky130_fd_pr__pfet_01v8
M$2290 635 632 37 37 sky130_fd_pr__pfet_01v8 L=0.15U W=1U AS=0.1575P AD=0.26P
+ PS=1.315U PD=2.52U
* device instance $2291 r0 *1 30.87,38.815 sky130_fd_pr__pfet_01v8
M$2291 636 597 37 37 sky130_fd_pr__pfet_01v8 L=0.15U W=1U AS=0.3P AD=0.135P
+ PS=2.6U PD=1.27U
* device instance $2292 r0 *1 31.29,38.815 sky130_fd_pr__pfet_01v8
M$2292 37 650 636 636 sky130_fd_pr__pfet_01v8 L=0.15U W=1U AS=0.135P AD=0.365P
+ PS=1.27U PD=1.73U
* device instance $2293 r0 *1 32.17,38.815 sky130_fd_pr__pfet_01v8
M$2293 657 650 37 37 sky130_fd_pr__pfet_01v8 L=0.15U W=1U AS=0.365P AD=0.105P
+ PS=1.73U PD=1.21U
* device instance $2294 r0 *1 32.53,38.815 sky130_fd_pr__pfet_01v8
M$2294 595 597 657 657 sky130_fd_pr__pfet_01v8 L=0.15U W=1U AS=0.105P AD=0.165P
+ PS=1.21U PD=1.33U
* device instance $2295 r0 *1 33.01,38.815 sky130_fd_pr__pfet_01v8
M$2295 37 636 595 595 sky130_fd_pr__pfet_01v8 L=0.15U W=1U AS=0.165P AD=0.36P
+ PS=1.33U PD=2.72U
* device instance $2296 r0 *1 35.435,38.815 sky130_fd_pr__pfet_01v8
M$2296 637 661 37 37 sky130_fd_pr__pfet_01v8 L=0.15U W=4U AS=0.685P AD=0.56P
+ PS=6.37U PD=5.12U
* device instance $2300 r0 *1 37.155,38.815 sky130_fd_pr__pfet_01v8
M$2300 297 637 37 37 sky130_fd_pr__pfet_01v8 L=0.15U W=16U AS=2.2375P
+ AD=2.3625P PS=20.475U PD=21.725U
* device instance $2316 r0 *1 55.67,38.815 sky130_fd_pr__pfet_01v8
M$2316 638 577 37 37 sky130_fd_pr__pfet_01v8 L=0.15U W=1U AS=0.26P AD=0.135P
+ PS=2.52U PD=1.27U
* device instance $2317 r0 *1 56.09,38.815 sky130_fd_pr__pfet_01v8
M$2317 37 342 638 638 sky130_fd_pr__pfet_01v8 L=0.15U W=1U AS=0.135P AD=0.1525P
+ PS=1.27U PD=1.305U
* device instance $2318 r0 *1 56.545,38.815 sky130_fd_pr__pfet_01v8
M$2318 638 602 37 37 sky130_fd_pr__pfet_01v8 L=0.15U W=1U AS=0.1525P AD=0.1625P
+ PS=1.305U PD=1.325U
* device instance $2319 r0 *1 57.02,38.815 sky130_fd_pr__pfet_01v8
M$2319 639 605 638 638 sky130_fd_pr__pfet_01v8 L=0.15U W=1U AS=0.1625P AD=0.27P
+ PS=1.325U PD=2.54U
* device instance $2320 r0 *1 59.35,38.815 sky130_fd_pr__pfet_01v8
M$2320 640 342 37 37 sky130_fd_pr__pfet_01v8 L=0.15U W=1U AS=0.26P AD=0.1375P
+ PS=2.52U PD=1.275U
* device instance $2321 r0 *1 59.775,38.815 sky130_fd_pr__pfet_01v8
M$2321 37 307 640 640 sky130_fd_pr__pfet_01v8 L=0.15U W=1U AS=0.1375P AD=0.14P
+ PS=1.275U PD=1.28U
* device instance $2322 r0 *1 60.205,38.815 sky130_fd_pr__pfet_01v8
M$2322 640 602 37 37 sky130_fd_pr__pfet_01v8 L=0.15U W=1U AS=0.14P AD=0.165P
+ PS=1.28U PD=1.33U
* device instance $2323 r0 *1 60.685,38.815 sky130_fd_pr__pfet_01v8
M$2323 654 605 640 640 sky130_fd_pr__pfet_01v8 L=0.15U W=1U AS=0.165P
+ AD=0.1725P PS=1.33U PD=1.345U
* device instance $2324 r0 *1 61.18,38.815 sky130_fd_pr__pfet_01v8
M$2324 641 662 654 654 sky130_fd_pr__pfet_01v8 L=0.15U W=1U AS=0.1725P AD=0.26P
+ PS=1.345U PD=2.52U
* device instance $2325 r0 *1 64.45,38.815 sky130_fd_pr__pfet_01v8
M$2325 642 651 37 37 sky130_fd_pr__pfet_01v8 L=0.15U W=1U AS=0.3P AD=0.135P
+ PS=2.6U PD=1.27U
* device instance $2326 r0 *1 64.87,38.815 sky130_fd_pr__pfet_01v8
M$2326 37 568 642 642 sky130_fd_pr__pfet_01v8 L=0.15U W=1U AS=0.135P AD=0.365P
+ PS=1.27U PD=1.73U
* device instance $2327 r0 *1 65.75,38.815 sky130_fd_pr__pfet_01v8
M$2327 653 568 37 37 sky130_fd_pr__pfet_01v8 L=0.15U W=1U AS=0.365P AD=0.105P
+ PS=1.73U PD=1.21U
* device instance $2328 r0 *1 66.11,38.815 sky130_fd_pr__pfet_01v8
M$2328 602 651 653 653 sky130_fd_pr__pfet_01v8 L=0.15U W=1U AS=0.105P AD=0.165P
+ PS=1.21U PD=1.33U
* device instance $2329 r0 *1 66.59,38.815 sky130_fd_pr__pfet_01v8
M$2329 37 642 602 602 sky130_fd_pr__pfet_01v8 L=0.15U W=1U AS=0.165P AD=0.36P
+ PS=1.33U PD=2.72U
* device instance $2330 r0 *1 68.635,38.72 sky130_fd_pr__pfet_01v8
M$2330 648 64 37 37 sky130_fd_pr__pfet_01v8 L=0.15U W=0.42U AS=0.15835P
+ AD=0.07665P PS=1.395U PD=0.785U
* device instance $2331 r0 *1 69.15,38.72 sky130_fd_pr__pfet_01v8
M$2331 644 651 648 648 sky130_fd_pr__pfet_01v8 L=0.15U W=0.42U AS=0.07665P
+ AD=0.1932P PS=0.785U PD=1.34U
* device instance $2332 r0 *1 70.22,38.72 sky130_fd_pr__pfet_01v8
M$2332 647 652 644 644 sky130_fd_pr__pfet_01v8 L=0.15U W=0.42U AS=0.1932P
+ AD=0.0441P PS=1.34U PD=0.63U
* device instance $2333 r0 *1 70.58,38.72 sky130_fd_pr__pfet_01v8
M$2333 37 664 647 647 sky130_fd_pr__pfet_01v8 L=0.15U W=0.42U AS=0.0441P
+ AD=0.0693P PS=0.63U PD=0.75U
* device instance $2334 r0 *1 71.06,38.72 sky130_fd_pr__pfet_01v8
M$2334 664 64 37 37 sky130_fd_pr__pfet_01v8 L=0.15U W=0.42U AS=0.0693P
+ AD=0.1176P PS=0.75U PD=1.4U
* device instance $2335 r0 *1 68.09,38.815 sky130_fd_pr__pfet_01v8
M$2335 37 644 643 643 sky130_fd_pr__pfet_01v8 L=0.15U W=1U AS=0.26P AD=0.15835P
+ PS=2.52U PD=1.395U
* device instance $2336 r0 *1 2.77,42.935 sky130_fd_pr__pfet_01v8
M$2336 37 681 680 680 sky130_fd_pr__pfet_01v8 L=0.15U W=0.64U AS=0.1664P
+ AD=0.0864P PS=1.8U PD=0.91U
* device instance $2337 r0 *1 3.19,42.935 sky130_fd_pr__pfet_01v8
M$2337 682 680 37 37 sky130_fd_pr__pfet_01v8 L=0.15U W=0.64U AS=0.0864P
+ AD=0.1664P PS=0.91U PD=1.8U
* device instance $2338 r0 *1 4.13,42.965 sky130_fd_pr__pfet_01v8
M$2338 737 624 683 683 sky130_fd_pr__pfet_01v8 L=0.15U W=0.64U AS=0.1664P
+ AD=0.0672P PS=1.8U PD=0.85U
* device instance $2339 r0 *1 4.49,42.965 sky130_fd_pr__pfet_01v8
M$2339 37 684 737 737 sky130_fd_pr__pfet_01v8 L=0.15U W=0.64U AS=0.0672P
+ AD=0.1664P PS=0.85U PD=1.8U
* device instance $2340 r0 *1 5.43,42.965 sky130_fd_pr__pfet_01v8
M$2340 37 94 684 684 sky130_fd_pr__pfet_01v8 L=0.15U W=0.64U AS=0.1664P
+ AD=0.0928P PS=1.8U PD=0.93U
* device instance $2341 r0 *1 5.87,42.965 sky130_fd_pr__pfet_01v8
M$2341 739 94 37 37 sky130_fd_pr__pfet_01v8 L=0.15U W=0.64U AS=0.0928P
+ AD=0.1152P PS=0.93U PD=1U
* device instance $2342 r0 *1 6.38,42.965 sky130_fd_pr__pfet_01v8
M$2342 683 685 739 739 sky130_fd_pr__pfet_01v8 L=0.15U W=0.64U AS=0.1152P
+ AD=0.15985P PS=1U PD=1.265U
* device instance $2343 r0 *1 7.155,43.075 sky130_fd_pr__pfet_01v8
M$2343 686 682 683 683 sky130_fd_pr__pfet_01v8 L=0.15U W=0.42U AS=0.15985P
+ AD=0.06405P PS=1.265U PD=0.725U
* device instance $2344 r0 *1 7.61,43.075 sky130_fd_pr__pfet_01v8
M$2344 742 680 686 686 sky130_fd_pr__pfet_01v8 L=0.15U W=0.42U AS=0.06405P
+ AD=0.07665P PS=0.725U PD=0.785U
* device instance $2345 r0 *1 8.125,43.075 sky130_fd_pr__pfet_01v8
M$2345 742 687 37 37 sky130_fd_pr__pfet_01v8 L=0.15U W=0.42U AS=0.178875P
+ AD=0.07665P PS=1.26U PD=0.785U
* device instance $2346 r0 *1 8.785,42.91 sky130_fd_pr__pfet_01v8
M$2346 687 686 37 37 sky130_fd_pr__pfet_01v8 L=0.15U W=0.75U AS=0.178875P
+ AD=0.195P PS=1.26U PD=2.02U
* device instance $2347 r0 *1 12.225,42.965 sky130_fd_pr__pfet_01v8
M$2347 685 688 37 37 sky130_fd_pr__pfet_01v8 L=0.15U W=0.64U AS=0.154P
+ AD=0.1728P PS=1.335U PD=1.82U
* device instance $2348 r0 *1 12.71,42.785 sky130_fd_pr__pfet_01v8
M$2348 553 688 37 37 sky130_fd_pr__pfet_01v8 L=0.15U W=1U AS=0.154P AD=0.28P
+ PS=1.335U PD=2.56U
* device instance $2349 r0 *1 13.81,42.785 sky130_fd_pr__pfet_01v8
M$2349 37 553 689 689 sky130_fd_pr__pfet_01v8 L=0.15U W=1U AS=0.26P AD=0.135P
+ PS=2.52U PD=1.27U
* device instance $2350 r0 *1 14.23,42.785 sky130_fd_pr__pfet_01v8
M$2350 589 689 37 37 sky130_fd_pr__pfet_01v8 L=0.15U W=4U AS=0.54P AD=0.665P
+ PS=5.08U PD=6.33U
* device instance $2354 r0 *1 17.03,42.785 sky130_fd_pr__pfet_01v8
M$2354 37 593 690 690 sky130_fd_pr__pfet_01v8 L=0.15U W=1U AS=0.26P AD=0.135P
+ PS=2.52U PD=1.27U
* device instance $2355 r0 *1 17.45,42.785 sky130_fd_pr__pfet_01v8
M$2355 628 690 37 37 sky130_fd_pr__pfet_01v8 L=0.15U W=4U AS=0.54P AD=0.665P
+ PS=5.08U PD=6.33U
* device instance $2359 r0 *1 26.23,42.935 sky130_fd_pr__pfet_01v8
M$2359 37 681 692 692 sky130_fd_pr__pfet_01v8 L=0.15U W=0.64U AS=0.1664P
+ AD=0.0864P PS=1.8U PD=0.91U
* device instance $2360 r0 *1 26.65,42.935 sky130_fd_pr__pfet_01v8
M$2360 693 692 37 37 sky130_fd_pr__pfet_01v8 L=0.15U W=0.64U AS=0.0864P
+ AD=0.1664P PS=0.91U PD=1.8U
* device instance $2361 r0 *1 27.59,42.965 sky130_fd_pr__pfet_01v8
M$2361 754 727 694 694 sky130_fd_pr__pfet_01v8 L=0.15U W=0.64U AS=0.1664P
+ AD=0.0672P PS=1.8U PD=0.85U
* device instance $2362 r0 *1 27.95,42.965 sky130_fd_pr__pfet_01v8
M$2362 37 695 754 754 sky130_fd_pr__pfet_01v8 L=0.15U W=0.64U AS=0.0672P
+ AD=0.1664P PS=0.85U PD=1.8U
* device instance $2363 r0 *1 28.89,42.965 sky130_fd_pr__pfet_01v8
M$2363 37 94 695 695 sky130_fd_pr__pfet_01v8 L=0.15U W=0.64U AS=0.1664P
+ AD=0.0928P PS=1.8U PD=0.93U
* device instance $2364 r0 *1 29.33,42.965 sky130_fd_pr__pfet_01v8
M$2364 753 94 37 37 sky130_fd_pr__pfet_01v8 L=0.15U W=0.64U AS=0.0928P
+ AD=0.1152P PS=0.93U PD=1U
* device instance $2365 r0 *1 29.84,42.965 sky130_fd_pr__pfet_01v8
M$2365 694 696 753 753 sky130_fd_pr__pfet_01v8 L=0.15U W=0.64U AS=0.1152P
+ AD=0.15985P PS=1U PD=1.265U
* device instance $2366 r0 *1 30.615,43.075 sky130_fd_pr__pfet_01v8
M$2366 697 693 694 694 sky130_fd_pr__pfet_01v8 L=0.15U W=0.42U AS=0.15985P
+ AD=0.06405P PS=1.265U PD=0.725U
* device instance $2367 r0 *1 31.07,43.075 sky130_fd_pr__pfet_01v8
M$2367 752 692 697 697 sky130_fd_pr__pfet_01v8 L=0.15U W=0.42U AS=0.06405P
+ AD=0.07665P PS=0.725U PD=0.785U
* device instance $2368 r0 *1 31.585,43.075 sky130_fd_pr__pfet_01v8
M$2368 752 698 37 37 sky130_fd_pr__pfet_01v8 L=0.15U W=0.42U AS=0.178875P
+ AD=0.07665P PS=1.26U PD=0.785U
* device instance $2369 r0 *1 32.245,42.91 sky130_fd_pr__pfet_01v8
M$2369 698 697 37 37 sky130_fd_pr__pfet_01v8 L=0.15U W=0.75U AS=0.178875P
+ AD=0.195P PS=1.26U PD=2.02U
* device instance $2370 r0 *1 35.685,42.965 sky130_fd_pr__pfet_01v8
M$2370 696 699 37 37 sky130_fd_pr__pfet_01v8 L=0.15U W=0.64U AS=0.154P
+ AD=0.1728P PS=1.335U PD=1.82U
* device instance $2371 r0 *1 36.17,42.785 sky130_fd_pr__pfet_01v8
M$2371 650 699 37 37 sky130_fd_pr__pfet_01v8 L=0.15U W=1U AS=0.154P AD=0.28P
+ PS=1.335U PD=2.56U
* device instance $2372 r0 *1 44.63,42.785 sky130_fd_pr__pfet_01v8
M$2372 749 650 734 734 sky130_fd_pr__pfet_01v8 L=0.15U W=1U AS=0.26P AD=0.13P
+ PS=2.52U PD=1.26U
* device instance $2373 r0 *1 45.04,42.785 sky130_fd_pr__pfet_01v8
M$2373 748 372 749 749 sky130_fd_pr__pfet_01v8 L=0.15U W=1U AS=0.13P AD=0.19P
+ PS=1.26U PD=1.38U
* device instance $2374 r0 *1 45.57,42.785 sky130_fd_pr__pfet_01v8
M$2374 747 728 748 748 sky130_fd_pr__pfet_01v8 L=0.15U W=1U AS=0.19P AD=0.135P
+ PS=1.38U PD=1.27U
* device instance $2375 r0 *1 45.99,42.785 sky130_fd_pr__pfet_01v8
M$2375 37 1134 747 747 sky130_fd_pr__pfet_01v8 L=0.15U W=1U AS=0.135P AD=0.26P
+ PS=1.27U PD=2.52U
* device instance $2376 r0 *1 49.23,42.785 sky130_fd_pr__pfet_01v8
M$2376 896 734 37 37 sky130_fd_pr__pfet_01v8 L=0.15U W=1U AS=0.26P AD=0.135P
+ PS=2.52U PD=1.27U
* device instance $2377 r0 *1 49.65,42.785 sky130_fd_pr__pfet_01v8
M$2377 37 700 896 896 sky130_fd_pr__pfet_01v8 L=0.15U W=1U AS=0.135P AD=0.165P
+ PS=1.27U PD=1.33U
* device instance $2378 r0 *1 50.13,42.785 sky130_fd_pr__pfet_01v8
M$2378 896 408 37 37 sky130_fd_pr__pfet_01v8 L=0.15U W=1U AS=0.165P AD=0.26P
+ PS=1.33U PD=2.52U
* device instance $2379 r0 *1 57.55,42.785 sky130_fd_pr__pfet_01v8
M$2379 730 729 37 37 sky130_fd_pr__pfet_01v8 L=0.15U W=1U AS=0.3P AD=0.135P
+ PS=2.6U PD=1.27U
* device instance $2380 r0 *1 57.97,42.785 sky130_fd_pr__pfet_01v8
M$2380 37 639 730 730 sky130_fd_pr__pfet_01v8 L=0.15U W=1U AS=0.135P AD=0.365P
+ PS=1.27U PD=1.73U
* device instance $2381 r0 *1 58.85,42.785 sky130_fd_pr__pfet_01v8
M$2381 746 639 37 37 sky130_fd_pr__pfet_01v8 L=0.15U W=1U AS=0.365P AD=0.105P
+ PS=1.73U PD=1.21U
* device instance $2382 r0 *1 59.21,42.785 sky130_fd_pr__pfet_01v8
M$2382 735 729 746 746 sky130_fd_pr__pfet_01v8 L=0.15U W=1U AS=0.105P AD=0.165P
+ PS=1.21U PD=1.33U
* device instance $2383 r0 *1 59.69,42.785 sky130_fd_pr__pfet_01v8
M$2383 37 730 735 735 sky130_fd_pr__pfet_01v8 L=0.15U W=1U AS=0.165P AD=0.36P
+ PS=1.33U PD=2.72U
* device instance $2384 r0 *1 60.73,42.935 sky130_fd_pr__pfet_01v8
M$2384 37 979 702 702 sky130_fd_pr__pfet_01v8 L=0.15U W=0.64U AS=0.1664P
+ AD=0.0864P PS=1.8U PD=0.91U
* device instance $2385 r0 *1 61.15,42.935 sky130_fd_pr__pfet_01v8
M$2385 703 702 37 37 sky130_fd_pr__pfet_01v8 L=0.15U W=0.64U AS=0.0864P
+ AD=0.1664P PS=0.91U PD=1.8U
* device instance $2386 r0 *1 62.09,42.965 sky130_fd_pr__pfet_01v8
M$2386 743 570 704 704 sky130_fd_pr__pfet_01v8 L=0.15U W=0.64U AS=0.1664P
+ AD=0.0672P PS=1.8U PD=0.85U
* device instance $2387 r0 *1 62.45,42.965 sky130_fd_pr__pfet_01v8
M$2387 37 705 743 743 sky130_fd_pr__pfet_01v8 L=0.15U W=0.64U AS=0.0672P
+ AD=0.1664P PS=0.85U PD=1.8U
* device instance $2388 r0 *1 63.39,42.965 sky130_fd_pr__pfet_01v8
M$2388 37 302 705 705 sky130_fd_pr__pfet_01v8 L=0.15U W=0.64U AS=0.1664P
+ AD=0.0928P PS=1.8U PD=0.93U
* device instance $2389 r0 *1 63.83,42.965 sky130_fd_pr__pfet_01v8
M$2389 741 302 37 37 sky130_fd_pr__pfet_01v8 L=0.15U W=0.64U AS=0.0928P
+ AD=0.1152P PS=0.93U PD=1U
* device instance $2390 r0 *1 64.34,42.965 sky130_fd_pr__pfet_01v8
M$2390 704 706 741 741 sky130_fd_pr__pfet_01v8 L=0.15U W=0.64U AS=0.1152P
+ AD=0.15985P PS=1U PD=1.265U
* device instance $2391 r0 *1 65.115,43.075 sky130_fd_pr__pfet_01v8
M$2391 707 703 704 704 sky130_fd_pr__pfet_01v8 L=0.15U W=0.42U AS=0.15985P
+ AD=0.06405P PS=1.265U PD=0.725U
* device instance $2392 r0 *1 65.57,43.075 sky130_fd_pr__pfet_01v8
M$2392 740 702 707 707 sky130_fd_pr__pfet_01v8 L=0.15U W=0.42U AS=0.06405P
+ AD=0.07665P PS=0.725U PD=0.785U
* device instance $2393 r0 *1 66.085,43.075 sky130_fd_pr__pfet_01v8
M$2393 740 708 37 37 sky130_fd_pr__pfet_01v8 L=0.15U W=0.42U AS=0.178875P
+ AD=0.07665P PS=1.26U PD=0.785U
* device instance $2394 r0 *1 66.745,42.91 sky130_fd_pr__pfet_01v8
M$2394 708 707 37 37 sky130_fd_pr__pfet_01v8 L=0.15U W=0.75U AS=0.178875P
+ AD=0.195P PS=1.26U PD=2.02U
* device instance $2395 r0 *1 70.185,42.965 sky130_fd_pr__pfet_01v8
M$2395 706 709 37 37 sky130_fd_pr__pfet_01v8 L=0.15U W=0.64U AS=0.154P
+ AD=0.1728P PS=1.335U PD=1.82U
* device instance $2396 r0 *1 70.67,42.785 sky130_fd_pr__pfet_01v8
M$2396 651 709 37 37 sky130_fd_pr__pfet_01v8 L=0.15U W=1U AS=0.154P AD=0.28P
+ PS=1.335U PD=2.56U
* device instance $2397 r0 *1 9.725,43.075 sky130_fd_pr__pfet_01v8
M$2397 744 687 37 37 sky130_fd_pr__pfet_01v8 L=0.15U W=0.42U AS=0.1092P
+ AD=0.06405P PS=1.36U PD=0.725U
* device instance $2398 r0 *1 10.18,43.075 sky130_fd_pr__pfet_01v8
M$2398 688 680 744 744 sky130_fd_pr__pfet_01v8 L=0.15U W=0.42U AS=0.06405P
+ AD=0.0567P PS=0.725U PD=0.69U
* device instance $2399 r0 *1 10.6,43.075 sky130_fd_pr__pfet_01v8
M$2399 745 682 688 688 sky130_fd_pr__pfet_01v8 L=0.15U W=0.42U AS=0.0567P
+ AD=0.0882P PS=0.69U PD=0.84U
* device instance $2400 r0 *1 11.17,43.075 sky130_fd_pr__pfet_01v8
M$2400 37 685 745 745 sky130_fd_pr__pfet_01v8 L=0.15U W=0.42U AS=0.0882P
+ AD=0.1113P PS=0.84U PD=1.37U
* device instance $2401 r0 *1 10.57,44.075 sky130_fd_pr__pfet_01v8
M$2401 800 591 757 757 sky130_fd_pr__pfet_01v8 L=0.15U W=0.64U AS=0.1664P
+ AD=0.0672P PS=1.8U PD=0.85U
* device instance $2402 r0 *1 10.93,44.075 sky130_fd_pr__pfet_01v8
M$2402 37 758 800 800 sky130_fd_pr__pfet_01v8 L=0.15U W=0.64U AS=0.0672P
+ AD=0.1664P PS=0.85U PD=1.8U
* device instance $2403 r0 *1 13.595,43.965 sky130_fd_pr__pfet_01v8
M$2403 759 756 757 757 sky130_fd_pr__pfet_01v8 L=0.15U W=0.42U AS=0.15985P
+ AD=0.06405P PS=1.265U PD=0.725U
* device instance $2404 r0 *1 14.05,43.965 sky130_fd_pr__pfet_01v8
M$2404 787 755 759 759 sky130_fd_pr__pfet_01v8 L=0.15U W=0.42U AS=0.06405P
+ AD=0.07665P PS=0.725U PD=0.785U
* device instance $2405 r0 *1 14.565,43.965 sky130_fd_pr__pfet_01v8
M$2405 37 760 787 787 sky130_fd_pr__pfet_01v8 L=0.15U W=0.42U AS=0.07665P
+ AD=0.178875P PS=0.785U PD=1.26U
* device instance $2406 r0 *1 11.87,44.075 sky130_fd_pr__pfet_01v8
M$2406 37 302 758 758 sky130_fd_pr__pfet_01v8 L=0.15U W=0.64U AS=0.1664P
+ AD=0.0928P PS=1.8U PD=0.93U
* device instance $2407 r0 *1 12.31,44.075 sky130_fd_pr__pfet_01v8
M$2407 801 302 37 37 sky130_fd_pr__pfet_01v8 L=0.15U W=0.64U AS=0.0928P
+ AD=0.1152P PS=0.93U PD=1U
* device instance $2408 r0 *1 12.82,44.075 sky130_fd_pr__pfet_01v8
M$2408 757 762 801 801 sky130_fd_pr__pfet_01v8 L=0.15U W=0.64U AS=0.1152P
+ AD=0.15985P PS=1U PD=1.265U
* device instance $2409 r0 *1 15.225,44.13 sky130_fd_pr__pfet_01v8
M$2409 760 759 37 37 sky130_fd_pr__pfet_01v8 L=0.15U W=0.75U AS=0.178875P
+ AD=0.195P PS=1.26U PD=2.02U
* device instance $2410 r0 *1 16.165,43.965 sky130_fd_pr__pfet_01v8
M$2410 789 760 37 37 sky130_fd_pr__pfet_01v8 L=0.15U W=0.42U AS=0.1092P
+ AD=0.06405P PS=1.36U PD=0.725U
* device instance $2411 r0 *1 16.62,43.965 sky130_fd_pr__pfet_01v8
M$2411 761 755 789 789 sky130_fd_pr__pfet_01v8 L=0.15U W=0.42U AS=0.06405P
+ AD=0.0567P PS=0.725U PD=0.69U
* device instance $2412 r0 *1 17.04,43.965 sky130_fd_pr__pfet_01v8
M$2412 790 756 761 761 sky130_fd_pr__pfet_01v8 L=0.15U W=0.42U AS=0.0567P
+ AD=0.0882P PS=0.69U PD=0.84U
* device instance $2413 r0 *1 17.61,43.965 sky130_fd_pr__pfet_01v8
M$2413 37 762 790 790 sky130_fd_pr__pfet_01v8 L=0.15U W=0.42U AS=0.0882P
+ AD=0.1113P PS=0.84U PD=1.37U
* device instance $2414 r0 *1 18.665,44.075 sky130_fd_pr__pfet_01v8
M$2414 37 761 762 762 sky130_fd_pr__pfet_01v8 L=0.15U W=0.64U AS=0.1728P
+ AD=0.154P PS=1.82U PD=1.335U
* device instance $2415 r0 *1 19.15,44.255 sky130_fd_pr__pfet_01v8
M$2415 594 761 37 37 sky130_fd_pr__pfet_01v8 L=0.15U W=1U AS=0.154P AD=0.28P
+ PS=1.335U PD=2.56U
* device instance $2416 r0 *1 23.08,43.075 sky130_fd_pr__pfet_01v8
M$2416 691 726 37 37 sky130_fd_pr__pfet_01v8 L=0.15U W=0.42U AS=0.1113P
+ AD=0.0609P PS=1.37U PD=0.71U
* device instance $2417 r0 *1 23.52,43.075 sky130_fd_pr__pfet_01v8
M$2417 691 115 37 37 sky130_fd_pr__pfet_01v8 L=0.15U W=0.42U AS=0.1841P
+ AD=0.0609P PS=1.26U PD=0.71U
* device instance $2418 r0 *1 24.29,42.965 sky130_fd_pr__pfet_01v8
M$2418 649 691 37 37 sky130_fd_pr__pfet_01v8 L=0.15U W=0.64U AS=0.1841P
+ AD=0.1696P PS=1.26U PD=1.81U
* device instance $2419 r0 *1 26.775,44.16 sky130_fd_pr__pfet_01v8
M$2419 804 64 37 37 sky130_fd_pr__pfet_01v8 L=0.15U W=0.42U AS=0.15835P
+ AD=0.07665P PS=1.395U PD=0.785U
* device instance $2420 r0 *1 27.29,44.16 sky130_fd_pr__pfet_01v8
M$2420 763 597 804 804 sky130_fd_pr__pfet_01v8 L=0.15U W=0.42U AS=0.07665P
+ AD=0.1932P PS=0.785U PD=1.34U
* device instance $2421 r0 *1 28.36,44.16 sky130_fd_pr__pfet_01v8
M$2421 805 794 763 763 sky130_fd_pr__pfet_01v8 L=0.15U W=0.42U AS=0.1932P
+ AD=0.0441P PS=1.34U PD=0.63U
* device instance $2422 r0 *1 28.72,44.16 sky130_fd_pr__pfet_01v8
M$2422 37 812 805 805 sky130_fd_pr__pfet_01v8 L=0.15U W=0.42U AS=0.0441P
+ AD=0.0693P PS=0.63U PD=0.75U
* device instance $2423 r0 *1 29.2,44.16 sky130_fd_pr__pfet_01v8
M$2423 812 64 37 37 sky130_fd_pr__pfet_01v8 L=0.15U W=0.42U AS=0.0693P
+ AD=0.1176P PS=0.75U PD=1.4U
* device instance $2424 r0 *1 26.23,44.255 sky130_fd_pr__pfet_01v8
M$2424 37 763 727 727 sky130_fd_pr__pfet_01v8 L=0.15U W=1U AS=0.26P AD=0.15835P
+ PS=2.52U PD=1.395U
* device instance $2425 r0 *1 33.185,43.075 sky130_fd_pr__pfet_01v8
M$2425 751 698 37 37 sky130_fd_pr__pfet_01v8 L=0.15U W=0.42U AS=0.1092P
+ AD=0.06405P PS=1.36U PD=0.725U
* device instance $2426 r0 *1 33.64,43.075 sky130_fd_pr__pfet_01v8
M$2426 699 692 751 751 sky130_fd_pr__pfet_01v8 L=0.15U W=0.42U AS=0.06405P
+ AD=0.0567P PS=0.725U PD=0.69U
* device instance $2427 r0 *1 34.06,43.075 sky130_fd_pr__pfet_01v8
M$2427 750 693 699 699 sky130_fd_pr__pfet_01v8 L=0.15U W=0.42U AS=0.0567P
+ AD=0.0882P PS=0.69U PD=0.84U
* device instance $2428 r0 *1 34.63,43.075 sky130_fd_pr__pfet_01v8
M$2428 37 696 750 750 sky130_fd_pr__pfet_01v8 L=0.15U W=0.42U AS=0.0882P
+ AD=0.1113P PS=0.84U PD=1.37U
* device instance $2429 r0 *1 34.95,44.075 sky130_fd_pr__pfet_01v8
M$2429 808 795 766 766 sky130_fd_pr__pfet_01v8 L=0.15U W=0.64U AS=0.1664P
+ AD=0.0672P PS=1.8U PD=0.85U
* device instance $2430 r0 *1 35.31,44.075 sky130_fd_pr__pfet_01v8
M$2430 37 767 808 808 sky130_fd_pr__pfet_01v8 L=0.15U W=0.64U AS=0.0672P
+ AD=0.1664P PS=0.85U PD=1.8U
* device instance $2431 r0 *1 37.975,43.965 sky130_fd_pr__pfet_01v8
M$2431 768 765 766 766 sky130_fd_pr__pfet_01v8 L=0.15U W=0.42U AS=0.15985P
+ AD=0.06405P PS=1.265U PD=0.725U
* device instance $2432 r0 *1 38.43,43.965 sky130_fd_pr__pfet_01v8
M$2432 791 764 768 768 sky130_fd_pr__pfet_01v8 L=0.15U W=0.42U AS=0.06405P
+ AD=0.07665P PS=0.725U PD=0.785U
* device instance $2433 r0 *1 38.945,43.965 sky130_fd_pr__pfet_01v8
M$2433 37 769 791 791 sky130_fd_pr__pfet_01v8 L=0.15U W=0.42U AS=0.07665P
+ AD=0.178875P PS=0.785U PD=1.26U
* device instance $2434 r0 *1 36.25,44.075 sky130_fd_pr__pfet_01v8
M$2434 37 94 767 767 sky130_fd_pr__pfet_01v8 L=0.15U W=0.64U AS=0.1664P
+ AD=0.0928P PS=1.8U PD=0.93U
* device instance $2435 r0 *1 36.69,44.075 sky130_fd_pr__pfet_01v8
M$2435 809 94 37 37 sky130_fd_pr__pfet_01v8 L=0.15U W=0.64U AS=0.0928P
+ AD=0.1152P PS=0.93U PD=1U
* device instance $2436 r0 *1 37.2,44.075 sky130_fd_pr__pfet_01v8
M$2436 766 771 809 809 sky130_fd_pr__pfet_01v8 L=0.15U W=0.64U AS=0.1152P
+ AD=0.15985P PS=1U PD=1.265U
* device instance $2437 r0 *1 39.605,44.13 sky130_fd_pr__pfet_01v8
M$2437 769 768 37 37 sky130_fd_pr__pfet_01v8 L=0.15U W=0.75U AS=0.178875P
+ AD=0.195P PS=1.26U PD=2.02U
* device instance $2438 r0 *1 40.545,43.965 sky130_fd_pr__pfet_01v8
M$2438 792 769 37 37 sky130_fd_pr__pfet_01v8 L=0.15U W=0.42U AS=0.1092P
+ AD=0.06405P PS=1.36U PD=0.725U
* device instance $2439 r0 *1 41,43.965 sky130_fd_pr__pfet_01v8
M$2439 770 764 792 792 sky130_fd_pr__pfet_01v8 L=0.15U W=0.42U AS=0.06405P
+ AD=0.0567P PS=0.725U PD=0.69U
* device instance $2440 r0 *1 41.42,43.965 sky130_fd_pr__pfet_01v8
M$2440 793 765 770 770 sky130_fd_pr__pfet_01v8 L=0.15U W=0.42U AS=0.0567P
+ AD=0.0882P PS=0.69U PD=0.84U
* device instance $2441 r0 *1 41.99,43.965 sky130_fd_pr__pfet_01v8
M$2441 37 771 793 793 sky130_fd_pr__pfet_01v8 L=0.15U W=0.42U AS=0.0882P
+ AD=0.1113P PS=0.84U PD=1.37U
* device instance $2442 r0 *1 43.045,44.075 sky130_fd_pr__pfet_01v8
M$2442 37 770 771 771 sky130_fd_pr__pfet_01v8 L=0.15U W=0.64U AS=0.1728P
+ AD=0.154P PS=1.82U PD=1.335U
* device instance $2443 r0 *1 43.53,44.255 sky130_fd_pr__pfet_01v8
M$2443 728 770 37 37 sky130_fd_pr__pfet_01v8 L=0.15U W=1U AS=0.154P AD=0.28P
+ PS=1.335U PD=2.56U
* device instance $2444 r0 *1 44.63,44.255 sky130_fd_pr__pfet_01v8
M$2444 773 796 772 772 sky130_fd_pr__pfet_01v8 L=0.15U W=1U AS=0.26P AD=0.135P
+ PS=2.52U PD=1.27U
* device instance $2445 r0 *1 45.05,44.255 sky130_fd_pr__pfet_01v8
M$2445 775 728 773 773 sky130_fd_pr__pfet_01v8 L=0.15U W=1U AS=0.135P AD=0.135P
+ PS=1.27U PD=1.27U
* device instance $2446 r0 *1 45.47,44.255 sky130_fd_pr__pfet_01v8
M$2446 773 92 775 775 sky130_fd_pr__pfet_01v8 L=0.15U W=1U AS=0.135P AD=0.26P
+ PS=1.27U PD=2.52U
* device instance $2447 r0 *1 46.41,44.255 sky130_fd_pr__pfet_01v8
M$2447 775 135 37 37 sky130_fd_pr__pfet_01v8 L=0.15U W=1U AS=0.26P AD=0.165P
+ PS=2.52U PD=1.33U
* device instance $2448 r0 *1 46.89,44.255 sky130_fd_pr__pfet_01v8
M$2448 37 735 775 775 sky130_fd_pr__pfet_01v8 L=0.15U W=1U AS=0.165P AD=0.1575P
+ PS=1.33U PD=1.315U
* device instance $2449 r0 *1 47.355,44.255 sky130_fd_pr__pfet_01v8
M$2449 774 772 37 37 sky130_fd_pr__pfet_01v8 L=0.15U W=1U AS=0.1575P AD=0.26P
+ PS=1.315U PD=2.52U
* device instance $2450 r0 *1 48.31,44.175 sky130_fd_pr__pfet_01v8
M$2450 776 797 37 37 sky130_fd_pr__pfet_01v8 L=0.15U W=1.68U AS=0.3318P
+ AD=0.3486P PS=3.31U PD=3.35U
* device instance $2452 r0 *1 49.69,44.255 sky130_fd_pr__pfet_01v8
M$2452 811 776 662 662 sky130_fd_pr__pfet_01v8 L=0.15U W=1U AS=0.26P AD=0.105P
+ PS=2.52U PD=1.21U
* device instance $2453 r0 *1 50.05,44.255 sky130_fd_pr__pfet_01v8
M$2453 37 728 811 811 sky130_fd_pr__pfet_01v8 L=0.15U W=1U AS=0.105P AD=0.26P
+ PS=1.21U PD=2.52U
* device instance $2454 r0 *1 51.31,44.545 sky130_fd_pr__pfet_01v8
M$2454 798 728 37 37 sky130_fd_pr__pfet_01v8 L=0.15U W=0.42U AS=0.1573P
+ AD=0.1092P PS=1.39U PD=1.36U
* device instance $2455 r0 *1 51.85,44.255 sky130_fd_pr__pfet_01v8
M$2455 810 797 37 37 sky130_fd_pr__pfet_01v8 L=0.15U W=1U AS=0.1573P AD=0.105P
+ PS=1.39U PD=1.21U
* device instance $2456 r0 *1 52.21,44.255 sky130_fd_pr__pfet_01v8
M$2456 799 798 810 810 sky130_fd_pr__pfet_01v8 L=0.15U W=1U AS=0.105P AD=0.26P
+ PS=1.21U PD=2.52U
* device instance $2457 r0 *1 56.59,44.255 sky130_fd_pr__pfet_01v8
M$2457 807 799 729 729 sky130_fd_pr__pfet_01v8 L=0.15U W=1U AS=0.26P AD=0.105P
+ PS=2.52U PD=1.21U
* device instance $2458 r0 *1 56.95,44.255 sky130_fd_pr__pfet_01v8
M$2458 37 662 807 807 sky130_fd_pr__pfet_01v8 L=0.15U W=1U AS=0.105P AD=0.26P
+ PS=1.21U PD=2.52U
* device instance $2459 r0 *1 61.19,44.255 sky130_fd_pr__pfet_01v8
M$2459 806 568 700 700 sky130_fd_pr__pfet_01v8 L=0.15U W=1U AS=0.26P AD=0.105P
+ PS=2.52U PD=1.21U
* device instance $2460 r0 *1 61.55,44.255 sky130_fd_pr__pfet_01v8
M$2460 37 985 806 806 sky130_fd_pr__pfet_01v8 L=0.15U W=1U AS=0.105P AD=0.26P
+ PS=1.21U PD=2.52U
* device instance $2461 r0 *1 66.23,44.075 sky130_fd_pr__pfet_01v8
M$2461 803 643 779 779 sky130_fd_pr__pfet_01v8 L=0.15U W=0.64U AS=0.1664P
+ AD=0.0672P PS=1.8U PD=0.85U
* device instance $2462 r0 *1 66.59,44.075 sky130_fd_pr__pfet_01v8
M$2462 37 780 803 803 sky130_fd_pr__pfet_01v8 L=0.15U W=0.64U AS=0.0672P
+ AD=0.1664P PS=0.85U PD=1.8U
* device instance $2463 r0 *1 69.255,43.965 sky130_fd_pr__pfet_01v8
M$2463 781 778 779 779 sky130_fd_pr__pfet_01v8 L=0.15U W=0.42U AS=0.15985P
+ AD=0.06405P PS=1.265U PD=0.725U
* device instance $2464 r0 *1 69.71,43.965 sky130_fd_pr__pfet_01v8
M$2464 788 777 781 781 sky130_fd_pr__pfet_01v8 L=0.15U W=0.42U AS=0.06405P
+ AD=0.07665P PS=0.725U PD=0.785U
* device instance $2465 r0 *1 70.225,43.965 sky130_fd_pr__pfet_01v8
M$2465 37 782 788 788 sky130_fd_pr__pfet_01v8 L=0.15U W=0.42U AS=0.07665P
+ AD=0.178875P PS=0.785U PD=1.26U
* device instance $2466 r0 *1 67.53,44.075 sky130_fd_pr__pfet_01v8
M$2466 37 409 780 780 sky130_fd_pr__pfet_01v8 L=0.15U W=0.64U AS=0.1664P
+ AD=0.0928P PS=1.8U PD=0.93U
* device instance $2467 r0 *1 67.97,44.075 sky130_fd_pr__pfet_01v8
M$2467 802 409 37 37 sky130_fd_pr__pfet_01v8 L=0.15U W=0.64U AS=0.0928P
+ AD=0.1152P PS=0.93U PD=1U
* device instance $2468 r0 *1 68.48,44.075 sky130_fd_pr__pfet_01v8
M$2468 779 784 802 802 sky130_fd_pr__pfet_01v8 L=0.15U W=0.64U AS=0.1152P
+ AD=0.15985P PS=1U PD=1.265U
* device instance $2469 r0 *1 70.885,44.13 sky130_fd_pr__pfet_01v8
M$2469 782 781 37 37 sky130_fd_pr__pfet_01v8 L=0.15U W=0.75U AS=0.178875P
+ AD=0.195P PS=1.26U PD=2.02U
* device instance $2470 r0 *1 67.685,43.075 sky130_fd_pr__pfet_01v8
M$2470 738 708 37 37 sky130_fd_pr__pfet_01v8 L=0.15U W=0.42U AS=0.1092P
+ AD=0.06405P PS=1.36U PD=0.725U
* device instance $2471 r0 *1 68.14,43.075 sky130_fd_pr__pfet_01v8
M$2471 709 702 738 738 sky130_fd_pr__pfet_01v8 L=0.15U W=0.42U AS=0.06405P
+ AD=0.0567P PS=0.725U PD=0.69U
* device instance $2472 r0 *1 68.56,43.075 sky130_fd_pr__pfet_01v8
M$2472 736 703 709 709 sky130_fd_pr__pfet_01v8 L=0.15U W=0.42U AS=0.0567P
+ AD=0.0882P PS=0.69U PD=0.84U
* device instance $2473 r0 *1 69.13,43.075 sky130_fd_pr__pfet_01v8
M$2473 37 706 736 736 sky130_fd_pr__pfet_01v8 L=0.15U W=0.42U AS=0.0882P
+ AD=0.1113P PS=0.84U PD=1.37U
* device instance $2474 r0 *1 71.825,43.965 sky130_fd_pr__pfet_01v8
M$2474 786 782 37 37 sky130_fd_pr__pfet_01v8 L=0.15U W=0.42U AS=0.1092P
+ AD=0.06405P PS=1.36U PD=0.725U
* device instance $2475 r0 *1 72.28,43.965 sky130_fd_pr__pfet_01v8
M$2475 783 777 786 786 sky130_fd_pr__pfet_01v8 L=0.15U W=0.42U AS=0.06405P
+ AD=0.0567P PS=0.725U PD=0.69U
* device instance $2476 r0 *1 72.7,43.965 sky130_fd_pr__pfet_01v8
M$2476 785 778 783 783 sky130_fd_pr__pfet_01v8 L=0.15U W=0.42U AS=0.0567P
+ AD=0.0882P PS=0.69U PD=0.84U
* device instance $2477 r0 *1 73.27,43.965 sky130_fd_pr__pfet_01v8
M$2477 37 784 785 785 sky130_fd_pr__pfet_01v8 L=0.15U W=0.42U AS=0.0882P
+ AD=0.1113P PS=0.84U PD=1.37U
* device instance $2478 r0 *1 74.325,44.075 sky130_fd_pr__pfet_01v8
M$2478 37 783 784 784 sky130_fd_pr__pfet_01v8 L=0.15U W=0.64U AS=0.1728P
+ AD=0.154P PS=1.82U PD=1.335U
* device instance $2479 r0 *1 74.81,44.255 sky130_fd_pr__pfet_01v8
M$2479 568 783 37 37 sky130_fd_pr__pfet_01v8 L=0.15U W=1U AS=0.154P AD=0.28P
+ PS=1.335U PD=2.56U
* device instance $2480 r0 *1 7.83,48.225 sky130_fd_pr__pfet_01v8
M$2480 874 867 832 832 sky130_fd_pr__pfet_01v8 L=0.15U W=1U AS=0.26P AD=0.135P
+ PS=2.52U PD=1.27U
* device instance $2481 r0 *1 8.25,48.225 sky130_fd_pr__pfet_01v8
M$2481 872 833 874 874 sky130_fd_pr__pfet_01v8 L=0.15U W=1U AS=0.135P AD=0.135P
+ PS=1.27U PD=1.27U
* device instance $2482 r0 *1 8.67,48.225 sky130_fd_pr__pfet_01v8
M$2482 874 92 872 872 sky130_fd_pr__pfet_01v8 L=0.15U W=1U AS=0.135P AD=0.26P
+ PS=1.27U PD=2.52U
* device instance $2483 r0 *1 9.21,44.105 sky130_fd_pr__pfet_01v8
M$2483 37 681 755 755 sky130_fd_pr__pfet_01v8 L=0.15U W=0.64U AS=0.1664P
+ AD=0.0864P PS=1.8U PD=0.91U
* device instance $2484 r0 *1 9.63,44.105 sky130_fd_pr__pfet_01v8
M$2484 756 755 37 37 sky130_fd_pr__pfet_01v8 L=0.15U W=0.64U AS=0.0864P
+ AD=0.1664P PS=0.91U PD=1.8U
* device instance $2485 r0 *1 9.61,48.225 sky130_fd_pr__pfet_01v8
M$2485 872 158 37 37 sky130_fd_pr__pfet_01v8 L=0.15U W=1U AS=0.26P AD=0.165P
+ PS=2.52U PD=1.33U
* device instance $2486 r0 *1 10.09,48.225 sky130_fd_pr__pfet_01v8
M$2486 37 868 872 872 sky130_fd_pr__pfet_01v8 L=0.15U W=1U AS=0.165P AD=0.1575P
+ PS=1.33U PD=1.315U
* device instance $2487 r0 *1 10.555,48.225 sky130_fd_pr__pfet_01v8
M$2487 873 832 37 37 sky130_fd_pr__pfet_01v8 L=0.15U W=1U AS=0.1575P AD=0.26P
+ PS=1.315U PD=2.52U
* device instance $2488 r0 *1 11.51,48.225 sky130_fd_pr__pfet_01v8
M$2488 37 869 835 835 sky130_fd_pr__pfet_01v8 L=0.15U W=1U AS=0.26P AD=0.26P
+ PS=2.52U PD=2.52U
* device instance $2489 r0 *1 12.45,48.225 sky130_fd_pr__pfet_01v8
M$2489 593 835 37 37 sky130_fd_pr__pfet_01v8 L=0.15U W=4U AS=0.665P AD=0.5475P
+ PS=6.33U PD=5.095U
* device instance $2493 r0 *1 14.145,48.225 sky130_fd_pr__pfet_01v8
M$2493 593 836 37 37 sky130_fd_pr__pfet_01v8 L=0.15U W=4U AS=0.5475P AD=0.795P
+ PS=5.095U PD=6.59U
* device instance $2497 r0 *1 25.77,48.375 sky130_fd_pr__pfet_01v8
M$2497 37 681 837 837 sky130_fd_pr__pfet_01v8 L=0.15U W=0.64U AS=0.1664P
+ AD=0.0864P PS=1.8U PD=0.91U
* device instance $2498 r0 *1 26.19,48.375 sky130_fd_pr__pfet_01v8
M$2498 870 837 37 37 sky130_fd_pr__pfet_01v8 L=0.15U W=0.64U AS=0.0864P
+ AD=0.1664P PS=0.91U PD=1.8U
* device instance $2499 r0 *1 27.13,48.405 sky130_fd_pr__pfet_01v8
M$2499 881 635 838 838 sky130_fd_pr__pfet_01v8 L=0.15U W=0.64U AS=0.1664P
+ AD=0.0672P PS=1.8U PD=0.85U
* device instance $2500 r0 *1 27.49,48.405 sky130_fd_pr__pfet_01v8
M$2500 37 839 881 881 sky130_fd_pr__pfet_01v8 L=0.15U W=0.64U AS=0.0672P
+ AD=0.1664P PS=0.85U PD=1.8U
* device instance $2501 r0 *1 28.43,48.405 sky130_fd_pr__pfet_01v8
M$2501 37 302 839 839 sky130_fd_pr__pfet_01v8 L=0.15U W=0.64U AS=0.1664P
+ AD=0.0928P PS=1.8U PD=0.93U
* device instance $2502 r0 *1 28.87,48.405 sky130_fd_pr__pfet_01v8
M$2502 883 302 37 37 sky130_fd_pr__pfet_01v8 L=0.15U W=0.64U AS=0.0928P
+ AD=0.1152P PS=0.93U PD=1U
* device instance $2503 r0 *1 29.38,48.405 sky130_fd_pr__pfet_01v8
M$2503 838 840 883 883 sky130_fd_pr__pfet_01v8 L=0.15U W=0.64U AS=0.1152P
+ AD=0.15985P PS=1U PD=1.265U
* device instance $2504 r0 *1 30.155,48.515 sky130_fd_pr__pfet_01v8
M$2504 841 870 838 838 sky130_fd_pr__pfet_01v8 L=0.15U W=0.42U AS=0.15985P
+ AD=0.06405P PS=1.265U PD=0.725U
* device instance $2505 r0 *1 30.61,48.515 sky130_fd_pr__pfet_01v8
M$2505 885 837 841 841 sky130_fd_pr__pfet_01v8 L=0.15U W=0.42U AS=0.06405P
+ AD=0.07665P PS=0.725U PD=0.785U
* device instance $2506 r0 *1 31.125,48.515 sky130_fd_pr__pfet_01v8
M$2506 885 842 37 37 sky130_fd_pr__pfet_01v8 L=0.15U W=0.42U AS=0.178875P
+ AD=0.07665P PS=1.26U PD=0.785U
* device instance $2507 r0 *1 31.785,48.35 sky130_fd_pr__pfet_01v8
M$2507 842 841 37 37 sky130_fd_pr__pfet_01v8 L=0.15U W=0.75U AS=0.178875P
+ AD=0.195P PS=1.26U PD=2.02U
* device instance $2508 r0 *1 32.725,48.515 sky130_fd_pr__pfet_01v8
M$2508 884 842 37 37 sky130_fd_pr__pfet_01v8 L=0.15U W=0.42U AS=0.1092P
+ AD=0.06405P PS=1.36U PD=0.725U
* device instance $2509 r0 *1 33.18,48.515 sky130_fd_pr__pfet_01v8
M$2509 843 837 884 884 sky130_fd_pr__pfet_01v8 L=0.15U W=0.42U AS=0.06405P
+ AD=0.0567P PS=0.725U PD=0.69U
* device instance $2510 r0 *1 33.6,48.515 sky130_fd_pr__pfet_01v8
M$2510 882 870 843 843 sky130_fd_pr__pfet_01v8 L=0.15U W=0.42U AS=0.0567P
+ AD=0.0882P PS=0.69U PD=0.84U
* device instance $2511 r0 *1 34.17,48.515 sky130_fd_pr__pfet_01v8
M$2511 37 840 882 882 sky130_fd_pr__pfet_01v8 L=0.15U W=0.42U AS=0.0882P
+ AD=0.1113P PS=0.84U PD=1.37U
* device instance $2512 r0 *1 33.59,44.105 sky130_fd_pr__pfet_01v8
M$2512 37 681 764 764 sky130_fd_pr__pfet_01v8 L=0.15U W=0.64U AS=0.1664P
+ AD=0.0864P PS=1.8U PD=0.91U
* device instance $2513 r0 *1 34.01,44.105 sky130_fd_pr__pfet_01v8
M$2513 765 764 37 37 sky130_fd_pr__pfet_01v8 L=0.15U W=0.64U AS=0.0864P
+ AD=0.1664P PS=0.91U PD=1.8U
* device instance $2514 r0 *1 35.225,48.405 sky130_fd_pr__pfet_01v8
M$2514 840 843 37 37 sky130_fd_pr__pfet_01v8 L=0.15U W=0.64U AS=0.154P
+ AD=0.1728P PS=1.335U PD=1.82U
* device instance $2515 r0 *1 35.71,48.225 sky130_fd_pr__pfet_01v8
M$2515 597 843 37 37 sky130_fd_pr__pfet_01v8 L=0.15U W=1U AS=0.154P AD=0.28P
+ PS=1.335U PD=2.56U
* device instance $2516 r0 *1 41.005,48.405 sky130_fd_pr__pfet_01v8
M$2516 880 776 37 37 sky130_fd_pr__pfet_01v8 L=0.15U W=0.64U AS=0.1696P
+ AD=0.0768P PS=1.81U PD=0.88U
* device instance $2517 r0 *1 41.395,48.405 sky130_fd_pr__pfet_01v8
M$2517 795 64 880 880 sky130_fd_pr__pfet_01v8 L=0.15U W=0.64U AS=0.0768P
+ AD=0.0896P PS=0.88U PD=0.92U
* device instance $2518 r0 *1 41.825,48.405 sky130_fd_pr__pfet_01v8
M$2518 37 845 795 795 sky130_fd_pr__pfet_01v8 L=0.15U W=0.64U AS=0.0896P
+ AD=0.1824P PS=0.92U PD=1.85U
* device instance $2519 r0 *1 44.63,48.375 sky130_fd_pr__pfet_01v8
M$2519 37 979 846 846 sky130_fd_pr__pfet_01v8 L=0.15U W=0.64U AS=0.1664P
+ AD=0.0864P PS=1.8U PD=0.91U
* device instance $2520 r0 *1 45.05,48.375 sky130_fd_pr__pfet_01v8
M$2520 871 846 37 37 sky130_fd_pr__pfet_01v8 L=0.15U W=0.64U AS=0.0864P
+ AD=0.1664P PS=0.91U PD=1.8U
* device instance $2521 r0 *1 45.99,48.405 sky130_fd_pr__pfet_01v8
M$2521 879 774 847 847 sky130_fd_pr__pfet_01v8 L=0.15U W=0.64U AS=0.1664P
+ AD=0.0672P PS=1.8U PD=0.85U
* device instance $2522 r0 *1 46.35,48.405 sky130_fd_pr__pfet_01v8
M$2522 37 848 879 879 sky130_fd_pr__pfet_01v8 L=0.15U W=0.64U AS=0.0672P
+ AD=0.1664P PS=0.85U PD=1.8U
* device instance $2523 r0 *1 47.29,48.405 sky130_fd_pr__pfet_01v8
M$2523 37 302 848 848 sky130_fd_pr__pfet_01v8 L=0.15U W=0.64U AS=0.1664P
+ AD=0.0928P PS=1.8U PD=0.93U
* device instance $2524 r0 *1 47.73,48.405 sky130_fd_pr__pfet_01v8
M$2524 878 302 37 37 sky130_fd_pr__pfet_01v8 L=0.15U W=0.64U AS=0.0928P
+ AD=0.1152P PS=0.93U PD=1U
* device instance $2525 r0 *1 48.24,48.405 sky130_fd_pr__pfet_01v8
M$2525 847 849 878 878 sky130_fd_pr__pfet_01v8 L=0.15U W=0.64U AS=0.1152P
+ AD=0.15985P PS=1U PD=1.265U
* device instance $2526 r0 *1 49.015,48.515 sky130_fd_pr__pfet_01v8
M$2526 850 871 847 847 sky130_fd_pr__pfet_01v8 L=0.15U W=0.42U AS=0.15985P
+ AD=0.06405P PS=1.265U PD=0.725U
* device instance $2527 r0 *1 49.47,48.515 sky130_fd_pr__pfet_01v8
M$2527 877 846 850 850 sky130_fd_pr__pfet_01v8 L=0.15U W=0.42U AS=0.06405P
+ AD=0.07665P PS=0.725U PD=0.785U
* device instance $2528 r0 *1 49.985,48.515 sky130_fd_pr__pfet_01v8
M$2528 877 851 37 37 sky130_fd_pr__pfet_01v8 L=0.15U W=0.42U AS=0.178875P
+ AD=0.07665P PS=1.26U PD=0.785U
* device instance $2529 r0 *1 50.645,48.35 sky130_fd_pr__pfet_01v8
M$2529 851 850 37 37 sky130_fd_pr__pfet_01v8 L=0.15U W=0.75U AS=0.178875P
+ AD=0.195P PS=1.26U PD=2.02U
* device instance $2530 r0 *1 51.585,48.515 sky130_fd_pr__pfet_01v8
M$2530 876 851 37 37 sky130_fd_pr__pfet_01v8 L=0.15U W=0.42U AS=0.1092P
+ AD=0.06405P PS=1.36U PD=0.725U
* device instance $2531 r0 *1 52.04,48.515 sky130_fd_pr__pfet_01v8
M$2531 852 846 876 876 sky130_fd_pr__pfet_01v8 L=0.15U W=0.42U AS=0.06405P
+ AD=0.0567P PS=0.725U PD=0.69U
* device instance $2532 r0 *1 52.46,48.515 sky130_fd_pr__pfet_01v8
M$2532 875 871 852 852 sky130_fd_pr__pfet_01v8 L=0.15U W=0.42U AS=0.0567P
+ AD=0.0882P PS=0.69U PD=0.84U
* device instance $2533 r0 *1 53.03,48.515 sky130_fd_pr__pfet_01v8
M$2533 37 849 875 875 sky130_fd_pr__pfet_01v8 L=0.15U W=0.42U AS=0.0882P
+ AD=0.1113P PS=0.84U PD=1.37U
* device instance $2534 r0 *1 54.085,48.405 sky130_fd_pr__pfet_01v8
M$2534 849 852 37 37 sky130_fd_pr__pfet_01v8 L=0.15U W=0.64U AS=0.154P
+ AD=0.1728P PS=1.335U PD=1.82U
* device instance $2535 r0 *1 54.57,48.225 sky130_fd_pr__pfet_01v8
M$2535 797 852 37 37 sky130_fd_pr__pfet_01v8 L=0.15U W=1U AS=0.154P AD=0.28P
+ PS=1.335U PD=2.56U
* device instance $2536 r0 *1 61.65,48.225 sky130_fd_pr__pfet_01v8
M$2536 37 641 853 853 sky130_fd_pr__pfet_01v8 L=0.15U W=1U AS=0.26P AD=0.135P
+ PS=2.52U PD=1.27U
* device instance $2537 r0 *1 62.07,48.225 sky130_fd_pr__pfet_01v8
M$2537 854 853 37 37 sky130_fd_pr__pfet_01v8 L=0.15U W=4U AS=0.54P AD=0.665P
+ PS=5.08U PD=6.33U
* device instance $2541 r0 *1 64.87,44.105 sky130_fd_pr__pfet_01v8
M$2541 37 979 777 777 sky130_fd_pr__pfet_01v8 L=0.15U W=0.64U AS=0.1664P
+ AD=0.0864P PS=1.8U PD=0.91U
* device instance $2542 r0 *1 65.29,44.105 sky130_fd_pr__pfet_01v8
M$2542 778 777 37 37 sky130_fd_pr__pfet_01v8 L=0.15U W=0.64U AS=0.0864P
+ AD=0.1664P PS=0.91U PD=1.8U
* device instance $2543 r0 *1 4.68,49.405 sky130_fd_pr__pfet_01v8
M$2543 887 886 37 37 sky130_fd_pr__pfet_01v8 L=0.15U W=0.42U AS=0.1113P
+ AD=0.0609P PS=1.37U PD=0.71U
* device instance $2544 r0 *1 5.12,49.405 sky130_fd_pr__pfet_01v8
M$2544 37 115 887 887 sky130_fd_pr__pfet_01v8 L=0.15U W=0.42U AS=0.0609P
+ AD=0.1841P PS=0.71U PD=1.26U
* device instance $2545 r0 *1 5.89,49.515 sky130_fd_pr__pfet_01v8
M$2545 867 887 37 37 sky130_fd_pr__pfet_01v8 L=0.15U W=0.64U AS=0.1841P
+ AD=0.1696P PS=1.26U PD=1.81U
* device instance $2546 r0 *1 7.455,49.6 sky130_fd_pr__pfet_01v8
M$2546 909 64 37 37 sky130_fd_pr__pfet_01v8 L=0.15U W=0.42U AS=0.15835P
+ AD=0.07665P PS=1.395U PD=0.785U
* device instance $2547 r0 *1 7.97,49.6 sky130_fd_pr__pfet_01v8
M$2547 889 916 909 909 sky130_fd_pr__pfet_01v8 L=0.15U W=0.42U AS=0.07665P
+ AD=0.1932P PS=0.785U PD=1.34U
* device instance $2548 r0 *1 9.04,49.6 sky130_fd_pr__pfet_01v8
M$2548 910 915 889 889 sky130_fd_pr__pfet_01v8 L=0.15U W=0.42U AS=0.1932P
+ AD=0.0441P PS=1.34U PD=0.63U
* device instance $2549 r0 *1 9.4,49.6 sky130_fd_pr__pfet_01v8
M$2549 37 917 910 910 sky130_fd_pr__pfet_01v8 L=0.15U W=0.42U AS=0.0441P
+ AD=0.0693P PS=0.63U PD=0.75U
* device instance $2550 r0 *1 9.88,49.6 sky130_fd_pr__pfet_01v8
M$2550 917 64 37 37 sky130_fd_pr__pfet_01v8 L=0.15U W=0.42U AS=0.0693P
+ AD=0.1176P PS=0.75U PD=1.4U
* device instance $2551 r0 *1 6.91,49.695 sky130_fd_pr__pfet_01v8
M$2551 37 889 888 888 sky130_fd_pr__pfet_01v8 L=0.15U W=1U AS=0.26P AD=0.15835P
+ PS=2.52U PD=1.395U
* device instance $2552 r0 *1 11.09,49.695 sky130_fd_pr__pfet_01v8
M$2552 919 833 890 890 sky130_fd_pr__pfet_01v8 L=0.15U W=1U AS=0.26P AD=0.135P
+ PS=2.52U PD=1.27U
* device instance $2553 r0 *1 11.51,49.695 sky130_fd_pr__pfet_01v8
M$2553 37 916 919 919 sky130_fd_pr__pfet_01v8 L=0.15U W=1U AS=0.135P AD=0.135P
+ PS=1.27U PD=1.27U
* device instance $2554 r0 *1 11.93,49.695 sky130_fd_pr__pfet_01v8
M$2554 891 916 37 37 sky130_fd_pr__pfet_01v8 L=0.15U W=1U AS=0.135P AD=0.135P
+ PS=1.27U PD=1.27U
* device instance $2555 r0 *1 12.35,49.695 sky130_fd_pr__pfet_01v8
M$2555 37 833 891 891 sky130_fd_pr__pfet_01v8 L=0.15U W=1U AS=0.135P AD=0.26P
+ PS=1.27U PD=2.52U
* device instance $2556 r0 *1 12.225,53.845 sky130_fd_pr__pfet_01v8
M$2556 934 937 37 37 sky130_fd_pr__pfet_01v8 L=0.15U W=0.64U AS=0.154P
+ AD=0.1728P PS=1.335U PD=1.82U
* device instance $2557 r0 *1 12.71,53.665 sky130_fd_pr__pfet_01v8
M$2557 836 937 37 37 sky130_fd_pr__pfet_01v8 L=0.15U W=1U AS=0.154P AD=0.28P
+ PS=1.335U PD=2.56U
* device instance $2558 r0 *1 13.29,49.695 sky130_fd_pr__pfet_01v8
M$2558 868 890 891 891 sky130_fd_pr__pfet_01v8 L=0.15U W=1U AS=0.26P AD=0.3P
+ PS=2.52U PD=2.6U
* device instance $2559 r0 *1 13.81,53.665 sky130_fd_pr__pfet_01v8
M$2559 37 869 938 938 sky130_fd_pr__pfet_01v8 L=0.15U W=1U AS=0.26P AD=0.135P
+ PS=2.52U PD=1.27U
* device instance $2560 r0 *1 14.23,53.665 sky130_fd_pr__pfet_01v8
M$2560 916 938 37 37 sky130_fd_pr__pfet_01v8 L=0.15U W=4U AS=0.54P AD=0.665P
+ PS=5.08U PD=6.33U
* device instance $2564 r0 *1 17.03,53.665 sky130_fd_pr__pfet_01v8
M$2564 37 836 939 939 sky130_fd_pr__pfet_01v8 L=0.15U W=1U AS=0.26P AD=0.135P
+ PS=2.52U PD=1.27U
* device instance $2565 r0 *1 17.45,53.665 sky130_fd_pr__pfet_01v8
M$2565 833 939 37 37 sky130_fd_pr__pfet_01v8 L=0.15U W=4U AS=0.54P AD=0.665P
+ PS=5.08U PD=6.33U
* device instance $2569 r0 *1 21.19,49.695 sky130_fd_pr__pfet_01v8
M$2569 37 833 892 892 sky130_fd_pr__pfet_01v8 L=0.15U W=4U AS=0.685P AD=0.54P
+ PS=6.37U PD=5.08U
* device instance $2573 r0 *1 22.87,49.695 sky130_fd_pr__pfet_01v8
M$2573 894 893 892 892 sky130_fd_pr__pfet_01v8 L=0.15U W=4U AS=0.54P AD=0.665P
+ PS=5.08U PD=6.33U
* device instance $2577 r0 *1 23.935,53.665 sky130_fd_pr__pfet_01v8
M$2577 940 297 37 37 sky130_fd_pr__pfet_01v8 L=0.15U W=4U AS=0.685P AD=0.56P
+ PS=6.37U PD=5.12U
* device instance $2581 r0 *1 25.655,53.665 sky130_fd_pr__pfet_01v8
M$2581 681 940 37 37 sky130_fd_pr__pfet_01v8 L=0.15U W=16U AS=2.2375P
+ AD=2.3625P PS=20.475U PD=21.725U
* device instance $2597 r0 *1 25.07,49.695 sky130_fd_pr__pfet_01v8
M$2597 894 896 895 895 sky130_fd_pr__pfet_01v8 L=0.15U W=4U AS=0.665P AD=0.54P
+ PS=6.33U PD=5.08U
* device instance $2601 r0 *1 26.75,49.695 sky130_fd_pr__pfet_01v8
M$2601 918 362 895 895 sky130_fd_pr__pfet_01v8 L=0.15U W=4U AS=0.54P AD=0.665P
+ PS=5.08U PD=6.33U
* device instance $2605 r0 *1 43.32,49.405 sky130_fd_pr__pfet_01v8
M$2605 898 897 37 37 sky130_fd_pr__pfet_01v8 L=0.15U W=0.42U AS=0.1113P
+ AD=0.0609P PS=1.37U PD=0.71U
* device instance $2606 r0 *1 43.76,49.405 sky130_fd_pr__pfet_01v8
M$2606 37 115 898 898 sky130_fd_pr__pfet_01v8 L=0.15U W=0.42U AS=0.0609P
+ AD=0.1841P PS=0.71U PD=1.26U
* device instance $2607 r0 *1 44.53,49.515 sky130_fd_pr__pfet_01v8
M$2607 796 898 37 37 sky130_fd_pr__pfet_01v8 L=0.15U W=0.64U AS=0.1841P
+ AD=0.1696P PS=1.26U PD=1.81U
* device instance $2608 r0 *1 56.13,53.665 sky130_fd_pr__pfet_01v8
M$2608 962 941 942 942 sky130_fd_pr__pfet_01v8 L=0.15U W=1U AS=0.26P AD=0.135P
+ PS=2.52U PD=1.27U
* device instance $2609 r0 *1 56.55,53.665 sky130_fd_pr__pfet_01v8
M$2609 960 799 962 962 sky130_fd_pr__pfet_01v8 L=0.15U W=1U AS=0.135P AD=0.135P
+ PS=1.27U PD=1.27U
* device instance $2610 r0 *1 56.97,53.665 sky130_fd_pr__pfet_01v8
M$2610 37 980 960 960 sky130_fd_pr__pfet_01v8 L=0.15U W=1U AS=0.135P AD=0.4P
+ PS=1.27U PD=1.8U
* device instance $2611 r0 *1 57.92,53.665 sky130_fd_pr__pfet_01v8
M$2611 943 942 37 37 sky130_fd_pr__pfet_01v8 L=0.15U W=4U AS=0.805P AD=0.765P
+ PS=5.61U PD=6.53U
* device instance $2615 r0 *1 60.27,53.665 sky130_fd_pr__pfet_01v8
M$2615 37 854 944 944 sky130_fd_pr__pfet_01v8 L=0.15U W=1U AS=0.26P AD=0.135P
+ PS=2.52U PD=1.27U
* device instance $2616 r0 *1 60.69,53.665 sky130_fd_pr__pfet_01v8
M$2616 941 944 37 37 sky130_fd_pr__pfet_01v8 L=0.15U W=4U AS=0.54P AD=0.665P
+ PS=5.08U PD=6.33U
* device instance $2620 r0 *1 64.87,49.545 sky130_fd_pr__pfet_01v8
M$2620 37 979 899 899 sky130_fd_pr__pfet_01v8 L=0.15U W=0.64U AS=0.1664P
+ AD=0.0864P PS=1.8U PD=0.91U
* device instance $2621 r0 *1 65.29,49.545 sky130_fd_pr__pfet_01v8
M$2621 900 899 37 37 sky130_fd_pr__pfet_01v8 L=0.15U W=0.64U AS=0.0864P
+ AD=0.1664P PS=0.91U PD=1.8U
* device instance $2622 r0 *1 66.23,49.515 sky130_fd_pr__pfet_01v8
M$2622 914 902 901 901 sky130_fd_pr__pfet_01v8 L=0.15U W=0.64U AS=0.1664P
+ AD=0.0672P PS=1.8U PD=0.85U
* device instance $2623 r0 *1 66.59,49.515 sky130_fd_pr__pfet_01v8
M$2623 37 903 914 914 sky130_fd_pr__pfet_01v8 L=0.15U W=0.64U AS=0.0672P
+ AD=0.1664P PS=0.85U PD=1.8U
* device instance $2624 r0 *1 69.255,49.405 sky130_fd_pr__pfet_01v8
M$2624 904 900 901 901 sky130_fd_pr__pfet_01v8 L=0.15U W=0.42U AS=0.15985P
+ AD=0.06405P PS=1.265U PD=0.725U
* device instance $2625 r0 *1 69.71,49.405 sky130_fd_pr__pfet_01v8
M$2625 912 899 904 904 sky130_fd_pr__pfet_01v8 L=0.15U W=0.42U AS=0.06405P
+ AD=0.07665P PS=0.725U PD=0.785U
* device instance $2626 r0 *1 70.225,49.405 sky130_fd_pr__pfet_01v8
M$2626 37 905 912 912 sky130_fd_pr__pfet_01v8 L=0.15U W=0.42U AS=0.07665P
+ AD=0.178875P PS=0.785U PD=1.26U
* device instance $2627 r0 *1 67.53,49.515 sky130_fd_pr__pfet_01v8
M$2627 37 409 903 903 sky130_fd_pr__pfet_01v8 L=0.15U W=0.64U AS=0.1664P
+ AD=0.0928P PS=1.8U PD=0.93U
* device instance $2628 r0 *1 67.97,49.515 sky130_fd_pr__pfet_01v8
M$2628 913 409 37 37 sky130_fd_pr__pfet_01v8 L=0.15U W=0.64U AS=0.0928P
+ AD=0.1152P PS=0.93U PD=1U
* device instance $2629 r0 *1 68.48,49.515 sky130_fd_pr__pfet_01v8
M$2629 901 907 913 913 sky130_fd_pr__pfet_01v8 L=0.15U W=0.64U AS=0.1152P
+ AD=0.15985P PS=1U PD=1.265U
* device instance $2630 r0 *1 70.885,49.57 sky130_fd_pr__pfet_01v8
M$2630 905 904 37 37 sky130_fd_pr__pfet_01v8 L=0.15U W=0.75U AS=0.178875P
+ AD=0.195P PS=1.26U PD=2.02U
* device instance $2631 r0 *1 68.175,53.76 sky130_fd_pr__pfet_01v8
M$2631 957 64 37 37 sky130_fd_pr__pfet_01v8 L=0.15U W=0.42U AS=0.15835P
+ AD=0.07665P PS=1.395U PD=0.785U
* device instance $2632 r0 *1 68.69,53.76 sky130_fd_pr__pfet_01v8
M$2632 945 955 957 957 sky130_fd_pr__pfet_01v8 L=0.15U W=0.42U AS=0.07665P
+ AD=0.1932P PS=0.785U PD=1.34U
* device instance $2633 r0 *1 69.76,53.76 sky130_fd_pr__pfet_01v8
M$2633 956 946 945 945 sky130_fd_pr__pfet_01v8 L=0.15U W=0.42U AS=0.1932P
+ AD=0.0441P PS=1.34U PD=0.63U
* device instance $2634 r0 *1 70.12,53.76 sky130_fd_pr__pfet_01v8
M$2634 37 947 956 956 sky130_fd_pr__pfet_01v8 L=0.15U W=0.42U AS=0.0441P
+ AD=0.0693P PS=0.63U PD=0.75U
* device instance $2635 r0 *1 70.6,53.76 sky130_fd_pr__pfet_01v8
M$2635 947 64 37 37 sky130_fd_pr__pfet_01v8 L=0.15U W=0.42U AS=0.0693P
+ AD=0.1176P PS=0.75U PD=1.4U
* device instance $2636 r0 *1 67.63,53.665 sky130_fd_pr__pfet_01v8
M$2636 37 945 902 902 sky130_fd_pr__pfet_01v8 L=0.15U W=1U AS=0.26P AD=0.15835P
+ PS=2.52U PD=1.395U
* device instance $2637 r0 *1 71.825,49.405 sky130_fd_pr__pfet_01v8
M$2637 911 905 37 37 sky130_fd_pr__pfet_01v8 L=0.15U W=0.42U AS=0.1092P
+ AD=0.06405P PS=1.36U PD=0.725U
* device instance $2638 r0 *1 72.28,49.405 sky130_fd_pr__pfet_01v8
M$2638 906 899 911 911 sky130_fd_pr__pfet_01v8 L=0.15U W=0.42U AS=0.06405P
+ AD=0.0567P PS=0.725U PD=0.69U
* device instance $2639 r0 *1 72.7,49.405 sky130_fd_pr__pfet_01v8
M$2639 908 900 906 906 sky130_fd_pr__pfet_01v8 L=0.15U W=0.42U AS=0.0567P
+ AD=0.0882P PS=0.69U PD=0.84U
* device instance $2640 r0 *1 73.27,49.405 sky130_fd_pr__pfet_01v8
M$2640 37 907 908 908 sky130_fd_pr__pfet_01v8 L=0.15U W=0.42U AS=0.0882P
+ AD=0.1113P PS=0.84U PD=1.37U
* device instance $2641 r0 *1 74.325,49.515 sky130_fd_pr__pfet_01v8
M$2641 37 906 907 907 sky130_fd_pr__pfet_01v8 L=0.15U W=0.64U AS=0.1728P
+ AD=0.154P PS=1.82U PD=1.335U
* device instance $2642 r0 *1 74.81,49.695 sky130_fd_pr__pfet_01v8
M$2642 985 906 37 37 sky130_fd_pr__pfet_01v8 L=0.15U W=1U AS=0.154P AD=0.28P
+ PS=1.335U PD=2.56U
* device instance $2643 r0 *1 2.77,53.815 sky130_fd_pr__pfet_01v8
M$2643 37 681 930 930 sky130_fd_pr__pfet_01v8 L=0.15U W=0.64U AS=0.1664P
+ AD=0.0864P PS=1.8U PD=0.91U
* device instance $2644 r0 *1 3.19,53.815 sky130_fd_pr__pfet_01v8
M$2644 931 930 37 37 sky130_fd_pr__pfet_01v8 L=0.15U W=0.64U AS=0.0864P
+ AD=0.1664P PS=0.91U PD=1.8U
* device instance $2645 r0 *1 4.13,53.845 sky130_fd_pr__pfet_01v8
M$2645 958 888 932 932 sky130_fd_pr__pfet_01v8 L=0.15U W=0.64U AS=0.1664P
+ AD=0.0672P PS=1.8U PD=0.85U
* device instance $2646 r0 *1 4.49,53.845 sky130_fd_pr__pfet_01v8
M$2646 37 933 958 958 sky130_fd_pr__pfet_01v8 L=0.15U W=0.64U AS=0.0672P
+ AD=0.1664P PS=0.85U PD=1.8U
* device instance $2647 r0 *1 5.43,53.845 sky130_fd_pr__pfet_01v8
M$2647 37 94 933 933 sky130_fd_pr__pfet_01v8 L=0.15U W=0.64U AS=0.1664P
+ AD=0.0928P PS=1.8U PD=0.93U
* device instance $2648 r0 *1 5.87,53.845 sky130_fd_pr__pfet_01v8
M$2648 959 94 37 37 sky130_fd_pr__pfet_01v8 L=0.15U W=0.64U AS=0.0928P
+ AD=0.1152P PS=0.93U PD=1U
* device instance $2649 r0 *1 6.38,53.845 sky130_fd_pr__pfet_01v8
M$2649 932 934 959 959 sky130_fd_pr__pfet_01v8 L=0.15U W=0.64U AS=0.1152P
+ AD=0.15985P PS=1U PD=1.265U
* device instance $2650 r0 *1 7.155,53.955 sky130_fd_pr__pfet_01v8
M$2650 935 931 932 932 sky130_fd_pr__pfet_01v8 L=0.15U W=0.42U AS=0.15985P
+ AD=0.06405P PS=1.265U PD=0.725U
* device instance $2651 r0 *1 7.61,53.955 sky130_fd_pr__pfet_01v8
M$2651 961 930 935 935 sky130_fd_pr__pfet_01v8 L=0.15U W=0.42U AS=0.06405P
+ AD=0.07665P PS=0.725U PD=0.785U
* device instance $2652 r0 *1 8.125,53.955 sky130_fd_pr__pfet_01v8
M$2652 961 936 37 37 sky130_fd_pr__pfet_01v8 L=0.15U W=0.42U AS=0.178875P
+ AD=0.07665P PS=1.26U PD=0.785U
* device instance $2653 r0 *1 8.785,53.79 sky130_fd_pr__pfet_01v8
M$2653 936 935 37 37 sky130_fd_pr__pfet_01v8 L=0.15U W=0.75U AS=0.178875P
+ AD=0.195P PS=1.26U PD=2.02U
* device instance $2654 r0 *1 9.725,53.955 sky130_fd_pr__pfet_01v8
M$2654 963 936 37 37 sky130_fd_pr__pfet_01v8 L=0.15U W=0.42U AS=0.1092P
+ AD=0.06405P PS=1.36U PD=0.725U
* device instance $2655 r0 *1 10.18,53.955 sky130_fd_pr__pfet_01v8
M$2655 937 930 963 963 sky130_fd_pr__pfet_01v8 L=0.15U W=0.42U AS=0.06405P
+ AD=0.0567P PS=0.725U PD=0.69U
* device instance $2656 r0 *1 10.6,53.955 sky130_fd_pr__pfet_01v8
M$2656 964 931 937 937 sky130_fd_pr__pfet_01v8 L=0.15U W=0.42U AS=0.0567P
+ AD=0.0882P PS=0.69U PD=0.84U
* device instance $2657 r0 *1 11.17,53.955 sky130_fd_pr__pfet_01v8
M$2657 37 934 964 964 sky130_fd_pr__pfet_01v8 L=0.15U W=0.42U AS=0.0882P
+ AD=0.1113P PS=0.84U PD=1.37U
* device instance $2658 r0 *1 10.57,54.955 sky130_fd_pr__pfet_01v8
M$2658 987 873 967 967 sky130_fd_pr__pfet_01v8 L=0.15U W=0.64U AS=0.1664P
+ AD=0.0672P PS=1.8U PD=0.85U
* device instance $2659 r0 *1 10.93,54.955 sky130_fd_pr__pfet_01v8
M$2659 37 968 987 987 sky130_fd_pr__pfet_01v8 L=0.15U W=0.64U AS=0.0672P
+ AD=0.1664P PS=0.85U PD=1.8U
* device instance $2660 r0 *1 13.595,54.845 sky130_fd_pr__pfet_01v8
M$2660 969 966 967 967 sky130_fd_pr__pfet_01v8 L=0.15U W=0.42U AS=0.15985P
+ AD=0.06405P PS=1.265U PD=0.725U
* device instance $2661 r0 *1 14.05,54.845 sky130_fd_pr__pfet_01v8
M$2661 989 965 969 969 sky130_fd_pr__pfet_01v8 L=0.15U W=0.42U AS=0.06405P
+ AD=0.07665P PS=0.725U PD=0.785U
* device instance $2662 r0 *1 14.565,54.845 sky130_fd_pr__pfet_01v8
M$2662 37 970 989 989 sky130_fd_pr__pfet_01v8 L=0.15U W=0.42U AS=0.07665P
+ AD=0.178875P PS=0.785U PD=1.26U
* device instance $2663 r0 *1 11.87,54.955 sky130_fd_pr__pfet_01v8
M$2663 37 302 968 968 sky130_fd_pr__pfet_01v8 L=0.15U W=0.64U AS=0.1664P
+ AD=0.0928P PS=1.8U PD=0.93U
* device instance $2664 r0 *1 12.31,54.955 sky130_fd_pr__pfet_01v8
M$2664 988 302 37 37 sky130_fd_pr__pfet_01v8 L=0.15U W=0.64U AS=0.0928P
+ AD=0.1152P PS=0.93U PD=1U
* device instance $2665 r0 *1 12.82,54.955 sky130_fd_pr__pfet_01v8
M$2665 967 972 988 988 sky130_fd_pr__pfet_01v8 L=0.15U W=0.64U AS=0.1152P
+ AD=0.15985P PS=1U PD=1.265U
* device instance $2666 r0 *1 15.225,55.01 sky130_fd_pr__pfet_01v8
M$2666 970 969 37 37 sky130_fd_pr__pfet_01v8 L=0.15U W=0.75U AS=0.178875P
+ AD=0.195P PS=1.26U PD=2.02U
* device instance $2667 r0 *1 16.165,54.845 sky130_fd_pr__pfet_01v8
M$2667 990 970 37 37 sky130_fd_pr__pfet_01v8 L=0.15U W=0.42U AS=0.1092P
+ AD=0.06405P PS=1.36U PD=0.725U
* device instance $2668 r0 *1 16.62,54.845 sky130_fd_pr__pfet_01v8
M$2668 971 965 990 990 sky130_fd_pr__pfet_01v8 L=0.15U W=0.42U AS=0.06405P
+ AD=0.0567P PS=0.725U PD=0.69U
* device instance $2669 r0 *1 17.04,54.845 sky130_fd_pr__pfet_01v8
M$2669 991 966 971 971 sky130_fd_pr__pfet_01v8 L=0.15U W=0.42U AS=0.0567P
+ AD=0.0882P PS=0.69U PD=0.84U
* device instance $2670 r0 *1 17.61,54.845 sky130_fd_pr__pfet_01v8
M$2670 37 972 991 991 sky130_fd_pr__pfet_01v8 L=0.15U W=0.42U AS=0.0882P
+ AD=0.1113P PS=0.84U PD=1.37U
* device instance $2671 r0 *1 18.665,54.955 sky130_fd_pr__pfet_01v8
M$2671 37 971 972 972 sky130_fd_pr__pfet_01v8 L=0.15U W=0.64U AS=0.1728P
+ AD=0.154P PS=1.82U PD=1.335U
* device instance $2672 r0 *1 19.15,55.135 sky130_fd_pr__pfet_01v8
M$2672 869 971 37 37 sky130_fd_pr__pfet_01v8 L=0.15U W=1U AS=0.154P AD=0.28P
+ PS=1.335U PD=2.56U
* device instance $2673 r0 *1 28.31,55.425 sky130_fd_pr__pfet_01v8
M$2673 973 893 37 37 sky130_fd_pr__pfet_01v8 L=0.15U W=0.42U AS=0.1573P
+ AD=0.1092P PS=1.39U PD=1.36U
* device instance $2674 r0 *1 28.85,55.135 sky130_fd_pr__pfet_01v8
M$2674 998 993 37 37 sky130_fd_pr__pfet_01v8 L=0.15U W=1U AS=0.1573P AD=0.105P
+ PS=1.39U PD=1.21U
* device instance $2675 r0 *1 29.21,55.135 sky130_fd_pr__pfet_01v8
M$2675 976 973 998 998 sky130_fd_pr__pfet_01v8 L=0.15U W=1U AS=0.105P AD=0.26P
+ PS=1.21U PD=2.52U
* device instance $2676 r0 *1 30.85,55.135 sky130_fd_pr__pfet_01v8
M$2676 37 994 974 974 sky130_fd_pr__pfet_01v8 L=0.15U W=4U AS=0.685P AD=0.54P
+ PS=6.37U PD=5.08U
* device instance $2680 r0 *1 32.53,55.135 sky130_fd_pr__pfet_01v8
M$2680 975 115 974 974 sky130_fd_pr__pfet_01v8 L=0.15U W=4U AS=0.54P AD=0.665P
+ PS=5.08U PD=6.33U
* device instance $2683 r0 *1 33.79,55.135 sky130_fd_pr__pfet_01v8
M$2683 999 976 975 975 sky130_fd_pr__pfet_01v8 L=0.15U W=4U AS=0.54P AD=0.54P
+ PS=5.08U PD=5.08U
* device instance $2688 r0 *1 42.815,55.135 sky130_fd_pr__pfet_01v8
M$2688 37 979 977 977 sky130_fd_pr__pfet_01v8 L=0.15U W=3U AS=0.545P AD=0.545P
+ PS=5.09U PD=5.09U
* device instance $2691 r0 *1 44.635,55.135 sky130_fd_pr__pfet_01v8
M$2691 978 297 37 37 sky130_fd_pr__pfet_01v8 L=0.15U W=4U AS=0.685P AD=0.56P
+ PS=6.37U PD=5.12U
* device instance $2695 r0 *1 46.355,55.135 sky130_fd_pr__pfet_01v8
M$2695 979 978 37 37 sky130_fd_pr__pfet_01v8 L=0.15U W=16U AS=2.2375P
+ AD=2.3625P PS=20.475U PD=21.725U
* device instance $2711 r0 *1 59.405,54.955 sky130_fd_pr__pfet_01v8
M$2711 992 799 37 37 sky130_fd_pr__pfet_01v8 L=0.15U W=0.64U AS=0.1696P
+ AD=0.0768P PS=1.81U PD=0.88U
* device instance $2712 r0 *1 59.795,54.955 sky130_fd_pr__pfet_01v8
M$2712 995 941 992 992 sky130_fd_pr__pfet_01v8 L=0.15U W=0.64U AS=0.0768P
+ AD=0.0896P PS=0.88U PD=0.92U
* device instance $2713 r0 *1 60.225,54.955 sky130_fd_pr__pfet_01v8
M$2713 37 980 995 995 sky130_fd_pr__pfet_01v8 L=0.15U W=0.64U AS=0.0896P
+ AD=0.1824P PS=0.92U PD=1.85U
* device instance $2714 r0 *1 62.115,55.135 sky130_fd_pr__pfet_01v8
M$2714 981 943 37 37 sky130_fd_pr__pfet_01v8 L=0.15U W=1U AS=0.265P AD=0.14P
+ PS=2.53U PD=1.28U
* device instance $2715 r0 *1 62.545,55.135 sky130_fd_pr__pfet_01v8
M$2715 37 995 981 981 sky130_fd_pr__pfet_01v8 L=0.15U W=1U AS=0.14P AD=0.1775P
+ PS=1.28U PD=1.355U
* device instance $2716 r0 *1 63.05,55.135 sky130_fd_pr__pfet_01v8
M$2716 996 981 37 37 sky130_fd_pr__pfet_01v8 L=0.15U W=4U AS=0.5975P AD=0.705P
+ PS=5.195U PD=6.41U
* device instance $2720 r0 *1 65.33,55.055 sky130_fd_pr__pfet_01v8
M$2720 980 986 37 37 sky130_fd_pr__pfet_01v8 L=0.15U W=1.68U AS=0.3318P
+ AD=0.3486P PS=3.31U PD=3.35U
* device instance $2722 r0 *1 66.71,55.425 sky130_fd_pr__pfet_01v8
M$2722 982 985 37 37 sky130_fd_pr__pfet_01v8 L=0.15U W=0.42U AS=0.14575P
+ AD=0.1092P PS=1.335U PD=1.36U
* device instance $2723 r0 *1 67.195,55.135 sky130_fd_pr__pfet_01v8
M$2723 983 955 37 37 sky130_fd_pr__pfet_01v8 L=0.15U W=1U AS=0.14575P AD=0.135P
+ PS=1.335U PD=1.27U
* device instance $2724 r0 *1 67.615,55.135 sky130_fd_pr__pfet_01v8
M$2724 37 982 983 983 sky130_fd_pr__pfet_01v8 L=0.15U W=1U AS=0.135P AD=0.265P
+ PS=1.27U PD=2.53U
* device instance $2725 r0 *1 69.05,55.135 sky130_fd_pr__pfet_01v8
M$2725 984 955 37 37 sky130_fd_pr__pfet_01v8 L=0.15U W=1U AS=0.3P AD=0.135P
+ PS=2.6U PD=1.27U
* device instance $2726 r0 *1 69.47,55.135 sky130_fd_pr__pfet_01v8
M$2726 37 985 984 984 sky130_fd_pr__pfet_01v8 L=0.15U W=1U AS=0.135P AD=0.365P
+ PS=1.27U PD=1.73U
* device instance $2727 r0 *1 70.35,55.135 sky130_fd_pr__pfet_01v8
M$2727 997 985 37 37 sky130_fd_pr__pfet_01v8 L=0.15U W=1U AS=0.365P AD=0.105P
+ PS=1.73U PD=1.21U
* device instance $2728 r0 *1 70.71,55.135 sky130_fd_pr__pfet_01v8
M$2728 986 955 997 997 sky130_fd_pr__pfet_01v8 L=0.15U W=1U AS=0.105P AD=0.165P
+ PS=1.21U PD=1.33U
* device instance $2729 r0 *1 71.19,55.135 sky130_fd_pr__pfet_01v8
M$2729 37 984 986 986 sky130_fd_pr__pfet_01v8 L=0.15U W=1U AS=0.165P AD=0.36P
+ PS=1.33U PD=2.72U
* device instance $2730 r0 *1 9.21,54.985 sky130_fd_pr__pfet_01v8
M$2730 37 681 965 965 sky130_fd_pr__pfet_01v8 L=0.15U W=0.64U AS=0.1664P
+ AD=0.0864P PS=1.8U PD=0.91U
* device instance $2731 r0 *1 9.63,54.985 sky130_fd_pr__pfet_01v8
M$2731 966 965 37 37 sky130_fd_pr__pfet_01v8 L=0.15U W=0.64U AS=0.0864P
+ AD=0.1664P PS=0.91U PD=1.8U
* device instance $2732 r0 *1 11.03,60.285 sky130_fd_pr__pfet_01v8
M$2732 1043 1072 37 37 sky130_fd_pr__pfet_01v8 L=0.15U W=0.42U AS=0.1092P
+ AD=0.0672P PS=1.36U PD=0.74U
* device instance $2733 r0 *1 11.5,60.285 sky130_fd_pr__pfet_01v8
M$2733 1044 1042 1043 1043 sky130_fd_pr__pfet_01v8 L=0.15U W=0.42U AS=0.0672P
+ AD=0.06615P PS=0.74U PD=0.735U
* device instance $2734 r0 *1 11.965,60.285 sky130_fd_pr__pfet_01v8
M$2734 1067 1041 1044 1044 sky130_fd_pr__pfet_01v8 L=0.15U W=0.42U AS=0.06615P
+ AD=0.0693P PS=0.735U PD=0.75U
* device instance $2735 r0 *1 12.445,60.285 sky130_fd_pr__pfet_01v8
M$2735 37 1045 1067 1067 sky130_fd_pr__pfet_01v8 L=0.15U W=0.42U AS=0.0693P
+ AD=0.178875P PS=0.75U PD=1.26U
* device instance $2736 r0 *1 13.58,60.285 sky130_fd_pr__pfet_01v8
M$2736 1046 1041 1045 1045 sky130_fd_pr__pfet_01v8 L=0.15U W=0.42U AS=0.1095P
+ AD=0.0567P PS=1.075U PD=0.69U
* device instance $2737 r0 *1 14,60.285 sky130_fd_pr__pfet_01v8
M$2737 1068 1042 1046 1046 sky130_fd_pr__pfet_01v8 L=0.15U W=0.42U AS=0.0567P
+ AD=0.09135P PS=0.69U PD=0.855U
* device instance $2738 r0 *1 14.585,60.285 sky130_fd_pr__pfet_01v8
M$2738 37 1047 1068 1068 sky130_fd_pr__pfet_01v8 L=0.15U W=0.42U AS=0.09135P
+ AD=0.1218P PS=0.855U PD=1.42U
* device instance $2739 r0 *1 13.105,60.45 sky130_fd_pr__pfet_01v8
M$2739 1045 1044 37 37 sky130_fd_pr__pfet_01v8 L=0.15U W=0.75U AS=0.178875P
+ AD=0.1095P PS=1.26U PD=1.075U
* device instance $2740 r0 *1 15.665,60.575 sky130_fd_pr__pfet_01v8
M$2740 37 1046 1047 1047 sky130_fd_pr__pfet_01v8 L=0.15U W=1U AS=0.28P
+ AD=0.1625P PS=2.56U PD=1.325U
* device instance $2741 r0 *1 16.14,60.575 sky130_fd_pr__pfet_01v8
M$2741 64 1047 37 37 sky130_fd_pr__pfet_01v8 L=0.15U W=4U AS=0.575P AD=0.6925P
+ PS=5.15U PD=6.385U
* device instance $2745 r0 *1 20.73,60.575 sky130_fd_pr__pfet_01v8
M$2745 37 1101 1048 1048 sky130_fd_pr__pfet_01v8 L=0.15U W=4U AS=0.685P
+ AD=0.54P PS=6.37U PD=5.08U
* device instance $2749 r0 *1 22.41,60.575 sky130_fd_pr__pfet_01v8
M$2749 1049 1010 1048 1048 sky130_fd_pr__pfet_01v8 L=0.15U W=4U AS=0.54P
+ AD=0.675P PS=5.08U PD=6.35U
* device instance $2753 r0 *1 24.85,60.575 sky130_fd_pr__pfet_01v8
M$2753 37 1049 1050 1050 sky130_fd_pr__pfet_01v8 L=0.15U W=3U AS=0.53P
+ AD=0.405P PS=5.06U PD=3.81U
* device instance $2756 r0 *1 26.11,60.575 sky130_fd_pr__pfet_01v8
M$2756 94 1050 37 37 sky130_fd_pr__pfet_01v8 L=0.15U W=8U AS=1.08P AD=1.205P
+ PS=10.16U PD=11.41U
* device instance $2764 r0 *1 24.87,59.105 sky130_fd_pr__pfet_01v8
M$2764 37 64 1031 1031 sky130_fd_pr__pfet_01v8 L=0.15U W=2U AS=0.415P AD=0.27P
+ PS=3.83U PD=2.54U
* device instance $2766 r0 *1 25.71,59.105 sky130_fd_pr__pfet_01v8
M$2766 1034 976 1031 1031 sky130_fd_pr__pfet_01v8 L=0.15U W=2U AS=0.27P
+ AD=0.415P PS=2.54U PD=3.83U
* device instance $2768 r0 *1 27.09,59.105 sky130_fd_pr__pfet_01v8
M$2768 1010 1015 1034 1034 sky130_fd_pr__pfet_01v8 L=0.15U W=2U AS=0.395P
+ AD=0.395P PS=3.79U PD=3.79U
* device instance $2770 r0 *1 28.65,59.105 sky130_fd_pr__pfet_01v8
M$2770 37 115 1012 1012 sky130_fd_pr__pfet_01v8 L=0.15U W=1U AS=0.38P AD=0.135P
+ PS=2.76U PD=1.27U
* device instance $2771 r0 *1 29.07,59.105 sky130_fd_pr__pfet_01v8
M$2771 92 1011 37 37 sky130_fd_pr__pfet_01v8 L=0.15U W=4U AS=0.54P AD=0.54P
+ PS=5.08U PD=5.08U
* device instance $2775 r0 *1 30.75,59.105 sky130_fd_pr__pfet_01v8
M$2775 1011 1012 37 37 sky130_fd_pr__pfet_01v8 L=0.15U W=2U AS=0.27P AD=0.395P
+ PS=2.54U PD=3.79U
* device instance $2777 r0 *1 32.11,59.105 sky130_fd_pr__pfet_01v8
M$2777 1011 1015 1035 1035 sky130_fd_pr__pfet_01v8 L=0.15U W=2U AS=0.395P
+ AD=0.27P PS=3.79U PD=2.54U
* device instance $2779 r0 *1 32.95,59.105 sky130_fd_pr__pfet_01v8
M$2779 37 976 1035 1035 sky130_fd_pr__pfet_01v8 L=0.15U W=2U AS=0.27P AD=0.415P
+ PS=2.54U PD=3.83U
* device instance $2781 r0 *1 32.21,60.575 sky130_fd_pr__pfet_01v8
M$2781 1081 976 1051 1051 sky130_fd_pr__pfet_01v8 L=0.15U W=1U AS=0.26P
+ AD=0.105P PS=2.52U PD=1.21U
* device instance $2782 r0 *1 32.57,60.575 sky130_fd_pr__pfet_01v8
M$2782 37 1073 1081 1081 sky130_fd_pr__pfet_01v8 L=0.15U W=1U AS=0.105P
+ AD=0.26P PS=1.21U PD=2.52U
* device instance $2783 r0 *1 33.83,60.865 sky130_fd_pr__pfet_01v8
M$2783 1074 993 37 37 sky130_fd_pr__pfet_01v8 L=0.15U W=0.42U AS=0.1573P
+ AD=0.1092P PS=1.39U PD=1.36U
* device instance $2784 r0 *1 34.37,60.575 sky130_fd_pr__pfet_01v8
M$2784 1082 893 37 37 sky130_fd_pr__pfet_01v8 L=0.15U W=1U AS=0.1573P AD=0.105P
+ PS=1.39U PD=1.21U
* device instance $2785 r0 *1 34.73,60.575 sky130_fd_pr__pfet_01v8
M$2785 1073 1074 1082 1082 sky130_fd_pr__pfet_01v8 L=0.15U W=1U AS=0.105P
+ AD=0.26P PS=1.21U PD=2.52U
* device instance $2786 r0 *1 34.97,59.105 sky130_fd_pr__pfet_01v8
M$2786 37 994 1014 1014 sky130_fd_pr__pfet_01v8 L=0.15U W=1U AS=0.26P AD=0.135P
+ PS=2.52U PD=1.27U
* device instance $2787 r0 *1 35.39,59.105 sky130_fd_pr__pfet_01v8
M$2787 1015 1014 37 37 sky130_fd_pr__pfet_01v8 L=0.15U W=4U AS=0.54P AD=0.665P
+ PS=5.08U PD=6.33U
* device instance $2791 r0 *1 37.99,59.105 sky130_fd_pr__pfet_01v8
M$2791 1016 999 37 37 sky130_fd_pr__pfet_01v8 L=0.15U W=2U AS=0.395P AD=0.27P
+ PS=3.79U PD=2.54U
* device instance $2793 r0 *1 38.83,59.105 sky130_fd_pr__pfet_01v8
M$2793 158 1016 37 37 sky130_fd_pr__pfet_01v8 L=0.15U W=6U AS=0.81P AD=0.935P
+ PS=7.62U PD=8.87U
* device instance $2799 r0 *1 40.03,60.575 sky130_fd_pr__pfet_01v8
M$2799 1053 1052 37 37 sky130_fd_pr__pfet_01v8 L=0.15U W=2U AS=0.395P AD=0.27P
+ PS=3.79U PD=2.54U
* device instance $2801 r0 *1 40.87,60.575 sky130_fd_pr__pfet_01v8
M$2801 1053 1033 37 37 sky130_fd_pr__pfet_01v8 L=0.15U W=2U AS=0.275P AD=0.285P
+ PS=2.55U PD=2.57U
* device instance $2803 r0 *1 41.74,60.575 sky130_fd_pr__pfet_01v8
M$2803 1053 1054 37 37 sky130_fd_pr__pfet_01v8 L=0.15U W=2U AS=0.28P AD=0.395P
+ PS=2.56U PD=3.79U
* device instance $2805 r0 *1 42.79,59.105 sky130_fd_pr__pfet_01v8
M$2805 1040 1017 1018 1018 sky130_fd_pr__pfet_01v8 L=0.15U W=1U AS=0.26P
+ AD=0.105P PS=2.52U PD=1.21U
* device instance $2806 r0 *1 43.15,59.105 sky130_fd_pr__pfet_01v8
M$2806 37 1019 1040 1040 sky130_fd_pr__pfet_01v8 L=0.15U W=1U AS=0.105P
+ AD=0.26P PS=1.21U PD=2.52U
* device instance $2807 r0 *1 43.1,60.575 sky130_fd_pr__pfet_01v8
M$2807 1053 1073 1055 1055 sky130_fd_pr__pfet_01v8 L=0.15U W=2U AS=0.395P
+ AD=0.395P PS=3.79U PD=2.79U
* device instance $2809 r0 *1 44.19,60.575 sky130_fd_pr__pfet_01v8
M$2809 1075 1076 1055 1055 sky130_fd_pr__pfet_01v8 L=0.15U W=2U AS=0.395P
+ AD=0.395P PS=2.79U PD=3.79U
* device instance $2811 r0 *1 45.57,60.575 sky130_fd_pr__pfet_01v8
M$2811 1056 1054 1019 1019 sky130_fd_pr__pfet_01v8 L=0.15U W=1U AS=0.265P
+ AD=0.14P PS=2.53U PD=1.28U
* device instance $2812 r0 *1 46,60.575 sky130_fd_pr__pfet_01v8
M$2812 37 1052 1056 1056 sky130_fd_pr__pfet_01v8 L=0.15U W=1U AS=0.14P
+ AD=0.1475P PS=1.28U PD=1.295U
* device instance $2813 r0 *1 46.445,60.575 sky130_fd_pr__pfet_01v8
M$2813 1056 1077 37 37 sky130_fd_pr__pfet_01v8 L=0.15U W=1U AS=0.1475P
+ AD=0.265P PS=1.295U PD=2.53U
* device instance $2814 r0 *1 46.47,59.105 sky130_fd_pr__pfet_01v8
M$2814 37 999 1020 1020 sky130_fd_pr__pfet_01v8 L=0.15U W=1U AS=0.26P AD=0.135P
+ PS=2.52U PD=1.27U
* device instance $2815 r0 *1 46.89,59.105 sky130_fd_pr__pfet_01v8
M$2815 1021 1020 37 37 sky130_fd_pr__pfet_01v8 L=0.15U W=4U AS=0.54P AD=0.665P
+ PS=5.08U PD=6.33U
* device instance $2819 r0 *1 49.69,60.575 sky130_fd_pr__pfet_01v8
M$2819 37 1052 1057 1057 sky130_fd_pr__pfet_01v8 L=0.15U W=2U AS=0.395P
+ AD=0.27P PS=3.79U PD=2.54U
* device instance $2821 r0 *1 50.53,60.575 sky130_fd_pr__pfet_01v8
M$2821 37 1077 1057 1057 sky130_fd_pr__pfet_01v8 L=0.15U W=2U AS=0.27P AD=0.27P
+ PS=2.54U PD=2.54U
* device instance $2823 r0 *1 51.37,60.575 sky130_fd_pr__pfet_01v8
M$2823 37 1054 1057 1057 sky130_fd_pr__pfet_01v8 L=0.15U W=2U AS=0.545P
+ AD=0.59P PS=3.09U PD=3.18U
* device instance $2825 r0 *1 52.85,60.575 sky130_fd_pr__pfet_01v8
M$2825 1058 1076 1057 1057 sky130_fd_pr__pfet_01v8 L=0.15U W=2U AS=0.355P
+ AD=0.435P PS=2.71U PD=3.87U
* device instance $2827 r0 *1 51.15,59.105 sky130_fd_pr__pfet_01v8
M$2827 37 854 1032 1032 sky130_fd_pr__pfet_01v8 L=0.15U W=4U AS=0.685P AD=0.54P
+ PS=6.37U PD=5.08U
* device instance $2831 r0 *1 52.83,59.105 sky130_fd_pr__pfet_01v8
M$2831 1036 799 1032 1032 sky130_fd_pr__pfet_01v8 L=0.15U W=4U AS=0.54P
+ AD=0.665P PS=5.08U PD=6.33U
* device instance $2835 r0 *1 55.03,59.105 sky130_fd_pr__pfet_01v8
M$2835 1036 980 1033 1033 sky130_fd_pr__pfet_01v8 L=0.15U W=4U AS=0.665P
+ AD=0.55P PS=6.33U PD=5.1U
* device instance $2839 r0 *1 56.73,59.105 sky130_fd_pr__pfet_01v8
M$2839 37 983 1033 1033 sky130_fd_pr__pfet_01v8 L=0.15U W=4U AS=0.55P AD=0.54P
+ PS=5.1U PD=5.08U
* device instance $2843 r0 *1 58.41,59.105 sky130_fd_pr__pfet_01v8
M$2843 37 1024 1033 1033 sky130_fd_pr__pfet_01v8 L=0.15U W=4U AS=0.54P
+ AD=0.665P PS=5.08U PD=6.33U
* device instance $2847 r0 *1 60.73,59.105 sky130_fd_pr__pfet_01v8
M$2847 1037 1025 1026 1026 sky130_fd_pr__pfet_01v8 L=0.15U W=1U AS=0.26P
+ AD=0.135P PS=2.52U PD=1.27U
* device instance $2848 r0 *1 61.15,59.105 sky130_fd_pr__pfet_01v8
M$2848 1038 985 1037 1037 sky130_fd_pr__pfet_01v8 L=0.15U W=1U AS=0.135P
+ AD=0.135P PS=1.27U PD=1.27U
* device instance $2849 r0 *1 61.57,59.105 sky130_fd_pr__pfet_01v8
M$2849 1037 92 1038 1038 sky130_fd_pr__pfet_01v8 L=0.15U W=1U AS=0.135P
+ AD=0.26P PS=1.27U PD=2.52U
* device instance $2850 r0 *1 62.51,59.105 sky130_fd_pr__pfet_01v8
M$2850 1038 1021 37 37 sky130_fd_pr__pfet_01v8 L=0.15U W=1U AS=0.26P AD=0.165P
+ PS=2.52U PD=1.33U
* device instance $2851 r0 *1 62.99,59.105 sky130_fd_pr__pfet_01v8
M$2851 37 996 1038 1038 sky130_fd_pr__pfet_01v8 L=0.15U W=1U AS=0.165P
+ AD=0.1575P PS=1.33U PD=1.315U
* device instance $2852 r0 *1 63.455,59.105 sky130_fd_pr__pfet_01v8
M$2852 1027 1026 37 37 sky130_fd_pr__pfet_01v8 L=0.15U W=1U AS=0.1575P AD=0.26P
+ PS=1.315U PD=2.52U
* device instance $2853 r0 *1 64.43,59.105 sky130_fd_pr__pfet_01v8
M$2853 1039 943 37 37 sky130_fd_pr__pfet_01v8 L=0.15U W=1U AS=0.26P AD=0.135P
+ PS=2.52U PD=1.27U
* device instance $2854 r0 *1 64.85,59.105 sky130_fd_pr__pfet_01v8
M$2854 37 983 1039 1039 sky130_fd_pr__pfet_01v8 L=0.15U W=1U AS=0.135P AD=0.26P
+ PS=1.27U PD=2.52U
* device instance $2855 r0 *1 64.85,60.395 sky130_fd_pr__pfet_01v8
M$2855 1080 1027 1061 1061 sky130_fd_pr__pfet_01v8 L=0.15U W=0.64U AS=0.1664P
+ AD=0.0672P PS=1.8U PD=0.85U
* device instance $2856 r0 *1 65.21,60.395 sky130_fd_pr__pfet_01v8
M$2856 37 1062 1080 1080 sky130_fd_pr__pfet_01v8 L=0.15U W=0.64U AS=0.0672P
+ AD=0.1664P PS=0.85U PD=1.8U
* device instance $2857 r0 *1 67.875,60.285 sky130_fd_pr__pfet_01v8
M$2857 1063 1060 1061 1061 sky130_fd_pr__pfet_01v8 L=0.15U W=0.42U AS=0.15985P
+ AD=0.06405P PS=1.265U PD=0.725U
* device instance $2858 r0 *1 68.33,60.285 sky130_fd_pr__pfet_01v8
M$2858 1071 1059 1063 1063 sky130_fd_pr__pfet_01v8 L=0.15U W=0.42U AS=0.06405P
+ AD=0.07665P PS=0.725U PD=0.785U
* device instance $2859 r0 *1 68.845,60.285 sky130_fd_pr__pfet_01v8
M$2859 37 1064 1071 1071 sky130_fd_pr__pfet_01v8 L=0.15U W=0.42U AS=0.07665P
+ AD=0.178875P PS=0.785U PD=1.26U
* device instance $2860 r0 *1 66.15,60.395 sky130_fd_pr__pfet_01v8
M$2860 37 302 1062 1062 sky130_fd_pr__pfet_01v8 L=0.15U W=0.64U AS=0.1664P
+ AD=0.0928P PS=1.8U PD=0.93U
* device instance $2861 r0 *1 66.59,60.395 sky130_fd_pr__pfet_01v8
M$2861 1079 302 37 37 sky130_fd_pr__pfet_01v8 L=0.15U W=0.64U AS=0.0928P
+ AD=0.1152P PS=0.93U PD=1U
* device instance $2862 r0 *1 67.1,60.395 sky130_fd_pr__pfet_01v8
M$2862 1061 1066 1079 1079 sky130_fd_pr__pfet_01v8 L=0.15U W=0.64U AS=0.1152P
+ AD=0.15985P PS=1U PD=1.265U
* device instance $2863 r0 *1 69.505,60.45 sky130_fd_pr__pfet_01v8
M$2863 1064 1063 37 37 sky130_fd_pr__pfet_01v8 L=0.15U W=0.75U AS=0.178875P
+ AD=0.195P PS=1.26U PD=2.02U
* device instance $2864 r0 *1 70.445,60.285 sky130_fd_pr__pfet_01v8
M$2864 1070 1064 37 37 sky130_fd_pr__pfet_01v8 L=0.15U W=0.42U AS=0.1092P
+ AD=0.06405P PS=1.36U PD=0.725U
* device instance $2865 r0 *1 70.9,60.285 sky130_fd_pr__pfet_01v8
M$2865 1065 1059 1070 1070 sky130_fd_pr__pfet_01v8 L=0.15U W=0.42U AS=0.06405P
+ AD=0.0567P PS=0.725U PD=0.69U
* device instance $2866 r0 *1 71.32,60.285 sky130_fd_pr__pfet_01v8
M$2866 1069 1060 1065 1065 sky130_fd_pr__pfet_01v8 L=0.15U W=0.42U AS=0.0567P
+ AD=0.0882P PS=0.69U PD=0.84U
* device instance $2867 r0 *1 71.89,60.285 sky130_fd_pr__pfet_01v8
M$2867 37 1066 1069 1069 sky130_fd_pr__pfet_01v8 L=0.15U W=0.42U AS=0.0882P
+ AD=0.1113P PS=0.84U PD=1.37U
* device instance $2868 r0 *1 72.945,60.395 sky130_fd_pr__pfet_01v8
M$2868 37 1065 1066 1066 sky130_fd_pr__pfet_01v8 L=0.15U W=0.64U AS=0.1728P
+ AD=0.154P PS=1.82U PD=1.335U
* device instance $2869 r0 *1 73.43,60.575 sky130_fd_pr__pfet_01v8
M$2869 955 1065 37 37 sky130_fd_pr__pfet_01v8 L=0.15U W=1U AS=0.154P AD=0.28P
+ PS=1.335U PD=2.56U
* device instance $2870 r0 *1 7.83,64.625 sky130_fd_pr__pfet_01v8
M$2870 1185 1128 37 37 sky130_fd_pr__pfet_01v8 L=0.15U W=1.68U AS=0.3318P
+ AD=0.3486P PS=3.31U PD=3.35U
* device instance $2872 r0 *1 9.21,64.545 sky130_fd_pr__pfet_01v8
M$2872 1135 1129 37 37 sky130_fd_pr__pfet_01v8 L=0.15U W=1U AS=0.26P AD=0.1125P
+ PS=2.52U PD=1.225U
* device instance $2873 r0 *1 9.585,64.545 sky130_fd_pr__pfet_01v8
M$2873 1098 1128 1135 1135 sky130_fd_pr__pfet_01v8 L=0.15U W=1U AS=0.1125P
+ AD=0.2325P PS=1.225U PD=1.465U
* device instance $2874 r0 *1 10.2,64.545 sky130_fd_pr__pfet_01v8
M$2874 1137 1099 1098 1098 sky130_fd_pr__pfet_01v8 L=0.15U W=1U AS=0.2325P
+ AD=0.105P PS=1.465U PD=1.21U
* device instance $2875 r0 *1 10.56,64.545 sky130_fd_pr__pfet_01v8
M$2875 37 918 1137 1137 sky130_fd_pr__pfet_01v8 L=0.15U W=1U AS=0.105P AD=0.27P
+ PS=1.21U PD=2.54U
* device instance $2876 r0 *1 9.67,60.425 sky130_fd_pr__pfet_01v8
M$2876 37 681 1041 1041 sky130_fd_pr__pfet_01v8 L=0.15U W=0.64U AS=0.1664P
+ AD=0.0864P PS=1.8U PD=0.91U
* device instance $2877 r0 *1 10.09,60.425 sky130_fd_pr__pfet_01v8
M$2877 1042 1041 37 37 sky130_fd_pr__pfet_01v8 L=0.15U W=0.64U AS=0.0864P
+ AD=0.1664P PS=0.91U PD=1.8U
* device instance $2878 r0 *1 11.53,64.545 sky130_fd_pr__pfet_01v8
M$2878 115 1130 37 37 sky130_fd_pr__pfet_01v8 L=0.15U W=1U AS=0.26P AD=0.135P
+ PS=2.52U PD=1.27U
* device instance $2879 r0 *1 11.95,64.545 sky130_fd_pr__pfet_01v8
M$2879 37 1100 115 115 sky130_fd_pr__pfet_01v8 L=0.15U W=1U AS=0.135P AD=0.26P
+ PS=1.27U PD=2.52U
* device instance $2880 r0 *1 12.89,64.625 sky130_fd_pr__pfet_01v8
M$2880 1100 64 37 37 sky130_fd_pr__pfet_01v8 L=0.15U W=1.68U AS=0.3318P
+ AD=0.3486P PS=3.31U PD=3.35U
* device instance $2882 r0 *1 17.05,64.545 sky130_fd_pr__pfet_01v8
M$2882 37 1130 1133 1133 sky130_fd_pr__pfet_01v8 L=0.15U W=4U AS=0.685P
+ AD=0.54P PS=6.37U PD=5.08U
* device instance $2886 r0 *1 18.73,64.545 sky130_fd_pr__pfet_01v8
M$2886 1101 64 1133 1133 sky130_fd_pr__pfet_01v8 L=0.15U W=4U AS=0.54P
+ AD=0.675P PS=5.08U PD=6.35U
* device instance $2890 r0 *1 22.255,64.545 sky130_fd_pr__pfet_01v8
M$2890 302 1101 37 37 sky130_fd_pr__pfet_01v8 L=0.15U W=8U AS=1.205P AD=1.205P
+ PS=11.41U PD=11.41U
* device instance $2898 r0 *1 26.49,64.545 sky130_fd_pr__pfet_01v8
M$2898 1102 1049 37 37 sky130_fd_pr__pfet_01v8 L=0.15U W=2U AS=0.395P AD=0.27P
+ PS=3.79U PD=2.54U
* device instance $2900 r0 *1 27.33,64.545 sky130_fd_pr__pfet_01v8
M$2900 409 1102 37 37 sky130_fd_pr__pfet_01v8 L=0.15U W=6U AS=0.81P AD=0.935P
+ PS=7.62U PD=8.87U
* device instance $2906 r0 *1 30.37,64.695 sky130_fd_pr__pfet_01v8
M$2906 37 681 1103 1103 sky130_fd_pr__pfet_01v8 L=0.15U W=0.64U AS=0.1664P
+ AD=0.0864P PS=1.8U PD=0.91U
* device instance $2907 r0 *1 30.79,64.695 sky130_fd_pr__pfet_01v8
M$2907 1105 1103 37 37 sky130_fd_pr__pfet_01v8 L=0.15U W=0.64U AS=0.0864P
+ AD=0.1664P PS=0.91U PD=1.8U
* device instance $2908 r0 *1 39.825,64.725 sky130_fd_pr__pfet_01v8
M$2908 1108 1111 37 37 sky130_fd_pr__pfet_01v8 L=0.15U W=0.64U AS=0.154P
+ AD=0.1728P PS=1.335U PD=1.82U
* device instance $2909 r0 *1 40.31,64.545 sky130_fd_pr__pfet_01v8
M$2909 993 1111 37 37 sky130_fd_pr__pfet_01v8 L=0.15U W=1U AS=0.154P AD=0.28P
+ PS=1.335U PD=2.56U
* device instance $2910 r0 *1 41.41,64.545 sky130_fd_pr__pfet_01v8
M$2910 37 1075 1112 1112 sky130_fd_pr__pfet_01v8 L=0.15U W=1U AS=0.26P
+ AD=0.135P PS=2.52U PD=1.27U
* device instance $2911 r0 *1 41.83,64.545 sky130_fd_pr__pfet_01v8
M$2911 994 1112 37 37 sky130_fd_pr__pfet_01v8 L=0.15U W=4U AS=0.54P AD=0.665P
+ PS=5.08U PD=6.33U
* device instance $2915 r0 *1 45.59,64.545 sky130_fd_pr__pfet_01v8
M$2915 1113 1134 37 37 sky130_fd_pr__pfet_01v8 L=0.15U W=1U AS=0.3P AD=0.135P
+ PS=2.6U PD=1.27U
* device instance $2916 r0 *1 46.01,64.545 sky130_fd_pr__pfet_01v8
M$2916 37 1114 1113 1113 sky130_fd_pr__pfet_01v8 L=0.15U W=1U AS=0.135P
+ AD=0.365P PS=1.27U PD=1.73U
* device instance $2917 r0 *1 46.89,64.545 sky130_fd_pr__pfet_01v8
M$2917 1138 1114 37 37 sky130_fd_pr__pfet_01v8 L=0.15U W=1U AS=0.365P AD=0.105P
+ PS=1.73U PD=1.21U
* device instance $2918 r0 *1 47.25,64.545 sky130_fd_pr__pfet_01v8
M$2918 1054 1134 1138 1138 sky130_fd_pr__pfet_01v8 L=0.15U W=1U AS=0.105P
+ AD=0.165P PS=1.21U PD=1.33U
* device instance $2919 r0 *1 47.73,64.545 sky130_fd_pr__pfet_01v8
M$2919 37 1113 1054 1054 sky130_fd_pr__pfet_01v8 L=0.15U W=1U AS=0.165P
+ AD=0.36P PS=1.33U PD=2.72U
* device instance $2920 r0 *1 47.39,60.85 sky130_fd_pr__pfet_01v8
M$2920 37 1054 1078 1078 sky130_fd_pr__pfet_01v8 L=0.15U W=0.42U AS=0.1092P
+ AD=0.0567P PS=1.36U PD=0.69U
* device instance $2921 r0 *1 47.81,60.85 sky130_fd_pr__pfet_01v8
M$2921 1078 1052 37 37 sky130_fd_pr__pfet_01v8 L=0.15U W=0.42U AS=0.0567P
+ AD=0.06615P PS=0.69U PD=0.735U
* device instance $2922 r0 *1 48.275,60.85 sky130_fd_pr__pfet_01v8
M$2922 1078 1077 37 37 sky130_fd_pr__pfet_01v8 L=0.15U W=0.42U AS=0.142225P
+ AD=0.06615P PS=1.335U PD=0.735U
* device instance $2923 r0 *1 48.75,60.575 sky130_fd_pr__pfet_01v8
M$2923 1017 1078 37 37 sky130_fd_pr__pfet_01v8 L=0.15U W=1U AS=0.142225P
+ AD=0.26P PS=1.335U PD=2.52U
* device instance $2924 r0 *1 48.77,64.545 sky130_fd_pr__pfet_01v8
M$2924 37 1033 1116 1116 sky130_fd_pr__pfet_01v8 L=0.15U W=1U AS=0.26P
+ AD=0.135P PS=2.52U PD=1.27U
* device instance $2925 r0 *1 49.19,64.545 sky130_fd_pr__pfet_01v8
M$2925 1077 1116 37 37 sky130_fd_pr__pfet_01v8 L=0.15U W=4U AS=0.54P AD=0.665P
+ PS=5.08U PD=6.33U
* device instance $2929 r0 *1 51.77,64.255 sky130_fd_pr__pfet_01v8
M$2929 37 1114 1117 1117 sky130_fd_pr__pfet_01v8 L=0.15U W=0.42U AS=0.1092P
+ AD=0.1573P PS=1.36U PD=1.39U
* device instance $2930 r0 *1 52.31,64.545 sky130_fd_pr__pfet_01v8
M$2930 1136 1134 37 37 sky130_fd_pr__pfet_01v8 L=0.15U W=1U AS=0.1573P
+ AD=0.105P PS=1.39U PD=1.21U
* device instance $2931 r0 *1 52.67,64.545 sky130_fd_pr__pfet_01v8
M$2931 1076 1117 1136 1136 sky130_fd_pr__pfet_01v8 L=0.15U W=1U AS=0.105P
+ AD=0.26P PS=1.21U PD=2.52U
* device instance $2932 r0 *1 63.49,60.425 sky130_fd_pr__pfet_01v8
M$2932 37 979 1059 1059 sky130_fd_pr__pfet_01v8 L=0.15U W=0.64U AS=0.1664P
+ AD=0.0864P PS=1.8U PD=0.91U
* device instance $2933 r0 *1 63.91,60.425 sky130_fd_pr__pfet_01v8
M$2933 1060 1059 37 37 sky130_fd_pr__pfet_01v8 L=0.15U W=0.64U AS=0.0864P
+ AD=0.1664P PS=0.91U PD=1.8U
* device instance $2934 r0 *1 64.41,64.255 sky130_fd_pr__pfet_01v8
M$2934 37 1131 1118 1118 sky130_fd_pr__pfet_01v8 L=0.15U W=0.42U AS=0.1092P
+ AD=0.14575P PS=1.36U PD=1.335U
* device instance $2935 r0 *1 64.895,64.545 sky130_fd_pr__pfet_01v8
M$2935 1052 1132 37 37 sky130_fd_pr__pfet_01v8 L=0.15U W=1U AS=0.14575P
+ AD=0.135P PS=1.335U PD=1.27U
* device instance $2936 r0 *1 65.315,64.545 sky130_fd_pr__pfet_01v8
M$2936 37 1118 1052 1052 sky130_fd_pr__pfet_01v8 L=0.15U W=1U AS=0.135P
+ AD=0.265P PS=1.27U PD=2.53U
* device instance $2937 r0 *1 66.71,64.545 sky130_fd_pr__pfet_01v8
M$2937 37 1132 1119 1119 sky130_fd_pr__pfet_01v8 L=0.15U W=1U AS=0.26P
+ AD=0.135P PS=2.52U PD=1.27U
* device instance $2938 r0 *1 67.13,64.545 sky130_fd_pr__pfet_01v8
M$2938 374 1119 37 37 sky130_fd_pr__pfet_01v8 L=0.15U W=4U AS=0.54P AD=0.665P
+ PS=5.08U PD=6.33U
* device instance $2942 r0 *1 5.09,66.015 sky130_fd_pr__pfet_01v8
M$2942 1129 1144 37 37 sky130_fd_pr__pfet_01v8 L=0.15U W=1U AS=0.26P AD=0.135P
+ PS=2.52U PD=1.27U
* device instance $2943 r0 *1 5.51,66.015 sky130_fd_pr__pfet_01v8
M$2943 37 64 1129 1129 sky130_fd_pr__pfet_01v8 L=0.15U W=1U AS=0.135P AD=0.26P
+ PS=1.27U PD=2.52U
* device instance $2944 r0 *1 8.805,65.835 sky130_fd_pr__pfet_01v8
M$2944 1193 1100 37 37 sky130_fd_pr__pfet_01v8 L=0.15U W=0.64U AS=0.1696P
+ AD=0.0768P PS=1.81U PD=0.88U
* device instance $2945 r0 *1 9.195,65.835 sky130_fd_pr__pfet_01v8
M$2945 1072 1144 1193 1193 sky130_fd_pr__pfet_01v8 L=0.15U W=0.64U AS=0.0768P
+ AD=0.0896P PS=0.88U PD=0.92U
* device instance $2946 r0 *1 9.625,65.835 sky130_fd_pr__pfet_01v8
M$2946 37 1145 1072 1072 sky130_fd_pr__pfet_01v8 L=0.15U W=0.64U AS=0.0896P
+ AD=0.1824P PS=0.92U PD=1.85U
* device instance $2947 r0 *1 10.61,66.015 sky130_fd_pr__pfet_01v8
M$2947 1099 1185 37 37 sky130_fd_pr__pfet_01v8 L=0.15U W=1U AS=0.26P AD=0.135P
+ PS=2.52U PD=1.27U
* device instance $2948 r0 *1 11.03,66.015 sky130_fd_pr__pfet_01v8
M$2948 37 1130 1099 1099 sky130_fd_pr__pfet_01v8 L=0.15U W=1U AS=0.135P
+ AD=0.26P PS=1.27U PD=2.52U
* device instance $2949 r0 *1 12.04,66.015 sky130_fd_pr__pfet_01v8
M$2949 37 1186 1146 1146 sky130_fd_pr__pfet_01v8 L=0.15U W=1U AS=0.33P
+ AD=0.2425P PS=2.66U PD=1.485U
* device instance $2950 r0 *1 12.675,66.015 sky130_fd_pr__pfet_01v8
M$2950 1147 918 37 37 sky130_fd_pr__pfet_01v8 L=0.15U W=1U AS=0.2425P AD=0.165P
+ PS=1.485U PD=1.33U
* device instance $2951 r0 *1 13.155,66.015 sky130_fd_pr__pfet_01v8
M$2951 37 1185 1147 1147 sky130_fd_pr__pfet_01v8 L=0.15U W=1U AS=0.165P
+ AD=0.225P PS=1.33U PD=1.45U
* device instance $2952 r0 *1 13.755,66.015 sky130_fd_pr__pfet_01v8
M$2952 1147 1130 37 37 sky130_fd_pr__pfet_01v8 L=0.15U W=1U AS=0.225P AD=0.185P
+ PS=1.45U PD=1.37U
* device instance $2953 r0 *1 14.275,66.015 sky130_fd_pr__pfet_01v8
M$2953 1186 1145 1147 1147 sky130_fd_pr__pfet_01v8 L=0.15U W=1U AS=0.185P
+ AD=0.14P PS=1.37U PD=1.28U
* device instance $2954 r0 *1 14.705,66.015 sky130_fd_pr__pfet_01v8
M$2954 1147 1187 1186 1186 sky130_fd_pr__pfet_01v8 L=0.15U W=1U AS=0.14P
+ AD=0.265P PS=1.28U PD=2.53U
* device instance $2955 r0 *1 24.46,65.725 sky130_fd_pr__pfet_01v8
M$2955 1149 1188 37 37 sky130_fd_pr__pfet_01v8 L=0.15U W=0.42U AS=0.1113P
+ AD=0.0609P PS=1.37U PD=0.71U
* device instance $2956 r0 *1 24.9,65.725 sky130_fd_pr__pfet_01v8
M$2956 37 115 1149 1149 sky130_fd_pr__pfet_01v8 L=0.15U W=0.42U AS=0.0609P
+ AD=0.1841P PS=0.71U PD=1.26U
* device instance $2957 r0 *1 25.67,65.835 sky130_fd_pr__pfet_01v8
M$2957 1150 1149 37 37 sky130_fd_pr__pfet_01v8 L=0.15U W=0.64U AS=0.1841P
+ AD=0.1696P PS=1.26U PD=1.81U
* device instance $2958 r0 *1 26.69,66.015 sky130_fd_pr__pfet_01v8
M$2958 1152 1150 1151 1151 sky130_fd_pr__pfet_01v8 L=0.15U W=1U AS=0.26P
+ AD=0.135P PS=2.52U PD=1.27U
* device instance $2959 r0 *1 27.11,66.015 sky130_fd_pr__pfet_01v8
M$2959 1153 893 1152 1152 sky130_fd_pr__pfet_01v8 L=0.15U W=1U AS=0.135P
+ AD=0.135P PS=1.27U PD=1.27U
* device instance $2960 r0 *1 27.53,66.015 sky130_fd_pr__pfet_01v8
M$2960 1152 92 1153 1153 sky130_fd_pr__pfet_01v8 L=0.15U W=1U AS=0.135P
+ AD=0.26P PS=1.27U PD=2.52U
* device instance $2961 r0 *1 28.47,66.015 sky130_fd_pr__pfet_01v8
M$2961 1153 1154 37 37 sky130_fd_pr__pfet_01v8 L=0.15U W=1U AS=0.26P AD=0.165P
+ PS=2.52U PD=1.33U
* device instance $2962 r0 *1 28.95,66.015 sky130_fd_pr__pfet_01v8
M$2962 37 999 1153 1153 sky130_fd_pr__pfet_01v8 L=0.15U W=1U AS=0.165P
+ AD=0.1575P PS=1.33U PD=1.315U
* device instance $2963 r0 *1 29.415,66.015 sky130_fd_pr__pfet_01v8
M$2963 1104 1151 37 37 sky130_fd_pr__pfet_01v8 L=0.15U W=1U AS=0.1575P AD=0.26P
+ PS=1.315U PD=2.52U
* device instance $2964 r0 *1 31.73,64.725 sky130_fd_pr__pfet_01v8
M$2964 1143 1104 1106 1106 sky130_fd_pr__pfet_01v8 L=0.15U W=0.64U AS=0.1664P
+ AD=0.0672P PS=1.8U PD=0.85U
* device instance $2965 r0 *1 32.09,64.725 sky130_fd_pr__pfet_01v8
M$2965 37 1107 1143 1143 sky130_fd_pr__pfet_01v8 L=0.15U W=0.64U AS=0.0672P
+ AD=0.1664P PS=0.85U PD=1.8U
* device instance $2966 r0 *1 32.25,66.015 sky130_fd_pr__pfet_01v8
M$2966 1155 1058 37 37 sky130_fd_pr__pfet_01v8 L=0.15U W=1U AS=0.3P AD=0.135P
+ PS=2.6U PD=1.27U
* device instance $2967 r0 *1 32.67,66.015 sky130_fd_pr__pfet_01v8
M$2967 37 1051 1155 1155 sky130_fd_pr__pfet_01v8 L=0.15U W=1U AS=0.135P
+ AD=0.365P PS=1.27U PD=1.73U
* device instance $2968 r0 *1 33.55,66.015 sky130_fd_pr__pfet_01v8
M$2968 1197 1051 37 37 sky130_fd_pr__pfet_01v8 L=0.15U W=1U AS=0.365P AD=0.105P
+ PS=1.73U PD=1.21U
* device instance $2969 r0 *1 33.91,66.015 sky130_fd_pr__pfet_01v8
M$2969 1154 1058 1197 1197 sky130_fd_pr__pfet_01v8 L=0.15U W=1U AS=0.105P
+ AD=0.165P PS=1.21U PD=1.33U
* device instance $2970 r0 *1 34.39,66.015 sky130_fd_pr__pfet_01v8
M$2970 37 1155 1154 1154 sky130_fd_pr__pfet_01v8 L=0.15U W=1U AS=0.165P
+ AD=0.36P PS=1.33U PD=2.72U
* device instance $2971 r0 *1 33.03,64.725 sky130_fd_pr__pfet_01v8
M$2971 37 302 1107 1107 sky130_fd_pr__pfet_01v8 L=0.15U W=0.64U AS=0.1664P
+ AD=0.0928P PS=1.8U PD=0.93U
* device instance $2972 r0 *1 33.47,64.725 sky130_fd_pr__pfet_01v8
M$2972 1142 302 37 37 sky130_fd_pr__pfet_01v8 L=0.15U W=0.64U AS=0.0928P
+ AD=0.1152P PS=0.93U PD=1U
* device instance $2973 r0 *1 33.98,64.725 sky130_fd_pr__pfet_01v8
M$2973 1106 1108 1142 1142 sky130_fd_pr__pfet_01v8 L=0.15U W=0.64U AS=0.1152P
+ AD=0.15985P PS=1U PD=1.265U
* device instance $2974 r0 *1 34.755,64.835 sky130_fd_pr__pfet_01v8
M$2974 1109 1105 1106 1106 sky130_fd_pr__pfet_01v8 L=0.15U W=0.42U AS=0.15985P
+ AD=0.06405P PS=1.265U PD=0.725U
* device instance $2975 r0 *1 35.21,64.835 sky130_fd_pr__pfet_01v8
M$2975 1141 1103 1109 1109 sky130_fd_pr__pfet_01v8 L=0.15U W=0.42U AS=0.06405P
+ AD=0.07665P PS=0.725U PD=0.785U
* device instance $2976 r0 *1 35.725,64.835 sky130_fd_pr__pfet_01v8
M$2976 1141 1110 37 37 sky130_fd_pr__pfet_01v8 L=0.15U W=0.42U AS=0.178875P
+ AD=0.07665P PS=1.26U PD=0.785U
* device instance $2977 r0 *1 36.385,64.67 sky130_fd_pr__pfet_01v8
M$2977 1110 1109 37 37 sky130_fd_pr__pfet_01v8 L=0.15U W=0.75U AS=0.178875P
+ AD=0.195P PS=1.26U PD=2.02U
* device instance $2978 r0 *1 36.81,66.015 sky130_fd_pr__pfet_01v8
M$2978 1157 1189 1156 1156 sky130_fd_pr__pfet_01v8 L=0.15U W=1U AS=0.26P
+ AD=0.135P PS=2.52U PD=1.27U
* device instance $2979 r0 *1 37.23,66.015 sky130_fd_pr__pfet_01v8
M$2979 1158 1134 1157 1157 sky130_fd_pr__pfet_01v8 L=0.15U W=1U AS=0.135P
+ AD=0.135P PS=1.27U PD=1.27U
* device instance $2980 r0 *1 37.65,66.015 sky130_fd_pr__pfet_01v8
M$2980 1157 92 1158 1158 sky130_fd_pr__pfet_01v8 L=0.15U W=1U AS=0.135P
+ AD=0.26P PS=1.27U PD=2.52U
* device instance $2981 r0 *1 37.325,64.835 sky130_fd_pr__pfet_01v8
M$2981 1140 1110 37 37 sky130_fd_pr__pfet_01v8 L=0.15U W=0.42U AS=0.1092P
+ AD=0.06405P PS=1.36U PD=0.725U
* device instance $2982 r0 *1 37.78,64.835 sky130_fd_pr__pfet_01v8
M$2982 1111 1103 1140 1140 sky130_fd_pr__pfet_01v8 L=0.15U W=0.42U AS=0.06405P
+ AD=0.0567P PS=0.725U PD=0.69U
* device instance $2983 r0 *1 38.2,64.835 sky130_fd_pr__pfet_01v8
M$2983 1139 1105 1111 1111 sky130_fd_pr__pfet_01v8 L=0.15U W=0.42U AS=0.0567P
+ AD=0.0882P PS=0.69U PD=0.84U
* device instance $2984 r0 *1 38.77,64.835 sky130_fd_pr__pfet_01v8
M$2984 37 1108 1139 1139 sky130_fd_pr__pfet_01v8 L=0.15U W=0.42U AS=0.0882P
+ AD=0.1113P PS=0.84U PD=1.37U
* device instance $2985 r0 *1 38.59,66.015 sky130_fd_pr__pfet_01v8
M$2985 1158 1203 37 37 sky130_fd_pr__pfet_01v8 L=0.15U W=1U AS=0.26P AD=0.165P
+ PS=2.52U PD=1.33U
* device instance $2986 r0 *1 39.07,66.015 sky130_fd_pr__pfet_01v8
M$2986 37 1018 1158 1158 sky130_fd_pr__pfet_01v8 L=0.15U W=1U AS=0.165P
+ AD=0.1575P PS=1.33U PD=1.315U
* device instance $2987 r0 *1 39.535,66.015 sky130_fd_pr__pfet_01v8
M$2987 1204 1156 37 37 sky130_fd_pr__pfet_01v8 L=0.15U W=1U AS=0.1575P AD=0.26P
+ PS=1.315U PD=2.52U
* device instance $2988 r0 *1 41.85,65.835 sky130_fd_pr__pfet_01v8
M$2988 1199 1190 1161 1161 sky130_fd_pr__pfet_01v8 L=0.15U W=0.64U AS=0.1664P
+ AD=0.0672P PS=1.8U PD=0.85U
* device instance $2989 r0 *1 42.21,65.835 sky130_fd_pr__pfet_01v8
M$2989 37 1162 1199 1199 sky130_fd_pr__pfet_01v8 L=0.15U W=0.64U AS=0.0672P
+ AD=0.1664P PS=0.85U PD=1.8U
* device instance $2990 r0 *1 44.875,65.725 sky130_fd_pr__pfet_01v8
M$2990 1163 1160 1161 1161 sky130_fd_pr__pfet_01v8 L=0.15U W=0.42U AS=0.15985P
+ AD=0.06405P PS=1.265U PD=0.725U
* device instance $2991 r0 *1 45.33,65.725 sky130_fd_pr__pfet_01v8
M$2991 1183 1159 1163 1163 sky130_fd_pr__pfet_01v8 L=0.15U W=0.42U AS=0.06405P
+ AD=0.07665P PS=0.725U PD=0.785U
* device instance $2992 r0 *1 45.845,65.725 sky130_fd_pr__pfet_01v8
M$2992 37 1164 1183 1183 sky130_fd_pr__pfet_01v8 L=0.15U W=0.42U AS=0.07665P
+ AD=0.178875P PS=0.785U PD=1.26U
* device instance $2993 r0 *1 43.15,65.835 sky130_fd_pr__pfet_01v8
M$2993 37 409 1162 1162 sky130_fd_pr__pfet_01v8 L=0.15U W=0.64U AS=0.1664P
+ AD=0.0928P PS=1.8U PD=0.93U
* device instance $2994 r0 *1 43.59,65.835 sky130_fd_pr__pfet_01v8
M$2994 1198 409 37 37 sky130_fd_pr__pfet_01v8 L=0.15U W=0.64U AS=0.0928P
+ AD=0.1152P PS=0.93U PD=1U
* device instance $2995 r0 *1 44.1,65.835 sky130_fd_pr__pfet_01v8
M$2995 1161 1166 1198 1198 sky130_fd_pr__pfet_01v8 L=0.15U W=0.64U AS=0.1152P
+ AD=0.15985P PS=1U PD=1.265U
* device instance $2996 r0 *1 46.505,65.89 sky130_fd_pr__pfet_01v8
M$2996 1164 1163 37 37 sky130_fd_pr__pfet_01v8 L=0.15U W=0.75U AS=0.178875P
+ AD=0.195P PS=1.26U PD=2.02U
* device instance $2997 r0 *1 47.445,65.725 sky130_fd_pr__pfet_01v8
M$2997 1184 1164 37 37 sky130_fd_pr__pfet_01v8 L=0.15U W=0.42U AS=0.1092P
+ AD=0.06405P PS=1.36U PD=0.725U
* device instance $2998 r0 *1 47.9,65.725 sky130_fd_pr__pfet_01v8
M$2998 1165 1159 1184 1184 sky130_fd_pr__pfet_01v8 L=0.15U W=0.42U AS=0.06405P
+ AD=0.0567P PS=0.725U PD=0.69U
* device instance $2999 r0 *1 48.32,65.725 sky130_fd_pr__pfet_01v8
M$2999 1182 1160 1165 1165 sky130_fd_pr__pfet_01v8 L=0.15U W=0.42U AS=0.0567P
+ AD=0.0882P PS=0.69U PD=0.84U
* device instance $3000 r0 *1 48.89,65.725 sky130_fd_pr__pfet_01v8
M$3000 37 1166 1182 1182 sky130_fd_pr__pfet_01v8 L=0.15U W=0.42U AS=0.0882P
+ AD=0.1113P PS=0.84U PD=1.37U
* device instance $3001 r0 *1 49.945,65.835 sky130_fd_pr__pfet_01v8
M$3001 37 1165 1166 1166 sky130_fd_pr__pfet_01v8 L=0.15U W=0.64U AS=0.1728P
+ AD=0.154P PS=1.82U PD=1.335U
* device instance $3002 r0 *1 50.43,66.015 sky130_fd_pr__pfet_01v8
M$3002 1134 1165 37 37 sky130_fd_pr__pfet_01v8 L=0.15U W=1U AS=0.154P AD=0.28P
+ PS=1.335U PD=2.56U
* device instance $3003 r0 *1 60.34,65.725 sky130_fd_pr__pfet_01v8
M$3003 1167 1024 37 37 sky130_fd_pr__pfet_01v8 L=0.15U W=0.42U AS=0.1113P
+ AD=0.0609P PS=1.37U PD=0.71U
* device instance $3004 r0 *1 60.78,65.725 sky130_fd_pr__pfet_01v8
M$3004 37 1052 1167 1167 sky130_fd_pr__pfet_01v8 L=0.15U W=0.42U AS=0.0609P
+ AD=0.1841P PS=0.71U PD=1.26U
* device instance $3005 r0 *1 61.55,65.835 sky130_fd_pr__pfet_01v8
M$3005 1168 1167 37 37 sky130_fd_pr__pfet_01v8 L=0.15U W=0.64U AS=0.1841P
+ AD=0.1696P PS=1.26U PD=1.81U
* device instance $3006 r0 *1 62.61,66.015 sky130_fd_pr__pfet_01v8
M$3006 1196 1039 1169 1169 sky130_fd_pr__pfet_01v8 L=0.15U W=1U AS=0.26P
+ AD=0.135P PS=2.52U PD=1.27U
* device instance $3007 r0 *1 63.03,66.015 sky130_fd_pr__pfet_01v8
M$3007 37 1168 1196 1196 sky130_fd_pr__pfet_01v8 L=0.15U W=1U AS=0.135P
+ AD=0.135P PS=1.27U PD=1.27U
* device instance $3008 r0 *1 63.45,66.015 sky130_fd_pr__pfet_01v8
M$3008 1170 1168 37 37 sky130_fd_pr__pfet_01v8 L=0.15U W=1U AS=0.135P AD=0.135P
+ PS=1.27U PD=1.27U
* device instance $3009 r0 *1 63.87,66.015 sky130_fd_pr__pfet_01v8
M$3009 37 1039 1170 1170 sky130_fd_pr__pfet_01v8 L=0.15U W=1U AS=0.135P
+ AD=0.26P PS=1.27U PD=2.52U
* device instance $3010 r0 *1 64.81,66.015 sky130_fd_pr__pfet_01v8
M$3010 1191 1169 1170 1170 sky130_fd_pr__pfet_01v8 L=0.15U W=1U AS=0.26P
+ AD=0.3P PS=2.52U PD=2.6U
* device instance $3011 r0 *1 67.15,65.835 sky130_fd_pr__pfet_01v8
M$3011 1195 1192 1173 1173 sky130_fd_pr__pfet_01v8 L=0.15U W=0.64U AS=0.1664P
+ AD=0.0672P PS=1.8U PD=0.85U
* device instance $3012 r0 *1 67.51,65.835 sky130_fd_pr__pfet_01v8
M$3012 37 1174 1195 1195 sky130_fd_pr__pfet_01v8 L=0.15U W=0.64U AS=0.0672P
+ AD=0.1664P PS=0.85U PD=1.8U
* device instance $3013 r0 *1 70.175,65.725 sky130_fd_pr__pfet_01v8
M$3013 1175 1172 1173 1173 sky130_fd_pr__pfet_01v8 L=0.15U W=0.42U AS=0.15985P
+ AD=0.06405P PS=1.265U PD=0.725U
* device instance $3014 r0 *1 70.63,65.725 sky130_fd_pr__pfet_01v8
M$3014 1181 1171 1175 1175 sky130_fd_pr__pfet_01v8 L=0.15U W=0.42U AS=0.06405P
+ AD=0.07665P PS=0.725U PD=0.785U
* device instance $3015 r0 *1 71.145,65.725 sky130_fd_pr__pfet_01v8
M$3015 37 1176 1181 1181 sky130_fd_pr__pfet_01v8 L=0.15U W=0.42U AS=0.07665P
+ AD=0.178875P PS=0.785U PD=1.26U
* device instance $3016 r0 *1 68.45,65.835 sky130_fd_pr__pfet_01v8
M$3016 37 409 1174 1174 sky130_fd_pr__pfet_01v8 L=0.15U W=0.64U AS=0.1664P
+ AD=0.0928P PS=1.8U PD=0.93U
* device instance $3017 r0 *1 68.89,65.835 sky130_fd_pr__pfet_01v8
M$3017 1194 409 37 37 sky130_fd_pr__pfet_01v8 L=0.15U W=0.64U AS=0.0928P
+ AD=0.1152P PS=0.93U PD=1U
* device instance $3018 r0 *1 69.4,65.835 sky130_fd_pr__pfet_01v8
M$3018 1173 1178 1194 1194 sky130_fd_pr__pfet_01v8 L=0.15U W=0.64U AS=0.1152P
+ AD=0.15985P PS=1U PD=1.265U
* device instance $3019 r0 *1 71.805,65.89 sky130_fd_pr__pfet_01v8
M$3019 1176 1175 37 37 sky130_fd_pr__pfet_01v8 L=0.15U W=0.75U AS=0.178875P
+ AD=0.195P PS=1.26U PD=2.02U
* device instance $3020 r0 *1 72.745,65.725 sky130_fd_pr__pfet_01v8
M$3020 1180 1176 37 37 sky130_fd_pr__pfet_01v8 L=0.15U W=0.42U AS=0.1092P
+ AD=0.06405P PS=1.36U PD=0.725U
* device instance $3021 r0 *1 73.2,65.725 sky130_fd_pr__pfet_01v8
M$3021 1177 1171 1180 1180 sky130_fd_pr__pfet_01v8 L=0.15U W=0.42U AS=0.06405P
+ AD=0.0567P PS=0.725U PD=0.69U
* device instance $3022 r0 *1 73.62,65.725 sky130_fd_pr__pfet_01v8
M$3022 1179 1172 1177 1177 sky130_fd_pr__pfet_01v8 L=0.15U W=0.42U AS=0.0567P
+ AD=0.0882P PS=0.69U PD=0.84U
* device instance $3023 r0 *1 74.19,65.725 sky130_fd_pr__pfet_01v8
M$3023 37 1178 1179 1179 sky130_fd_pr__pfet_01v8 L=0.15U W=0.42U AS=0.0882P
+ AD=0.1113P PS=0.84U PD=1.37U
* device instance $3024 r0 *1 75.245,65.835 sky130_fd_pr__pfet_01v8
M$3024 37 1177 1178 1178 sky130_fd_pr__pfet_01v8 L=0.15U W=0.64U AS=0.1728P
+ AD=0.154P PS=1.82U PD=1.335U
* device instance $3025 r0 *1 75.73,66.015 sky130_fd_pr__pfet_01v8
M$3025 1132 1177 37 37 sky130_fd_pr__pfet_01v8 L=0.15U W=1U AS=0.154P AD=0.28P
+ PS=1.335U PD=2.56U
* device instance $3026 r0 *1 5.55,69.985 sky130_fd_pr__pfet_01v8
M$3026 37 1200 1291 1291 sky130_fd_pr__pfet_01v8 L=0.15U W=2U AS=0.415P
+ AD=0.275P PS=3.83U PD=2.55U
* device instance $3027 r0 *1 5.98,69.985 sky130_fd_pr__pfet_01v8
M$3027 1291 1229 37 37 sky130_fd_pr__pfet_01v8 L=0.15U W=2U AS=0.28P AD=0.275P
+ PS=2.56U PD=2.55U
* device instance $3030 r0 *1 7.25,69.985 sky130_fd_pr__pfet_01v8
M$3030 1145 1128 1291 1291 sky130_fd_pr__pfet_01v8 L=0.15U W=2U AS=0.27P
+ AD=0.495P PS=2.54U PD=3.99U
* device instance $3032 r0 *1 8.75,70.135 sky130_fd_pr__pfet_01v8
M$3032 37 681 1230 1230 sky130_fd_pr__pfet_01v8 L=0.15U W=0.64U AS=0.1664P
+ AD=0.0864P PS=1.8U PD=0.91U
* device instance $3033 r0 *1 9.17,70.135 sky130_fd_pr__pfet_01v8
M$3033 1231 1230 37 37 sky130_fd_pr__pfet_01v8 L=0.15U W=0.64U AS=0.0864P
+ AD=0.1664P PS=0.91U PD=1.8U
* device instance $3034 r0 *1 10.11,70.275 sky130_fd_pr__pfet_01v8
M$3034 1232 1146 37 37 sky130_fd_pr__pfet_01v8 L=0.15U W=0.42U AS=0.1092P
+ AD=0.05775P PS=1.36U PD=0.695U
* device instance $3035 r0 *1 10.535,70.275 sky130_fd_pr__pfet_01v8
M$3035 1233 1231 1232 1232 sky130_fd_pr__pfet_01v8 L=0.15U W=0.42U AS=0.05775P
+ AD=0.06825P PS=0.695U PD=0.745U
* device instance $3036 r0 *1 11.01,70.275 sky130_fd_pr__pfet_01v8
M$3036 1295 1230 1233 1233 sky130_fd_pr__pfet_01v8 L=0.15U W=0.42U AS=0.06825P
+ AD=0.07665P PS=0.745U PD=0.785U
* device instance $3037 r0 *1 11.525,70.275 sky130_fd_pr__pfet_01v8
M$3037 1295 1234 37 37 sky130_fd_pr__pfet_01v8 L=0.15U W=0.42U AS=0.178875P
+ AD=0.07665P PS=1.26U PD=0.785U
* device instance $3038 r0 *1 12.185,70.11 sky130_fd_pr__pfet_01v8
M$3038 1234 1233 37 37 sky130_fd_pr__pfet_01v8 L=0.15U W=0.75U AS=0.178875P
+ AD=0.1095P PS=1.26U PD=1.075U
* device instance $3039 r0 *1 12.66,70.275 sky130_fd_pr__pfet_01v8
M$3039 1235 1230 1234 1234 sky130_fd_pr__pfet_01v8 L=0.15U W=0.42U AS=0.1095P
+ AD=0.0567P PS=1.075U PD=0.69U
* device instance $3040 r0 *1 13.08,70.275 sky130_fd_pr__pfet_01v8
M$3040 1296 1231 1235 1235 sky130_fd_pr__pfet_01v8 L=0.15U W=0.42U AS=0.0567P
+ AD=0.0882P PS=0.69U PD=0.84U
* device instance $3041 r0 *1 13.65,70.275 sky130_fd_pr__pfet_01v8
M$3041 37 1236 1296 1296 sky130_fd_pr__pfet_01v8 L=0.15U W=0.42U AS=0.0882P
+ AD=0.1113P PS=0.84U PD=1.37U
* device instance $3042 r0 *1 14.7,69.985 sky130_fd_pr__pfet_01v8
M$3042 37 1235 1236 1236 sky130_fd_pr__pfet_01v8 L=0.15U W=1U AS=0.27P
+ AD=0.135P PS=2.54U PD=1.27U
* device instance $3043 r0 *1 15.12,69.985 sky130_fd_pr__pfet_01v8
M$3043 1187 1236 37 37 sky130_fd_pr__pfet_01v8 L=0.15U W=1U AS=0.135P AD=0.26P
+ PS=1.27U PD=2.52U
* device instance $3044 r0 *1 15.83,65.935 sky130_fd_pr__pfet_01v8
M$3044 1148 1187 37 37 sky130_fd_pr__pfet_01v8 L=0.15U W=0.42U AS=0.1176P
+ AD=0.0567P PS=1.4U PD=0.69U
* device instance $3045 r0 *1 16.25,65.935 sky130_fd_pr__pfet_01v8
M$3045 1148 1101 37 37 sky130_fd_pr__pfet_01v8 L=0.15U W=0.42U AS=0.16655P
+ AD=0.0567P PS=1.39U PD=0.69U
* device instance $3046 r0 *1 16.79,66.015 sky130_fd_pr__pfet_01v8
M$3046 1229 1148 37 37 sky130_fd_pr__pfet_01v8 L=0.15U W=1U AS=0.16655P
+ AD=0.475P PS=1.39U PD=2.95U
* device instance $3047 r0 *1 22.09,70.135 sky130_fd_pr__pfet_01v8
M$3047 37 681 1237 1237 sky130_fd_pr__pfet_01v8 L=0.15U W=0.64U AS=0.1664P
+ AD=0.0864P PS=1.8U PD=0.91U
* device instance $3048 r0 *1 22.51,70.135 sky130_fd_pr__pfet_01v8
M$3048 1238 1237 37 37 sky130_fd_pr__pfet_01v8 L=0.15U W=0.64U AS=0.0864P
+ AD=0.1664P PS=0.91U PD=1.8U
* device instance $3049 r0 *1 23.45,70.165 sky130_fd_pr__pfet_01v8
M$3049 1297 1274 1239 1239 sky130_fd_pr__pfet_01v8 L=0.15U W=0.64U AS=0.1664P
+ AD=0.0672P PS=1.8U PD=0.85U
* device instance $3050 r0 *1 23.81,70.165 sky130_fd_pr__pfet_01v8
M$3050 37 1240 1297 1297 sky130_fd_pr__pfet_01v8 L=0.15U W=0.64U AS=0.0672P
+ AD=0.1664P PS=0.85U PD=1.8U
* device instance $3051 r0 *1 24.75,70.165 sky130_fd_pr__pfet_01v8
M$3051 37 409 1240 1240 sky130_fd_pr__pfet_01v8 L=0.15U W=0.64U AS=0.1664P
+ AD=0.0928P PS=1.8U PD=0.93U
* device instance $3052 r0 *1 25.19,70.165 sky130_fd_pr__pfet_01v8
M$3052 1298 409 37 37 sky130_fd_pr__pfet_01v8 L=0.15U W=0.64U AS=0.0928P
+ AD=0.1152P PS=0.93U PD=1U
* device instance $3053 r0 *1 25.7,70.165 sky130_fd_pr__pfet_01v8
M$3053 1239 1275 1298 1298 sky130_fd_pr__pfet_01v8 L=0.15U W=0.64U AS=0.1152P
+ AD=0.15985P PS=1U PD=1.265U
* device instance $3054 r0 *1 26.475,70.275 sky130_fd_pr__pfet_01v8
M$3054 1241 1238 1239 1239 sky130_fd_pr__pfet_01v8 L=0.15U W=0.42U AS=0.15985P
+ AD=0.06405P PS=1.265U PD=0.725U
* device instance $3055 r0 *1 26.93,70.275 sky130_fd_pr__pfet_01v8
M$3055 1299 1237 1241 1241 sky130_fd_pr__pfet_01v8 L=0.15U W=0.42U AS=0.06405P
+ AD=0.07665P PS=0.725U PD=0.785U
* device instance $3056 r0 *1 27.445,70.275 sky130_fd_pr__pfet_01v8
M$3056 1299 1242 37 37 sky130_fd_pr__pfet_01v8 L=0.15U W=0.42U AS=0.178875P
+ AD=0.07665P PS=1.26U PD=0.785U
* device instance $3057 r0 *1 28.105,70.11 sky130_fd_pr__pfet_01v8
M$3057 1242 1241 37 37 sky130_fd_pr__pfet_01v8 L=0.15U W=0.75U AS=0.178875P
+ AD=0.195P PS=1.26U PD=2.02U
* device instance $3058 r0 *1 29.045,70.275 sky130_fd_pr__pfet_01v8
M$3058 1301 1242 37 37 sky130_fd_pr__pfet_01v8 L=0.15U W=0.42U AS=0.1092P
+ AD=0.06405P PS=1.36U PD=0.725U
* device instance $3059 r0 *1 29.5,70.275 sky130_fd_pr__pfet_01v8
M$3059 1243 1237 1301 1301 sky130_fd_pr__pfet_01v8 L=0.15U W=0.42U AS=0.06405P
+ AD=0.0567P PS=0.725U PD=0.69U
* device instance $3060 r0 *1 29.92,70.275 sky130_fd_pr__pfet_01v8
M$3060 1302 1238 1243 1243 sky130_fd_pr__pfet_01v8 L=0.15U W=0.42U AS=0.0567P
+ AD=0.0882P PS=0.69U PD=0.84U
* device instance $3061 r0 *1 30.49,70.275 sky130_fd_pr__pfet_01v8
M$3061 37 1275 1302 1302 sky130_fd_pr__pfet_01v8 L=0.15U W=0.42U AS=0.0882P
+ AD=0.1113P PS=0.84U PD=1.37U
* device instance $3062 r0 *1 31.545,70.165 sky130_fd_pr__pfet_01v8
M$3062 1275 1243 37 37 sky130_fd_pr__pfet_01v8 L=0.15U W=0.64U AS=0.154P
+ AD=0.1728P PS=1.335U PD=1.82U
* device instance $3063 r0 *1 32.03,69.985 sky130_fd_pr__pfet_01v8
M$3063 893 1243 37 37 sky130_fd_pr__pfet_01v8 L=0.15U W=1U AS=0.154P AD=0.28P
+ PS=1.335U PD=2.56U
* device instance $3064 r0 *1 33.13,69.985 sky130_fd_pr__pfet_01v8
M$3064 37 999 1244 1244 sky130_fd_pr__pfet_01v8 L=0.15U W=1U AS=0.26P AD=0.135P
+ PS=2.52U PD=1.27U
* device instance $3065 r0 *1 33.55,69.985 sky130_fd_pr__pfet_01v8
M$3065 1203 1244 37 37 sky130_fd_pr__pfet_01v8 L=0.15U W=4U AS=0.54P AD=0.665P
+ PS=5.08U PD=6.33U
* device instance $3069 r0 *1 40.49,65.865 sky130_fd_pr__pfet_01v8
M$3069 37 979 1159 1159 sky130_fd_pr__pfet_01v8 L=0.15U W=0.64U AS=0.1664P
+ AD=0.0864P PS=1.8U PD=0.91U
* device instance $3070 r0 *1 40.91,65.865 sky130_fd_pr__pfet_01v8
M$3070 1160 1159 37 37 sky130_fd_pr__pfet_01v8 L=0.15U W=0.64U AS=0.0864P
+ AD=0.1664P PS=0.91U PD=1.8U
* device instance $3071 r0 *1 40.51,69.985 sky130_fd_pr__pfet_01v8
M$3071 845 1276 37 37 sky130_fd_pr__pfet_01v8 L=0.15U W=1U AS=0.26P AD=0.135P
+ PS=2.52U PD=1.27U
* device instance $3072 r0 *1 40.93,69.985 sky130_fd_pr__pfet_01v8
M$3072 37 64 845 845 sky130_fd_pr__pfet_01v8 L=0.15U W=1U AS=0.135P AD=0.26P
+ PS=1.27U PD=2.52U
* device instance $3073 r0 *1 41.94,70.275 sky130_fd_pr__pfet_01v8
M$3073 1245 1286 37 37 sky130_fd_pr__pfet_01v8 L=0.15U W=0.42U AS=0.1113P
+ AD=0.0609P PS=1.37U PD=0.71U
* device instance $3074 r0 *1 42.38,70.275 sky130_fd_pr__pfet_01v8
M$3074 1245 115 37 37 sky130_fd_pr__pfet_01v8 L=0.15U W=0.42U AS=0.1841P
+ AD=0.0609P PS=1.26U PD=0.71U
* device instance $3075 r0 *1 43.15,70.165 sky130_fd_pr__pfet_01v8
M$3075 1189 1245 37 37 sky130_fd_pr__pfet_01v8 L=0.15U W=0.64U AS=0.1841P
+ AD=0.1696P PS=1.26U PD=1.81U
* device instance $3076 r0 *1 44.63,70.135 sky130_fd_pr__pfet_01v8
M$3076 37 979 1246 1246 sky130_fd_pr__pfet_01v8 L=0.15U W=0.64U AS=0.1664P
+ AD=0.0864P PS=1.8U PD=0.91U
* device instance $3077 r0 *1 45.05,70.135 sky130_fd_pr__pfet_01v8
M$3077 1247 1246 37 37 sky130_fd_pr__pfet_01v8 L=0.15U W=0.64U AS=0.0864P
+ AD=0.1664P PS=0.91U PD=1.8U
* device instance $3078 r0 *1 45.99,70.165 sky130_fd_pr__pfet_01v8
M$3078 1306 1204 1248 1248 sky130_fd_pr__pfet_01v8 L=0.15U W=0.64U AS=0.1664P
+ AD=0.0672P PS=1.8U PD=0.85U
* device instance $3079 r0 *1 46.35,70.165 sky130_fd_pr__pfet_01v8
M$3079 37 1249 1306 1306 sky130_fd_pr__pfet_01v8 L=0.15U W=0.64U AS=0.0672P
+ AD=0.1664P PS=0.85U PD=1.8U
* device instance $3080 r0 *1 47.29,70.165 sky130_fd_pr__pfet_01v8
M$3080 37 302 1249 1249 sky130_fd_pr__pfet_01v8 L=0.15U W=0.64U AS=0.1664P
+ AD=0.0928P PS=1.8U PD=0.93U
* device instance $3081 r0 *1 47.73,70.165 sky130_fd_pr__pfet_01v8
M$3081 1305 302 37 37 sky130_fd_pr__pfet_01v8 L=0.15U W=0.64U AS=0.0928P
+ AD=0.1152P PS=0.93U PD=1U
* device instance $3082 r0 *1 48.24,70.165 sky130_fd_pr__pfet_01v8
M$3082 1248 1277 1305 1305 sky130_fd_pr__pfet_01v8 L=0.15U W=0.64U AS=0.1152P
+ AD=0.15985P PS=1U PD=1.265U
* device instance $3083 r0 *1 49.015,70.275 sky130_fd_pr__pfet_01v8
M$3083 1250 1247 1248 1248 sky130_fd_pr__pfet_01v8 L=0.15U W=0.42U AS=0.15985P
+ AD=0.06405P PS=1.265U PD=0.725U
* device instance $3084 r0 *1 49.47,70.275 sky130_fd_pr__pfet_01v8
M$3084 1304 1246 1250 1250 sky130_fd_pr__pfet_01v8 L=0.15U W=0.42U AS=0.06405P
+ AD=0.07665P PS=0.725U PD=0.785U
* device instance $3085 r0 *1 49.985,70.275 sky130_fd_pr__pfet_01v8
M$3085 1304 1251 37 37 sky130_fd_pr__pfet_01v8 L=0.15U W=0.42U AS=0.178875P
+ AD=0.07665P PS=1.26U PD=0.785U
* device instance $3086 r0 *1 50.645,70.11 sky130_fd_pr__pfet_01v8
M$3086 1251 1250 37 37 sky130_fd_pr__pfet_01v8 L=0.15U W=0.75U AS=0.178875P
+ AD=0.195P PS=1.26U PD=2.02U
* device instance $3087 r0 *1 51.585,70.275 sky130_fd_pr__pfet_01v8
M$3087 1303 1251 37 37 sky130_fd_pr__pfet_01v8 L=0.15U W=0.42U AS=0.1092P
+ AD=0.06405P PS=1.36U PD=0.725U
* device instance $3088 r0 *1 52.04,70.275 sky130_fd_pr__pfet_01v8
M$3088 1252 1246 1303 1303 sky130_fd_pr__pfet_01v8 L=0.15U W=0.42U AS=0.06405P
+ AD=0.0567P PS=0.725U PD=0.69U
* device instance $3089 r0 *1 52.46,70.275 sky130_fd_pr__pfet_01v8
M$3089 1300 1247 1252 1252 sky130_fd_pr__pfet_01v8 L=0.15U W=0.42U AS=0.0567P
+ AD=0.0882P PS=0.69U PD=0.84U
* device instance $3090 r0 *1 53.03,70.275 sky130_fd_pr__pfet_01v8
M$3090 37 1277 1300 1300 sky130_fd_pr__pfet_01v8 L=0.15U W=0.42U AS=0.0882P
+ AD=0.1113P PS=0.84U PD=1.37U
* device instance $3091 r0 *1 54.085,70.165 sky130_fd_pr__pfet_01v8
M$3091 1277 1252 37 37 sky130_fd_pr__pfet_01v8 L=0.15U W=0.64U AS=0.154P
+ AD=0.1728P PS=1.335U PD=1.82U
* device instance $3092 r0 *1 54.57,69.985 sky130_fd_pr__pfet_01v8
M$3092 1114 1252 37 37 sky130_fd_pr__pfet_01v8 L=0.15U W=1U AS=0.154P AD=0.28P
+ PS=1.335U PD=2.56U
* device instance $3093 r0 *1 57.12,70.275 sky130_fd_pr__pfet_01v8
M$3093 1253 1287 37 37 sky130_fd_pr__pfet_01v8 L=0.15U W=0.42U AS=0.1113P
+ AD=0.0609P PS=1.37U PD=0.71U
* device instance $3094 r0 *1 57.56,70.275 sky130_fd_pr__pfet_01v8
M$3094 1253 115 37 37 sky130_fd_pr__pfet_01v8 L=0.15U W=0.42U AS=0.1841P
+ AD=0.0609P PS=1.26U PD=0.71U
* device instance $3095 r0 *1 58.33,70.165 sky130_fd_pr__pfet_01v8
M$3095 1025 1253 37 37 sky130_fd_pr__pfet_01v8 L=0.15U W=0.64U AS=0.1841P
+ AD=0.1696P PS=1.26U PD=1.81U
* device instance $3096 r0 *1 60.27,69.985 sky130_fd_pr__pfet_01v8
M$3096 1292 1278 1254 1254 sky130_fd_pr__pfet_01v8 L=0.15U W=1U AS=0.26P
+ AD=0.135P PS=2.52U PD=1.27U
* device instance $3097 r0 *1 60.69,69.985 sky130_fd_pr__pfet_01v8
M$3097 1288 1279 1292 1292 sky130_fd_pr__pfet_01v8 L=0.15U W=1U AS=0.135P
+ AD=0.135P PS=1.27U PD=1.27U
* device instance $3098 r0 *1 61.11,69.985 sky130_fd_pr__pfet_01v8
M$3098 1292 92 1288 1288 sky130_fd_pr__pfet_01v8 L=0.15U W=1U AS=0.135P
+ AD=0.26P PS=1.27U PD=2.52U
* device instance $3099 r0 *1 62.05,69.985 sky130_fd_pr__pfet_01v8
M$3099 1288 1021 37 37 sky130_fd_pr__pfet_01v8 L=0.15U W=1U AS=0.26P AD=0.165P
+ PS=2.52U PD=1.33U
* device instance $3100 r0 *1 62.53,69.985 sky130_fd_pr__pfet_01v8
M$3100 37 1191 1288 1288 sky130_fd_pr__pfet_01v8 L=0.15U W=1U AS=0.165P
+ AD=0.1575P PS=1.33U PD=1.315U
* device instance $3101 r0 *1 62.995,69.985 sky130_fd_pr__pfet_01v8
M$3101 1289 1254 37 37 sky130_fd_pr__pfet_01v8 L=0.15U W=1U AS=0.1575P AD=0.26P
+ PS=1.315U PD=2.52U
* device instance $3102 r0 *1 63.95,69.695 sky130_fd_pr__pfet_01v8
M$3102 37 1132 1255 1255 sky130_fd_pr__pfet_01v8 L=0.15U W=0.42U AS=0.1092P
+ AD=0.14575P PS=1.36U PD=1.335U
* device instance $3103 r0 *1 64.435,69.985 sky130_fd_pr__pfet_01v8
M$3103 1024 1131 37 37 sky130_fd_pr__pfet_01v8 L=0.15U W=1U AS=0.14575P
+ AD=0.135P PS=1.335U PD=1.27U
* device instance $3104 r0 *1 64.855,69.985 sky130_fd_pr__pfet_01v8
M$3104 37 1255 1024 1024 sky130_fd_pr__pfet_01v8 L=0.15U W=1U AS=0.135P
+ AD=0.265P PS=1.27U PD=2.53U
* device instance $3105 r0 *1 65.79,65.865 sky130_fd_pr__pfet_01v8
M$3105 37 979 1171 1171 sky130_fd_pr__pfet_01v8 L=0.15U W=0.64U AS=0.1664P
+ AD=0.0864P PS=1.8U PD=0.91U
* device instance $3106 r0 *1 66.21,65.865 sky130_fd_pr__pfet_01v8
M$3106 1172 1171 37 37 sky130_fd_pr__pfet_01v8 L=0.15U W=0.64U AS=0.0864P
+ AD=0.1664P PS=0.91U PD=1.8U
* device instance $3107 r0 *1 68.175,70.08 sky130_fd_pr__pfet_01v8
M$3107 1294 64 37 37 sky130_fd_pr__pfet_01v8 L=0.15U W=0.42U AS=0.15835P
+ AD=0.07665P PS=1.395U PD=0.785U
* device instance $3108 r0 *1 68.69,70.08 sky130_fd_pr__pfet_01v8
M$3108 1256 1131 1294 1294 sky130_fd_pr__pfet_01v8 L=0.15U W=0.42U AS=0.07665P
+ AD=0.1932P PS=0.785U PD=1.34U
* device instance $3109 r0 *1 69.76,70.08 sky130_fd_pr__pfet_01v8
M$3109 1293 1290 1256 1256 sky130_fd_pr__pfet_01v8 L=0.15U W=0.42U AS=0.1932P
+ AD=0.0441P PS=1.34U PD=0.63U
* device instance $3110 r0 *1 70.12,70.08 sky130_fd_pr__pfet_01v8
M$3110 37 1257 1293 1293 sky130_fd_pr__pfet_01v8 L=0.15U W=0.42U AS=0.0441P
+ AD=0.0693P PS=0.63U PD=0.75U
* device instance $3111 r0 *1 70.6,70.08 sky130_fd_pr__pfet_01v8
M$3111 1257 64 37 37 sky130_fd_pr__pfet_01v8 L=0.15U W=0.42U AS=0.0693P
+ AD=0.1176P PS=0.75U PD=1.4U
* device instance $3112 r0 *1 67.63,69.985 sky130_fd_pr__pfet_01v8
M$3112 37 1256 1192 1192 sky130_fd_pr__pfet_01v8 L=0.15U W=1U AS=0.26P
+ AD=0.15835P PS=2.52U PD=1.395U
* device instance $3113 r0 *1 8.29,71.305 sky130_fd_pr__pfet_01v8
M$3113 37 681 1307 1307 sky130_fd_pr__pfet_01v8 L=0.15U W=0.64U AS=0.1664P
+ AD=0.0864P PS=1.8U PD=0.91U
* device instance $3114 r0 *1 8.71,71.305 sky130_fd_pr__pfet_01v8
M$3114 1308 1307 37 37 sky130_fd_pr__pfet_01v8 L=0.15U W=0.64U AS=0.0864P
+ AD=0.1664P PS=0.91U PD=1.8U
* device instance $3115 r0 *1 9.65,71.165 sky130_fd_pr__pfet_01v8
M$3115 1309 1098 37 37 sky130_fd_pr__pfet_01v8 L=0.15U W=0.42U AS=0.1092P
+ AD=0.05775P PS=1.36U PD=0.695U
* device instance $3116 r0 *1 10.075,71.165 sky130_fd_pr__pfet_01v8
M$3116 1310 1308 1309 1309 sky130_fd_pr__pfet_01v8 L=0.15U W=0.42U AS=0.05775P
+ AD=0.06825P PS=0.695U PD=0.745U
* device instance $3117 r0 *1 10.55,71.165 sky130_fd_pr__pfet_01v8
M$3117 1328 1307 1310 1310 sky130_fd_pr__pfet_01v8 L=0.15U W=0.42U AS=0.06825P
+ AD=0.07665P PS=0.745U PD=0.785U
* device instance $3118 r0 *1 11.065,71.165 sky130_fd_pr__pfet_01v8
M$3118 37 1311 1328 1328 sky130_fd_pr__pfet_01v8 L=0.15U W=0.42U AS=0.07665P
+ AD=0.178875P PS=0.785U PD=1.26U
* device instance $3119 r0 *1 12.2,71.165 sky130_fd_pr__pfet_01v8
M$3119 1312 1307 1311 1311 sky130_fd_pr__pfet_01v8 L=0.15U W=0.42U AS=0.1095P
+ AD=0.0567P PS=1.075U PD=0.69U
* device instance $3120 r0 *1 12.62,71.165 sky130_fd_pr__pfet_01v8
M$3120 1329 1308 1312 1312 sky130_fd_pr__pfet_01v8 L=0.15U W=0.42U AS=0.0567P
+ AD=0.0882P PS=0.69U PD=0.84U
* device instance $3121 r0 *1 13.19,71.165 sky130_fd_pr__pfet_01v8
M$3121 37 1313 1329 1329 sky130_fd_pr__pfet_01v8 L=0.15U W=0.42U AS=0.0882P
+ AD=0.1113P PS=0.84U PD=1.37U
* device instance $3122 r0 *1 11.725,71.33 sky130_fd_pr__pfet_01v8
M$3122 1311 1310 37 37 sky130_fd_pr__pfet_01v8 L=0.15U W=0.75U AS=0.178875P
+ AD=0.1095P PS=1.26U PD=1.075U
* device instance $3123 r0 *1 14.24,71.455 sky130_fd_pr__pfet_01v8
M$3123 37 1312 1313 1313 sky130_fd_pr__pfet_01v8 L=0.15U W=1U AS=0.27P
+ AD=0.135P PS=2.54U PD=1.27U
* device instance $3124 r0 *1 14.66,71.455 sky130_fd_pr__pfet_01v8
M$3124 1130 1313 37 37 sky130_fd_pr__pfet_01v8 L=0.15U W=1U AS=0.135P AD=0.26P
+ PS=1.27U PD=2.52U
* device instance $3125 r0 *1 26.775,71.36 sky130_fd_pr__pfet_01v8
M$3125 1330 64 37 37 sky130_fd_pr__pfet_01v8 L=0.15U W=0.42U AS=0.15835P
+ AD=0.07665P PS=1.395U PD=0.785U
* device instance $3126 r0 *1 27.29,71.36 sky130_fd_pr__pfet_01v8
M$3126 1314 993 1330 1330 sky130_fd_pr__pfet_01v8 L=0.15U W=0.42U AS=0.07665P
+ AD=0.1932P PS=0.785U PD=1.34U
* device instance $3127 r0 *1 28.36,71.36 sky130_fd_pr__pfet_01v8
M$3127 1331 1315 1314 1314 sky130_fd_pr__pfet_01v8 L=0.15U W=0.42U AS=0.1932P
+ AD=0.0441P PS=1.34U PD=0.63U
* device instance $3128 r0 *1 28.72,71.36 sky130_fd_pr__pfet_01v8
M$3128 37 1339 1331 1331 sky130_fd_pr__pfet_01v8 L=0.15U W=0.42U AS=0.0441P
+ AD=0.0693P PS=0.63U PD=0.75U
* device instance $3129 r0 *1 29.2,71.36 sky130_fd_pr__pfet_01v8
M$3129 1339 64 37 37 sky130_fd_pr__pfet_01v8 L=0.15U W=0.42U AS=0.0693P
+ AD=0.1176P PS=0.75U PD=1.4U
* device instance $3130 r0 *1 26.23,71.455 sky130_fd_pr__pfet_01v8
M$3130 37 1314 1274 1274 sky130_fd_pr__pfet_01v8 L=0.15U W=1U AS=0.26P
+ AD=0.15835P PS=2.52U PD=1.395U
* device instance $3131 r0 *1 45.175,71.36 sky130_fd_pr__pfet_01v8
M$3131 1332 64 37 37 sky130_fd_pr__pfet_01v8 L=0.15U W=0.42U AS=0.15835P
+ AD=0.07665P PS=1.395U PD=0.785U
* device instance $3132 r0 *1 45.69,71.36 sky130_fd_pr__pfet_01v8
M$3132 1316 1114 1332 1332 sky130_fd_pr__pfet_01v8 L=0.15U W=0.42U AS=0.07665P
+ AD=0.1932P PS=0.785U PD=1.34U
* device instance $3133 r0 *1 46.76,71.36 sky130_fd_pr__pfet_01v8
M$3133 1333 1317 1316 1316 sky130_fd_pr__pfet_01v8 L=0.15U W=0.42U AS=0.1932P
+ AD=0.0441P PS=1.34U PD=0.63U
* device instance $3134 r0 *1 47.12,71.36 sky130_fd_pr__pfet_01v8
M$3134 37 1340 1333 1333 sky130_fd_pr__pfet_01v8 L=0.15U W=0.42U AS=0.0441P
+ AD=0.0693P PS=0.63U PD=0.75U
* device instance $3135 r0 *1 47.6,71.36 sky130_fd_pr__pfet_01v8
M$3135 1340 64 37 37 sky130_fd_pr__pfet_01v8 L=0.15U W=0.42U AS=0.0693P
+ AD=0.1176P PS=0.75U PD=1.4U
* device instance $3136 r0 *1 44.63,71.455 sky130_fd_pr__pfet_01v8
M$3136 37 1316 1190 1190 sky130_fd_pr__pfet_01v8 L=0.15U W=1U AS=0.26P
+ AD=0.15835P PS=2.52U PD=1.395U
* device instance $3137 r0 *1 58.5,71.165 sky130_fd_pr__pfet_01v8
M$3137 1319 1318 37 37 sky130_fd_pr__pfet_01v8 L=0.15U W=0.42U AS=0.1113P
+ AD=0.0609P PS=1.37U PD=0.71U
* device instance $3138 r0 *1 58.94,71.165 sky130_fd_pr__pfet_01v8
M$3138 37 115 1319 1319 sky130_fd_pr__pfet_01v8 L=0.15U W=0.42U AS=0.0609P
+ AD=0.1841P PS=0.71U PD=1.26U
* device instance $3139 r0 *1 59.71,71.275 sky130_fd_pr__pfet_01v8
M$3139 1278 1319 37 37 sky130_fd_pr__pfet_01v8 L=0.15U W=0.64U AS=0.1841P
+ AD=0.1696P PS=1.26U PD=1.81U
* device instance $3140 r0 *1 60.73,71.305 sky130_fd_pr__pfet_01v8
M$3140 37 979 1320 1320 sky130_fd_pr__pfet_01v8 L=0.15U W=0.64U AS=0.1664P
+ AD=0.0864P PS=1.8U PD=0.91U
* device instance $3141 r0 *1 61.15,71.305 sky130_fd_pr__pfet_01v8
M$3141 1321 1320 37 37 sky130_fd_pr__pfet_01v8 L=0.15U W=0.64U AS=0.0864P
+ AD=0.1664P PS=0.91U PD=1.8U
* device instance $3142 r0 *1 62.09,71.275 sky130_fd_pr__pfet_01v8
M$3142 1336 1289 1322 1322 sky130_fd_pr__pfet_01v8 L=0.15U W=0.64U AS=0.1664P
+ AD=0.0672P PS=1.8U PD=0.85U
* device instance $3143 r0 *1 62.45,71.275 sky130_fd_pr__pfet_01v8
M$3143 37 1323 1336 1336 sky130_fd_pr__pfet_01v8 L=0.15U W=0.64U AS=0.0672P
+ AD=0.1664P PS=0.85U PD=1.8U
* device instance $3144 r0 *1 65.115,71.165 sky130_fd_pr__pfet_01v8
M$3144 1324 1321 1322 1322 sky130_fd_pr__pfet_01v8 L=0.15U W=0.42U AS=0.15985P
+ AD=0.06405P PS=1.265U PD=0.725U
* device instance $3145 r0 *1 65.57,71.165 sky130_fd_pr__pfet_01v8
M$3145 1338 1320 1324 1324 sky130_fd_pr__pfet_01v8 L=0.15U W=0.42U AS=0.06405P
+ AD=0.07665P PS=0.725U PD=0.785U
* device instance $3146 r0 *1 66.085,71.165 sky130_fd_pr__pfet_01v8
M$3146 37 1325 1338 1338 sky130_fd_pr__pfet_01v8 L=0.15U W=0.42U AS=0.07665P
+ AD=0.178875P PS=0.785U PD=1.26U
* device instance $3147 r0 *1 63.39,71.275 sky130_fd_pr__pfet_01v8
M$3147 37 302 1323 1323 sky130_fd_pr__pfet_01v8 L=0.15U W=0.64U AS=0.1664P
+ AD=0.0928P PS=1.8U PD=0.93U
* device instance $3148 r0 *1 63.83,71.275 sky130_fd_pr__pfet_01v8
M$3148 1337 302 37 37 sky130_fd_pr__pfet_01v8 L=0.15U W=0.64U AS=0.0928P
+ AD=0.1152P PS=0.93U PD=1U
* device instance $3149 r0 *1 64.34,71.275 sky130_fd_pr__pfet_01v8
M$3149 1322 1327 1337 1337 sky130_fd_pr__pfet_01v8 L=0.15U W=0.64U AS=0.1152P
+ AD=0.15985P PS=1U PD=1.265U
* device instance $3150 r0 *1 66.745,71.33 sky130_fd_pr__pfet_01v8
M$3150 1325 1324 37 37 sky130_fd_pr__pfet_01v8 L=0.15U W=0.75U AS=0.178875P
+ AD=0.195P PS=1.26U PD=2.02U
* device instance $3151 r0 *1 65.79,75.425 sky130_fd_pr__pfet_01v8
M$3151 37 1132 1353 1353 sky130_fd_pr__pfet_01v8 L=0.15U W=1U AS=0.26P
+ AD=0.135P PS=2.52U PD=1.27U
* device instance $3152 r0 *1 66.21,75.425 sky130_fd_pr__pfet_01v8
M$3152 1279 1353 37 37 sky130_fd_pr__pfet_01v8 L=0.15U W=4U AS=0.54P AD=0.665P
+ PS=5.08U PD=6.33U
* device instance $3156 r0 *1 67.685,71.165 sky130_fd_pr__pfet_01v8
M$3156 1335 1325 37 37 sky130_fd_pr__pfet_01v8 L=0.15U W=0.42U AS=0.1092P
+ AD=0.06405P PS=1.36U PD=0.725U
* device instance $3157 r0 *1 68.14,71.165 sky130_fd_pr__pfet_01v8
M$3157 1326 1320 1335 1335 sky130_fd_pr__pfet_01v8 L=0.15U W=0.42U AS=0.06405P
+ AD=0.0567P PS=0.725U PD=0.69U
* device instance $3158 r0 *1 68.56,71.165 sky130_fd_pr__pfet_01v8
M$3158 1334 1321 1326 1326 sky130_fd_pr__pfet_01v8 L=0.15U W=0.42U AS=0.0567P
+ AD=0.0882P PS=0.69U PD=0.84U
* device instance $3159 r0 *1 69.13,71.165 sky130_fd_pr__pfet_01v8
M$3159 37 1327 1334 1334 sky130_fd_pr__pfet_01v8 L=0.15U W=0.42U AS=0.0882P
+ AD=0.1113P PS=0.84U PD=1.37U
* device instance $3160 r0 *1 70.185,71.275 sky130_fd_pr__pfet_01v8
M$3160 37 1326 1327 1327 sky130_fd_pr__pfet_01v8 L=0.15U W=0.64U AS=0.1728P
+ AD=0.154P PS=1.82U PD=1.335U
* device instance $3161 r0 *1 70.67,71.455 sky130_fd_pr__pfet_01v8
M$3161 1131 1326 37 37 sky130_fd_pr__pfet_01v8 L=0.15U W=1U AS=0.154P AD=0.28P
+ PS=1.335U PD=2.56U
.ENDS gcd
