* layopt extraction of kestrel_pll_top (sky130)
.SUBCKT kestrel_pll_top
M1 1 9 5 5 sky130_fd_pr__nfet_01v8 L=0.15U W=0.3U AS=0.075P AD=0.15P PS=1.1U PD=1.6U
M2 5 10 4 4 sky130_fd_pr__nfet_01v8 L=0.36U W=4.61U AS=1.1525P AD=2.305P PS=9.72U PD=10.22U
M3 15 12 14 14 sky130_fd_pr__pfet_01v8 L=0.36U W=4.095U AS=1.02375P AD=1.02375P PS=4.595U PD=4.595U
M4 16 13 15 15 sky130_fd_pr__pfet_01v8 L=0.36U W=4.095U AS=1.02375P AD=2.0475P PS=4.595U PD=9.19U
M5 14 11 3 3 sky130_fd_pr__pfet_01v8 L=0.36U W=4.095U AS=1.02375P AD=1.02375P PS=8.69U PD=4.595U
M6 1 17 5 5 sky130_fd_pr__nfet_01v8 L=0.15U W=0.3U AS=0.075P AD=0.15P PS=1.1U PD=1.6U
M7 22 18 21 21 sky130_fd_pr__pfet_01v8 L=0.36U W=4.095U AS=1.02375P AD=1.02375P PS=8.69U PD=4.595U
M8 23 19 22 22 sky130_fd_pr__pfet_01v8 L=0.36U W=4.095U AS=1.02375P AD=1.02375P PS=4.595U PD=4.595U
M9 24 20 23 23 sky130_fd_pr__pfet_01v8 L=0.36U W=4.095U AS=1.02375P AD=2.0475P PS=4.595U PD=9.19U
M10 30 27 29 29 sky130_fd_pr__pfet_01v8 L=0.36U W=4.095U AS=1.02375P AD=2.0475P PS=4.595U PD=9.19U
M11 28 25 3 3 sky130_fd_pr__pfet_01v8 L=0.36U W=4.095U AS=1.02375P AD=1.02375P PS=8.69U PD=4.595U
M12 29 26 28 28 sky130_fd_pr__pfet_01v8 L=0.36U W=4.095U AS=1.02375P AD=1.02375P PS=4.595U PD=4.595U
M13 35 31 34 34 sky130_fd_pr__pfet_01v8 L=0.36U W=4.095U AS=1.02375P AD=1.02375P PS=8.69U PD=4.595U
M14 36 32 35 35 sky130_fd_pr__pfet_01v8 L=0.36U W=4.095U AS=1.02375P AD=1.02375P PS=4.595U PD=4.595U
M15 37 33 36 36 sky130_fd_pr__pfet_01v8 L=0.36U W=4.095U AS=1.02375P AD=2.0475P PS=4.595U PD=9.19U
M16 1 43 39 39 sky130_fd_pr__nfet_01v8 L=0.15U W=0.3U AS=0.075P AD=0.15P PS=1.1U PD=1.6U
M17 39 44 38 38 sky130_fd_pr__nfet_01v8 L=0.36U W=4.61U AS=1.1525P AD=2.305P PS=9.72U PD=10.22U
M18 49 46 48 48 sky130_fd_pr__pfet_01v8 L=0.36U W=4.095U AS=1.02375P AD=1.02375P PS=4.595U PD=4.595U
M19 50 47 49 49 sky130_fd_pr__pfet_01v8 L=0.36U W=4.095U AS=1.02375P AD=2.0475P PS=4.595U PD=9.19U
M20 48 45 3 3 sky130_fd_pr__pfet_01v8 L=0.36U W=4.095U AS=1.02375P AD=1.02375P PS=8.69U PD=4.595U
M21 1 51 39 39 sky130_fd_pr__nfet_01v8 L=0.15U W=0.3U AS=0.075P AD=0.15P PS=1.1U PD=1.6U
M22 56 52 55 55 sky130_fd_pr__pfet_01v8 L=0.36U W=4.095U AS=1.02375P AD=1.02375P PS=8.69U PD=4.595U
M23 57 53 56 56 sky130_fd_pr__pfet_01v8 L=0.36U W=4.095U AS=1.02375P AD=1.02375P PS=4.595U PD=4.595U
M24 58 54 57 57 sky130_fd_pr__pfet_01v8 L=0.36U W=4.095U AS=1.02375P AD=2.0475P PS=4.595U PD=9.19U
M25 64 61 63 63 sky130_fd_pr__pfet_01v8 L=0.36U W=4.095U AS=1.02375P AD=2.0475P PS=4.595U PD=9.19U
M26 62 59 3 3 sky130_fd_pr__pfet_01v8 L=0.36U W=4.095U AS=1.02375P AD=1.02375P PS=8.69U PD=4.595U
M27 63 60 62 62 sky130_fd_pr__pfet_01v8 L=0.36U W=4.095U AS=1.02375P AD=1.02375P PS=4.595U PD=4.595U
M28 69 65 68 68 sky130_fd_pr__pfet_01v8 L=0.36U W=4.095U AS=1.02375P AD=1.02375P PS=8.69U PD=4.595U
M29 70 66 69 69 sky130_fd_pr__pfet_01v8 L=0.36U W=4.095U AS=1.02375P AD=1.02375P PS=4.595U PD=4.595U
M30 71 67 70 70 sky130_fd_pr__pfet_01v8 L=0.36U W=4.095U AS=1.02375P AD=2.0475P PS=4.595U PD=9.19U
M31 1 77 73 73 sky130_fd_pr__nfet_01v8 L=0.15U W=0.3U AS=0.075P AD=0.15P PS=1.1U PD=1.6U
M32 73 78 72 72 sky130_fd_pr__nfet_01v8 L=0.36U W=4.61U AS=1.1525P AD=2.305P PS=9.72U PD=10.22U
M33 83 80 82 82 sky130_fd_pr__pfet_01v8 L=0.36U W=4.095U AS=1.02375P AD=1.02375P PS=4.595U PD=4.595U
M34 84 81 83 83 sky130_fd_pr__pfet_01v8 L=0.36U W=4.095U AS=1.02375P AD=2.0475P PS=4.595U PD=9.19U
M35 82 79 3 3 sky130_fd_pr__pfet_01v8 L=0.36U W=4.095U AS=1.02375P AD=1.02375P PS=8.69U PD=4.595U
M36 1 85 73 73 sky130_fd_pr__nfet_01v8 L=0.15U W=0.3U AS=0.075P AD=0.15P PS=1.1U PD=1.6U
M37 90 86 89 89 sky130_fd_pr__pfet_01v8 L=0.36U W=4.095U AS=1.02375P AD=1.02375P PS=8.69U PD=4.595U
M38 91 87 90 90 sky130_fd_pr__pfet_01v8 L=0.36U W=4.095U AS=1.02375P AD=1.02375P PS=4.595U PD=4.595U
M39 92 88 91 91 sky130_fd_pr__pfet_01v8 L=0.36U W=4.095U AS=1.02375P AD=2.0475P PS=4.595U PD=9.19U
M40 98 95 97 97 sky130_fd_pr__pfet_01v8 L=0.36U W=4.095U AS=1.02375P AD=2.0475P PS=4.595U PD=9.19U
M41 96 93 3 3 sky130_fd_pr__pfet_01v8 L=0.36U W=4.095U AS=1.02375P AD=1.02375P PS=8.69U PD=4.595U
M42 97 94 96 96 sky130_fd_pr__pfet_01v8 L=0.36U W=4.095U AS=1.02375P AD=1.02375P PS=4.595U PD=4.595U
M43 103 99 102 102 sky130_fd_pr__pfet_01v8 L=0.36U W=4.095U AS=1.02375P AD=1.02375P PS=8.69U PD=4.595U
M44 104 100 103 103 sky130_fd_pr__pfet_01v8 L=0.36U W=4.095U AS=1.02375P AD=1.02375P PS=4.595U PD=4.595U
M45 105 101 104 104 sky130_fd_pr__pfet_01v8 L=0.36U W=4.095U AS=1.02375P AD=2.0475P PS=4.595U PD=9.19U
M46 1 111 107 107 sky130_fd_pr__nfet_01v8 L=0.15U W=0.3U AS=0.075P AD=0.15P PS=1.1U PD=1.6U
M47 107 112 106 106 sky130_fd_pr__nfet_01v8 L=0.36U W=4.61U AS=1.1525P AD=2.305P PS=9.72U PD=10.22U
M48 117 114 116 116 sky130_fd_pr__pfet_01v8 L=0.36U W=4.095U AS=1.02375P AD=1.02375P PS=4.595U PD=4.595U
M49 118 115 117 117 sky130_fd_pr__pfet_01v8 L=0.36U W=4.095U AS=1.02375P AD=2.0475P PS=4.595U PD=9.19U
M50 116 113 3 3 sky130_fd_pr__pfet_01v8 L=0.36U W=4.095U AS=1.02375P AD=1.02375P PS=8.69U PD=4.595U
M51 1 119 107 107 sky130_fd_pr__nfet_01v8 L=0.15U W=0.3U AS=0.075P AD=0.15P PS=1.1U PD=1.6U
M52 124 120 123 123 sky130_fd_pr__pfet_01v8 L=0.36U W=4.095U AS=1.02375P AD=1.02375P PS=8.69U PD=4.595U
M53 125 121 124 124 sky130_fd_pr__pfet_01v8 L=0.36U W=4.095U AS=1.02375P AD=1.02375P PS=4.595U PD=4.595U
M54 126 122 125 125 sky130_fd_pr__pfet_01v8 L=0.36U W=4.095U AS=1.02375P AD=2.0475P PS=4.595U PD=9.19U
M55 132 129 131 131 sky130_fd_pr__pfet_01v8 L=0.36U W=4.095U AS=1.02375P AD=2.0475P PS=4.595U PD=9.19U
M56 130 127 3 3 sky130_fd_pr__pfet_01v8 L=0.36U W=4.095U AS=1.02375P AD=1.02375P PS=8.69U PD=4.595U
M57 131 128 130 130 sky130_fd_pr__pfet_01v8 L=0.36U W=4.095U AS=1.02375P AD=1.02375P PS=4.595U PD=4.595U
M58 137 133 136 136 sky130_fd_pr__pfet_01v8 L=0.36U W=4.095U AS=1.02375P AD=1.02375P PS=8.69U PD=4.595U
M59 138 134 137 137 sky130_fd_pr__pfet_01v8 L=0.36U W=4.095U AS=1.02375P AD=1.02375P PS=4.595U PD=4.595U
M60 139 135 138 138 sky130_fd_pr__pfet_01v8 L=0.36U W=4.095U AS=1.02375P AD=2.0475P PS=4.595U PD=9.19U
M61 142 140 141 141 sky130_fd_pr__pfet_01v8 L=0.15U W=1U AS=0.25P AD=0.5P PS=2.5U PD=3U
M62 145 143 144 144 sky130_fd_pr__nfet_01v8 L=0.15U W=0.5U AS=0.125P AD=0.25P PS=1.5U PD=2U
M63 148 146 147 147 sky130_fd_pr__nfet_01v8 L=0.15U W=0.5U AS=0.125P AD=0.25P PS=1.5U PD=2U
M64 151 149 150 150 sky130_fd_pr__nfet_01v8 L=0.15U W=0.5U AS=0.125P AD=0.25P PS=1.5U PD=2U
M65 154 152 153 153 sky130_fd_pr__pfet_01v8 L=0.15U W=1U AS=0.25P AD=0.5P PS=2.5U PD=3U
M66 157 155 156 156 sky130_fd_pr__pfet_01v8 L=0.15U W=1U AS=0.25P AD=0.5P PS=2.5U PD=3U
M67 160 158 159 159 sky130_fd_pr__pfet_01v8 L=0.15U W=1U AS=0.25P AD=0.5P PS=2.5U PD=3U
M68 163 161 162 162 sky130_fd_pr__nfet_01v8 L=0.15U W=0.5U AS=0.125P AD=0.25P PS=1.5U PD=2U
M69 166 164 165 165 sky130_fd_pr__nfet_01v8 L=0.15U W=0.5U AS=0.125P AD=0.25P PS=1.5U PD=2U
M70 169 167 168 168 sky130_fd_pr__nfet_01v8 L=0.15U W=0.5U AS=0.125P AD=0.25P PS=1.5U PD=2U
M71 172 170 171 171 sky130_fd_pr__pfet_01v8 L=0.15U W=1U AS=0.25P AD=0.5P PS=2.5U PD=3U
M72 175 173 174 174 sky130_fd_pr__pfet_01v8 L=0.15U W=1U AS=0.25P AD=0.5P PS=2.5U PD=3U
M73 178 176 177 177 sky130_fd_pr__nfet_01v8 L=0.15U W=0.5U AS=0.125P AD=0.25P PS=1.5U PD=2U
M74 181 179 180 180 sky130_fd_pr__nfet_01v8 L=0.15U W=0.5U AS=0.125P AD=0.25P PS=1.5U PD=2U
M75 184 182 183 183 sky130_fd_pr__pfet_01v8 L=0.15U W=1U AS=0.25P AD=0.5P PS=2.5U PD=3U
M76 187 185 186 186 sky130_fd_pr__pfet_01v8 L=0.15U W=1U AS=0.25P AD=0.5P PS=2.5U PD=3U
M77 190 188 189 189 sky130_fd_pr__pfet_01v8 L=0.15U W=1U AS=0.25P AD=0.5P PS=2.5U PD=3U
M78 193 191 192 192 sky130_fd_pr__nfet_01v8 L=0.15U W=0.5U AS=0.125P AD=0.25P PS=1.5U PD=2U
M79 198 194 197 197 sky130_fd_pr__pfet_01v8 L=0.36U W=4.265U AS=1.06625P AD=1.06625P PS=9.03U PD=4.765U
M80 199 195 198 198 sky130_fd_pr__pfet_01v8 L=0.36U W=4.265U AS=1.06625P AD=1.06625P PS=4.765U PD=4.765U
M81 200 196 199 199 sky130_fd_pr__pfet_01v8 L=0.36U W=4.265U AS=1.06625P AD=2.1325P PS=4.765U PD=9.53U
M82 205 201 204 204 sky130_fd_pr__pfet_01v8 L=0.36U W=4.265U AS=1.06625P AD=1.06625P PS=9.03U PD=4.765U
M83 206 202 205 205 sky130_fd_pr__pfet_01v8 L=0.36U W=4.265U AS=1.06625P AD=1.06625P PS=4.765U PD=4.765U
M84 207 203 206 206 sky130_fd_pr__pfet_01v8 L=0.36U W=4.265U AS=1.06625P AD=2.1325P PS=4.765U PD=9.53U
M85 215 208 214 214 sky130_fd_pr__pfet_01v8 L=0.15U W=4.265U AS=1.06625P AD=1.06625P PS=9.03U PD=4.765U
M86 216 209 215 215 sky130_fd_pr__pfet_01v8 L=0.15U W=4.265U AS=1.06625P AD=1.06625P PS=4.765U PD=4.765U
M87 217 210 216 216 sky130_fd_pr__pfet_01v8 L=0.15U W=4.265U AS=1.06625P AD=1.06625P PS=4.765U PD=4.765U
M88 218 211 217 217 sky130_fd_pr__pfet_01v8 L=0.15U W=4.265U AS=1.06625P AD=1.06625P PS=4.765U PD=4.765U
M89 219 212 218 218 sky130_fd_pr__pfet_01v8 L=0.15U W=4.265U AS=1.06625P AD=1.06625P PS=4.765U PD=4.765U
M90 220 213 219 219 sky130_fd_pr__pfet_01v8 L=0.15U W=4.265U AS=1.06625P AD=2.1325P PS=4.765U PD=9.53U
M91 223 221 222 222 sky130_fd_pr__nfet_01v8 L=0.36U W=4.265U AS=1.06625P AD=2.1325P PS=9.03U PD=9.53U
M92 226 224 225 225 sky130_fd_pr__nfet_01v8 L=0.36U W=4.265U AS=1.06625P AD=2.1325P PS=9.03U PD=9.53U
M93 233 229 232 232 sky130_fd_pr__nfet_01v8 L=0.15U W=4.265U AS=1.06625P AD=2.1325P PS=4.765U PD=9.53U
M94 231 227 230 230 sky130_fd_pr__nfet_01v8 L=0.15U W=4.265U AS=1.06625P AD=1.06625P PS=9.03U PD=4.765U
M95 232 228 231 231 sky130_fd_pr__nfet_01v8 L=0.15U W=4.265U AS=1.06625P AD=1.06625P PS=4.765U PD=4.765U
M96 244 242 243 243 sky130_fd_pr__pfet_01v8 L=0.15U W=1.2U AS=0.3P AD=0.6P PS=2.9U PD=3.4U
M97 247 245 246 246 sky130_fd_pr__nfet_01v8 L=0.15U W=0.6U AS=0.15P AD=0.3P PS=1.7U PD=2.2U
M98 250 248 249 249 sky130_fd_pr__pfet_01v8 L=0.15U W=1.2U AS=0.3P AD=0.6P PS=2.9U PD=3.4U
M99 253 251 252 252 sky130_fd_pr__nfet_01v8 L=0.15U W=0.6U AS=0.15P AD=0.3P PS=1.7U PD=2.2U
M100 256 254 255 255 sky130_fd_pr__pfet_01v8 L=0.15U W=1.2U AS=0.3P AD=0.6P PS=2.9U PD=3.4U
M101 259 257 258 258 sky130_fd_pr__nfet_01v8 L=0.15U W=0.6U AS=0.15P AD=0.3P PS=1.7U PD=2.2U
M102 262 260 261 261 sky130_fd_pr__pfet_01v8 L=0.15U W=1.2U AS=0.3P AD=0.6P PS=2.9U PD=3.4U
M103 265 263 264 264 sky130_fd_pr__nfet_01v8 L=0.15U W=0.6U AS=0.15P AD=0.3P PS=1.7U PD=2.2U
M104 268 266 267 267 sky130_fd_pr__pfet_01v8 L=0.15U W=1.2U AS=0.3P AD=0.6P PS=2.9U PD=3.4U
M105 271 269 270 270 sky130_fd_pr__nfet_01v8 L=0.15U W=0.6U AS=0.15P AD=0.3P PS=1.7U PD=2.2U
M106 274 272 273 273 sky130_fd_pr__pfet_01v8 L=0.15U W=1.2U AS=0.3P AD=0.6P PS=2.9U PD=3.4U
M107 277 275 276 276 sky130_fd_pr__nfet_01v8 L=0.15U W=0.6U AS=0.15P AD=0.3P PS=1.7U PD=2.2U
M108 280 278 279 279 sky130_fd_pr__pfet_01v8 L=0.15U W=1.2U AS=0.3P AD=0.6P PS=2.9U PD=3.4U
M109 283 281 282 282 sky130_fd_pr__nfet_01v8 L=0.15U W=0.6U AS=0.15P AD=0.3P PS=1.7U PD=2.2U
M110 286 284 285 285 sky130_fd_pr__pfet_01v8 L=0.15U W=1.2U AS=0.3P AD=0.6P PS=2.9U PD=3.4U
M111 289 287 288 288 sky130_fd_pr__nfet_01v8 L=0.15U W=0.6U AS=0.15P AD=0.3P PS=1.7U PD=2.2U
M112 292 290 291 291 sky130_fd_pr__pfet_01v8 L=0.15U W=1.2U AS=0.3P AD=0.6P PS=2.9U PD=3.4U
M113 295 293 294 294 sky130_fd_pr__nfet_01v8 L=0.15U W=0.6U AS=0.15P AD=0.3P PS=1.7U PD=2.2U
M114 298 296 297 297 sky130_fd_pr__pfet_01v8 L=0.15U W=1.2U AS=0.3P AD=0.6P PS=2.9U PD=3.4U
M115 301 299 300 300 sky130_fd_pr__nfet_01v8 L=0.15U W=0.6U AS=0.15P AD=0.3P PS=1.7U PD=2.2U
M116 304 302 303 303 sky130_fd_pr__pfet_01v8 L=0.15U W=1.2U AS=0.3P AD=0.6P PS=2.9U PD=3.4U
M117 307 305 306 306 sky130_fd_pr__nfet_01v8 L=0.15U W=0.6U AS=0.15P AD=0.3P PS=1.7U PD=2.2U
M118 310 308 309 309 sky130_fd_pr__pfet_01v8 L=0.15U W=1.2U AS=0.3P AD=0.6P PS=2.9U PD=3.4U
M119 313 311 312 312 sky130_fd_pr__nfet_01v8 L=0.15U W=0.6U AS=0.15P AD=0.3P PS=1.7U PD=2.2U
M120 316 314 315 315 sky130_fd_pr__pfet_01v8 L=0.15U W=1.2U AS=0.3P AD=0.6P PS=2.9U PD=3.4U
M121 319 317 318 318 sky130_fd_pr__nfet_01v8 L=0.15U W=0.6U AS=0.15P AD=0.3P PS=1.7U PD=2.2U
M122 322 320 321 321 sky130_fd_pr__pfet_01v8 L=0.15U W=1.2U AS=0.3P AD=0.6P PS=2.9U PD=3.4U
M123 325 323 324 324 sky130_fd_pr__nfet_01v8 L=0.15U W=0.6U AS=0.15P AD=0.3P PS=1.7U PD=2.2U
M124 328 326 327 327 sky130_fd_pr__pfet_01v8 L=0.15U W=1.2U AS=0.3P AD=0.6P PS=2.9U PD=3.4U
M125 331 329 330 330 sky130_fd_pr__nfet_01v8 L=0.15U W=0.6U AS=0.15P AD=0.3P PS=1.7U PD=2.2U
M126 334 332 333 333 sky130_fd_pr__pfet_01v8 L=0.15U W=1.2U AS=0.3P AD=0.6P PS=2.9U PD=3.4U
M127 337 335 336 336 sky130_fd_pr__nfet_01v8 L=0.15U W=0.6U AS=0.15P AD=0.3P PS=1.7U PD=2.2U
M128 340 338 339 339 sky130_fd_pr__pfet_01v8 L=0.15U W=1.2U AS=0.3P AD=0.6P PS=2.9U PD=3.4U
M129 343 341 342 342 sky130_fd_pr__nfet_01v8 L=0.15U W=0.6U AS=0.15P AD=0.3P PS=1.7U PD=2.2U
M130 346 344 345 345 sky130_fd_pr__pfet_01v8 L=0.15U W=1.2U AS=0.3P AD=0.6P PS=2.9U PD=3.4U
M131 349 347 348 348 sky130_fd_pr__nfet_01v8 L=0.15U W=0.6U AS=0.15P AD=0.3P PS=1.7U PD=2.2U
.ENDS kestrel_pll_top
