* cell gcd
.SUBCKT gcd
* net 1 req_msg[6]
* net 2 resp_msg[5]
* net 3 req_msg[24]
* net 4 resp_msg[8]
* net 12 dpath.a_lt_b$in1\[2\]
* net 20 dpath.a_lt_b$in0\[8\]
* net 31 clknet_2_0__leaf_clk
* net 32 dpath.b_mux$out\[2\]
* net 34 clknet_2_1__leaf_clk
* net 35 dpath.a_mux$out\[8\]
* net 37 VDD
* net 51 dpath.a_mux$out\[2\]
* net 57 dpath.a_lt_b$in0\[2\]
* net 61 dpath.b_mux$out\[6\]
* net 62 dpath.a_mux$out\[6\]
* net 63 _004_
* net 64 req_rdy
* net 65 _075_
* net 67 _048_
* net 68 _069_
* net 70 resp_msg[7]
* net 74 dpath.b_mux$out\[8\]
* net 91 _089_
* net 92 _080_
* net 93 resp_msg[6]
* net 94 net1
* net 97 VSS
* net 112 _093_
* net 115 _076_
* net 126 dpath.b_mux$out\[7\]
* net 128 dpath.a_lt_b$in0\[7\]
* net 129 req_msg[7]
* net 132 _087_
* net 134 net6
* net 136 req_msg[8]
* net 156 req_msg[18]
* net 157 net2
* net 158 resp_msg[2]
* net 159 req_msg[22]
* net 160 req_msg[23]
* net 161 dpath.a_lt_b$in1\[8\]
* net 163 req_msg[21]
* net 166 _090_
* net 167 _088_
* net 180 net9
* net 191 dpath.a_lt_b$in0\[6\]
* net 195 dpath.a_lt_b$in1\[7\]
* net 197 dpath.a_mux$out\[7\]
* net 210 _022_
* net 217 req_msg[2]
* net 218 _040_
* net 219 dpath.a_lt_b$in1\[6\]
* net 220 net32
* net 221 _023_
* net 257 _041_
* net 260 _047_
* net 261 _070_
* net 263 _027_
* net 265 _030_
* net 267 net11
* net 269 _046_
* net 271 _049_
* net 272 _026_
* net 273 _024_
* net 275 _025_
* net 278 _050_
* net 280 _051_
* net 283 _036_
* net 294 _042_
* net 298 clknet_0_clk
* net 303 ctrl$a_reg_en\[0\]
* net 308 _052_
* net 311 _020_
* net 329 _043_
* net 330 _034_
* net 334 _068_
* net 338 _019_
* net 341 _039_
* net 342 _021_
* net 343 dpath.a_lt_b$in0\[9\]
* net 344 dpath.a_lt_b$in1\[9\]
* net 347 resp_msg[9]
* net 352 req_msg[19]
* net 354 _092_
* net 360 resp_msg[3]
* net 362 _103_
* net 372 dpath.a_lt_b$in1\[5\]
* net 374 net52
* net 380 dpath.a_mux$out\[9\]
* net 399 dpath.a_lt_b$in1\[3\]
* net 400 _073_
* net 401 dpath.b_mux$out\[5\]
* net 402 _086_
* net 403 dpath.b_mux$out\[9\]
* net 408 net16
* net 409 _100_
* net 410 net5
* net 411 dpath.a_mux$out\[3\]
* net 436 _035_
* net 440 _071_
* net 441 _045_
* net 449 req_msg[9]
* net 459 dpath.b_mux$out\[3\]
* net 461 dpath.a_lt_b$in0\[3\]
* net 462 req_msg[25]
* net 464 req_msg[3]
* net 487 _029_
* net 490 req_msg[5]
* net 513 _031_
* net 514 dpath.a_lt_b$in0\[5\]
* net 535 _033_
* net 538 _028_
* net 545 _072_
* net 546 _044_
* net 549 dpath.a_mux$out\[5\]
* net 554 dpath.a_lt_b$in1\[1\]
* net 556 resp_msg[4]
* net 566 _085_
* net 569 dpath.a_lt_b$in1\[10\]
* net 571 dpath.a_mux$out\[10\]
* net 572 resp_msg[10]
* net 578 net8
* net 579 _005_
* net 588 _094_
* net 590 resp_msg[1]
* net 591 dpath.a_mux$out\[1\]
* net 593 _037_
* net 594 dpath.a_lt_b$in0\[1\]
* net 595 _032_
* net 597 dpath.a_lt_b$in0\[4\]
* net 599 req_msg[26]
* net 600 _053_
* net 602 _018_
* net 605 _017_
* net 622 req_msg[17]
* net 624 dpath.b_mux$out\[1\]
* net 626 req_msg[1]
* net 628 net12
* net 629 _038_
* net 635 dpath.a_mux$out\[4\]
* net 639 _054_
* net 641 _055_
* net 643 dpath.b_mux$out\[10\]
* net 645 req_msg[10]
* net 650 _091_
* net 651 dpath.a_lt_b$in1\[4\]
* net 652 dpath.a_lt_b$in0\[10\]
* net 661 clk
* net 662 _015_
* net 681 clknet_2_2__leaf_clk
* net 700 _099_
* net 726 req_msg[20]
* net 727 dpath.b_mux$out\[4\]
* net 728 dpath.a_lt_b$in1\[11\]
* net 729 _067_
* net 734 _101_
* net 735 resp_msg[11]
* net 774 dpath.a_mux$out\[11\]
* net 776 _003_
* net 794 req_msg[4]
* net 795 dpath.b_mux$out\[11\]
* net 796 _084_
* net 797 dpath.a_lt_b$in0\[11\]
* net 799 _016_
* net 833 net13
* net 836 dpath.a_lt_b$in1\[0\]
* net 845 _074_
* net 854 net3
* net 867 _095_
* net 868 resp_msg[0]
* net 869 dpath.a_lt_b$in0\[0\]
* net 873 dpath.a_mux$out\[0\]
* net 886 req_msg[16]
* net 888 dpath.b_mux$out\[0\]
* net 893 dpath.a_lt_b$in1\[15\]
* net 896 _102_
* net 897 req_msg[27]
* net 902 dpath.b_mux$out\[12\]
* net 915 req_msg[0]
* net 916 net7
* net 918 _104_
* net 941 net30
* net 943 _056_
* net 946 req_msg[12]
* net 955 dpath.a_lt_b$in0\[12\]
* net 976 _062_
* net 979 clknet_2_3__leaf_clk
* net 980 _014_
* net 983 _012_
* net 985 dpath.a_lt_b$in1\[12\]
* net 986 _013_
* net 993 dpath.a_lt_b$in0\[15\]
* net 994 net4
* net 995 _066_
* net 996 resp_msg[12]
* net 999 _079_
* net 1010 _078_
* net 1015 net10
* net 1017 _059_
* net 1018 resp_msg[14]
* net 1019 _064_
* net 1021 net15
* net 1024 _010_
* net 1025 _083_
* net 1027 dpath.a_mux$out\[12\]
* net 1033 _058_
* net 1039 _057_
* net 1049 ctrl$b_reg_en\[0\]
* net 1051 _063_
* net 1052 _011_
* net 1054 _009_
* net 1058 _060_
* net 1072 _000_
* net 1073 _061_
* net 1075 _077_
* net 1076 _008_
* net 1077 net28
* net 1098 _002_
* net 1099 _105_
* net 1100 _006_
* net 1101 _096_
* net 1104 dpath.a_mux$out\[15\]
* net 1114 dpath.a_lt_b$in0\[14\]
* net 1128 reset
* net 1129 _106_
* net 1130 ctrl.state.out\[2\]
* net 1131 dpath.a_lt_b$in0\[13\]
* net 1132 dpath.a_lt_b$in1\[13\]
* net 1134 dpath.a_lt_b$in1\[14\]
* net 1144 req_val
* net 1145 _097_
* net 1146 _001_
* net 1150 _098_
* net 1154 resp_msg[15]
* net 1168 _065_
* net 1185 _007_
* net 1187 ctrl.state.out\[1\]
* net 1188 req_msg[31]
* net 1189 _081_
* net 1190 net14
* net 1191 dpath.b_mux$out\[14\]
* net 1192 resp_msg[13]
* net 1193 dpath.b_mux$out\[13\]
* net 1201 resp_rdy
* net 1204 dpath.a_mux$out\[14\]
* net 1229 resp_val
* net 1274 dpath.b_mux$out\[15\]
* net 1276 req_msg[11]
* net 1278 _082_
* net 1279 net53
* net 1286 req_msg[30]
* net 1287 req_msg[28]
* net 1289 dpath.a_mux$out\[13\]
* net 1290 req_msg[13]
* net 1315 req_msg[15]
* net 1317 req_msg[14]
* net 1318 req_msg[29]
* device instance $1 r0 *1 5.07,3.165 sky130_fd_pr__nfet_01v8
M$1 97 31 5 5 sky130_fd_pr__nfet_01v8 L=0.15U W=0.42U AS=0.1092P AD=0.0567P
+ PS=1.36U PD=0.69U
* device instance $2 r0 *1 5.49,3.165 sky130_fd_pr__nfet_01v8
M$2 6 5 97 97 sky130_fd_pr__nfet_01v8 L=0.15U W=0.42U AS=0.0567P AD=0.1092P
+ PS=0.69U PD=1.36U
* device instance $3 r0 *1 6.43,3.165 sky130_fd_pr__nfet_01v8
M$3 21 32 7 7 sky130_fd_pr__nfet_01v8 L=0.15U W=0.42U AS=0.1092P AD=0.0441P
+ PS=1.36U PD=0.63U
* device instance $4 r0 *1 6.79,3.165 sky130_fd_pr__nfet_01v8
M$4 97 94 21 21 sky130_fd_pr__nfet_01v8 L=0.15U W=0.42U AS=0.0441P AD=0.1092P
+ PS=0.63U PD=1.36U
* device instance $5 r0 *1 9.59,3.135 sky130_fd_pr__nfet_01v8
M$5 9 5 7 7 sky130_fd_pr__nfet_01v8 L=0.15U W=0.36U AS=0.1446P AD=0.0522P
+ PS=1.18U PD=0.65U
* device instance $6 r0 *1 10.03,3.135 sky130_fd_pr__nfet_01v8
M$6 23 6 9 9 sky130_fd_pr__nfet_01v8 L=0.15U W=0.36U AS=0.0522P AD=0.0759P
+ PS=0.65U PD=0.8U
* device instance $7 r0 *1 7.73,3.165 sky130_fd_pr__nfet_01v8
M$7 97 94 33 33 sky130_fd_pr__nfet_01v8 L=0.15U W=0.42U AS=0.1092P AD=0.0609P
+ PS=1.36U PD=0.71U
* device instance $8 r0 *1 8.17,3.165 sky130_fd_pr__nfet_01v8
M$8 22 33 97 97 sky130_fd_pr__nfet_01v8 L=0.15U W=0.42U AS=0.0609P AD=0.0756P
+ PS=0.71U PD=0.78U
* device instance $9 r0 *1 8.68,3.165 sky130_fd_pr__nfet_01v8
M$9 7 8 22 22 sky130_fd_pr__nfet_01v8 L=0.15U W=0.42U AS=0.0756P AD=0.1446P
+ PS=0.78U PD=1.18U
* device instance $10 r0 *1 10.56,3.165 sky130_fd_pr__nfet_01v8
M$10 97 10 23 23 sky130_fd_pr__nfet_01v8 L=0.15U W=0.42U AS=0.0759P AD=0.12095P
+ PS=0.8U PD=1.085U
* device instance $11 r0 *1 11.155,3.275 sky130_fd_pr__nfet_01v8
M$11 10 9 97 97 sky130_fd_pr__nfet_01v8 L=0.15U W=0.64U AS=0.12095P AD=0.1664P
+ PS=1.085U PD=1.8U
* device instance $12 r0 *1 12.58,3.135 sky130_fd_pr__nfet_01v8
M$12 11 6 24 24 sky130_fd_pr__nfet_01v8 L=0.15U W=0.36U AS=0.0678P AD=0.0684P
+ PS=0.755U PD=0.74U
* device instance $13 r0 *1 13.11,3.135 sky130_fd_pr__nfet_01v8
M$13 26 5 11 11 sky130_fd_pr__nfet_01v8 L=0.15U W=0.36U AS=0.0684P AD=0.066P
+ PS=0.74U PD=0.745U
* device instance $14 r0 *1 12.095,3.165 sky130_fd_pr__nfet_01v8
M$14 24 10 97 97 sky130_fd_pr__nfet_01v8 L=0.15U W=0.42U AS=0.1092P AD=0.0678P
+ PS=1.36U PD=0.755U
* device instance $15 r0 *1 13.585,3.165 sky130_fd_pr__nfet_01v8
M$15 97 8 26 26 sky130_fd_pr__nfet_01v8 L=0.15U W=0.42U AS=0.066P AD=0.1092P
+ PS=0.745U PD=1.36U
* device instance $16 r0 *1 14.525,3.165 sky130_fd_pr__nfet_01v8
M$16 97 11 8 8 sky130_fd_pr__nfet_01v8 L=0.15U W=0.42U AS=0.1092P AD=0.10025P
+ PS=1.36U PD=0.985U
* device instance $17 r0 *1 15.01,3.28 sky130_fd_pr__nfet_01v8
M$17 12 11 97 97 sky130_fd_pr__nfet_01v8 L=0.15U W=0.65U AS=0.10025P AD=0.182P
+ PS=0.985U PD=1.86U
* device instance $18 r0 *1 60.73,3.165 sky130_fd_pr__nfet_01v8
M$18 97 34 13 13 sky130_fd_pr__nfet_01v8 L=0.15U W=0.42U AS=0.1092P AD=0.0567P
+ PS=1.36U PD=0.69U
* device instance $19 r0 *1 61.15,3.165 sky130_fd_pr__nfet_01v8
M$19 14 13 97 97 sky130_fd_pr__nfet_01v8 L=0.15U W=0.42U AS=0.0567P AD=0.1092P
+ PS=0.69U PD=1.36U
* device instance $20 r0 *1 62.09,3.165 sky130_fd_pr__nfet_01v8
M$20 30 35 15 15 sky130_fd_pr__nfet_01v8 L=0.15U W=0.42U AS=0.1092P AD=0.0441P
+ PS=1.36U PD=0.63U
* device instance $21 r0 *1 62.45,3.165 sky130_fd_pr__nfet_01v8
M$21 97 303 30 30 sky130_fd_pr__nfet_01v8 L=0.15U W=0.42U AS=0.0441P AD=0.1092P
+ PS=0.63U PD=1.36U
* device instance $22 r0 *1 65.25,3.135 sky130_fd_pr__nfet_01v8
M$22 17 13 15 15 sky130_fd_pr__nfet_01v8 L=0.15U W=0.36U AS=0.1446P AD=0.0522P
+ PS=1.18U PD=0.65U
* device instance $23 r0 *1 65.69,3.135 sky130_fd_pr__nfet_01v8
M$23 28 14 17 17 sky130_fd_pr__nfet_01v8 L=0.15U W=0.36U AS=0.0522P AD=0.0759P
+ PS=0.65U PD=0.8U
* device instance $24 r0 *1 63.39,3.165 sky130_fd_pr__nfet_01v8
M$24 97 303 36 36 sky130_fd_pr__nfet_01v8 L=0.15U W=0.42U AS=0.1092P AD=0.0609P
+ PS=1.36U PD=0.71U
* device instance $25 r0 *1 63.83,3.165 sky130_fd_pr__nfet_01v8
M$25 29 36 97 97 sky130_fd_pr__nfet_01v8 L=0.15U W=0.42U AS=0.0609P AD=0.0756P
+ PS=0.71U PD=0.78U
* device instance $26 r0 *1 64.34,3.165 sky130_fd_pr__nfet_01v8
M$26 15 16 29 29 sky130_fd_pr__nfet_01v8 L=0.15U W=0.42U AS=0.0756P AD=0.1446P
+ PS=0.78U PD=1.18U
* device instance $27 r0 *1 66.22,3.165 sky130_fd_pr__nfet_01v8
M$27 97 18 28 28 sky130_fd_pr__nfet_01v8 L=0.15U W=0.42U AS=0.0759P AD=0.12095P
+ PS=0.8U PD=1.085U
* device instance $28 r0 *1 66.815,3.275 sky130_fd_pr__nfet_01v8
M$28 18 17 97 97 sky130_fd_pr__nfet_01v8 L=0.15U W=0.64U AS=0.12095P AD=0.1664P
+ PS=1.085U PD=1.8U
* device instance $29 r0 *1 68.24,3.135 sky130_fd_pr__nfet_01v8
M$29 19 14 27 27 sky130_fd_pr__nfet_01v8 L=0.15U W=0.36U AS=0.0678P AD=0.0684P
+ PS=0.755U PD=0.74U
* device instance $30 r0 *1 68.77,3.135 sky130_fd_pr__nfet_01v8
M$30 25 13 19 19 sky130_fd_pr__nfet_01v8 L=0.15U W=0.36U AS=0.0684P AD=0.066P
+ PS=0.74U PD=0.745U
* device instance $31 r0 *1 67.755,3.165 sky130_fd_pr__nfet_01v8
M$31 27 18 97 97 sky130_fd_pr__nfet_01v8 L=0.15U W=0.42U AS=0.1092P AD=0.0678P
+ PS=1.36U PD=0.755U
* device instance $32 r0 *1 69.245,3.165 sky130_fd_pr__nfet_01v8
M$32 97 16 25 25 sky130_fd_pr__nfet_01v8 L=0.15U W=0.42U AS=0.066P AD=0.1092P
+ PS=0.745U PD=1.36U
* device instance $33 r0 *1 70.185,3.165 sky130_fd_pr__nfet_01v8
M$33 97 19 16 16 sky130_fd_pr__nfet_01v8 L=0.15U W=0.42U AS=0.1092P AD=0.10025P
+ PS=1.36U PD=0.985U
* device instance $34 r0 *1 70.67,3.28 sky130_fd_pr__nfet_01v8
M$34 20 19 97 97 sky130_fd_pr__nfet_01v8 L=0.15U W=0.65U AS=0.10025P AD=0.182P
+ PS=0.985U PD=1.86U
* device instance $35 r0 *1 5.53,7.715 sky130_fd_pr__nfet_01v8
M$35 97 31 48 48 sky130_fd_pr__nfet_01v8 L=0.15U W=0.42U AS=0.1092P AD=0.0567P
+ PS=1.36U PD=0.69U
* device instance $36 r0 *1 5.95,7.715 sky130_fd_pr__nfet_01v8
M$36 49 48 97 97 sky130_fd_pr__nfet_01v8 L=0.15U W=0.42U AS=0.0567P AD=0.1092P
+ PS=0.69U PD=1.36U
* device instance $37 r0 *1 6.89,7.715 sky130_fd_pr__nfet_01v8
M$37 99 51 50 50 sky130_fd_pr__nfet_01v8 L=0.15U W=0.42U AS=0.1092P AD=0.0441P
+ PS=1.36U PD=0.63U
* device instance $38 r0 *1 7.25,7.715 sky130_fd_pr__nfet_01v8
M$38 97 303 99 99 sky130_fd_pr__nfet_01v8 L=0.15U W=0.42U AS=0.0441P AD=0.1092P
+ PS=0.63U PD=1.36U
* device instance $39 r0 *1 8.19,7.715 sky130_fd_pr__nfet_01v8
M$39 97 303 52 52 sky130_fd_pr__nfet_01v8 L=0.15U W=0.42U AS=0.1092P AD=0.0609P
+ PS=1.36U PD=0.71U
* device instance $40 r0 *1 8.63,7.715 sky130_fd_pr__nfet_01v8
M$40 101 52 97 97 sky130_fd_pr__nfet_01v8 L=0.15U W=0.42U AS=0.0609P AD=0.0756P
+ PS=0.71U PD=0.78U
* device instance $41 r0 *1 9.14,7.715 sky130_fd_pr__nfet_01v8
M$41 50 56 101 101 sky130_fd_pr__nfet_01v8 L=0.15U W=0.42U AS=0.0756P
+ AD=0.1446P PS=0.78U PD=1.18U
* device instance $42 r0 *1 10.05,7.745 sky130_fd_pr__nfet_01v8
M$42 53 48 50 50 sky130_fd_pr__nfet_01v8 L=0.15U W=0.36U AS=0.1446P AD=0.0522P
+ PS=1.18U PD=0.65U
* device instance $43 r0 *1 10.49,7.745 sky130_fd_pr__nfet_01v8
M$43 53 49 103 103 sky130_fd_pr__nfet_01v8 L=0.15U W=0.36U AS=0.0759P
+ AD=0.0522P PS=0.8U PD=0.65U
* device instance $44 r0 *1 11.02,7.715 sky130_fd_pr__nfet_01v8
M$44 103 54 97 97 sky130_fd_pr__nfet_01v8 L=0.15U W=0.42U AS=0.12095P
+ AD=0.0759P PS=1.085U PD=0.8U
* device instance $45 r0 *1 11.615,7.605 sky130_fd_pr__nfet_01v8
M$45 54 53 97 97 sky130_fd_pr__nfet_01v8 L=0.15U W=0.64U AS=0.12095P AD=0.1664P
+ PS=1.085U PD=1.8U
* device instance $46 r0 *1 12.555,7.715 sky130_fd_pr__nfet_01v8
M$46 105 54 97 97 sky130_fd_pr__nfet_01v8 L=0.15U W=0.42U AS=0.1092P AD=0.0678P
+ PS=1.36U PD=0.755U
* device instance $47 r0 *1 13.04,7.745 sky130_fd_pr__nfet_01v8
M$47 55 49 105 105 sky130_fd_pr__nfet_01v8 L=0.15U W=0.36U AS=0.0678P
+ AD=0.0684P PS=0.755U PD=0.74U
* device instance $48 r0 *1 13.57,7.745 sky130_fd_pr__nfet_01v8
M$48 55 48 106 106 sky130_fd_pr__nfet_01v8 L=0.15U W=0.36U AS=0.066P AD=0.0684P
+ PS=0.745U PD=0.74U
* device instance $49 r0 *1 14.045,7.715 sky130_fd_pr__nfet_01v8
M$49 97 56 106 106 sky130_fd_pr__nfet_01v8 L=0.15U W=0.42U AS=0.066P AD=0.1092P
+ PS=0.745U PD=1.36U
* device instance $50 r0 *1 14.985,7.715 sky130_fd_pr__nfet_01v8
M$50 56 55 97 97 sky130_fd_pr__nfet_01v8 L=0.15U W=0.42U AS=0.10025P AD=0.1092P
+ PS=0.985U PD=1.36U
* device instance $51 r0 *1 15.47,7.6 sky130_fd_pr__nfet_01v8
M$51 57 55 97 97 sky130_fd_pr__nfet_01v8 L=0.15U W=0.65U AS=0.10025P AD=0.182P
+ PS=0.985U PD=1.86U
* device instance $52 r0 *1 23.47,7.6 sky130_fd_pr__nfet_01v8
M$52 97 91 58 58 sky130_fd_pr__nfet_01v8 L=0.15U W=0.65U AS=0.169P AD=0.10725P
+ PS=1.82U PD=0.98U
* device instance $53 r0 *1 23.95,7.6 sky130_fd_pr__nfet_01v8
M$53 110 219 97 97 sky130_fd_pr__nfet_01v8 L=0.15U W=0.65U AS=0.10725P
+ AD=0.06825P PS=0.98U PD=0.86U
* device instance $54 r0 *1 24.31,7.6 sky130_fd_pr__nfet_01v8
M$54 58 92 110 110 sky130_fd_pr__nfet_01v8 L=0.15U W=0.65U AS=0.06825P
+ AD=0.169P PS=0.86U PD=1.82U
* device instance $55 r0 *1 25.25,7.6 sky130_fd_pr__nfet_01v8
M$55 109 157 58 58 sky130_fd_pr__nfet_01v8 L=0.15U W=0.65U AS=0.169P
+ AD=0.10725P PS=1.82U PD=0.98U
* device instance $56 r0 *1 25.73,7.6 sky130_fd_pr__nfet_01v8
M$56 97 93 109 109 sky130_fd_pr__nfet_01v8 L=0.15U W=0.65U AS=0.10725P
+ AD=0.102375P PS=0.98U PD=0.965U
* device instance $57 r0 *1 26.195,7.6 sky130_fd_pr__nfet_01v8
M$57 62 58 97 97 sky130_fd_pr__nfet_01v8 L=0.15U W=0.65U AS=0.102375P AD=0.169P
+ PS=0.965U PD=1.82U
* device instance $58 r0 *1 27.64,7.715 sky130_fd_pr__nfet_01v8
M$58 97 63 96 96 sky130_fd_pr__nfet_01v8 L=0.15U W=0.42U AS=0.1113P AD=0.0588P
+ PS=1.37U PD=0.7U
* device instance $59 r0 *1 28.07,7.715 sky130_fd_pr__nfet_01v8
M$59 96 64 97 97 sky130_fd_pr__nfet_01v8 L=0.15U W=0.42U AS=0.0588P AD=0.0588P
+ PS=0.7U PD=0.7U
* device instance $60 r0 *1 28.5,7.715 sky130_fd_pr__nfet_01v8
M$60 61 65 96 96 sky130_fd_pr__nfet_01v8 L=0.15U W=0.42U AS=0.0588P AD=0.1113P
+ PS=0.7U PD=1.37U
* device instance $61 r0 *1 44.67,7.6 sky130_fd_pr__nfet_01v8
M$61 66 67 97 97 sky130_fd_pr__nfet_01v8 L=0.15U W=0.65U AS=0.169P AD=0.08775P
+ PS=1.82U PD=0.92U
* device instance $62 r0 *1 45.09,7.6 sky130_fd_pr__nfet_01v8
M$62 97 68 66 66 sky130_fd_pr__nfet_01v8 L=0.15U W=0.65U AS=0.08775P
+ AD=0.08775P PS=0.92U PD=0.92U
* device instance $63 r0 *1 45.51,7.6 sky130_fd_pr__nfet_01v8
M$63 108 68 97 97 sky130_fd_pr__nfet_01v8 L=0.15U W=0.65U AS=0.08775P
+ AD=0.08775P PS=0.92U PD=0.92U
* device instance $64 r0 *1 45.93,7.6 sky130_fd_pr__nfet_01v8
M$64 70 67 108 108 sky130_fd_pr__nfet_01v8 L=0.15U W=0.65U AS=0.08775P
+ AD=0.25025P PS=0.92U PD=1.42U
* device instance $65 r0 *1 46.85,7.6 sky130_fd_pr__nfet_01v8
M$65 97 66 70 70 sky130_fd_pr__nfet_01v8 L=0.15U W=0.65U AS=0.25025P AD=0.208P
+ PS=1.42U PD=1.94U
* device instance $66 r0 *1 64.87,7.715 sky130_fd_pr__nfet_01v8
M$66 97 34 71 71 sky130_fd_pr__nfet_01v8 L=0.15U W=0.42U AS=0.1092P AD=0.0567P
+ PS=1.36U PD=0.69U
* device instance $67 r0 *1 65.29,7.715 sky130_fd_pr__nfet_01v8
M$67 72 71 97 97 sky130_fd_pr__nfet_01v8 L=0.15U W=0.42U AS=0.0567P AD=0.1092P
+ PS=0.69U PD=1.36U
* device instance $68 r0 *1 66.23,7.715 sky130_fd_pr__nfet_01v8
M$68 107 74 73 73 sky130_fd_pr__nfet_01v8 L=0.15U W=0.42U AS=0.1092P AD=0.0441P
+ PS=1.36U PD=0.63U
* device instance $69 r0 *1 66.59,7.715 sky130_fd_pr__nfet_01v8
M$69 97 94 107 107 sky130_fd_pr__nfet_01v8 L=0.15U W=0.42U AS=0.0441P
+ AD=0.1092P PS=0.63U PD=1.36U
* device instance $70 r0 *1 67.53,7.715 sky130_fd_pr__nfet_01v8
M$70 97 94 75 75 sky130_fd_pr__nfet_01v8 L=0.15U W=0.42U AS=0.1092P AD=0.0609P
+ PS=1.36U PD=0.71U
* device instance $71 r0 *1 67.97,7.715 sky130_fd_pr__nfet_01v8
M$71 104 75 97 97 sky130_fd_pr__nfet_01v8 L=0.15U W=0.42U AS=0.0609P AD=0.0756P
+ PS=0.71U PD=0.78U
* device instance $72 r0 *1 68.48,7.715 sky130_fd_pr__nfet_01v8
M$72 73 79 104 104 sky130_fd_pr__nfet_01v8 L=0.15U W=0.42U AS=0.0756P
+ AD=0.1446P PS=0.78U PD=1.18U
* device instance $73 r0 *1 69.39,7.745 sky130_fd_pr__nfet_01v8
M$73 76 71 73 73 sky130_fd_pr__nfet_01v8 L=0.15U W=0.36U AS=0.1446P AD=0.0522P
+ PS=1.18U PD=0.65U
* device instance $74 r0 *1 69.83,7.745 sky130_fd_pr__nfet_01v8
M$74 76 72 102 102 sky130_fd_pr__nfet_01v8 L=0.15U W=0.36U AS=0.0759P
+ AD=0.0522P PS=0.8U PD=0.65U
* device instance $75 r0 *1 70.36,7.715 sky130_fd_pr__nfet_01v8
M$75 102 77 97 97 sky130_fd_pr__nfet_01v8 L=0.15U W=0.42U AS=0.12095P
+ AD=0.0759P PS=1.085U PD=0.8U
* device instance $76 r0 *1 70.955,7.605 sky130_fd_pr__nfet_01v8
M$76 77 76 97 97 sky130_fd_pr__nfet_01v8 L=0.15U W=0.64U AS=0.12095P AD=0.1664P
+ PS=1.085U PD=1.8U
* device instance $77 r0 *1 71.895,7.715 sky130_fd_pr__nfet_01v8
M$77 100 77 97 97 sky130_fd_pr__nfet_01v8 L=0.15U W=0.42U AS=0.1092P AD=0.0678P
+ PS=1.36U PD=0.755U
* device instance $78 r0 *1 72.38,7.745 sky130_fd_pr__nfet_01v8
M$78 78 72 100 100 sky130_fd_pr__nfet_01v8 L=0.15U W=0.36U AS=0.0678P
+ AD=0.0684P PS=0.755U PD=0.74U
* device instance $79 r0 *1 72.91,7.745 sky130_fd_pr__nfet_01v8
M$79 78 71 98 98 sky130_fd_pr__nfet_01v8 L=0.15U W=0.36U AS=0.066P AD=0.0684P
+ PS=0.745U PD=0.74U
* device instance $80 r0 *1 73.385,7.715 sky130_fd_pr__nfet_01v8
M$80 97 79 98 98 sky130_fd_pr__nfet_01v8 L=0.15U W=0.42U AS=0.066P AD=0.1092P
+ PS=0.745U PD=1.36U
* device instance $81 r0 *1 74.325,7.715 sky130_fd_pr__nfet_01v8
M$81 79 78 97 97 sky130_fd_pr__nfet_01v8 L=0.15U W=0.42U AS=0.10025P AD=0.1092P
+ PS=0.985U PD=1.36U
* device instance $82 r0 *1 74.81,7.6 sky130_fd_pr__nfet_01v8
M$82 161 78 97 97 sky130_fd_pr__nfet_01v8 L=0.15U W=0.65U AS=0.10025P AD=0.182P
+ PS=0.985U PD=1.86U
* device instance $83 r0 *1 6.98,8.605 sky130_fd_pr__nfet_01v8
M$83 138 156 111 111 sky130_fd_pr__nfet_01v8 L=0.15U W=0.42U AS=0.1113P
+ AD=0.0441P PS=1.37U PD=0.63U
* device instance $84 r0 *1 7.34,8.605 sky130_fd_pr__nfet_01v8
M$84 97 115 138 138 sky130_fd_pr__nfet_01v8 L=0.15U W=0.42U AS=0.0441P
+ AD=0.0966P PS=0.63U PD=0.88U
* device instance $85 r0 *1 7.95,8.605 sky130_fd_pr__nfet_01v8
M$85 112 111 97 97 sky130_fd_pr__nfet_01v8 L=0.15U W=0.42U AS=0.0966P
+ AD=0.1113P PS=0.88U PD=1.37U
* device instance $86 r0 *1 9.21,8.72 sky130_fd_pr__nfet_01v8
M$86 97 112 113 113 sky130_fd_pr__nfet_01v8 L=0.15U W=0.65U AS=0.169P
+ AD=0.10725P PS=1.82U PD=0.98U
* device instance $87 r0 *1 9.69,8.72 sky130_fd_pr__nfet_01v8
M$87 139 12 97 97 sky130_fd_pr__nfet_01v8 L=0.15U W=0.65U AS=0.10725P
+ AD=0.06825P PS=0.98U PD=0.86U
* device instance $88 r0 *1 10.05,8.72 sky130_fd_pr__nfet_01v8
M$88 113 92 139 139 sky130_fd_pr__nfet_01v8 L=0.15U W=0.65U AS=0.06825P
+ AD=0.169P PS=0.86U PD=1.82U
* device instance $89 r0 *1 10.99,8.72 sky130_fd_pr__nfet_01v8
M$89 140 157 113 113 sky130_fd_pr__nfet_01v8 L=0.15U W=0.65U AS=0.169P
+ AD=0.10725P PS=1.82U PD=0.98U
* device instance $90 r0 *1 11.47,8.72 sky130_fd_pr__nfet_01v8
M$90 97 158 140 140 sky130_fd_pr__nfet_01v8 L=0.15U W=0.65U AS=0.10725P
+ AD=0.102375P PS=0.98U PD=0.965U
* device instance $91 r0 *1 11.935,8.72 sky130_fd_pr__nfet_01v8
M$91 51 113 97 97 sky130_fd_pr__nfet_01v8 L=0.15U W=0.65U AS=0.102375P
+ AD=0.169P PS=0.965U PD=1.82U
* device instance $92 r0 *1 23.08,8.605 sky130_fd_pr__nfet_01v8
M$92 141 159 114 114 sky130_fd_pr__nfet_01v8 L=0.15U W=0.42U AS=0.1113P
+ AD=0.0441P PS=1.37U PD=0.63U
* device instance $93 r0 *1 23.44,8.605 sky130_fd_pr__nfet_01v8
M$93 97 115 141 141 sky130_fd_pr__nfet_01v8 L=0.15U W=0.42U AS=0.0441P
+ AD=0.0966P PS=0.63U PD=0.88U
* device instance $94 r0 *1 24.05,8.605 sky130_fd_pr__nfet_01v8
M$94 91 114 97 97 sky130_fd_pr__nfet_01v8 L=0.15U W=0.42U AS=0.0966P AD=0.1113P
+ PS=0.88U PD=1.37U
* device instance $95 r0 *1 25.31,8.605 sky130_fd_pr__nfet_01v8
M$95 97 31 116 116 sky130_fd_pr__nfet_01v8 L=0.15U W=0.42U AS=0.1092P
+ AD=0.0567P PS=1.36U PD=0.69U
* device instance $96 r0 *1 25.73,8.605 sky130_fd_pr__nfet_01v8
M$96 117 116 97 97 sky130_fd_pr__nfet_01v8 L=0.15U W=0.42U AS=0.0567P
+ AD=0.1092P PS=0.69U PD=1.36U
* device instance $97 r0 *1 26.67,8.605 sky130_fd_pr__nfet_01v8
M$97 142 61 118 118 sky130_fd_pr__nfet_01v8 L=0.15U W=0.42U AS=0.1092P
+ AD=0.0441P PS=1.36U PD=0.63U
* device instance $98 r0 *1 27.03,8.605 sky130_fd_pr__nfet_01v8
M$98 97 94 142 142 sky130_fd_pr__nfet_01v8 L=0.15U W=0.42U AS=0.0441P
+ AD=0.1092P PS=0.63U PD=1.36U
* device instance $99 r0 *1 29.83,8.575 sky130_fd_pr__nfet_01v8
M$99 121 116 118 118 sky130_fd_pr__nfet_01v8 L=0.15U W=0.36U AS=0.1446P
+ AD=0.0522P PS=1.18U PD=0.65U
* device instance $100 r0 *1 30.27,8.575 sky130_fd_pr__nfet_01v8
M$100 145 117 121 121 sky130_fd_pr__nfet_01v8 L=0.15U W=0.36U AS=0.0522P
+ AD=0.0759P PS=0.65U PD=0.8U
* device instance $101 r0 *1 27.97,8.605 sky130_fd_pr__nfet_01v8
M$101 97 94 119 119 sky130_fd_pr__nfet_01v8 L=0.15U W=0.42U AS=0.1092P
+ AD=0.0609P PS=1.36U PD=0.71U
* device instance $102 r0 *1 28.41,8.605 sky130_fd_pr__nfet_01v8
M$102 143 119 97 97 sky130_fd_pr__nfet_01v8 L=0.15U W=0.42U AS=0.0609P
+ AD=0.0756P PS=0.71U PD=0.78U
* device instance $103 r0 *1 28.92,8.605 sky130_fd_pr__nfet_01v8
M$103 118 120 143 143 sky130_fd_pr__nfet_01v8 L=0.15U W=0.42U AS=0.0756P
+ AD=0.1446P PS=0.78U PD=1.18U
* device instance $104 r0 *1 30.8,8.605 sky130_fd_pr__nfet_01v8
M$104 97 122 145 145 sky130_fd_pr__nfet_01v8 L=0.15U W=0.42U AS=0.0759P
+ AD=0.12095P PS=0.8U PD=1.085U
* device instance $105 r0 *1 31.395,8.715 sky130_fd_pr__nfet_01v8
M$105 122 121 97 97 sky130_fd_pr__nfet_01v8 L=0.15U W=0.64U AS=0.12095P
+ AD=0.1664P PS=1.085U PD=1.8U
* device instance $106 r0 *1 32.82,8.575 sky130_fd_pr__nfet_01v8
M$106 123 117 147 147 sky130_fd_pr__nfet_01v8 L=0.15U W=0.36U AS=0.0678P
+ AD=0.0684P PS=0.755U PD=0.74U
* device instance $107 r0 *1 33.35,8.575 sky130_fd_pr__nfet_01v8
M$107 148 116 123 123 sky130_fd_pr__nfet_01v8 L=0.15U W=0.36U AS=0.0684P
+ AD=0.066P PS=0.74U PD=0.745U
* device instance $108 r0 *1 32.335,8.605 sky130_fd_pr__nfet_01v8
M$108 147 122 97 97 sky130_fd_pr__nfet_01v8 L=0.15U W=0.42U AS=0.1092P
+ AD=0.0678P PS=1.36U PD=0.755U
* device instance $109 r0 *1 33.825,8.605 sky130_fd_pr__nfet_01v8
M$109 97 120 148 148 sky130_fd_pr__nfet_01v8 L=0.15U W=0.42U AS=0.066P
+ AD=0.1092P PS=0.745U PD=1.36U
* device instance $110 r0 *1 34.765,8.605 sky130_fd_pr__nfet_01v8
M$110 97 123 120 120 sky130_fd_pr__nfet_01v8 L=0.15U W=0.42U AS=0.1092P
+ AD=0.10025P PS=1.36U PD=0.985U
* device instance $111 r0 *1 35.25,8.72 sky130_fd_pr__nfet_01v8
M$111 219 123 97 97 sky130_fd_pr__nfet_01v8 L=0.15U W=0.65U AS=0.10025P
+ AD=0.182P PS=0.985U PD=1.86U
* device instance $112 r0 *1 37.34,8.605 sky130_fd_pr__nfet_01v8
M$112 149 163 124 124 sky130_fd_pr__nfet_01v8 L=0.15U W=0.42U AS=0.1113P
+ AD=0.0441P PS=1.37U PD=0.63U
* device instance $113 r0 *1 37.7,8.605 sky130_fd_pr__nfet_01v8
M$113 97 115 149 149 sky130_fd_pr__nfet_01v8 L=0.15U W=0.42U AS=0.0441P
+ AD=0.0966P PS=0.63U PD=0.88U
* device instance $114 r0 *1 38.31,8.605 sky130_fd_pr__nfet_01v8
M$114 166 124 97 97 sky130_fd_pr__nfet_01v8 L=0.15U W=0.42U AS=0.0966P
+ AD=0.1113P PS=0.88U PD=1.37U
* device instance $115 r0 *1 44.7,8.605 sky130_fd_pr__nfet_01v8
M$115 150 160 125 125 sky130_fd_pr__nfet_01v8 L=0.15U W=0.42U AS=0.1113P
+ AD=0.0441P PS=1.37U PD=0.63U
* device instance $116 r0 *1 45.06,8.605 sky130_fd_pr__nfet_01v8
M$116 97 115 150 150 sky130_fd_pr__nfet_01v8 L=0.15U W=0.42U AS=0.0441P
+ AD=0.0966P PS=0.63U PD=0.88U
* device instance $117 r0 *1 45.67,8.605 sky130_fd_pr__nfet_01v8
M$117 167 125 97 97 sky130_fd_pr__nfet_01v8 L=0.15U W=0.42U AS=0.0966P
+ AD=0.1113P PS=0.88U PD=1.37U
* device instance $118 r0 *1 47.475,8.605 sky130_fd_pr__nfet_01v8
M$118 151 64 97 97 sky130_fd_pr__nfet_01v8 L=0.15U W=0.42U AS=0.11285P
+ AD=0.0693P PS=1.045U PD=0.75U
* device instance $119 r0 *1 47.955,8.605 sky130_fd_pr__nfet_01v8
M$119 127 129 151 151 sky130_fd_pr__nfet_01v8 L=0.15U W=0.42U AS=0.0693P
+ AD=0.09975P PS=0.75U PD=0.895U
* device instance $120 r0 *1 48.58,8.605 sky130_fd_pr__nfet_01v8
M$120 152 128 127 127 sky130_fd_pr__nfet_01v8 L=0.15U W=0.42U AS=0.09975P
+ AD=0.0693P PS=0.895U PD=0.75U
* device instance $121 r0 *1 49.06,8.605 sky130_fd_pr__nfet_01v8
M$121 97 130 152 152 sky130_fd_pr__nfet_01v8 L=0.15U W=0.42U AS=0.0693P
+ AD=0.1449P PS=0.75U PD=1.11U
* device instance $122 r0 *1 49.9,8.605 sky130_fd_pr__nfet_01v8
M$122 130 64 97 97 sky130_fd_pr__nfet_01v8 L=0.15U W=0.42U AS=0.1449P
+ AD=0.1092P PS=1.11U PD=1.36U
* device instance $123 r0 *1 46.93,8.72 sky130_fd_pr__nfet_01v8
M$123 97 127 126 126 sky130_fd_pr__nfet_01v8 L=0.15U W=0.65U AS=0.169P
+ AD=0.11285P PS=1.82U PD=1.045U
* device instance $124 r0 *1 57.58,8.605 sky130_fd_pr__nfet_01v8
M$124 153 3 131 131 sky130_fd_pr__nfet_01v8 L=0.15U W=0.42U AS=0.1113P
+ AD=0.0441P PS=1.37U PD=0.63U
* device instance $125 r0 *1 57.94,8.605 sky130_fd_pr__nfet_01v8
M$125 97 115 153 153 sky130_fd_pr__nfet_01v8 L=0.15U W=0.42U AS=0.0441P
+ AD=0.0966P PS=0.63U PD=0.88U
* device instance $126 r0 *1 58.55,8.605 sky130_fd_pr__nfet_01v8
M$126 132 131 97 97 sky130_fd_pr__nfet_01v8 L=0.15U W=0.42U AS=0.0966P
+ AD=0.1113P PS=0.88U PD=1.37U
* device instance $127 r0 *1 59.81,8.72 sky130_fd_pr__nfet_01v8
M$127 97 132 133 133 sky130_fd_pr__nfet_01v8 L=0.15U W=0.65U AS=0.169P
+ AD=0.10725P PS=1.82U PD=0.98U
* device instance $128 r0 *1 60.29,8.72 sky130_fd_pr__nfet_01v8
M$128 155 161 97 97 sky130_fd_pr__nfet_01v8 L=0.15U W=0.65U AS=0.10725P
+ AD=0.06825P PS=0.98U PD=0.86U
* device instance $129 r0 *1 60.65,8.72 sky130_fd_pr__nfet_01v8
M$129 133 92 155 155 sky130_fd_pr__nfet_01v8 L=0.15U W=0.65U AS=0.06825P
+ AD=0.169P PS=0.86U PD=1.82U
* device instance $130 r0 *1 61.59,8.72 sky130_fd_pr__nfet_01v8
M$130 154 134 133 133 sky130_fd_pr__nfet_01v8 L=0.15U W=0.65U AS=0.169P
+ AD=0.10725P PS=1.82U PD=0.98U
* device instance $131 r0 *1 62.07,8.72 sky130_fd_pr__nfet_01v8
M$131 97 4 154 154 sky130_fd_pr__nfet_01v8 L=0.15U W=0.65U AS=0.10725P
+ AD=0.102375P PS=0.98U PD=0.965U
* device instance $132 r0 *1 62.535,8.72 sky130_fd_pr__nfet_01v8
M$132 35 133 97 97 sky130_fd_pr__nfet_01v8 L=0.15U W=0.65U AS=0.102375P
+ AD=0.169P PS=0.965U PD=1.82U
* device instance $133 r0 *1 68.175,8.605 sky130_fd_pr__nfet_01v8
M$133 146 64 97 97 sky130_fd_pr__nfet_01v8 L=0.15U W=0.42U AS=0.11285P
+ AD=0.0693P PS=1.045U PD=0.75U
* device instance $134 r0 *1 68.655,8.605 sky130_fd_pr__nfet_01v8
M$134 135 136 146 146 sky130_fd_pr__nfet_01v8 L=0.15U W=0.42U AS=0.0693P
+ AD=0.09975P PS=0.75U PD=0.895U
* device instance $135 r0 *1 69.28,8.605 sky130_fd_pr__nfet_01v8
M$135 144 20 135 135 sky130_fd_pr__nfet_01v8 L=0.15U W=0.42U AS=0.09975P
+ AD=0.0693P PS=0.895U PD=0.75U
* device instance $136 r0 *1 69.76,8.605 sky130_fd_pr__nfet_01v8
M$136 97 137 144 144 sky130_fd_pr__nfet_01v8 L=0.15U W=0.42U AS=0.0693P
+ AD=0.1449P PS=0.75U PD=1.11U
* device instance $137 r0 *1 70.6,8.605 sky130_fd_pr__nfet_01v8
M$137 137 64 97 97 sky130_fd_pr__nfet_01v8 L=0.15U W=0.42U AS=0.1449P
+ AD=0.1092P PS=1.11U PD=1.36U
* device instance $138 r0 *1 67.63,8.72 sky130_fd_pr__nfet_01v8
M$138 97 135 74 74 sky130_fd_pr__nfet_01v8 L=0.15U W=0.65U AS=0.169P
+ AD=0.11285P PS=1.82U PD=1.045U
* device instance $139 r0 *1 7.83,13.04 sky130_fd_pr__nfet_01v8
M$139 97 178 32 32 sky130_fd_pr__nfet_01v8 L=0.15U W=0.65U AS=0.169P
+ AD=0.11285P PS=1.82U PD=1.045U
* device instance $140 r0 *1 8.375,13.155 sky130_fd_pr__nfet_01v8
M$140 236 64 97 97 sky130_fd_pr__nfet_01v8 L=0.15U W=0.42U AS=0.11285P
+ AD=0.0693P PS=1.045U PD=0.75U
* device instance $141 r0 *1 8.855,13.155 sky130_fd_pr__nfet_01v8
M$141 178 217 236 236 sky130_fd_pr__nfet_01v8 L=0.15U W=0.42U AS=0.0693P
+ AD=0.09975P PS=0.75U PD=0.895U
* device instance $142 r0 *1 9.48,13.155 sky130_fd_pr__nfet_01v8
M$142 237 57 178 178 sky130_fd_pr__nfet_01v8 L=0.15U W=0.42U AS=0.09975P
+ AD=0.0693P PS=0.895U PD=0.75U
* device instance $143 r0 *1 9.96,13.155 sky130_fd_pr__nfet_01v8
M$143 97 233 237 237 sky130_fd_pr__nfet_01v8 L=0.15U W=0.42U AS=0.0693P
+ AD=0.1449P PS=0.75U PD=1.11U
* device instance $144 r0 *1 10.8,13.155 sky130_fd_pr__nfet_01v8
M$144 233 64 97 97 sky130_fd_pr__nfet_01v8 L=0.15U W=0.42U AS=0.1449P
+ AD=0.1092P PS=1.11U PD=1.36U
* device instance $145 r0 *1 12.53,13.04 sky130_fd_pr__nfet_01v8
M$145 239 218 179 179 sky130_fd_pr__nfet_01v8 L=0.15U W=0.65U AS=0.169P
+ AD=0.06825P PS=1.82U PD=0.86U
* device instance $146 r0 *1 12.89,13.04 sky130_fd_pr__nfet_01v8
M$146 97 180 239 239 sky130_fd_pr__nfet_01v8 L=0.15U W=0.65U AS=0.06825P
+ AD=0.08775P PS=0.86U PD=0.92U
* device instance $147 r0 *1 13.31,13.04 sky130_fd_pr__nfet_01v8
M$147 234 180 97 97 sky130_fd_pr__nfet_01v8 L=0.15U W=0.65U AS=0.08775P
+ AD=0.169P PS=0.92U PD=1.82U
* device instance $148 r0 *1 14.25,13.04 sky130_fd_pr__nfet_01v8
M$148 234 218 97 97 sky130_fd_pr__nfet_01v8 L=0.15U W=0.65U AS=0.169P
+ AD=0.08775P PS=1.82U PD=0.92U
* device instance $149 r0 *1 14.67,13.04 sky130_fd_pr__nfet_01v8
M$149 158 179 234 234 sky130_fd_pr__nfet_01v8 L=0.15U W=0.65U AS=0.08775P
+ AD=0.195P PS=0.92U PD=1.9U
* device instance $150 r0 *1 15.69,13.04 sky130_fd_pr__nfet_01v8
M$150 181 57 97 97 sky130_fd_pr__nfet_01v8 L=0.15U W=0.65U AS=0.169P
+ AD=0.08775P PS=1.82U PD=0.92U
* device instance $151 r0 *1 16.11,13.04 sky130_fd_pr__nfet_01v8
M$151 97 12 181 181 sky130_fd_pr__nfet_01v8 L=0.15U W=0.65U AS=0.08775P
+ AD=0.08775P PS=0.92U PD=0.92U
* device instance $152 r0 *1 16.53,13.04 sky130_fd_pr__nfet_01v8
M$152 241 12 97 97 sky130_fd_pr__nfet_01v8 L=0.15U W=0.65U AS=0.08775P
+ AD=0.08775P PS=0.92U PD=0.92U
* device instance $153 r0 *1 16.95,13.04 sky130_fd_pr__nfet_01v8
M$153 218 57 241 241 sky130_fd_pr__nfet_01v8 L=0.15U W=0.65U AS=0.08775P
+ AD=0.25025P PS=0.92U PD=1.42U
* device instance $154 r0 *1 17.87,13.04 sky130_fd_pr__nfet_01v8
M$154 97 181 218 218 sky130_fd_pr__nfet_01v8 L=0.15U W=0.65U AS=0.25025P
+ AD=0.208P PS=1.42U PD=1.94U
* device instance $155 r0 *1 19.33,13.155 sky130_fd_pr__nfet_01v8
M$155 97 31 183 183 sky130_fd_pr__nfet_01v8 L=0.15U W=0.42U AS=0.1092P
+ AD=0.0567P PS=1.36U PD=0.69U
* device instance $156 r0 *1 19.75,13.155 sky130_fd_pr__nfet_01v8
M$156 184 183 97 97 sky130_fd_pr__nfet_01v8 L=0.15U W=0.42U AS=0.0567P
+ AD=0.1092P PS=0.69U PD=1.36U
* device instance $157 r0 *1 20.69,13.155 sky130_fd_pr__nfet_01v8
M$157 242 62 185 185 sky130_fd_pr__nfet_01v8 L=0.15U W=0.42U AS=0.1092P
+ AD=0.0441P PS=1.36U PD=0.63U
* device instance $158 r0 *1 21.05,13.155 sky130_fd_pr__nfet_01v8
M$158 97 303 242 242 sky130_fd_pr__nfet_01v8 L=0.15U W=0.42U AS=0.0441P
+ AD=0.1092P PS=0.63U PD=1.36U
* device instance $159 r0 *1 21.99,13.155 sky130_fd_pr__nfet_01v8
M$159 97 303 186 186 sky130_fd_pr__nfet_01v8 L=0.15U W=0.42U AS=0.1092P
+ AD=0.0609P PS=1.36U PD=0.71U
* device instance $160 r0 *1 22.43,13.155 sky130_fd_pr__nfet_01v8
M$160 243 186 97 97 sky130_fd_pr__nfet_01v8 L=0.15U W=0.42U AS=0.0609P
+ AD=0.0756P PS=0.71U PD=0.78U
* device instance $161 r0 *1 22.94,13.155 sky130_fd_pr__nfet_01v8
M$161 185 190 243 243 sky130_fd_pr__nfet_01v8 L=0.15U W=0.42U AS=0.0756P
+ AD=0.1446P PS=0.78U PD=1.18U
* device instance $162 r0 *1 23.85,13.185 sky130_fd_pr__nfet_01v8
M$162 187 183 185 185 sky130_fd_pr__nfet_01v8 L=0.15U W=0.36U AS=0.1446P
+ AD=0.0522P PS=1.18U PD=0.65U
* device instance $163 r0 *1 24.29,13.185 sky130_fd_pr__nfet_01v8
M$163 187 184 245 245 sky130_fd_pr__nfet_01v8 L=0.15U W=0.36U AS=0.0759P
+ AD=0.0522P PS=0.8U PD=0.65U
* device instance $164 r0 *1 24.82,13.155 sky130_fd_pr__nfet_01v8
M$164 245 188 97 97 sky130_fd_pr__nfet_01v8 L=0.15U W=0.42U AS=0.12095P
+ AD=0.0759P PS=1.085U PD=0.8U
* device instance $165 r0 *1 25.415,13.045 sky130_fd_pr__nfet_01v8
M$165 188 187 97 97 sky130_fd_pr__nfet_01v8 L=0.15U W=0.64U AS=0.12095P
+ AD=0.1664P PS=1.085U PD=1.8U
* device instance $166 r0 *1 26.355,13.155 sky130_fd_pr__nfet_01v8
M$166 246 188 97 97 sky130_fd_pr__nfet_01v8 L=0.15U W=0.42U AS=0.1092P
+ AD=0.0678P PS=1.36U PD=0.755U
* device instance $167 r0 *1 26.84,13.185 sky130_fd_pr__nfet_01v8
M$167 189 184 246 246 sky130_fd_pr__nfet_01v8 L=0.15U W=0.36U AS=0.0678P
+ AD=0.0684P PS=0.755U PD=0.74U
* device instance $168 r0 *1 27.37,13.185 sky130_fd_pr__nfet_01v8
M$168 189 183 247 247 sky130_fd_pr__nfet_01v8 L=0.15U W=0.36U AS=0.066P
+ AD=0.0684P PS=0.745U PD=0.74U
* device instance $169 r0 *1 27.845,13.155 sky130_fd_pr__nfet_01v8
M$169 97 190 247 247 sky130_fd_pr__nfet_01v8 L=0.15U W=0.42U AS=0.066P
+ AD=0.1092P PS=0.745U PD=1.36U
* device instance $170 r0 *1 28.785,13.155 sky130_fd_pr__nfet_01v8
M$170 190 189 97 97 sky130_fd_pr__nfet_01v8 L=0.15U W=0.42U AS=0.10025P
+ AD=0.1092P PS=0.985U PD=1.36U
* device instance $171 r0 *1 29.27,13.04 sky130_fd_pr__nfet_01v8
M$171 191 189 97 97 sky130_fd_pr__nfet_01v8 L=0.15U W=0.65U AS=0.10025P
+ AD=0.182P PS=0.985U PD=1.86U
* device instance $172 r0 *1 30.85,13.04 sky130_fd_pr__nfet_01v8
M$172 248 1 97 97 sky130_fd_pr__nfet_01v8 L=0.15U W=0.65U AS=0.169P AD=0.08775P
+ PS=1.82U PD=0.92U
* device instance $173 r0 *1 31.27,13.04 sky130_fd_pr__nfet_01v8
M$173 65 64 248 248 sky130_fd_pr__nfet_01v8 L=0.15U W=0.65U AS=0.08775P
+ AD=0.169P PS=0.92U PD=1.82U
* device instance $174 r0 *1 32.625,13.155 sky130_fd_pr__nfet_01v8
M$174 97 191 63 63 sky130_fd_pr__nfet_01v8 L=0.15U W=0.42U AS=0.1092P
+ AD=0.1197P PS=1.36U PD=1.41U
* device instance $175 r0 *1 33.605,13.04 sky130_fd_pr__nfet_01v8
M$175 97 219 235 235 sky130_fd_pr__nfet_01v8 L=0.15U W=1.3U AS=0.299P AD=0.182P
+ PS=2.87U PD=1.86U
* device instance $176 r0 *1 34.035,13.04 sky130_fd_pr__nfet_01v8
M$176 235 63 97 97 sky130_fd_pr__nfet_01v8 L=0.15U W=1.3U AS=0.182P AD=0.21775P
+ PS=1.86U PD=1.97U
* device instance $179 r0 *1 35.435,13.04 sky130_fd_pr__nfet_01v8
M$179 67 260 235 235 sky130_fd_pr__nfet_01v8 L=0.15U W=1.3U AS=0.182P
+ AD=0.26325P PS=1.86U PD=2.76U
* device instance $181 r0 *1 40.95,13.04 sky130_fd_pr__nfet_01v8
M$181 97 167 193 193 sky130_fd_pr__nfet_01v8 L=0.15U W=0.65U AS=0.169P
+ AD=0.10725P PS=1.82U PD=0.98U
* device instance $182 r0 *1 41.43,13.04 sky130_fd_pr__nfet_01v8
M$182 249 195 97 97 sky130_fd_pr__nfet_01v8 L=0.15U W=0.65U AS=0.10725P
+ AD=0.06825P PS=0.98U PD=0.86U
* device instance $183 r0 *1 41.79,13.04 sky130_fd_pr__nfet_01v8
M$183 193 92 249 249 sky130_fd_pr__nfet_01v8 L=0.15U W=0.65U AS=0.06825P
+ AD=0.169P PS=0.86U PD=1.82U
* device instance $184 r0 *1 42.73,13.04 sky130_fd_pr__nfet_01v8
M$184 252 134 193 193 sky130_fd_pr__nfet_01v8 L=0.15U W=0.65U AS=0.169P
+ AD=0.10725P PS=1.82U PD=0.98U
* device instance $185 r0 *1 43.21,13.04 sky130_fd_pr__nfet_01v8
M$185 97 70 252 252 sky130_fd_pr__nfet_01v8 L=0.15U W=0.65U AS=0.10725P
+ AD=0.102375P PS=0.98U PD=0.965U
* device instance $186 r0 *1 43.675,13.04 sky130_fd_pr__nfet_01v8
M$186 197 193 97 97 sky130_fd_pr__nfet_01v8 L=0.15U W=0.65U AS=0.102375P
+ AD=0.169P PS=0.965U PD=1.82U
* device instance $187 r0 *1 46.93,13.155 sky130_fd_pr__nfet_01v8
M$187 97 34 198 198 sky130_fd_pr__nfet_01v8 L=0.15U W=0.42U AS=0.1092P
+ AD=0.0567P PS=1.36U PD=0.69U
* device instance $188 r0 *1 47.35,13.155 sky130_fd_pr__nfet_01v8
M$188 199 198 97 97 sky130_fd_pr__nfet_01v8 L=0.15U W=0.42U AS=0.0567P
+ AD=0.1092P PS=0.69U PD=1.36U
* device instance $189 r0 *1 48.29,13.155 sky130_fd_pr__nfet_01v8
M$189 254 126 200 200 sky130_fd_pr__nfet_01v8 L=0.15U W=0.42U AS=0.1092P
+ AD=0.0441P PS=1.36U PD=0.63U
* device instance $190 r0 *1 48.65,13.155 sky130_fd_pr__nfet_01v8
M$190 97 94 254 254 sky130_fd_pr__nfet_01v8 L=0.15U W=0.42U AS=0.0441P
+ AD=0.1092P PS=0.63U PD=1.36U
* device instance $191 r0 *1 49.59,13.155 sky130_fd_pr__nfet_01v8
M$191 97 94 201 201 sky130_fd_pr__nfet_01v8 L=0.15U W=0.42U AS=0.1092P
+ AD=0.0609P PS=1.36U PD=0.71U
* device instance $192 r0 *1 50.03,13.155 sky130_fd_pr__nfet_01v8
M$192 255 201 97 97 sky130_fd_pr__nfet_01v8 L=0.15U W=0.42U AS=0.0609P
+ AD=0.0756P PS=0.71U PD=0.78U
* device instance $193 r0 *1 50.54,13.155 sky130_fd_pr__nfet_01v8
M$193 200 205 255 255 sky130_fd_pr__nfet_01v8 L=0.15U W=0.42U AS=0.0756P
+ AD=0.1446P PS=0.78U PD=1.18U
* device instance $194 r0 *1 51.45,13.185 sky130_fd_pr__nfet_01v8
M$194 202 198 200 200 sky130_fd_pr__nfet_01v8 L=0.15U W=0.36U AS=0.1446P
+ AD=0.0522P PS=1.18U PD=0.65U
* device instance $195 r0 *1 51.89,13.185 sky130_fd_pr__nfet_01v8
M$195 202 199 253 253 sky130_fd_pr__nfet_01v8 L=0.15U W=0.36U AS=0.0759P
+ AD=0.0522P PS=0.8U PD=0.65U
* device instance $196 r0 *1 52.42,13.155 sky130_fd_pr__nfet_01v8
M$196 253 203 97 97 sky130_fd_pr__nfet_01v8 L=0.15U W=0.42U AS=0.12095P
+ AD=0.0759P PS=1.085U PD=0.8U
* device instance $197 r0 *1 53.015,13.045 sky130_fd_pr__nfet_01v8
M$197 203 202 97 97 sky130_fd_pr__nfet_01v8 L=0.15U W=0.64U AS=0.12095P
+ AD=0.1664P PS=1.085U PD=1.8U
* device instance $198 r0 *1 53.955,13.155 sky130_fd_pr__nfet_01v8
M$198 251 203 97 97 sky130_fd_pr__nfet_01v8 L=0.15U W=0.42U AS=0.1092P
+ AD=0.0678P PS=1.36U PD=0.755U
* device instance $199 r0 *1 54.44,13.185 sky130_fd_pr__nfet_01v8
M$199 204 199 251 251 sky130_fd_pr__nfet_01v8 L=0.15U W=0.36U AS=0.0678P
+ AD=0.0684P PS=0.755U PD=0.74U
* device instance $200 r0 *1 54.97,13.185 sky130_fd_pr__nfet_01v8
M$200 204 198 250 250 sky130_fd_pr__nfet_01v8 L=0.15U W=0.36U AS=0.066P
+ AD=0.0684P PS=0.745U PD=0.74U
* device instance $201 r0 *1 55.445,13.155 sky130_fd_pr__nfet_01v8
M$201 97 205 250 250 sky130_fd_pr__nfet_01v8 L=0.15U W=0.42U AS=0.066P
+ AD=0.1092P PS=0.745U PD=1.36U
* device instance $202 r0 *1 56.385,13.155 sky130_fd_pr__nfet_01v8
M$202 205 204 97 97 sky130_fd_pr__nfet_01v8 L=0.15U W=0.42U AS=0.10025P
+ AD=0.1092P PS=0.985U PD=1.36U
* device instance $203 r0 *1 56.87,13.04 sky130_fd_pr__nfet_01v8
M$203 195 204 97 97 sky130_fd_pr__nfet_01v8 L=0.15U W=0.65U AS=0.10025P
+ AD=0.182P PS=0.985U PD=1.86U
* device instance $204 r0 *1 61.69,13.04 sky130_fd_pr__nfet_01v8
M$204 206 220 97 97 sky130_fd_pr__nfet_01v8 L=0.15U W=0.65U AS=0.169P
+ AD=0.08775P PS=1.82U PD=0.92U
* device instance $205 r0 *1 62.11,13.04 sky130_fd_pr__nfet_01v8
M$205 97 221 206 206 sky130_fd_pr__nfet_01v8 L=0.15U W=0.65U AS=0.08775P
+ AD=0.08775P PS=0.92U PD=0.92U
* device instance $206 r0 *1 62.53,13.04 sky130_fd_pr__nfet_01v8
M$206 244 221 97 97 sky130_fd_pr__nfet_01v8 L=0.15U W=0.65U AS=0.08775P
+ AD=0.08775P PS=0.92U PD=0.92U
* device instance $207 r0 *1 62.95,13.04 sky130_fd_pr__nfet_01v8
M$207 4 220 244 244 sky130_fd_pr__nfet_01v8 L=0.15U W=0.65U AS=0.08775P
+ AD=0.25025P PS=0.92U PD=1.42U
* device instance $208 r0 *1 63.87,13.04 sky130_fd_pr__nfet_01v8
M$208 97 206 4 4 sky130_fd_pr__nfet_01v8 L=0.15U W=0.65U AS=0.25025P AD=0.208P
+ PS=1.42U PD=1.94U
* device instance $209 r0 *1 66.29,13.04 sky130_fd_pr__nfet_01v8
M$209 208 20 97 97 sky130_fd_pr__nfet_01v8 L=0.15U W=0.65U AS=0.169P
+ AD=0.08775P PS=1.82U PD=0.92U
* device instance $210 r0 *1 66.71,13.04 sky130_fd_pr__nfet_01v8
M$210 97 161 208 208 sky130_fd_pr__nfet_01v8 L=0.15U W=0.65U AS=0.08775P
+ AD=0.08775P PS=0.92U PD=0.92U
* device instance $211 r0 *1 67.13,13.04 sky130_fd_pr__nfet_01v8
M$211 240 161 97 97 sky130_fd_pr__nfet_01v8 L=0.15U W=0.65U AS=0.08775P
+ AD=0.08775P PS=0.92U PD=0.92U
* device instance $212 r0 *1 67.55,13.04 sky130_fd_pr__nfet_01v8
M$212 221 20 240 240 sky130_fd_pr__nfet_01v8 L=0.15U W=0.65U AS=0.08775P
+ AD=0.25025P PS=0.92U PD=1.42U
* device instance $213 r0 *1 68.47,13.04 sky130_fd_pr__nfet_01v8
M$213 97 208 221 221 sky130_fd_pr__nfet_01v8 L=0.15U W=0.65U AS=0.25025P
+ AD=0.208P PS=1.42U PD=1.94U
* device instance $214 r0 *1 69.47,12.925 sky130_fd_pr__nfet_01v8
M$214 97 161 222 222 sky130_fd_pr__nfet_01v8 L=0.15U W=0.42U AS=0.1092P
+ AD=0.10025P PS=1.36U PD=0.985U
* device instance $215 r0 *1 69.955,13.04 sky130_fd_pr__nfet_01v8
M$215 238 20 97 97 sky130_fd_pr__nfet_01v8 L=0.15U W=0.65U AS=0.10025P
+ AD=0.08775P PS=0.985U PD=0.92U
* device instance $216 r0 *1 70.375,13.04 sky130_fd_pr__nfet_01v8
M$216 210 222 238 238 sky130_fd_pr__nfet_01v8 L=0.15U W=0.65U AS=0.08775P
+ AD=0.169P PS=0.92U PD=1.82U
* device instance $217 r0 *1 12.665,14.045 sky130_fd_pr__nfet_01v8
M$217 97 57 256 256 sky130_fd_pr__nfet_01v8 L=0.15U W=0.42U AS=0.1092P
+ AD=0.10025P PS=1.36U PD=0.985U
* device instance $218 r0 *1 13.15,14.16 sky130_fd_pr__nfet_01v8
M$218 283 12 97 97 sky130_fd_pr__nfet_01v8 L=0.15U W=0.65U AS=0.10025P
+ AD=0.08775P PS=0.985U PD=0.92U
* device instance $219 r0 *1 13.57,14.16 sky130_fd_pr__nfet_01v8
M$219 97 256 283 283 sky130_fd_pr__nfet_01v8 L=0.15U W=0.65U AS=0.08775P
+ AD=0.169P PS=0.92U PD=1.82U
* device instance $220 r0 *1 13.82,18.48 sky130_fd_pr__nfet_01v8
M$220 97 295 294 294 sky130_fd_pr__nfet_01v8 L=0.15U W=0.65U AS=0.169P
+ AD=0.25675P PS=1.82U PD=1.44U
* device instance $221 r0 *1 14.76,18.48 sky130_fd_pr__nfet_01v8
M$221 295 283 97 97 sky130_fd_pr__nfet_01v8 L=0.15U W=0.65U AS=0.25675P
+ AD=0.089375P PS=1.44U PD=0.925U
* device instance $222 r0 *1 15.185,18.48 sky130_fd_pr__nfet_01v8
M$222 324 180 295 295 sky130_fd_pr__nfet_01v8 L=0.15U W=0.65U AS=0.089375P
+ AD=0.091P PS=0.925U PD=0.93U
* device instance $223 r0 *1 15.615,18.48 sky130_fd_pr__nfet_01v8
M$223 97 257 324 324 sky130_fd_pr__nfet_01v8 L=0.15U W=0.65U AS=0.091P
+ AD=0.17225P PS=0.93U PD=1.83U
* device instance $224 r0 *1 15.145,14.045 sky130_fd_pr__nfet_01v8
M$224 97 218 257 257 sky130_fd_pr__nfet_01v8 L=0.15U W=0.42U AS=0.1092P
+ AD=0.1197P PS=1.36U PD=1.41U
* device instance $225 r0 *1 28.63,14.16 sky130_fd_pr__nfet_01v8
M$225 282 191 258 258 sky130_fd_pr__nfet_01v8 L=0.15U W=0.65U AS=0.169P
+ AD=0.06825P PS=1.82U PD=0.86U
* device instance $226 r0 *1 28.99,14.16 sky130_fd_pr__nfet_01v8
M$226 97 219 282 282 sky130_fd_pr__nfet_01v8 L=0.15U W=0.65U AS=0.06825P
+ AD=0.08775P PS=0.86U PD=0.92U
* device instance $227 r0 *1 29.41,14.16 sky130_fd_pr__nfet_01v8
M$227 259 219 97 97 sky130_fd_pr__nfet_01v8 L=0.15U W=0.65U AS=0.08775P
+ AD=0.169P PS=0.92U PD=1.82U
* device instance $228 r0 *1 30.35,14.16 sky130_fd_pr__nfet_01v8
M$228 259 191 97 97 sky130_fd_pr__nfet_01v8 L=0.15U W=0.65U AS=0.169P
+ AD=0.08775P PS=1.82U PD=0.92U
* device instance $229 r0 *1 30.77,14.16 sky130_fd_pr__nfet_01v8
M$229 263 258 259 259 sky130_fd_pr__nfet_01v8 L=0.15U W=0.65U AS=0.08775P
+ AD=0.195P PS=0.92U PD=1.9U
* device instance $230 r0 *1 31.985,14.045 sky130_fd_pr__nfet_01v8
M$230 97 260 262 262 sky130_fd_pr__nfet_01v8 L=0.15U W=0.42U AS=0.1092P
+ AD=0.10025P PS=1.36U PD=0.985U
* device instance $231 r0 *1 32.47,14.16 sky130_fd_pr__nfet_01v8
M$231 93 261 97 97 sky130_fd_pr__nfet_01v8 L=0.15U W=0.65U AS=0.10025P
+ AD=0.08775P PS=0.985U PD=0.92U
* device instance $232 r0 *1 32.89,14.16 sky130_fd_pr__nfet_01v8
M$232 97 262 93 93 sky130_fd_pr__nfet_01v8 L=0.15U W=0.65U AS=0.08775P
+ AD=0.169P PS=0.92U PD=1.82U
* device instance $233 r0 *1 34.05,14.16 sky130_fd_pr__nfet_01v8
M$233 260 263 264 264 sky130_fd_pr__nfet_01v8 L=0.15U W=1.3U AS=0.25675P
+ AD=0.1755P PS=2.74U PD=1.84U
* device instance $235 r0 *1 34.89,14.16 sky130_fd_pr__nfet_01v8
M$235 266 265 264 264 sky130_fd_pr__nfet_01v8 L=0.15U W=1.3U AS=0.1755P
+ AD=0.25675P PS=1.84U PD=2.74U
* device instance $237 r0 *1 34.07,18.48 sky130_fd_pr__nfet_01v8
M$237 261 263 97 97 sky130_fd_pr__nfet_01v8 L=0.15U W=0.65U AS=0.17225P
+ AD=0.091P PS=1.83U PD=0.93U
* device instance $238 r0 *1 34.5,18.48 sky130_fd_pr__nfet_01v8
M$238 326 265 261 261 sky130_fd_pr__nfet_01v8 L=0.15U W=0.65U AS=0.091P
+ AD=0.095875P PS=0.93U PD=0.945U
* device instance $239 r0 *1 34.945,18.48 sky130_fd_pr__nfet_01v8
M$239 97 267 326 326 sky130_fd_pr__nfet_01v8 L=0.15U W=0.65U AS=0.095875P
+ AD=0.17225P PS=0.945U PD=1.83U
* device instance $240 r0 *1 35.89,18.48 sky130_fd_pr__nfet_01v8
M$240 272 63 97 97 sky130_fd_pr__nfet_01v8 L=0.15U W=0.65U AS=0.169P
+ AD=0.08775P PS=1.82U PD=0.92U
* device instance $241 r0 *1 36.31,18.48 sky130_fd_pr__nfet_01v8
M$241 97 219 272 272 sky130_fd_pr__nfet_01v8 L=0.15U W=0.65U AS=0.08775P
+ AD=0.169P PS=0.92U PD=1.82U
* device instance $242 r0 *1 36.25,14.16 sky130_fd_pr__nfet_01v8
M$242 266 267 97 97 sky130_fd_pr__nfet_01v8 L=0.15U W=1.3U AS=0.25675P
+ AD=0.28925P PS=2.74U PD=2.84U
* device instance $244 r0 *1 37.73,14.16 sky130_fd_pr__nfet_01v8
M$244 97 265 268 268 sky130_fd_pr__nfet_01v8 L=0.15U W=1.3U AS=0.25675P
+ AD=0.1755P PS=2.74U PD=1.84U
* device instance $246 r0 *1 38.57,14.16 sky130_fd_pr__nfet_01v8
M$246 270 269 268 268 sky130_fd_pr__nfet_01v8 L=0.15U W=1.3U AS=0.1755P
+ AD=0.25675P PS=1.84U PD=2.74U
* device instance $248 r0 *1 39.93,14.16 sky130_fd_pr__nfet_01v8
M$248 270 263 271 271 sky130_fd_pr__nfet_01v8 L=0.15U W=1.3U AS=0.25675P
+ AD=0.18525P PS=2.74U PD=1.87U
* device instance $250 r0 *1 40.8,14.16 sky130_fd_pr__nfet_01v8
M$250 97 272 271 271 sky130_fd_pr__nfet_01v8 L=0.15U W=1.3U AS=0.18525P
+ AD=0.25675P PS=1.87U PD=2.09U
* device instance $252 r0 *1 41.89,14.16 sky130_fd_pr__nfet_01v8
M$252 97 273 271 271 sky130_fd_pr__nfet_01v8 L=0.15U W=1.3U AS=0.25675P
+ AD=0.25675P PS=2.09U PD=2.74U
* device instance $254 r0 *1 45.325,14.045 sky130_fd_pr__nfet_01v8
M$254 97 128 274 274 sky130_fd_pr__nfet_01v8 L=0.15U W=0.42U AS=0.1092P
+ AD=0.10025P PS=1.36U PD=0.985U
* device instance $255 r0 *1 45.81,14.16 sky130_fd_pr__nfet_01v8
M$255 273 195 97 97 sky130_fd_pr__nfet_01v8 L=0.15U W=0.65U AS=0.10025P
+ AD=0.08775P PS=0.985U PD=0.92U
* device instance $256 r0 *1 46.23,14.16 sky130_fd_pr__nfet_01v8
M$256 97 274 273 273 sky130_fd_pr__nfet_01v8 L=0.15U W=0.65U AS=0.08775P
+ AD=0.169P PS=0.92U PD=1.82U
* device instance $257 r0 *1 47.39,14.16 sky130_fd_pr__nfet_01v8
M$257 68 275 97 97 sky130_fd_pr__nfet_01v8 L=0.15U W=0.65U AS=0.169P
+ AD=0.08775P PS=1.82U PD=0.92U
* device instance $258 r0 *1 47.81,14.16 sky130_fd_pr__nfet_01v8
M$258 97 273 68 68 sky130_fd_pr__nfet_01v8 L=0.15U W=0.65U AS=0.08775P
+ AD=0.169P PS=0.92U PD=1.82U
* device instance $259 r0 *1 50.385,14.045 sky130_fd_pr__nfet_01v8
M$259 97 195 276 276 sky130_fd_pr__nfet_01v8 L=0.15U W=0.42U AS=0.1092P
+ AD=0.10025P PS=1.36U PD=0.985U
* device instance $260 r0 *1 50.87,14.16 sky130_fd_pr__nfet_01v8
M$260 275 128 97 97 sky130_fd_pr__nfet_01v8 L=0.15U W=0.65U AS=0.10025P
+ AD=0.08775P PS=0.985U PD=0.92U
* device instance $261 r0 *1 51.29,14.16 sky130_fd_pr__nfet_01v8
M$261 97 276 275 275 sky130_fd_pr__nfet_01v8 L=0.15U W=0.65U AS=0.08775P
+ AD=0.169P PS=0.92U PD=1.82U
* device instance $262 r0 *1 53.625,18.595 sky130_fd_pr__nfet_01v8
M$262 307 306 97 97 sky130_fd_pr__nfet_01v8 L=0.15U W=0.42U AS=0.10025P
+ AD=0.1092P PS=0.985U PD=1.36U
* device instance $263 r0 *1 54.11,18.48 sky130_fd_pr__nfet_01v8
M$263 128 306 97 97 sky130_fd_pr__nfet_01v8 L=0.15U W=0.65U AS=0.10025P
+ AD=0.182P PS=0.985U PD=1.86U
* device instance $264 r0 *1 57.655,14.045 sky130_fd_pr__nfet_01v8
M$264 277 275 97 97 sky130_fd_pr__nfet_01v8 L=0.15U W=0.42U AS=0.1092P
+ AD=0.0567P PS=1.36U PD=0.69U
* device instance $265 r0 *1 58.075,14.045 sky130_fd_pr__nfet_01v8
M$265 97 271 277 277 sky130_fd_pr__nfet_01v8 L=0.15U W=0.42U AS=0.0567P
+ AD=0.10025P PS=0.69U PD=0.985U
* device instance $266 r0 *1 58.56,14.16 sky130_fd_pr__nfet_01v8
M$266 278 277 97 97 sky130_fd_pr__nfet_01v8 L=0.15U W=0.65U AS=0.10025P
+ AD=0.169P PS=0.985U PD=1.82U
* device instance $267 r0 *1 59.95,18.48 sky130_fd_pr__nfet_01v8
M$267 97 221 318 318 sky130_fd_pr__nfet_01v8 L=0.15U W=1.3U AS=0.25675P
+ AD=0.1755P PS=2.74U PD=1.84U
* device instance $269 r0 *1 60.79,18.48 sky130_fd_pr__nfet_01v8
M$269 97 271 318 318 sky130_fd_pr__nfet_01v8 L=0.15U W=1.3U AS=0.1755P
+ AD=0.1755P PS=1.84U PD=1.84U
* device instance $271 r0 *1 61.63,18.48 sky130_fd_pr__nfet_01v8
M$271 97 275 318 318 sky130_fd_pr__nfet_01v8 L=0.15U W=1.3U AS=0.3185P
+ AD=0.3185P PS=2.28U PD=2.28U
* device instance $273 r0 *1 62.91,18.48 sky130_fd_pr__nfet_01v8
M$273 319 210 318 318 sky130_fd_pr__nfet_01v8 L=0.15U W=1.3U AS=0.1755P
+ AD=0.26975P PS=1.84U PD=2.78U
* device instance $275 r0 *1 63.52,14.045 sky130_fd_pr__nfet_01v8
M$275 97 221 279 279 sky130_fd_pr__nfet_01v8 L=0.15U W=0.42U AS=0.1113P
+ AD=0.0588P PS=1.37U PD=0.7U
* device instance $276 r0 *1 63.95,14.045 sky130_fd_pr__nfet_01v8
M$276 279 278 97 97 sky130_fd_pr__nfet_01v8 L=0.15U W=0.42U AS=0.0588P
+ AD=0.0588P PS=0.7U PD=0.7U
* device instance $277 r0 *1 64.38,14.045 sky130_fd_pr__nfet_01v8
M$277 280 210 279 279 sky130_fd_pr__nfet_01v8 L=0.15U W=0.42U AS=0.0588P
+ AD=0.1113P PS=0.7U PD=1.37U
* device instance $278 r0 *1 64.31,18.48 sky130_fd_pr__nfet_01v8
M$278 319 311 308 308 sky130_fd_pr__nfet_01v8 L=0.15U W=1.3U AS=0.26975P
+ AD=0.25675P PS=2.78U PD=2.74U
* device instance $280 r0 *1 65.33,14.16 sky130_fd_pr__nfet_01v8
M$280 97 278 281 281 sky130_fd_pr__nfet_01v8 L=0.15U W=0.65U AS=0.169P
+ AD=0.08775P PS=1.82U PD=0.92U
* device instance $281 r0 *1 65.75,14.16 sky130_fd_pr__nfet_01v8
M$281 220 281 97 97 sky130_fd_pr__nfet_01v8 L=0.15U W=2.6U AS=0.351P
+ AD=0.43225P PS=3.68U PD=4.58U
* device instance $285 r0 *1 17.03,19.6 sky130_fd_pr__nfet_01v8
M$285 97 341 327 327 sky130_fd_pr__nfet_01v8 L=0.15U W=0.65U AS=0.169P
+ AD=0.08775P PS=1.82U PD=0.92U
* device instance $286 r0 *1 17.45,19.6 sky130_fd_pr__nfet_01v8
M$286 180 327 97 97 sky130_fd_pr__nfet_01v8 L=0.15U W=2.6U AS=0.351P
+ AD=0.43225P PS=3.68U PD=4.58U
* device instance $290 r0 *1 19.79,19.6 sky130_fd_pr__nfet_01v8
M$290 328 341 97 97 sky130_fd_pr__nfet_01v8 L=0.15U W=2.6U AS=0.43225P
+ AD=0.351P PS=4.58U PD=3.68U
* device instance $293 r0 *1 21.05,19.6 sky130_fd_pr__nfet_01v8
M$293 329 257 328 328 sky130_fd_pr__nfet_01v8 L=0.15U W=2.6U AS=0.351P
+ AD=0.351P PS=3.68U PD=3.68U
* device instance $298 r0 *1 23.15,19.6 sky130_fd_pr__nfet_01v8
M$298 329 330 97 97 sky130_fd_pr__nfet_01v8 L=0.15U W=2.6U AS=0.378625P
+ AD=0.47775P PS=3.765U PD=4.72U
* device instance $301 r0 *1 24.49,19.6 sky130_fd_pr__nfet_01v8
M$301 97 283 329 329 sky130_fd_pr__nfet_01v8 L=0.15U W=2.6U AS=0.352625P
+ AD=0.35425P PS=3.685U PD=3.69U
* device instance $306 r0 *1 27.155,19.485 sky130_fd_pr__nfet_01v8
M$306 331 298 97 97 sky130_fd_pr__nfet_01v8 L=0.15U W=1.68U AS=0.2877P
+ AD=0.2352P PS=3.47U PD=2.8U
* device instance $310 r0 *1 28.875,19.485 sky130_fd_pr__nfet_01v8
M$310 31 331 97 97 sky130_fd_pr__nfet_01v8 L=0.15U W=6.72U AS=0.93975P
+ AD=0.99225P PS=11.195U PD=11.865U
* device instance $326 r0 *1 36.35,19.6 sky130_fd_pr__nfet_01v8
M$326 97 269 332 332 sky130_fd_pr__nfet_01v8 L=0.15U W=0.65U AS=0.169P
+ AD=0.08775P PS=1.82U PD=0.92U
* device instance $327 r0 *1 36.77,19.6 sky130_fd_pr__nfet_01v8
M$327 267 332 97 97 sky130_fd_pr__nfet_01v8 L=0.15U W=2.6U AS=0.351P
+ AD=0.43225P PS=3.68U PD=4.58U
* device instance $331 r0 *1 44.17,18.595 sky130_fd_pr__nfet_01v8
M$331 97 34 299 299 sky130_fd_pr__nfet_01v8 L=0.15U W=0.42U AS=0.1092P
+ AD=0.0567P PS=1.36U PD=0.69U
* device instance $332 r0 *1 44.59,18.595 sky130_fd_pr__nfet_01v8
M$332 300 299 97 97 sky130_fd_pr__nfet_01v8 L=0.15U W=0.42U AS=0.0567P
+ AD=0.1092P PS=0.69U PD=1.36U
* device instance $333 r0 *1 45.53,18.595 sky130_fd_pr__nfet_01v8
M$333 325 197 301 301 sky130_fd_pr__nfet_01v8 L=0.15U W=0.42U AS=0.1092P
+ AD=0.0441P PS=1.36U PD=0.63U
* device instance $334 r0 *1 45.89,18.595 sky130_fd_pr__nfet_01v8
M$334 97 303 325 325 sky130_fd_pr__nfet_01v8 L=0.15U W=0.42U AS=0.0441P
+ AD=0.1092P PS=0.63U PD=1.36U
* device instance $335 r0 *1 46.475,19.485 sky130_fd_pr__nfet_01v8
M$335 333 298 97 97 sky130_fd_pr__nfet_01v8 L=0.15U W=1.68U AS=0.2877P
+ AD=0.2352P PS=3.47U PD=2.8U
* device instance $339 r0 *1 48.195,19.485 sky130_fd_pr__nfet_01v8
M$339 34 333 97 97 sky130_fd_pr__nfet_01v8 L=0.15U W=6.72U AS=0.93975P
+ AD=0.99225P PS=11.195U PD=11.865U
* device instance $355 r0 *1 46.83,18.595 sky130_fd_pr__nfet_01v8
M$355 97 303 302 302 sky130_fd_pr__nfet_01v8 L=0.15U W=0.42U AS=0.1092P
+ AD=0.0609P PS=1.36U PD=0.71U
* device instance $356 r0 *1 47.27,18.595 sky130_fd_pr__nfet_01v8
M$356 323 302 97 97 sky130_fd_pr__nfet_01v8 L=0.15U W=0.42U AS=0.0609P
+ AD=0.0756P PS=0.71U PD=0.78U
* device instance $357 r0 *1 47.78,18.595 sky130_fd_pr__nfet_01v8
M$357 301 307 323 323 sky130_fd_pr__nfet_01v8 L=0.15U W=0.42U AS=0.0756P
+ AD=0.1446P PS=0.78U PD=1.18U
* device instance $358 r0 *1 48.69,18.625 sky130_fd_pr__nfet_01v8
M$358 304 299 301 301 sky130_fd_pr__nfet_01v8 L=0.15U W=0.36U AS=0.1446P
+ AD=0.0522P PS=1.18U PD=0.65U
* device instance $359 r0 *1 49.13,18.625 sky130_fd_pr__nfet_01v8
M$359 304 300 322 322 sky130_fd_pr__nfet_01v8 L=0.15U W=0.36U AS=0.0759P
+ AD=0.0522P PS=0.8U PD=0.65U
* device instance $360 r0 *1 49.66,18.595 sky130_fd_pr__nfet_01v8
M$360 322 305 97 97 sky130_fd_pr__nfet_01v8 L=0.15U W=0.42U AS=0.12095P
+ AD=0.0759P PS=1.085U PD=0.8U
* device instance $361 r0 *1 50.255,18.485 sky130_fd_pr__nfet_01v8
M$361 305 304 97 97 sky130_fd_pr__nfet_01v8 L=0.15U W=0.64U AS=0.12095P
+ AD=0.1664P PS=1.085U PD=1.8U
* device instance $362 r0 *1 51.195,18.595 sky130_fd_pr__nfet_01v8
M$362 321 305 97 97 sky130_fd_pr__nfet_01v8 L=0.15U W=0.42U AS=0.1092P
+ AD=0.0678P PS=1.36U PD=0.755U
* device instance $363 r0 *1 51.68,18.625 sky130_fd_pr__nfet_01v8
M$363 306 300 321 321 sky130_fd_pr__nfet_01v8 L=0.15U W=0.36U AS=0.0678P
+ AD=0.0684P PS=0.755U PD=0.74U
* device instance $364 r0 *1 52.21,18.625 sky130_fd_pr__nfet_01v8
M$364 306 299 320 320 sky130_fd_pr__nfet_01v8 L=0.15U W=0.36U AS=0.066P
+ AD=0.0684P PS=0.745U PD=0.74U
* device instance $365 r0 *1 52.685,18.595 sky130_fd_pr__nfet_01v8
M$365 97 307 320 320 sky130_fd_pr__nfet_01v8 L=0.15U W=0.42U AS=0.066P
+ AD=0.1092P PS=0.745U PD=1.36U
* device instance $366 r0 *1 63.51,19.6 sky130_fd_pr__nfet_01v8
M$366 340 342 97 97 sky130_fd_pr__nfet_01v8 L=0.15U W=0.65U AS=0.169P
+ AD=0.08775P PS=1.82U PD=0.92U
* device instance $367 r0 *1 63.93,19.6 sky130_fd_pr__nfet_01v8
M$367 334 311 340 340 sky130_fd_pr__nfet_01v8 L=0.15U W=0.65U AS=0.08775P
+ AD=0.169P PS=0.92U PD=1.82U
* device instance $368 r0 *1 64.97,19.6 sky130_fd_pr__nfet_01v8
M$368 339 280 335 335 sky130_fd_pr__nfet_01v8 L=0.15U W=0.65U AS=0.169P
+ AD=0.06825P PS=1.82U PD=0.86U
* device instance $369 r0 *1 65.33,19.6 sky130_fd_pr__nfet_01v8
M$369 97 334 339 339 sky130_fd_pr__nfet_01v8 L=0.15U W=0.65U AS=0.06825P
+ AD=0.08775P PS=0.86U PD=0.92U
* device instance $370 r0 *1 65.75,19.6 sky130_fd_pr__nfet_01v8
M$370 336 334 97 97 sky130_fd_pr__nfet_01v8 L=0.15U W=0.65U AS=0.08775P
+ AD=0.169P PS=0.92U PD=1.82U
* device instance $371 r0 *1 66.69,19.6 sky130_fd_pr__nfet_01v8
M$371 336 280 97 97 sky130_fd_pr__nfet_01v8 L=0.15U W=0.65U AS=0.169P
+ AD=0.08775P PS=1.82U PD=0.92U
* device instance $372 r0 *1 67.11,19.6 sky130_fd_pr__nfet_01v8
M$372 347 335 336 336 sky130_fd_pr__nfet_01v8 L=0.15U W=0.65U AS=0.08775P
+ AD=0.195P PS=0.92U PD=1.9U
* device instance $373 r0 *1 68.325,19.485 sky130_fd_pr__nfet_01v8
M$373 97 343 337 337 sky130_fd_pr__nfet_01v8 L=0.15U W=0.42U AS=0.1092P
+ AD=0.10025P PS=1.36U PD=0.985U
* device instance $374 r0 *1 68.81,19.6 sky130_fd_pr__nfet_01v8
M$374 338 344 97 97 sky130_fd_pr__nfet_01v8 L=0.15U W=0.65U AS=0.10025P
+ AD=0.08775P PS=0.985U PD=0.92U
* device instance $375 r0 *1 69.23,19.6 sky130_fd_pr__nfet_01v8
M$375 97 337 338 338 sky130_fd_pr__nfet_01v8 L=0.15U W=0.65U AS=0.08775P
+ AD=0.169P PS=0.92U PD=1.82U
* device instance $376 r0 *1 6.98,24.035 sky130_fd_pr__nfet_01v8
M$376 414 352 353 353 sky130_fd_pr__nfet_01v8 L=0.15U W=0.42U AS=0.1113P
+ AD=0.0441P PS=1.37U PD=0.63U
* device instance $377 r0 *1 7.34,24.035 sky130_fd_pr__nfet_01v8
M$377 97 115 414 414 sky130_fd_pr__nfet_01v8 L=0.15U W=0.42U AS=0.0441P
+ AD=0.0966P PS=0.63U PD=0.88U
* device instance $378 r0 *1 7.95,24.035 sky130_fd_pr__nfet_01v8
M$378 354 353 97 97 sky130_fd_pr__nfet_01v8 L=0.15U W=0.42U AS=0.0966P
+ AD=0.1113P PS=0.88U PD=1.37U
* device instance $379 r0 *1 9.21,23.92 sky130_fd_pr__nfet_01v8
M$379 97 354 355 355 sky130_fd_pr__nfet_01v8 L=0.15U W=0.65U AS=0.169P
+ AD=0.10725P PS=1.82U PD=0.98U
* device instance $380 r0 *1 9.69,23.92 sky130_fd_pr__nfet_01v8
M$380 416 399 97 97 sky130_fd_pr__nfet_01v8 L=0.15U W=0.65U AS=0.10725P
+ AD=0.06825P PS=0.98U PD=0.86U
* device instance $381 r0 *1 10.05,23.92 sky130_fd_pr__nfet_01v8
M$381 355 92 416 416 sky130_fd_pr__nfet_01v8 L=0.15U W=0.65U AS=0.06825P
+ AD=0.169P PS=0.86U PD=1.82U
* device instance $382 r0 *1 10.99,23.92 sky130_fd_pr__nfet_01v8
M$382 417 157 355 355 sky130_fd_pr__nfet_01v8 L=0.15U W=0.65U AS=0.169P
+ AD=0.10725P PS=1.82U PD=0.98U
* device instance $383 r0 *1 11.47,23.92 sky130_fd_pr__nfet_01v8
M$383 97 360 417 417 sky130_fd_pr__nfet_01v8 L=0.15U W=0.65U AS=0.10725P
+ AD=0.102375P PS=0.98U PD=0.965U
* device instance $384 r0 *1 11.935,23.92 sky130_fd_pr__nfet_01v8
M$384 411 355 97 97 sky130_fd_pr__nfet_01v8 L=0.15U W=0.65U AS=0.102375P
+ AD=0.169P PS=0.965U PD=1.82U
* device instance $385 r0 *1 12.93,23.92 sky130_fd_pr__nfet_01v8
M$385 358 400 97 97 sky130_fd_pr__nfet_01v8 L=0.15U W=0.65U AS=0.169P
+ AD=0.08775P PS=1.82U PD=0.92U
* device instance $386 r0 *1 13.35,23.92 sky130_fd_pr__nfet_01v8
M$386 97 294 358 358 sky130_fd_pr__nfet_01v8 L=0.15U W=0.65U AS=0.08775P
+ AD=0.08775P PS=0.92U PD=0.92U
* device instance $387 r0 *1 13.77,23.92 sky130_fd_pr__nfet_01v8
M$387 420 294 97 97 sky130_fd_pr__nfet_01v8 L=0.15U W=0.65U AS=0.08775P
+ AD=0.08775P PS=0.92U PD=0.92U
* device instance $388 r0 *1 14.19,23.92 sky130_fd_pr__nfet_01v8
M$388 360 400 420 420 sky130_fd_pr__nfet_01v8 L=0.15U W=0.65U AS=0.08775P
+ AD=0.25025P PS=0.92U PD=1.42U
* device instance $389 r0 *1 15.11,23.92 sky130_fd_pr__nfet_01v8
M$389 97 358 360 360 sky130_fd_pr__nfet_01v8 L=0.15U W=0.65U AS=0.25025P
+ AD=0.208P PS=1.42U PD=1.94U
* device instance $390 r0 *1 17.49,24.005 sky130_fd_pr__nfet_01v8
M$390 361 408 97 97 sky130_fd_pr__nfet_01v8 L=0.15U W=0.42U AS=0.1092P
+ AD=0.0693P PS=1.36U PD=0.75U
* device instance $391 r0 *1 17.97,24.005 sky130_fd_pr__nfet_01v8
M$391 97 12 361 361 sky130_fd_pr__nfet_01v8 L=0.15U W=0.42U AS=0.0693P
+ AD=0.0567P PS=0.75U PD=0.69U
* device instance $392 r0 *1 18.39,24.005 sky130_fd_pr__nfet_01v8
M$392 361 399 97 97 sky130_fd_pr__nfet_01v8 L=0.15U W=0.42U AS=0.0567P
+ AD=0.0567P PS=0.69U PD=0.69U
* device instance $393 r0 *1 18.81,24.005 sky130_fd_pr__nfet_01v8
M$393 361 219 97 97 sky130_fd_pr__nfet_01v8 L=0.15U W=0.42U AS=0.101875P
+ AD=0.0567P PS=0.99U PD=0.69U
* device instance $394 r0 *1 19.3,23.92 sky130_fd_pr__nfet_01v8
M$394 362 361 97 97 sky130_fd_pr__nfet_01v8 L=0.15U W=0.65U AS=0.101875P
+ AD=0.1755P PS=0.99U PD=1.84U
* device instance $395 r0 *1 27.625,24.035 sky130_fd_pr__nfet_01v8
M$395 363 31 97 97 sky130_fd_pr__nfet_01v8 L=0.15U W=1.68U AS=0.315P AD=0.3423P
+ PS=3.6U PD=3.73U
* device instance $399 r0 *1 41.41,24.035 sky130_fd_pr__nfet_01v8
M$399 97 34 364 364 sky130_fd_pr__nfet_01v8 L=0.15U W=0.42U AS=0.1092P
+ AD=0.0567P PS=1.36U PD=0.69U
* device instance $400 r0 *1 41.83,24.035 sky130_fd_pr__nfet_01v8
M$400 365 364 97 97 sky130_fd_pr__nfet_01v8 L=0.15U W=0.42U AS=0.0567P
+ AD=0.1092P PS=0.69U PD=1.36U
* device instance $401 r0 *1 42.77,24.035 sky130_fd_pr__nfet_01v8
M$401 427 401 366 366 sky130_fd_pr__nfet_01v8 L=0.15U W=0.42U AS=0.1092P
+ AD=0.0441P PS=1.36U PD=0.63U
* device instance $402 r0 *1 43.13,24.035 sky130_fd_pr__nfet_01v8
M$402 97 94 427 427 sky130_fd_pr__nfet_01v8 L=0.15U W=0.42U AS=0.0441P
+ AD=0.1092P PS=0.63U PD=1.36U
* device instance $403 r0 *1 44.07,24.035 sky130_fd_pr__nfet_01v8
M$403 97 94 367 367 sky130_fd_pr__nfet_01v8 L=0.15U W=0.42U AS=0.1092P
+ AD=0.0609P PS=1.36U PD=0.71U
* device instance $404 r0 *1 44.51,24.035 sky130_fd_pr__nfet_01v8
M$404 426 367 97 97 sky130_fd_pr__nfet_01v8 L=0.15U W=0.42U AS=0.0609P
+ AD=0.0756P PS=0.71U PD=0.78U
* device instance $405 r0 *1 45.02,24.035 sky130_fd_pr__nfet_01v8
M$405 366 371 426 426 sky130_fd_pr__nfet_01v8 L=0.15U W=0.42U AS=0.0756P
+ AD=0.1446P PS=0.78U PD=1.18U
* device instance $406 r0 *1 45.93,24.065 sky130_fd_pr__nfet_01v8
M$406 368 364 366 366 sky130_fd_pr__nfet_01v8 L=0.15U W=0.36U AS=0.1446P
+ AD=0.0522P PS=1.18U PD=0.65U
* device instance $407 r0 *1 46.37,24.065 sky130_fd_pr__nfet_01v8
M$407 368 365 425 425 sky130_fd_pr__nfet_01v8 L=0.15U W=0.36U AS=0.0759P
+ AD=0.0522P PS=0.8U PD=0.65U
* device instance $408 r0 *1 46.9,24.035 sky130_fd_pr__nfet_01v8
M$408 425 369 97 97 sky130_fd_pr__nfet_01v8 L=0.15U W=0.42U AS=0.12095P
+ AD=0.0759P PS=1.085U PD=0.8U
* device instance $409 r0 *1 47.495,23.925 sky130_fd_pr__nfet_01v8
M$409 369 368 97 97 sky130_fd_pr__nfet_01v8 L=0.15U W=0.64U AS=0.12095P
+ AD=0.1664P PS=1.085U PD=1.8U
* device instance $410 r0 *1 48.435,24.035 sky130_fd_pr__nfet_01v8
M$410 424 369 97 97 sky130_fd_pr__nfet_01v8 L=0.15U W=0.42U AS=0.1092P
+ AD=0.0678P PS=1.36U PD=0.755U
* device instance $411 r0 *1 48.92,24.065 sky130_fd_pr__nfet_01v8
M$411 370 365 424 424 sky130_fd_pr__nfet_01v8 L=0.15U W=0.36U AS=0.0678P
+ AD=0.0684P PS=0.755U PD=0.74U
* device instance $412 r0 *1 49.45,24.065 sky130_fd_pr__nfet_01v8
M$412 370 364 423 423 sky130_fd_pr__nfet_01v8 L=0.15U W=0.36U AS=0.066P
+ AD=0.0684P PS=0.745U PD=0.74U
* device instance $413 r0 *1 49.925,24.035 sky130_fd_pr__nfet_01v8
M$413 97 371 423 423 sky130_fd_pr__nfet_01v8 L=0.15U W=0.42U AS=0.066P
+ AD=0.1092P PS=0.745U PD=1.36U
* device instance $414 r0 *1 50.865,24.035 sky130_fd_pr__nfet_01v8
M$414 371 370 97 97 sky130_fd_pr__nfet_01v8 L=0.15U W=0.42U AS=0.10025P
+ AD=0.1092P PS=0.985U PD=1.36U
* device instance $415 r0 *1 51.35,23.92 sky130_fd_pr__nfet_01v8
M$415 372 370 97 97 sky130_fd_pr__nfet_01v8 L=0.15U W=0.65U AS=0.10025P
+ AD=0.182P PS=0.985U PD=1.86U
* device instance $416 r0 *1 53.39,23.92 sky130_fd_pr__nfet_01v8
M$416 409 374 97 97 sky130_fd_pr__nfet_01v8 L=0.15U W=1.3U AS=0.26975P
+ AD=0.1755P PS=2.78U PD=1.84U
* device instance $418 r0 *1 54.23,23.92 sky130_fd_pr__nfet_01v8
M$418 409 344 97 97 sky130_fd_pr__nfet_01v8 L=0.15U W=1.3U AS=0.1755P
+ AD=0.26975P PS=1.84U PD=2.78U
* device instance $420 r0 *1 55.63,23.92 sky130_fd_pr__nfet_01v8
M$420 409 161 97 97 sky130_fd_pr__nfet_01v8 L=0.15U W=1.3U AS=0.26975P
+ AD=0.1755P PS=2.78U PD=1.84U
* device instance $422 r0 *1 56.47,23.92 sky130_fd_pr__nfet_01v8
M$422 409 195 97 97 sky130_fd_pr__nfet_01v8 L=0.15U W=1.3U AS=0.1755P
+ AD=0.25675P PS=1.84U PD=2.74U
* device instance $424 r0 *1 60.73,23.92 sky130_fd_pr__nfet_01v8
M$424 97 402 377 377 sky130_fd_pr__nfet_01v8 L=0.15U W=0.65U AS=0.169P
+ AD=0.10725P PS=1.82U PD=0.98U
* device instance $425 r0 *1 61.21,23.92 sky130_fd_pr__nfet_01v8
M$425 422 344 97 97 sky130_fd_pr__nfet_01v8 L=0.15U W=0.65U AS=0.10725P
+ AD=0.06825P PS=0.98U PD=0.86U
* device instance $426 r0 *1 61.57,23.92 sky130_fd_pr__nfet_01v8
M$426 377 92 422 422 sky130_fd_pr__nfet_01v8 L=0.15U W=0.65U AS=0.06825P
+ AD=0.169P PS=0.86U PD=1.82U
* device instance $427 r0 *1 62.51,23.92 sky130_fd_pr__nfet_01v8
M$427 421 134 377 377 sky130_fd_pr__nfet_01v8 L=0.15U W=0.65U AS=0.169P
+ AD=0.10725P PS=1.82U PD=0.98U
* device instance $428 r0 *1 62.99,23.92 sky130_fd_pr__nfet_01v8
M$428 97 347 421 421 sky130_fd_pr__nfet_01v8 L=0.15U W=0.65U AS=0.10725P
+ AD=0.102375P PS=0.98U PD=0.965U
* device instance $429 r0 *1 63.455,23.92 sky130_fd_pr__nfet_01v8
M$429 380 377 97 97 sky130_fd_pr__nfet_01v8 L=0.15U W=0.65U AS=0.102375P
+ AD=0.169P PS=0.965U PD=1.82U
* device instance $430 r0 *1 64.41,24.035 sky130_fd_pr__nfet_01v8
M$430 97 34 381 381 sky130_fd_pr__nfet_01v8 L=0.15U W=0.42U AS=0.1092P
+ AD=0.0567P PS=1.36U PD=0.69U
* device instance $431 r0 *1 64.83,24.035 sky130_fd_pr__nfet_01v8
M$431 382 381 97 97 sky130_fd_pr__nfet_01v8 L=0.15U W=0.42U AS=0.0567P
+ AD=0.1092P PS=0.69U PD=1.36U
* device instance $432 r0 *1 65.77,24.035 sky130_fd_pr__nfet_01v8
M$432 419 403 383 383 sky130_fd_pr__nfet_01v8 L=0.15U W=0.42U AS=0.1092P
+ AD=0.0441P PS=1.36U PD=0.63U
* device instance $433 r0 *1 66.13,24.035 sky130_fd_pr__nfet_01v8
M$433 97 410 419 419 sky130_fd_pr__nfet_01v8 L=0.15U W=0.42U AS=0.0441P
+ AD=0.1092P PS=0.63U PD=1.36U
* device instance $434 r0 *1 67.07,24.035 sky130_fd_pr__nfet_01v8
M$434 97 410 384 384 sky130_fd_pr__nfet_01v8 L=0.15U W=0.42U AS=0.1092P
+ AD=0.0609P PS=1.36U PD=0.71U
* device instance $435 r0 *1 67.51,24.035 sky130_fd_pr__nfet_01v8
M$435 418 384 97 97 sky130_fd_pr__nfet_01v8 L=0.15U W=0.42U AS=0.0609P
+ AD=0.0756P PS=0.71U PD=0.78U
* device instance $436 r0 *1 68.02,24.035 sky130_fd_pr__nfet_01v8
M$436 383 388 418 418 sky130_fd_pr__nfet_01v8 L=0.15U W=0.42U AS=0.0756P
+ AD=0.1446P PS=0.78U PD=1.18U
* device instance $437 r0 *1 68.93,24.065 sky130_fd_pr__nfet_01v8
M$437 385 381 383 383 sky130_fd_pr__nfet_01v8 L=0.15U W=0.36U AS=0.1446P
+ AD=0.0522P PS=1.18U PD=0.65U
* device instance $438 r0 *1 69.37,24.065 sky130_fd_pr__nfet_01v8
M$438 385 382 415 415 sky130_fd_pr__nfet_01v8 L=0.15U W=0.36U AS=0.0759P
+ AD=0.0522P PS=0.8U PD=0.65U
* device instance $439 r0 *1 69.9,24.035 sky130_fd_pr__nfet_01v8
M$439 415 386 97 97 sky130_fd_pr__nfet_01v8 L=0.15U W=0.42U AS=0.12095P
+ AD=0.0759P PS=1.085U PD=0.8U
* device instance $440 r0 *1 70.495,23.925 sky130_fd_pr__nfet_01v8
M$440 386 385 97 97 sky130_fd_pr__nfet_01v8 L=0.15U W=0.64U AS=0.12095P
+ AD=0.1664P PS=1.085U PD=1.8U
* device instance $441 r0 *1 71.435,24.035 sky130_fd_pr__nfet_01v8
M$441 413 386 97 97 sky130_fd_pr__nfet_01v8 L=0.15U W=0.42U AS=0.1092P
+ AD=0.0678P PS=1.36U PD=0.755U
* device instance $442 r0 *1 71.92,24.065 sky130_fd_pr__nfet_01v8
M$442 387 382 413 413 sky130_fd_pr__nfet_01v8 L=0.15U W=0.36U AS=0.0678P
+ AD=0.0684P PS=0.755U PD=0.74U
* device instance $443 r0 *1 72.45,24.065 sky130_fd_pr__nfet_01v8
M$443 387 381 412 412 sky130_fd_pr__nfet_01v8 L=0.15U W=0.36U AS=0.066P
+ AD=0.0684P PS=0.745U PD=0.74U
* device instance $444 r0 *1 72.925,24.035 sky130_fd_pr__nfet_01v8
M$444 97 388 412 412 sky130_fd_pr__nfet_01v8 L=0.15U W=0.42U AS=0.066P
+ AD=0.1092P PS=0.745U PD=1.36U
* device instance $445 r0 *1 73.865,24.035 sky130_fd_pr__nfet_01v8
M$445 388 387 97 97 sky130_fd_pr__nfet_01v8 L=0.15U W=0.42U AS=0.10025P
+ AD=0.1092P PS=0.985U PD=1.36U
* device instance $446 r0 *1 74.35,23.92 sky130_fd_pr__nfet_01v8
M$446 344 387 97 97 sky130_fd_pr__nfet_01v8 L=0.15U W=0.65U AS=0.10025P
+ AD=0.182P PS=0.985U PD=1.86U
* device instance $447 r0 *1 4.61,24.925 sky130_fd_pr__nfet_01v8
M$447 97 31 428 428 sky130_fd_pr__nfet_01v8 L=0.15U W=0.42U AS=0.1092P
+ AD=0.0567P PS=1.36U PD=0.69U
* device instance $448 r0 *1 5.03,24.925 sky130_fd_pr__nfet_01v8
M$448 429 428 97 97 sky130_fd_pr__nfet_01v8 L=0.15U W=0.42U AS=0.0567P
+ AD=0.1092P PS=0.69U PD=1.36U
* device instance $449 r0 *1 5.97,24.925 sky130_fd_pr__nfet_01v8
M$449 451 459 430 430 sky130_fd_pr__nfet_01v8 L=0.15U W=0.42U AS=0.1092P
+ AD=0.0441P PS=1.36U PD=0.63U
* device instance $450 r0 *1 6.33,24.925 sky130_fd_pr__nfet_01v8
M$450 97 94 451 451 sky130_fd_pr__nfet_01v8 L=0.15U W=0.42U AS=0.0441P
+ AD=0.1092P PS=0.63U PD=1.36U
* device instance $451 r0 *1 9.13,24.895 sky130_fd_pr__nfet_01v8
M$451 432 428 430 430 sky130_fd_pr__nfet_01v8 L=0.15U W=0.36U AS=0.1446P
+ AD=0.0522P PS=1.18U PD=0.65U
* device instance $452 r0 *1 9.57,24.895 sky130_fd_pr__nfet_01v8
M$452 453 429 432 432 sky130_fd_pr__nfet_01v8 L=0.15U W=0.36U AS=0.0522P
+ AD=0.0759P PS=0.65U PD=0.8U
* device instance $453 r0 *1 7.27,24.925 sky130_fd_pr__nfet_01v8
M$453 97 94 460 460 sky130_fd_pr__nfet_01v8 L=0.15U W=0.42U AS=0.1092P
+ AD=0.0609P PS=1.36U PD=0.71U
* device instance $454 r0 *1 7.71,24.925 sky130_fd_pr__nfet_01v8
M$454 452 460 97 97 sky130_fd_pr__nfet_01v8 L=0.15U W=0.42U AS=0.0609P
+ AD=0.0756P PS=0.71U PD=0.78U
* device instance $455 r0 *1 8.22,24.925 sky130_fd_pr__nfet_01v8
M$455 430 431 452 452 sky130_fd_pr__nfet_01v8 L=0.15U W=0.42U AS=0.0756P
+ AD=0.1446P PS=0.78U PD=1.18U
* device instance $456 r0 *1 10.1,24.925 sky130_fd_pr__nfet_01v8
M$456 97 433 453 453 sky130_fd_pr__nfet_01v8 L=0.15U W=0.42U AS=0.0759P
+ AD=0.12095P PS=0.8U PD=1.085U
* device instance $457 r0 *1 10.695,25.035 sky130_fd_pr__nfet_01v8
M$457 433 432 97 97 sky130_fd_pr__nfet_01v8 L=0.15U W=0.64U AS=0.12095P
+ AD=0.1664P PS=1.085U PD=1.8U
* device instance $458 r0 *1 12.12,24.895 sky130_fd_pr__nfet_01v8
M$458 434 429 454 454 sky130_fd_pr__nfet_01v8 L=0.15U W=0.36U AS=0.0678P
+ AD=0.0684P PS=0.755U PD=0.74U
* device instance $459 r0 *1 12.65,24.895 sky130_fd_pr__nfet_01v8
M$459 455 428 434 434 sky130_fd_pr__nfet_01v8 L=0.15U W=0.36U AS=0.0684P
+ AD=0.066P PS=0.74U PD=0.745U
* device instance $460 r0 *1 11.635,24.925 sky130_fd_pr__nfet_01v8
M$460 454 433 97 97 sky130_fd_pr__nfet_01v8 L=0.15U W=0.42U AS=0.1092P
+ AD=0.0678P PS=1.36U PD=0.755U
* device instance $461 r0 *1 13.125,24.925 sky130_fd_pr__nfet_01v8
M$461 97 431 455 455 sky130_fd_pr__nfet_01v8 L=0.15U W=0.42U AS=0.066P
+ AD=0.1092P PS=0.745U PD=1.36U
* device instance $462 r0 *1 14.065,24.925 sky130_fd_pr__nfet_01v8
M$462 97 434 431 431 sky130_fd_pr__nfet_01v8 L=0.15U W=0.42U AS=0.1092P
+ AD=0.10025P PS=1.36U PD=0.985U
* device instance $463 r0 *1 14.55,25.04 sky130_fd_pr__nfet_01v8
M$463 399 434 97 97 sky130_fd_pr__nfet_01v8 L=0.15U W=0.65U AS=0.10025P
+ AD=0.182P PS=0.985U PD=1.86U
* device instance $464 r0 *1 18.185,24.925 sky130_fd_pr__nfet_01v8
M$464 97 399 435 435 sky130_fd_pr__nfet_01v8 L=0.15U W=0.42U AS=0.1092P
+ AD=0.10025P PS=1.36U PD=0.985U
* device instance $465 r0 *1 18.67,25.04 sky130_fd_pr__nfet_01v8
M$465 436 461 97 97 sky130_fd_pr__nfet_01v8 L=0.15U W=0.65U AS=0.10025P
+ AD=0.08775P PS=0.985U PD=0.92U
* device instance $466 r0 *1 19.09,25.04 sky130_fd_pr__nfet_01v8
M$466 97 435 436 436 sky130_fd_pr__nfet_01v8 L=0.15U W=0.65U AS=0.08775P
+ AD=0.169P PS=0.92U PD=1.82U
* device instance $467 r0 *1 20.25,25.04 sky130_fd_pr__nfet_01v8
M$467 400 436 97 97 sky130_fd_pr__nfet_01v8 L=0.15U W=0.65U AS=0.169P
+ AD=0.08775P PS=1.82U PD=0.92U
* device instance $468 r0 *1 20.67,25.04 sky130_fd_pr__nfet_01v8
M$468 97 330 400 400 sky130_fd_pr__nfet_01v8 L=0.15U W=0.65U AS=0.08775P
+ AD=0.169P PS=0.92U PD=1.82U
* device instance $469 r0 *1 21.865,24.925 sky130_fd_pr__nfet_01v8
M$469 97 461 437 437 sky130_fd_pr__nfet_01v8 L=0.15U W=0.42U AS=0.1092P
+ AD=0.10025P PS=1.36U PD=0.985U
* device instance $470 r0 *1 22.35,25.04 sky130_fd_pr__nfet_01v8
M$470 330 399 97 97 sky130_fd_pr__nfet_01v8 L=0.15U W=0.65U AS=0.10025P
+ AD=0.08775P PS=0.985U PD=0.92U
* device instance $471 r0 *1 22.77,25.04 sky130_fd_pr__nfet_01v8
M$471 97 437 330 330 sky130_fd_pr__nfet_01v8 L=0.15U W=0.65U AS=0.08775P
+ AD=0.169P PS=0.92U PD=1.82U
* device instance $472 r0 *1 34.985,25.04 sky130_fd_pr__nfet_01v8
M$472 439 440 438 438 sky130_fd_pr__nfet_01v8 L=0.15U W=1.3U AS=0.2665P
+ AD=0.1755P PS=2.77U PD=1.84U
* device instance $474 r0 *1 35.825,25.04 sky130_fd_pr__nfet_01v8
M$474 97 441 438 438 sky130_fd_pr__nfet_01v8 L=0.15U W=1.3U AS=0.1755P
+ AD=0.26975P PS=1.84U PD=2.78U
* device instance $476 r0 *1 37.225,25.04 sky130_fd_pr__nfet_01v8
M$476 442 441 97 97 sky130_fd_pr__nfet_01v8 L=0.15U W=1.3U AS=0.26975P
+ AD=0.1755P PS=2.78U PD=1.84U
* device instance $478 r0 *1 38.065,25.04 sky130_fd_pr__nfet_01v8
M$478 442 440 97 97 sky130_fd_pr__nfet_01v8 L=0.15U W=1.3U AS=0.186875P
+ AD=0.268125P PS=1.875U PD=2.775U
* device instance $480 r0 *1 39.46,25.04 sky130_fd_pr__nfet_01v8
M$480 442 439 2 2 sky130_fd_pr__nfet_01v8 L=0.15U W=1.3U AS=0.25675P
+ AD=0.25675P PS=2.74U PD=2.74U
* device instance $482 r0 *1 46.47,25.04 sky130_fd_pr__nfet_01v8
M$482 97 34 443 443 sky130_fd_pr__nfet_01v8 L=0.15U W=1.95U AS=0.3445P
+ AD=0.26325P PS=3.66U PD=2.76U
* device instance $485 r0 *1 47.73,25.04 sky130_fd_pr__nfet_01v8
M$485 444 443 97 97 sky130_fd_pr__nfet_01v8 L=0.15U W=3.9U AS=0.5265P
+ AD=0.5265P PS=5.52U PD=5.52U
* device instance $491 r0 *1 50.25,25.04 sky130_fd_pr__nfet_01v8
M$491 445 444 97 97 sky130_fd_pr__nfet_01v8 L=0.15U W=10.4U AS=1.404P
+ AD=1.48525P PS=14.72U PD=15.62U
* device instance $507 r0 *1 61.26,24.925 sky130_fd_pr__nfet_01v8
M$507 458 462 446 446 sky130_fd_pr__nfet_01v8 L=0.15U W=0.42U AS=0.1113P
+ AD=0.0441P PS=1.37U PD=0.63U
* device instance $508 r0 *1 61.62,24.925 sky130_fd_pr__nfet_01v8
M$508 97 115 458 458 sky130_fd_pr__nfet_01v8 L=0.15U W=0.42U AS=0.0441P
+ AD=0.0966P PS=0.63U PD=0.88U
* device instance $509 r0 *1 62.23,24.925 sky130_fd_pr__nfet_01v8
M$509 402 446 97 97 sky130_fd_pr__nfet_01v8 L=0.15U W=0.42U AS=0.0966P
+ AD=0.1113P PS=0.88U PD=1.37U
* device instance $510 r0 *1 64.365,24.925 sky130_fd_pr__nfet_01v8
M$510 97 338 311 311 sky130_fd_pr__nfet_01v8 L=0.15U W=0.42U AS=0.1092P
+ AD=0.1197P PS=1.36U PD=1.41U
* device instance $511 r0 *1 65.33,25.155 sky130_fd_pr__nfet_01v8
M$511 447 343 97 97 sky130_fd_pr__nfet_01v8 L=0.15U W=0.42U AS=0.10025P
+ AD=0.1092P PS=0.985U PD=1.36U
* device instance $512 r0 *1 65.815,25.04 sky130_fd_pr__nfet_01v8
M$512 463 344 97 97 sky130_fd_pr__nfet_01v8 L=0.15U W=0.65U AS=0.10025P
+ AD=0.08775P PS=0.985U PD=0.92U
* device instance $513 r0 *1 66.235,25.04 sky130_fd_pr__nfet_01v8
M$513 342 447 463 463 sky130_fd_pr__nfet_01v8 L=0.15U W=0.65U AS=0.08775P
+ AD=0.169P PS=0.92U PD=1.82U
* device instance $514 r0 *1 68.175,24.925 sky130_fd_pr__nfet_01v8
M$514 457 64 97 97 sky130_fd_pr__nfet_01v8 L=0.15U W=0.42U AS=0.11285P
+ AD=0.0693P PS=1.045U PD=0.75U
* device instance $515 r0 *1 68.655,24.925 sky130_fd_pr__nfet_01v8
M$515 448 449 457 457 sky130_fd_pr__nfet_01v8 L=0.15U W=0.42U AS=0.0693P
+ AD=0.09975P PS=0.75U PD=0.895U
* device instance $516 r0 *1 69.28,24.925 sky130_fd_pr__nfet_01v8
M$516 456 343 448 448 sky130_fd_pr__nfet_01v8 L=0.15U W=0.42U AS=0.09975P
+ AD=0.0693P PS=0.895U PD=0.75U
* device instance $517 r0 *1 69.76,24.925 sky130_fd_pr__nfet_01v8
M$517 97 450 456 456 sky130_fd_pr__nfet_01v8 L=0.15U W=0.42U AS=0.0693P
+ AD=0.1449P PS=0.75U PD=1.11U
* device instance $518 r0 *1 70.6,24.925 sky130_fd_pr__nfet_01v8
M$518 450 64 97 97 sky130_fd_pr__nfet_01v8 L=0.15U W=0.42U AS=0.1449P
+ AD=0.1092P PS=1.11U PD=1.36U
* device instance $519 r0 *1 67.63,25.04 sky130_fd_pr__nfet_01v8
M$519 97 448 403 403 sky130_fd_pr__nfet_01v8 L=0.15U W=0.65U AS=0.169P
+ AD=0.11285P PS=1.82U PD=1.045U
* device instance $520 r0 *1 5.07,29.36 sky130_fd_pr__nfet_01v8
M$520 97 476 459 459 sky130_fd_pr__nfet_01v8 L=0.15U W=0.65U AS=0.169P
+ AD=0.11285P PS=1.82U PD=1.045U
* device instance $521 r0 *1 5.615,29.475 sky130_fd_pr__nfet_01v8
M$521 520 64 97 97 sky130_fd_pr__nfet_01v8 L=0.15U W=0.42U AS=0.11285P
+ AD=0.0693P PS=1.045U PD=0.75U
* device instance $522 r0 *1 6.095,29.475 sky130_fd_pr__nfet_01v8
M$522 476 464 520 520 sky130_fd_pr__nfet_01v8 L=0.15U W=0.42U AS=0.0693P
+ AD=0.09975P PS=0.75U PD=0.895U
* device instance $523 r0 *1 6.72,29.475 sky130_fd_pr__nfet_01v8
M$523 522 461 476 476 sky130_fd_pr__nfet_01v8 L=0.15U W=0.42U AS=0.09975P
+ AD=0.0693P PS=0.895U PD=0.75U
* device instance $524 r0 *1 7.2,29.475 sky130_fd_pr__nfet_01v8
M$524 97 515 522 522 sky130_fd_pr__nfet_01v8 L=0.15U W=0.42U AS=0.0693P
+ AD=0.1449P PS=0.75U PD=1.11U
* device instance $525 r0 *1 8.04,29.475 sky130_fd_pr__nfet_01v8
M$525 515 64 97 97 sky130_fd_pr__nfet_01v8 L=0.15U W=0.42U AS=0.1449P
+ AD=0.1092P PS=1.11U PD=1.36U
* device instance $526 r0 *1 9.21,29.475 sky130_fd_pr__nfet_01v8
M$526 97 31 477 477 sky130_fd_pr__nfet_01v8 L=0.15U W=0.42U AS=0.1092P
+ AD=0.0567P PS=1.36U PD=0.69U
* device instance $527 r0 *1 9.63,29.475 sky130_fd_pr__nfet_01v8
M$527 478 477 97 97 sky130_fd_pr__nfet_01v8 L=0.15U W=0.42U AS=0.0567P
+ AD=0.1092P PS=0.69U PD=1.36U
* device instance $528 r0 *1 10.57,29.475 sky130_fd_pr__nfet_01v8
M$528 524 411 479 479 sky130_fd_pr__nfet_01v8 L=0.15U W=0.42U AS=0.1092P
+ AD=0.0441P PS=1.36U PD=0.63U
* device instance $529 r0 *1 10.93,29.475 sky130_fd_pr__nfet_01v8
M$529 97 303 524 524 sky130_fd_pr__nfet_01v8 L=0.15U W=0.42U AS=0.0441P
+ AD=0.1092P PS=0.63U PD=1.36U
* device instance $530 r0 *1 11.87,29.475 sky130_fd_pr__nfet_01v8
M$530 97 303 480 480 sky130_fd_pr__nfet_01v8 L=0.15U W=0.42U AS=0.1092P
+ AD=0.0609P PS=1.36U PD=0.71U
* device instance $531 r0 *1 12.31,29.475 sky130_fd_pr__nfet_01v8
M$531 527 480 97 97 sky130_fd_pr__nfet_01v8 L=0.15U W=0.42U AS=0.0609P
+ AD=0.0756P PS=0.71U PD=0.78U
* device instance $532 r0 *1 12.82,29.475 sky130_fd_pr__nfet_01v8
M$532 479 484 527 527 sky130_fd_pr__nfet_01v8 L=0.15U W=0.42U AS=0.0756P
+ AD=0.1446P PS=0.78U PD=1.18U
* device instance $533 r0 *1 13.73,29.505 sky130_fd_pr__nfet_01v8
M$533 481 477 479 479 sky130_fd_pr__nfet_01v8 L=0.15U W=0.36U AS=0.1446P
+ AD=0.0522P PS=1.18U PD=0.65U
* device instance $534 r0 *1 14.17,29.505 sky130_fd_pr__nfet_01v8
M$534 481 478 528 528 sky130_fd_pr__nfet_01v8 L=0.15U W=0.36U AS=0.0759P
+ AD=0.0522P PS=0.8U PD=0.65U
* device instance $535 r0 *1 14.7,29.475 sky130_fd_pr__nfet_01v8
M$535 528 482 97 97 sky130_fd_pr__nfet_01v8 L=0.15U W=0.42U AS=0.12095P
+ AD=0.0759P PS=1.085U PD=0.8U
* device instance $536 r0 *1 15.295,29.365 sky130_fd_pr__nfet_01v8
M$536 482 481 97 97 sky130_fd_pr__nfet_01v8 L=0.15U W=0.64U AS=0.12095P
+ AD=0.1664P PS=1.085U PD=1.8U
* device instance $537 r0 *1 16.235,29.475 sky130_fd_pr__nfet_01v8
M$537 529 482 97 97 sky130_fd_pr__nfet_01v8 L=0.15U W=0.42U AS=0.1092P
+ AD=0.0678P PS=1.36U PD=0.755U
* device instance $538 r0 *1 16.72,29.505 sky130_fd_pr__nfet_01v8
M$538 483 478 529 529 sky130_fd_pr__nfet_01v8 L=0.15U W=0.36U AS=0.0678P
+ AD=0.0684P PS=0.755U PD=0.74U
* device instance $539 r0 *1 17.25,29.505 sky130_fd_pr__nfet_01v8
M$539 483 477 531 531 sky130_fd_pr__nfet_01v8 L=0.15U W=0.36U AS=0.066P
+ AD=0.0684P PS=0.745U PD=0.74U
* device instance $540 r0 *1 17.725,29.475 sky130_fd_pr__nfet_01v8
M$540 97 484 531 531 sky130_fd_pr__nfet_01v8 L=0.15U W=0.42U AS=0.066P
+ AD=0.1092P PS=0.745U PD=1.36U
* device instance $541 r0 *1 18.665,29.475 sky130_fd_pr__nfet_01v8
M$541 484 483 97 97 sky130_fd_pr__nfet_01v8 L=0.15U W=0.42U AS=0.10025P
+ AD=0.1092P PS=0.985U PD=1.36U
* device instance $542 r0 *1 19.15,29.36 sky130_fd_pr__nfet_01v8
M$542 461 483 97 97 sky130_fd_pr__nfet_01v8 L=0.15U W=0.65U AS=0.10025P
+ AD=0.182P PS=0.985U PD=1.86U
* device instance $543 r0 *1 26.26,30.365 sky130_fd_pr__nfet_01v8
M$543 97 436 534 534 sky130_fd_pr__nfet_01v8 L=0.15U W=0.42U AS=0.1113P
+ AD=0.0588P PS=1.37U PD=0.7U
* device instance $544 r0 *1 26.69,30.365 sky130_fd_pr__nfet_01v8
M$544 534 329 97 97 sky130_fd_pr__nfet_01v8 L=0.15U W=0.42U AS=0.0588P
+ AD=0.0588P PS=0.7U PD=0.7U
* device instance $545 r0 *1 27.12,30.365 sky130_fd_pr__nfet_01v8
M$545 545 535 534 534 sky130_fd_pr__nfet_01v8 L=0.15U W=0.42U AS=0.0588P
+ AD=0.1113P PS=0.7U PD=1.37U
* device instance $546 r0 *1 30.91,29.36 sky130_fd_pr__nfet_01v8
M$546 516 329 97 97 sky130_fd_pr__nfet_01v8 L=0.15U W=2.6U AS=0.44525P
+ AD=0.351P PS=4.62U PD=3.68U
* device instance $550 r0 *1 32.59,29.36 sky130_fd_pr__nfet_01v8
M$550 516 436 97 97 sky130_fd_pr__nfet_01v8 L=0.15U W=2.6U AS=0.351P AD=0.3575P
+ PS=3.68U PD=3.7U
* device instance $554 r0 *1 34.29,29.36 sky130_fd_pr__nfet_01v8
M$554 516 535 97 97 sky130_fd_pr__nfet_01v8 L=0.15U W=2.6U AS=0.3575P
+ AD=0.44525P PS=3.7U PD=4.62U
* device instance $558 r0 *1 31.77,30.48 sky130_fd_pr__nfet_01v8
M$558 541 546 97 97 sky130_fd_pr__nfet_01v8 L=0.15U W=0.65U AS=0.169P
+ AD=0.08775P PS=1.82U PD=0.92U
* device instance $559 r0 *1 32.19,30.48 sky130_fd_pr__nfet_01v8
M$559 441 513 541 541 sky130_fd_pr__nfet_01v8 L=0.15U W=0.65U AS=0.08775P
+ AD=0.169P PS=0.92U PD=1.82U
* device instance $560 r0 *1 35.91,30.48 sky130_fd_pr__nfet_01v8
M$560 542 265 97 97 sky130_fd_pr__nfet_01v8 L=0.15U W=0.65U AS=0.169P
+ AD=0.08775P PS=1.82U PD=0.92U
* device instance $561 r0 *1 36.33,30.48 sky130_fd_pr__nfet_01v8
M$561 440 487 542 542 sky130_fd_pr__nfet_01v8 L=0.15U W=0.65U AS=0.08775P
+ AD=0.169P PS=0.92U PD=1.82U
* device instance $562 r0 *1 36.53,29.36 sky130_fd_pr__nfet_01v8
M$562 516 513 518 518 sky130_fd_pr__nfet_01v8 L=0.15U W=2.6U AS=0.44525P
+ AD=0.351P PS=4.62U PD=3.68U
* device instance $566 r0 *1 38.21,29.36 sky130_fd_pr__nfet_01v8
M$566 269 487 518 518 sky130_fd_pr__nfet_01v8 L=0.15U W=2.6U AS=0.351P
+ AD=0.44525P PS=3.68U PD=4.62U
* device instance $570 r0 *1 38.19,30.48 sky130_fd_pr__nfet_01v8
M$570 97 166 537 537 sky130_fd_pr__nfet_01v8 L=0.15U W=0.65U AS=0.169P
+ AD=0.10725P PS=1.82U PD=0.98U
* device instance $571 r0 *1 38.67,30.48 sky130_fd_pr__nfet_01v8
M$571 543 372 97 97 sky130_fd_pr__nfet_01v8 L=0.15U W=0.65U AS=0.10725P
+ AD=0.06825P PS=0.98U PD=0.86U
* device instance $572 r0 *1 39.03,30.48 sky130_fd_pr__nfet_01v8
M$572 537 92 543 543 sky130_fd_pr__nfet_01v8 L=0.15U W=0.65U AS=0.06825P
+ AD=0.169P PS=0.86U PD=1.82U
* device instance $573 r0 *1 39.97,30.48 sky130_fd_pr__nfet_01v8
M$573 544 134 537 537 sky130_fd_pr__nfet_01v8 L=0.15U W=0.65U AS=0.169P
+ AD=0.10725P PS=1.82U PD=0.98U
* device instance $574 r0 *1 40.45,30.48 sky130_fd_pr__nfet_01v8
M$574 97 2 544 544 sky130_fd_pr__nfet_01v8 L=0.15U W=0.65U AS=0.10725P
+ AD=0.102375P PS=0.98U PD=0.965U
* device instance $575 r0 *1 40.915,30.48 sky130_fd_pr__nfet_01v8
M$575 549 537 97 97 sky130_fd_pr__nfet_01v8 L=0.15U W=0.65U AS=0.102375P
+ AD=0.169P PS=0.965U PD=1.82U
* device instance $576 r0 *1 41.87,29.245 sky130_fd_pr__nfet_01v8
M$576 97 514 488 488 sky130_fd_pr__nfet_01v8 L=0.15U W=0.42U AS=0.1092P
+ AD=0.10025P PS=1.36U PD=0.985U
* device instance $577 r0 *1 42.355,29.36 sky130_fd_pr__nfet_01v8
M$577 533 372 97 97 sky130_fd_pr__nfet_01v8 L=0.15U W=0.65U AS=0.10025P
+ AD=0.08775P PS=0.985U PD=0.92U
* device instance $578 r0 *1 42.775,29.36 sky130_fd_pr__nfet_01v8
M$578 265 488 533 533 sky130_fd_pr__nfet_01v8 L=0.15U W=0.65U AS=0.08775P
+ AD=0.169P PS=0.92U PD=1.82U
* device instance $579 r0 *1 42.285,30.365 sky130_fd_pr__nfet_01v8
M$579 97 538 487 487 sky130_fd_pr__nfet_01v8 L=0.15U W=0.42U AS=0.1092P
+ AD=0.1197P PS=1.36U PD=1.41U
* device instance $580 r0 *1 44.17,29.36 sky130_fd_pr__nfet_01v8
M$580 97 489 401 401 sky130_fd_pr__nfet_01v8 L=0.15U W=0.65U AS=0.169P
+ AD=0.11285P PS=1.82U PD=1.045U
* device instance $581 r0 *1 44.715,29.475 sky130_fd_pr__nfet_01v8
M$581 532 64 97 97 sky130_fd_pr__nfet_01v8 L=0.15U W=0.42U AS=0.11285P
+ AD=0.0693P PS=1.045U PD=0.75U
* device instance $582 r0 *1 45.195,29.475 sky130_fd_pr__nfet_01v8
M$582 489 490 532 532 sky130_fd_pr__nfet_01v8 L=0.15U W=0.42U AS=0.0693P
+ AD=0.09975P PS=0.75U PD=0.895U
* device instance $583 r0 *1 45.82,29.475 sky130_fd_pr__nfet_01v8
M$583 530 514 489 489 sky130_fd_pr__nfet_01v8 L=0.15U W=0.42U AS=0.09975P
+ AD=0.0693P PS=0.895U PD=0.75U
* device instance $584 r0 *1 46.3,29.475 sky130_fd_pr__nfet_01v8
M$584 97 517 530 530 sky130_fd_pr__nfet_01v8 L=0.15U W=0.42U AS=0.0693P
+ AD=0.1449P PS=0.75U PD=1.11U
* device instance $585 r0 *1 47.14,29.475 sky130_fd_pr__nfet_01v8
M$585 517 64 97 97 sky130_fd_pr__nfet_01v8 L=0.15U W=0.42U AS=0.1449P
+ AD=0.1092P PS=1.11U PD=1.36U
* device instance $586 r0 *1 44.865,30.365 sky130_fd_pr__nfet_01v8
M$586 97 514 539 539 sky130_fd_pr__nfet_01v8 L=0.15U W=0.42U AS=0.1092P
+ AD=0.10025P PS=1.36U PD=0.985U
* device instance $587 r0 *1 45.35,30.48 sky130_fd_pr__nfet_01v8
M$587 538 372 97 97 sky130_fd_pr__nfet_01v8 L=0.15U W=0.65U AS=0.10025P
+ AD=0.08775P PS=0.985U PD=0.92U
* device instance $588 r0 *1 45.77,30.48 sky130_fd_pr__nfet_01v8
M$588 97 539 538 538 sky130_fd_pr__nfet_01v8 L=0.15U W=0.65U AS=0.08775P
+ AD=0.169P PS=0.92U PD=1.82U
* device instance $589 r0 *1 47.19,30.48 sky130_fd_pr__nfet_01v8
M$589 540 999 97 97 sky130_fd_pr__nfet_01v8 L=0.15U W=1.3U AS=0.25675P
+ AD=0.1755P PS=2.74U PD=1.84U
* device instance $591 r0 *1 48.03,30.48 sky130_fd_pr__nfet_01v8
M$591 134 540 97 97 sky130_fd_pr__nfet_01v8 L=0.15U W=3.9U AS=0.5265P
+ AD=0.60775P PS=5.52U PD=6.42U
* device instance $597 r0 *1 60.73,29.475 sky130_fd_pr__nfet_01v8
M$597 97 34 491 491 sky130_fd_pr__nfet_01v8 L=0.15U W=0.42U AS=0.1092P
+ AD=0.0567P PS=1.36U PD=0.69U
* device instance $598 r0 *1 61.15,29.475 sky130_fd_pr__nfet_01v8
M$598 492 491 97 97 sky130_fd_pr__nfet_01v8 L=0.15U W=0.42U AS=0.0567P
+ AD=0.1092P PS=0.69U PD=1.36U
* device instance $599 r0 *1 62.09,29.475 sky130_fd_pr__nfet_01v8
M$599 526 380 493 493 sky130_fd_pr__nfet_01v8 L=0.15U W=0.42U AS=0.1092P
+ AD=0.0441P PS=1.36U PD=0.63U
* device instance $600 r0 *1 62.45,29.475 sky130_fd_pr__nfet_01v8
M$600 97 303 526 526 sky130_fd_pr__nfet_01v8 L=0.15U W=0.42U AS=0.0441P
+ AD=0.1092P PS=0.63U PD=1.36U
* device instance $601 r0 *1 63.39,29.475 sky130_fd_pr__nfet_01v8
M$601 97 303 494 494 sky130_fd_pr__nfet_01v8 L=0.15U W=0.42U AS=0.1092P
+ AD=0.0609P PS=1.36U PD=0.71U
* device instance $602 r0 *1 63.83,29.475 sky130_fd_pr__nfet_01v8
M$602 525 494 97 97 sky130_fd_pr__nfet_01v8 L=0.15U W=0.42U AS=0.0609P
+ AD=0.0756P PS=0.71U PD=0.78U
* device instance $603 r0 *1 64.34,29.475 sky130_fd_pr__nfet_01v8
M$603 493 498 525 525 sky130_fd_pr__nfet_01v8 L=0.15U W=0.42U AS=0.0756P
+ AD=0.1446P PS=0.78U PD=1.18U
* device instance $604 r0 *1 65.25,29.505 sky130_fd_pr__nfet_01v8
M$604 495 491 493 493 sky130_fd_pr__nfet_01v8 L=0.15U W=0.36U AS=0.1446P
+ AD=0.0522P PS=1.18U PD=0.65U
* device instance $605 r0 *1 65.69,29.505 sky130_fd_pr__nfet_01v8
M$605 495 492 523 523 sky130_fd_pr__nfet_01v8 L=0.15U W=0.36U AS=0.0759P
+ AD=0.0522P PS=0.8U PD=0.65U
* device instance $606 r0 *1 66.22,29.475 sky130_fd_pr__nfet_01v8
M$606 523 496 97 97 sky130_fd_pr__nfet_01v8 L=0.15U W=0.42U AS=0.12095P
+ AD=0.0759P PS=1.085U PD=0.8U
* device instance $607 r0 *1 66.815,29.365 sky130_fd_pr__nfet_01v8
M$607 496 495 97 97 sky130_fd_pr__nfet_01v8 L=0.15U W=0.64U AS=0.12095P
+ AD=0.1664P PS=1.085U PD=1.8U
* device instance $608 r0 *1 67.755,29.475 sky130_fd_pr__nfet_01v8
M$608 521 496 97 97 sky130_fd_pr__nfet_01v8 L=0.15U W=0.42U AS=0.1092P
+ AD=0.0678P PS=1.36U PD=0.755U
* device instance $609 r0 *1 68.24,29.505 sky130_fd_pr__nfet_01v8
M$609 497 492 521 521 sky130_fd_pr__nfet_01v8 L=0.15U W=0.36U AS=0.0678P
+ AD=0.0684P PS=0.755U PD=0.74U
* device instance $610 r0 *1 68.77,29.505 sky130_fd_pr__nfet_01v8
M$610 497 491 519 519 sky130_fd_pr__nfet_01v8 L=0.15U W=0.36U AS=0.066P
+ AD=0.0684P PS=0.745U PD=0.74U
* device instance $611 r0 *1 69.245,29.475 sky130_fd_pr__nfet_01v8
M$611 97 498 519 519 sky130_fd_pr__nfet_01v8 L=0.15U W=0.42U AS=0.066P
+ AD=0.1092P PS=0.745U PD=1.36U
* device instance $612 r0 *1 70.185,29.475 sky130_fd_pr__nfet_01v8
M$612 498 497 97 97 sky130_fd_pr__nfet_01v8 L=0.15U W=0.42U AS=0.10025P
+ AD=0.1092P PS=0.985U PD=1.36U
* device instance $613 r0 *1 70.67,29.36 sky130_fd_pr__nfet_01v8
M$613 343 497 97 97 sky130_fd_pr__nfet_01v8 L=0.15U W=0.65U AS=0.10025P
+ AD=0.182P PS=0.985U PD=1.86U
* device instance $614 r0 *1 13.765,34.915 sky130_fd_pr__nfet_01v8
M$614 97 554 579 579 sky130_fd_pr__nfet_01v8 L=0.15U W=0.42U AS=0.1092P
+ AD=0.1197P PS=1.36U PD=1.41U
* device instance $615 r0 *1 27.155,34.8 sky130_fd_pr__nfet_01v8
M$615 587 546 555 555 sky130_fd_pr__nfet_01v8 L=0.15U W=0.65U AS=0.17225P
+ AD=0.06825P PS=1.83U PD=0.86U
* device instance $616 r0 *1 27.515,34.8 sky130_fd_pr__nfet_01v8
M$616 97 545 587 587 sky130_fd_pr__nfet_01v8 L=0.15U W=0.65U AS=0.06825P
+ AD=0.138125P PS=0.86U PD=1.075U
* device instance $617 r0 *1 28.09,34.8 sky130_fd_pr__nfet_01v8
M$617 556 555 97 97 sky130_fd_pr__nfet_01v8 L=0.15U W=2.6U AS=0.411125P
+ AD=0.45825P PS=3.865U PD=4.66U
* device instance $621 r0 *1 28.08,30.395 sky130_fd_pr__nfet_01v8
M$621 97 329 536 536 sky130_fd_pr__nfet_01v8 L=0.15U W=0.42U AS=0.1092P
+ AD=0.0567P PS=1.36U PD=0.69U
* device instance $622 r0 *1 28.5,30.395 sky130_fd_pr__nfet_01v8
M$622 536 436 97 97 sky130_fd_pr__nfet_01v8 L=0.15U W=0.42U AS=0.0567P
+ AD=0.0567P PS=0.69U PD=0.69U
* device instance $623 r0 *1 28.92,30.395 sky130_fd_pr__nfet_01v8
M$623 536 535 97 97 sky130_fd_pr__nfet_01v8 L=0.15U W=0.42U AS=0.101875P
+ AD=0.0567P PS=0.99U PD=0.69U
* device instance $624 r0 *1 29.41,30.48 sky130_fd_pr__nfet_01v8
M$624 546 536 97 97 sky130_fd_pr__nfet_01v8 L=0.15U W=0.65U AS=0.101875P
+ AD=0.182P PS=0.99U PD=1.86U
* device instance $625 r0 *1 40.49,34.915 sky130_fd_pr__nfet_01v8
M$625 97 34 557 557 sky130_fd_pr__nfet_01v8 L=0.15U W=0.42U AS=0.1092P
+ AD=0.0567P PS=1.36U PD=0.69U
* device instance $626 r0 *1 40.91,34.915 sky130_fd_pr__nfet_01v8
M$626 558 557 97 97 sky130_fd_pr__nfet_01v8 L=0.15U W=0.42U AS=0.0567P
+ AD=0.1092P PS=0.69U PD=1.36U
* device instance $627 r0 *1 41.85,34.915 sky130_fd_pr__nfet_01v8
M$627 586 549 559 559 sky130_fd_pr__nfet_01v8 L=0.15U W=0.42U AS=0.1092P
+ AD=0.0441P PS=1.36U PD=0.63U
* device instance $628 r0 *1 42.21,34.915 sky130_fd_pr__nfet_01v8
M$628 97 303 586 586 sky130_fd_pr__nfet_01v8 L=0.15U W=0.42U AS=0.0441P
+ AD=0.1092P PS=0.63U PD=1.36U
* device instance $629 r0 *1 43.15,34.915 sky130_fd_pr__nfet_01v8
M$629 97 303 560 560 sky130_fd_pr__nfet_01v8 L=0.15U W=0.42U AS=0.1092P
+ AD=0.0609P PS=1.36U PD=0.71U
* device instance $630 r0 *1 43.59,34.915 sky130_fd_pr__nfet_01v8
M$630 585 560 97 97 sky130_fd_pr__nfet_01v8 L=0.15U W=0.42U AS=0.0609P
+ AD=0.0756P PS=0.71U PD=0.78U
* device instance $631 r0 *1 44.1,34.915 sky130_fd_pr__nfet_01v8
M$631 559 564 585 585 sky130_fd_pr__nfet_01v8 L=0.15U W=0.42U AS=0.0756P
+ AD=0.1446P PS=0.78U PD=1.18U
* device instance $632 r0 *1 45.01,34.945 sky130_fd_pr__nfet_01v8
M$632 561 557 559 559 sky130_fd_pr__nfet_01v8 L=0.15U W=0.36U AS=0.1446P
+ AD=0.0522P PS=1.18U PD=0.65U
* device instance $633 r0 *1 45.45,34.945 sky130_fd_pr__nfet_01v8
M$633 561 558 584 584 sky130_fd_pr__nfet_01v8 L=0.15U W=0.36U AS=0.0759P
+ AD=0.0522P PS=0.8U PD=0.65U
* device instance $634 r0 *1 45.98,34.915 sky130_fd_pr__nfet_01v8
M$634 584 562 97 97 sky130_fd_pr__nfet_01v8 L=0.15U W=0.42U AS=0.12095P
+ AD=0.0759P PS=1.085U PD=0.8U
* device instance $635 r0 *1 46.575,34.805 sky130_fd_pr__nfet_01v8
M$635 562 561 97 97 sky130_fd_pr__nfet_01v8 L=0.15U W=0.64U AS=0.12095P
+ AD=0.1664P PS=1.085U PD=1.8U
* device instance $636 r0 *1 47.515,34.915 sky130_fd_pr__nfet_01v8
M$636 583 562 97 97 sky130_fd_pr__nfet_01v8 L=0.15U W=0.42U AS=0.1092P
+ AD=0.0678P PS=1.36U PD=0.755U
* device instance $637 r0 *1 48,34.945 sky130_fd_pr__nfet_01v8
M$637 563 558 583 583 sky130_fd_pr__nfet_01v8 L=0.15U W=0.36U AS=0.0678P
+ AD=0.0684P PS=0.755U PD=0.74U
* device instance $638 r0 *1 48.53,34.945 sky130_fd_pr__nfet_01v8
M$638 563 557 582 582 sky130_fd_pr__nfet_01v8 L=0.15U W=0.36U AS=0.066P
+ AD=0.0684P PS=0.745U PD=0.74U
* device instance $639 r0 *1 49.005,34.915 sky130_fd_pr__nfet_01v8
M$639 97 564 582 582 sky130_fd_pr__nfet_01v8 L=0.15U W=0.42U AS=0.066P
+ AD=0.1092P PS=0.745U PD=1.36U
* device instance $640 r0 *1 49.945,34.915 sky130_fd_pr__nfet_01v8
M$640 564 563 97 97 sky130_fd_pr__nfet_01v8 L=0.15U W=0.42U AS=0.10025P
+ AD=0.1092P PS=0.985U PD=1.36U
* device instance $641 r0 *1 50.43,34.8 sky130_fd_pr__nfet_01v8
M$641 514 563 97 97 sky130_fd_pr__nfet_01v8 L=0.15U W=0.65U AS=0.10025P
+ AD=0.182P PS=0.985U PD=1.86U
* device instance $642 r0 *1 59.81,34.8 sky130_fd_pr__nfet_01v8
M$642 97 308 565 565 sky130_fd_pr__nfet_01v8 L=0.15U W=0.65U AS=0.169P
+ AD=0.08775P PS=1.82U PD=0.92U
* device instance $643 r0 *1 60.23,34.8 sky130_fd_pr__nfet_01v8
M$643 578 565 97 97 sky130_fd_pr__nfet_01v8 L=0.15U W=2.6U AS=0.351P
+ AD=0.43225P PS=3.68U PD=4.58U
* device instance $647 r0 *1 62.57,34.8 sky130_fd_pr__nfet_01v8
M$647 97 566 567 567 sky130_fd_pr__nfet_01v8 L=0.15U W=0.65U AS=0.169P
+ AD=0.10725P PS=1.82U PD=0.98U
* device instance $648 r0 *1 63.05,34.8 sky130_fd_pr__nfet_01v8
M$648 581 569 97 97 sky130_fd_pr__nfet_01v8 L=0.15U W=0.65U AS=0.10725P
+ AD=0.06825P PS=0.98U PD=0.86U
* device instance $649 r0 *1 63.41,34.8 sky130_fd_pr__nfet_01v8
M$649 567 92 581 581 sky130_fd_pr__nfet_01v8 L=0.15U W=0.65U AS=0.06825P
+ AD=0.169P PS=0.86U PD=1.82U
* device instance $650 r0 *1 64.35,34.8 sky130_fd_pr__nfet_01v8
M$650 580 157 567 567 sky130_fd_pr__nfet_01v8 L=0.15U W=0.65U AS=0.169P
+ AD=0.10725P PS=1.82U PD=0.98U
* device instance $651 r0 *1 64.83,34.8 sky130_fd_pr__nfet_01v8
M$651 97 572 580 580 sky130_fd_pr__nfet_01v8 L=0.15U W=0.65U AS=0.10725P
+ AD=0.102375P PS=0.98U PD=0.965U
* device instance $652 r0 *1 65.295,34.8 sky130_fd_pr__nfet_01v8
M$652 571 567 97 97 sky130_fd_pr__nfet_01v8 L=0.15U W=0.65U AS=0.102375P
+ AD=0.169P PS=0.965U PD=1.82U
* device instance $653 r0 *1 8.75,35.92 sky130_fd_pr__nfet_01v8
M$653 97 588 589 589 sky130_fd_pr__nfet_01v8 L=0.15U W=0.65U AS=0.169P
+ AD=0.10725P PS=1.82U PD=0.98U
* device instance $654 r0 *1 9.23,35.92 sky130_fd_pr__nfet_01v8
M$654 606 408 97 97 sky130_fd_pr__nfet_01v8 L=0.15U W=0.65U AS=0.10725P
+ AD=0.06825P PS=0.98U PD=0.86U
* device instance $655 r0 *1 9.59,35.92 sky130_fd_pr__nfet_01v8
M$655 589 92 606 606 sky130_fd_pr__nfet_01v8 L=0.15U W=0.65U AS=0.06825P
+ AD=0.169P PS=0.86U PD=1.82U
* device instance $656 r0 *1 10.53,35.92 sky130_fd_pr__nfet_01v8
M$656 607 157 589 589 sky130_fd_pr__nfet_01v8 L=0.15U W=0.65U AS=0.169P
+ AD=0.10725P PS=1.82U PD=0.98U
* device instance $657 r0 *1 11.01,35.92 sky130_fd_pr__nfet_01v8
M$657 97 590 607 607 sky130_fd_pr__nfet_01v8 L=0.15U W=0.65U AS=0.10725P
+ AD=0.102375P PS=0.98U PD=0.965U
* device instance $658 r0 *1 11.475,35.92 sky130_fd_pr__nfet_01v8
M$658 591 589 97 97 sky130_fd_pr__nfet_01v8 L=0.15U W=0.65U AS=0.102375P
+ AD=0.169P PS=0.965U PD=1.82U
* device instance $659 r0 *1 12.53,35.805 sky130_fd_pr__nfet_01v8
M$659 608 579 592 592 sky130_fd_pr__nfet_01v8 L=0.15U W=0.42U AS=0.1092P
+ AD=0.0441P PS=1.36U PD=0.63U
* device instance $660 r0 *1 12.89,35.805 sky130_fd_pr__nfet_01v8
M$660 97 593 608 608 sky130_fd_pr__nfet_01v8 L=0.15U W=0.42U AS=0.0441P
+ AD=0.0567P PS=0.63U PD=0.69U
* device instance $661 r0 *1 13.31,35.805 sky130_fd_pr__nfet_01v8
M$661 609 593 97 97 sky130_fd_pr__nfet_01v8 L=0.15U W=0.42U AS=0.0567P
+ AD=0.0441P PS=0.69U PD=0.63U
* device instance $662 r0 *1 13.67,35.805 sky130_fd_pr__nfet_01v8
M$662 592 594 609 609 sky130_fd_pr__nfet_01v8 L=0.15U W=0.42U AS=0.0441P
+ AD=0.0567P PS=0.63U PD=0.69U
* device instance $663 r0 *1 14.09,35.805 sky130_fd_pr__nfet_01v8
M$663 610 594 592 592 sky130_fd_pr__nfet_01v8 L=0.15U W=0.42U AS=0.0567P
+ AD=0.0441P PS=0.69U PD=0.63U
* device instance $664 r0 *1 14.45,35.805 sky130_fd_pr__nfet_01v8
M$664 97 579 610 610 sky130_fd_pr__nfet_01v8 L=0.15U W=0.42U AS=0.0441P
+ AD=0.162225P PS=0.63U PD=1.25U
* device instance $665 r0 *1 15.2,35.92 sky130_fd_pr__nfet_01v8
M$665 341 592 97 97 sky130_fd_pr__nfet_01v8 L=0.15U W=1.3U AS=0.249975P
+ AD=0.26325P PS=2.17U PD=2.76U
* device instance $667 r0 *1 31.705,35.805 sky130_fd_pr__nfet_01v8
M$667 97 595 535 535 sky130_fd_pr__nfet_01v8 L=0.15U W=0.42U AS=0.1092P
+ AD=0.1197P PS=1.36U PD=1.41U
* device instance $668 r0 *1 34.05,36.035 sky130_fd_pr__nfet_01v8
M$668 596 651 97 97 sky130_fd_pr__nfet_01v8 L=0.15U W=0.42U AS=0.10025P
+ AD=0.1092P PS=0.985U PD=1.36U
* device instance $669 r0 *1 34.535,35.92 sky130_fd_pr__nfet_01v8
M$669 611 597 97 97 sky130_fd_pr__nfet_01v8 L=0.15U W=0.65U AS=0.10025P
+ AD=0.08775P PS=0.985U PD=0.92U
* device instance $670 r0 *1 34.955,35.92 sky130_fd_pr__nfet_01v8
M$670 513 596 611 611 sky130_fd_pr__nfet_01v8 L=0.15U W=0.65U AS=0.08775P
+ AD=0.169P PS=0.92U PD=1.82U
* device instance $671 r0 *1 59.42,35.805 sky130_fd_pr__nfet_01v8
M$671 612 599 598 598 sky130_fd_pr__nfet_01v8 L=0.15U W=0.42U AS=0.1113P
+ AD=0.0441P PS=1.37U PD=0.63U
* device instance $672 r0 *1 59.78,35.805 sky130_fd_pr__nfet_01v8
M$672 97 115 612 612 sky130_fd_pr__nfet_01v8 L=0.15U W=0.42U AS=0.0441P
+ AD=0.0966P PS=0.63U PD=0.88U
* device instance $673 r0 *1 60.39,35.805 sky130_fd_pr__nfet_01v8
M$673 566 598 97 97 sky130_fd_pr__nfet_01v8 L=0.15U W=0.42U AS=0.0966P
+ AD=0.1113P PS=0.88U PD=1.37U
* device instance $674 r0 *1 61.67,35.92 sky130_fd_pr__nfet_01v8
M$674 613 578 97 97 sky130_fd_pr__nfet_01v8 L=0.15U W=0.65U AS=0.169P
+ AD=0.08775P PS=1.82U PD=0.92U
* device instance $675 r0 *1 62.09,35.92 sky130_fd_pr__nfet_01v8
M$675 600 342 613 613 sky130_fd_pr__nfet_01v8 L=0.15U W=0.65U AS=0.08775P
+ AD=0.169P PS=0.92U PD=1.82U
* device instance $676 r0 *1 63.13,35.92 sky130_fd_pr__nfet_01v8
M$676 614 600 601 601 sky130_fd_pr__nfet_01v8 L=0.15U W=0.65U AS=0.169P
+ AD=0.06825P PS=1.82U PD=0.86U
* device instance $677 r0 *1 63.49,35.92 sky130_fd_pr__nfet_01v8
M$677 97 602 614 614 sky130_fd_pr__nfet_01v8 L=0.15U W=0.65U AS=0.06825P
+ AD=0.08775P PS=0.86U PD=0.92U
* device instance $678 r0 *1 63.91,35.92 sky130_fd_pr__nfet_01v8
M$678 603 602 97 97 sky130_fd_pr__nfet_01v8 L=0.15U W=0.65U AS=0.08775P
+ AD=0.169P PS=0.92U PD=1.82U
* device instance $679 r0 *1 64.85,35.92 sky130_fd_pr__nfet_01v8
M$679 603 600 97 97 sky130_fd_pr__nfet_01v8 L=0.15U W=0.65U AS=0.169P
+ AD=0.08775P PS=1.82U PD=0.92U
* device instance $680 r0 *1 65.27,35.92 sky130_fd_pr__nfet_01v8
M$680 572 601 603 603 sky130_fd_pr__nfet_01v8 L=0.15U W=0.65U AS=0.08775P
+ AD=0.195P PS=0.92U PD=1.9U
* device instance $681 r0 *1 66.485,35.805 sky130_fd_pr__nfet_01v8
M$681 97 652 604 604 sky130_fd_pr__nfet_01v8 L=0.15U W=0.42U AS=0.1092P
+ AD=0.10025P PS=1.36U PD=0.985U
* device instance $682 r0 *1 66.97,35.92 sky130_fd_pr__nfet_01v8
M$682 605 569 97 97 sky130_fd_pr__nfet_01v8 L=0.15U W=0.65U AS=0.10025P
+ AD=0.08775P PS=0.985U PD=0.92U
* device instance $683 r0 *1 67.39,35.92 sky130_fd_pr__nfet_01v8
M$683 97 604 605 605 sky130_fd_pr__nfet_01v8 L=0.15U W=0.65U AS=0.08775P
+ AD=0.169P PS=0.92U PD=1.82U
* device instance $684 r0 *1 6.91,40.24 sky130_fd_pr__nfet_01v8
M$684 97 625 624 624 sky130_fd_pr__nfet_01v8 L=0.15U W=0.65U AS=0.169P
+ AD=0.11285P PS=1.82U PD=1.045U
* device instance $685 r0 *1 7.455,40.355 sky130_fd_pr__nfet_01v8
M$685 668 64 97 97 sky130_fd_pr__nfet_01v8 L=0.15U W=0.42U AS=0.11285P
+ AD=0.0693P PS=1.045U PD=0.75U
* device instance $686 r0 *1 7.935,40.355 sky130_fd_pr__nfet_01v8
M$686 625 626 668 668 sky130_fd_pr__nfet_01v8 L=0.15U W=0.42U AS=0.0693P
+ AD=0.09975P PS=0.75U PD=0.895U
* device instance $687 r0 *1 8.56,40.355 sky130_fd_pr__nfet_01v8
M$687 669 594 625 625 sky130_fd_pr__nfet_01v8 L=0.15U W=0.42U AS=0.09975P
+ AD=0.0693P PS=0.895U PD=0.75U
* device instance $688 r0 *1 9.04,40.355 sky130_fd_pr__nfet_01v8
M$688 97 658 669 669 sky130_fd_pr__nfet_01v8 L=0.15U W=0.42U AS=0.0693P
+ AD=0.1449P PS=0.75U PD=1.11U
* device instance $689 r0 *1 9.88,40.355 sky130_fd_pr__nfet_01v8
M$689 658 64 97 97 sky130_fd_pr__nfet_01v8 L=0.15U W=0.42U AS=0.1449P
+ AD=0.1092P PS=1.11U PD=1.36U
* device instance $690 r0 *1 11.15,40.24 sky130_fd_pr__nfet_01v8
M$690 670 629 627 627 sky130_fd_pr__nfet_01v8 L=0.15U W=0.65U AS=0.169P
+ AD=0.06825P PS=1.82U PD=0.86U
* device instance $691 r0 *1 11.51,40.24 sky130_fd_pr__nfet_01v8
M$691 97 628 670 670 sky130_fd_pr__nfet_01v8 L=0.15U W=0.65U AS=0.06825P
+ AD=0.08775P PS=0.86U PD=0.92U
* device instance $692 r0 *1 11.93,40.24 sky130_fd_pr__nfet_01v8
M$692 659 628 97 97 sky130_fd_pr__nfet_01v8 L=0.15U W=0.65U AS=0.08775P
+ AD=0.169P PS=0.92U PD=1.82U
* device instance $693 r0 *1 12.87,40.24 sky130_fd_pr__nfet_01v8
M$693 659 629 97 97 sky130_fd_pr__nfet_01v8 L=0.15U W=0.65U AS=0.169P
+ AD=0.08775P PS=1.82U PD=0.92U
* device instance $694 r0 *1 13.29,40.24 sky130_fd_pr__nfet_01v8
M$694 590 627 659 659 sky130_fd_pr__nfet_01v8 L=0.15U W=0.65U AS=0.08775P
+ AD=0.195P PS=0.92U PD=1.9U
* device instance $695 r0 *1 14.31,40.24 sky130_fd_pr__nfet_01v8
M$695 630 594 97 97 sky130_fd_pr__nfet_01v8 L=0.15U W=0.65U AS=0.169P
+ AD=0.08775P PS=1.82U PD=0.92U
* device instance $696 r0 *1 14.73,40.24 sky130_fd_pr__nfet_01v8
M$696 97 408 630 630 sky130_fd_pr__nfet_01v8 L=0.15U W=0.65U AS=0.08775P
+ AD=0.08775P PS=0.92U PD=0.92U
* device instance $697 r0 *1 15.15,40.24 sky130_fd_pr__nfet_01v8
M$697 672 408 97 97 sky130_fd_pr__nfet_01v8 L=0.15U W=0.65U AS=0.08775P
+ AD=0.08775P PS=0.92U PD=0.92U
* device instance $698 r0 *1 15.57,40.24 sky130_fd_pr__nfet_01v8
M$698 629 594 672 672 sky130_fd_pr__nfet_01v8 L=0.15U W=0.65U AS=0.08775P
+ AD=0.25025P PS=0.92U PD=1.42U
* device instance $699 r0 *1 16.49,40.24 sky130_fd_pr__nfet_01v8
M$699 97 630 629 629 sky130_fd_pr__nfet_01v8 L=0.15U W=0.65U AS=0.25025P
+ AD=0.208P PS=1.42U PD=1.94U
* device instance $700 r0 *1 25.77,40.24 sky130_fd_pr__nfet_01v8
M$700 97 650 632 632 sky130_fd_pr__nfet_01v8 L=0.15U W=0.65U AS=0.169P
+ AD=0.10725P PS=1.82U PD=0.98U
* device instance $701 r0 *1 26.25,40.24 sky130_fd_pr__nfet_01v8
M$701 677 651 97 97 sky130_fd_pr__nfet_01v8 L=0.15U W=0.65U AS=0.10725P
+ AD=0.06825P PS=0.98U PD=0.86U
* device instance $702 r0 *1 26.61,40.24 sky130_fd_pr__nfet_01v8
M$702 632 92 677 677 sky130_fd_pr__nfet_01v8 L=0.15U W=0.65U AS=0.06825P
+ AD=0.169P PS=0.86U PD=1.82U
* device instance $703 r0 *1 27.55,40.24 sky130_fd_pr__nfet_01v8
M$703 678 134 632 632 sky130_fd_pr__nfet_01v8 L=0.15U W=0.65U AS=0.169P
+ AD=0.10725P PS=1.82U PD=0.98U
* device instance $704 r0 *1 28.03,40.24 sky130_fd_pr__nfet_01v8
M$704 97 556 678 678 sky130_fd_pr__nfet_01v8 L=0.15U W=0.65U AS=0.10725P
+ AD=0.102375P PS=0.98U PD=0.965U
* device instance $705 r0 *1 28.495,40.24 sky130_fd_pr__nfet_01v8
M$705 635 632 97 97 sky130_fd_pr__nfet_01v8 L=0.15U W=0.65U AS=0.102375P
+ AD=0.169P PS=0.965U PD=1.82U
* device instance $706 r0 *1 30.93,40.24 sky130_fd_pr__nfet_01v8
M$706 679 597 636 636 sky130_fd_pr__nfet_01v8 L=0.15U W=0.65U AS=0.169P
+ AD=0.06825P PS=1.82U PD=0.86U
* device instance $707 r0 *1 31.29,40.24 sky130_fd_pr__nfet_01v8
M$707 97 651 679 679 sky130_fd_pr__nfet_01v8 L=0.15U W=0.65U AS=0.06825P
+ AD=0.08775P PS=0.86U PD=0.92U
* device instance $708 r0 *1 31.71,40.24 sky130_fd_pr__nfet_01v8
M$708 660 651 97 97 sky130_fd_pr__nfet_01v8 L=0.15U W=0.65U AS=0.08775P
+ AD=0.169P PS=0.92U PD=1.82U
* device instance $709 r0 *1 32.65,40.24 sky130_fd_pr__nfet_01v8
M$709 660 597 97 97 sky130_fd_pr__nfet_01v8 L=0.15U W=0.65U AS=0.169P
+ AD=0.08775P PS=1.82U PD=0.92U
* device instance $710 r0 *1 33.07,40.24 sky130_fd_pr__nfet_01v8
M$710 595 636 660 660 sky130_fd_pr__nfet_01v8 L=0.15U W=0.65U AS=0.08775P
+ AD=0.195P PS=0.92U PD=1.9U
* device instance $711 r0 *1 55.67,40.24 sky130_fd_pr__nfet_01v8
M$711 676 578 97 97 sky130_fd_pr__nfet_01v8 L=0.15U W=0.65U AS=0.169P
+ AD=0.06825P PS=1.82U PD=0.86U
* device instance $712 r0 *1 56.03,40.24 sky130_fd_pr__nfet_01v8
M$712 675 342 676 676 sky130_fd_pr__nfet_01v8 L=0.15U W=0.65U AS=0.06825P
+ AD=0.118625P PS=0.86U PD=1.015U
* device instance $713 r0 *1 56.545,40.24 sky130_fd_pr__nfet_01v8
M$713 639 602 675 675 sky130_fd_pr__nfet_01v8 L=0.15U W=0.65U AS=0.118625P
+ AD=0.105625P PS=1.015U PD=0.975U
* device instance $714 r0 *1 57.02,40.24 sky130_fd_pr__nfet_01v8
M$714 97 605 639 639 sky130_fd_pr__nfet_01v8 L=0.15U W=0.65U AS=0.105625P
+ AD=0.1755P PS=0.975U PD=1.84U
* device instance $715 r0 *1 59.35,40.24 sky130_fd_pr__nfet_01v8
M$715 674 342 97 97 sky130_fd_pr__nfet_01v8 L=0.15U W=0.65U AS=0.169P
+ AD=0.089375P PS=1.82U PD=0.925U
* device instance $716 r0 *1 59.775,40.24 sky130_fd_pr__nfet_01v8
M$716 673 308 674 674 sky130_fd_pr__nfet_01v8 L=0.15U W=0.65U AS=0.089375P
+ AD=0.091P PS=0.925U PD=0.93U
* device instance $717 r0 *1 60.205,40.24 sky130_fd_pr__nfet_01v8
M$717 641 602 673 673 sky130_fd_pr__nfet_01v8 L=0.15U W=0.65U AS=0.091P
+ AD=0.115375P PS=0.93U PD=1.005U
* device instance $718 r0 *1 60.71,40.24 sky130_fd_pr__nfet_01v8
M$718 97 605 641 641 sky130_fd_pr__nfet_01v8 L=0.15U W=0.65U AS=0.115375P
+ AD=0.112125P PS=1.005U PD=0.995U
* device instance $719 r0 *1 61.205,40.24 sky130_fd_pr__nfet_01v8
M$719 641 662 97 97 sky130_fd_pr__nfet_01v8 L=0.15U W=0.65U AS=0.112125P
+ AD=0.169P PS=0.995U PD=1.82U
* device instance $720 r0 *1 64.51,40.24 sky130_fd_pr__nfet_01v8
M$720 671 652 642 642 sky130_fd_pr__nfet_01v8 L=0.15U W=0.65U AS=0.169P
+ AD=0.06825P PS=1.82U PD=0.86U
* device instance $721 r0 *1 64.87,40.24 sky130_fd_pr__nfet_01v8
M$721 97 569 671 671 sky130_fd_pr__nfet_01v8 L=0.15U W=0.65U AS=0.06825P
+ AD=0.08775P PS=0.86U PD=0.92U
* device instance $722 r0 *1 65.29,40.24 sky130_fd_pr__nfet_01v8
M$722 663 569 97 97 sky130_fd_pr__nfet_01v8 L=0.15U W=0.65U AS=0.08775P
+ AD=0.169P PS=0.92U PD=1.82U
* device instance $723 r0 *1 66.23,40.24 sky130_fd_pr__nfet_01v8
M$723 663 652 97 97 sky130_fd_pr__nfet_01v8 L=0.15U W=0.65U AS=0.169P
+ AD=0.08775P PS=1.82U PD=0.92U
* device instance $724 r0 *1 66.65,40.24 sky130_fd_pr__nfet_01v8
M$724 602 642 663 663 sky130_fd_pr__nfet_01v8 L=0.15U W=0.65U AS=0.08775P
+ AD=0.195P PS=0.92U PD=1.9U
* device instance $725 r0 *1 68.09,40.24 sky130_fd_pr__nfet_01v8
M$725 97 644 643 643 sky130_fd_pr__nfet_01v8 L=0.15U W=0.65U AS=0.169P
+ AD=0.11285P PS=1.82U PD=1.045U
* device instance $726 r0 *1 68.635,40.355 sky130_fd_pr__nfet_01v8
M$726 667 64 97 97 sky130_fd_pr__nfet_01v8 L=0.15U W=0.42U AS=0.11285P
+ AD=0.0693P PS=1.045U PD=0.75U
* device instance $727 r0 *1 69.115,40.355 sky130_fd_pr__nfet_01v8
M$727 644 645 667 667 sky130_fd_pr__nfet_01v8 L=0.15U W=0.42U AS=0.0693P
+ AD=0.09975P PS=0.75U PD=0.895U
* device instance $728 r0 *1 69.74,40.355 sky130_fd_pr__nfet_01v8
M$728 666 652 644 644 sky130_fd_pr__nfet_01v8 L=0.15U W=0.42U AS=0.09975P
+ AD=0.0693P PS=0.895U PD=0.75U
* device instance $729 r0 *1 70.22,40.355 sky130_fd_pr__nfet_01v8
M$729 97 664 666 666 sky130_fd_pr__nfet_01v8 L=0.15U W=0.42U AS=0.0693P
+ AD=0.1449P PS=0.75U PD=1.11U
* device instance $730 r0 *1 71.06,40.355 sky130_fd_pr__nfet_01v8
M$730 664 64 97 97 sky130_fd_pr__nfet_01v8 L=0.15U W=0.42U AS=0.1449P
+ AD=0.1092P PS=1.11U PD=1.36U
* device instance $731 r0 *1 2.77,41.245 sky130_fd_pr__nfet_01v8
M$731 97 681 680 680 sky130_fd_pr__nfet_01v8 L=0.15U W=0.42U AS=0.1092P
+ AD=0.0567P PS=1.36U PD=0.69U
* device instance $732 r0 *1 3.19,41.245 sky130_fd_pr__nfet_01v8
M$732 682 680 97 97 sky130_fd_pr__nfet_01v8 L=0.15U W=0.42U AS=0.0567P
+ AD=0.1092P PS=0.69U PD=1.36U
* device instance $733 r0 *1 4.13,41.245 sky130_fd_pr__nfet_01v8
M$733 710 624 683 683 sky130_fd_pr__nfet_01v8 L=0.15U W=0.42U AS=0.1092P
+ AD=0.0441P PS=1.36U PD=0.63U
* device instance $734 r0 *1 4.49,41.245 sky130_fd_pr__nfet_01v8
M$734 97 94 710 710 sky130_fd_pr__nfet_01v8 L=0.15U W=0.42U AS=0.0441P
+ AD=0.1092P PS=0.63U PD=1.36U
* device instance $735 r0 *1 4.68,40.355 sky130_fd_pr__nfet_01v8
M$735 665 622 623 623 sky130_fd_pr__nfet_01v8 L=0.15U W=0.42U AS=0.1113P
+ AD=0.0441P PS=1.37U PD=0.63U
* device instance $736 r0 *1 5.04,40.355 sky130_fd_pr__nfet_01v8
M$736 97 115 665 665 sky130_fd_pr__nfet_01v8 L=0.15U W=0.42U AS=0.0441P
+ AD=0.0966P PS=0.63U PD=0.88U
* device instance $737 r0 *1 5.65,40.355 sky130_fd_pr__nfet_01v8
M$737 588 623 97 97 sky130_fd_pr__nfet_01v8 L=0.15U W=0.42U AS=0.0966P
+ AD=0.1113P PS=0.88U PD=1.37U
* device instance $738 r0 *1 7.29,41.215 sky130_fd_pr__nfet_01v8
M$738 686 680 683 683 sky130_fd_pr__nfet_01v8 L=0.15U W=0.36U AS=0.1446P
+ AD=0.0522P PS=1.18U PD=0.65U
* device instance $739 r0 *1 7.73,41.215 sky130_fd_pr__nfet_01v8
M$739 712 682 686 686 sky130_fd_pr__nfet_01v8 L=0.15U W=0.36U AS=0.0522P
+ AD=0.0759P PS=0.65U PD=0.8U
* device instance $740 r0 *1 5.43,41.245 sky130_fd_pr__nfet_01v8
M$740 97 94 684 684 sky130_fd_pr__nfet_01v8 L=0.15U W=0.42U AS=0.1092P
+ AD=0.0609P PS=1.36U PD=0.71U
* device instance $741 r0 *1 5.87,41.245 sky130_fd_pr__nfet_01v8
M$741 711 684 97 97 sky130_fd_pr__nfet_01v8 L=0.15U W=0.42U AS=0.0609P
+ AD=0.0756P PS=0.71U PD=0.78U
* device instance $742 r0 *1 6.38,41.245 sky130_fd_pr__nfet_01v8
M$742 683 685 711 711 sky130_fd_pr__nfet_01v8 L=0.15U W=0.42U AS=0.0756P
+ AD=0.1446P PS=0.78U PD=1.18U
* device instance $743 r0 *1 8.26,41.245 sky130_fd_pr__nfet_01v8
M$743 97 687 712 712 sky130_fd_pr__nfet_01v8 L=0.15U W=0.42U AS=0.0759P
+ AD=0.12095P PS=0.8U PD=1.085U
* device instance $744 r0 *1 8.855,41.355 sky130_fd_pr__nfet_01v8
M$744 687 686 97 97 sky130_fd_pr__nfet_01v8 L=0.15U W=0.64U AS=0.12095P
+ AD=0.1664P PS=1.085U PD=1.8U
* device instance $745 r0 *1 10.28,41.215 sky130_fd_pr__nfet_01v8
M$745 688 682 713 713 sky130_fd_pr__nfet_01v8 L=0.15U W=0.36U AS=0.0678P
+ AD=0.0684P PS=0.755U PD=0.74U
* device instance $746 r0 *1 10.81,41.215 sky130_fd_pr__nfet_01v8
M$746 714 680 688 688 sky130_fd_pr__nfet_01v8 L=0.15U W=0.36U AS=0.0684P
+ AD=0.066P PS=0.74U PD=0.745U
* device instance $747 r0 *1 9.795,41.245 sky130_fd_pr__nfet_01v8
M$747 713 687 97 97 sky130_fd_pr__nfet_01v8 L=0.15U W=0.42U AS=0.1092P
+ AD=0.0678P PS=1.36U PD=0.755U
* device instance $748 r0 *1 11.285,41.245 sky130_fd_pr__nfet_01v8
M$748 97 685 714 714 sky130_fd_pr__nfet_01v8 L=0.15U W=0.42U AS=0.066P
+ AD=0.1092P PS=0.745U PD=1.36U
* device instance $749 r0 *1 12.225,41.245 sky130_fd_pr__nfet_01v8
M$749 97 688 685 685 sky130_fd_pr__nfet_01v8 L=0.15U W=0.42U AS=0.1092P
+ AD=0.10025P PS=1.36U PD=0.985U
* device instance $750 r0 *1 12.71,41.36 sky130_fd_pr__nfet_01v8
M$750 554 688 97 97 sky130_fd_pr__nfet_01v8 L=0.15U W=0.65U AS=0.10025P
+ AD=0.182P PS=0.985U PD=1.86U
* device instance $751 r0 *1 13.81,41.36 sky130_fd_pr__nfet_01v8
M$751 97 554 689 689 sky130_fd_pr__nfet_01v8 L=0.15U W=0.65U AS=0.169P
+ AD=0.08775P PS=1.82U PD=0.92U
* device instance $752 r0 *1 14.23,41.36 sky130_fd_pr__nfet_01v8
M$752 408 689 97 97 sky130_fd_pr__nfet_01v8 L=0.15U W=2.6U AS=0.351P
+ AD=0.43225P PS=3.68U PD=4.58U
* device instance $756 r0 *1 17.03,41.36 sky130_fd_pr__nfet_01v8
M$756 97 593 690 690 sky130_fd_pr__nfet_01v8 L=0.15U W=0.65U AS=0.169P
+ AD=0.08775P PS=1.82U PD=0.92U
* device instance $757 r0 *1 17.45,41.36 sky130_fd_pr__nfet_01v8
M$757 628 690 97 97 sky130_fd_pr__nfet_01v8 L=0.15U W=2.6U AS=0.351P
+ AD=0.43225P PS=3.68U PD=4.58U
* device instance $761 r0 *1 23.08,41.245 sky130_fd_pr__nfet_01v8
M$761 718 726 691 691 sky130_fd_pr__nfet_01v8 L=0.15U W=0.42U AS=0.1113P
+ AD=0.0441P PS=1.37U PD=0.63U
* device instance $762 r0 *1 23.44,41.245 sky130_fd_pr__nfet_01v8
M$762 97 115 718 718 sky130_fd_pr__nfet_01v8 L=0.15U W=0.42U AS=0.0441P
+ AD=0.0966P PS=0.63U PD=0.88U
* device instance $763 r0 *1 24.05,41.245 sky130_fd_pr__nfet_01v8
M$763 650 691 97 97 sky130_fd_pr__nfet_01v8 L=0.15U W=0.42U AS=0.0966P
+ AD=0.1113P PS=0.88U PD=1.37U
* device instance $764 r0 *1 26.23,41.245 sky130_fd_pr__nfet_01v8
M$764 97 681 692 692 sky130_fd_pr__nfet_01v8 L=0.15U W=0.42U AS=0.1092P
+ AD=0.0567P PS=1.36U PD=0.69U
* device instance $765 r0 *1 26.65,41.245 sky130_fd_pr__nfet_01v8
M$765 693 692 97 97 sky130_fd_pr__nfet_01v8 L=0.15U W=0.42U AS=0.0567P
+ AD=0.1092P PS=0.69U PD=1.36U
* device instance $766 r0 *1 27.59,41.245 sky130_fd_pr__nfet_01v8
M$766 720 727 694 694 sky130_fd_pr__nfet_01v8 L=0.15U W=0.42U AS=0.1092P
+ AD=0.0441P PS=1.36U PD=0.63U
* device instance $767 r0 *1 27.95,41.245 sky130_fd_pr__nfet_01v8
M$767 97 94 720 720 sky130_fd_pr__nfet_01v8 L=0.15U W=0.42U AS=0.0441P
+ AD=0.1092P PS=0.63U PD=1.36U
* device instance $768 r0 *1 30.75,41.215 sky130_fd_pr__nfet_01v8
M$768 697 692 694 694 sky130_fd_pr__nfet_01v8 L=0.15U W=0.36U AS=0.1446P
+ AD=0.0522P PS=1.18U PD=0.65U
* device instance $769 r0 *1 31.19,41.215 sky130_fd_pr__nfet_01v8
M$769 723 693 697 697 sky130_fd_pr__nfet_01v8 L=0.15U W=0.36U AS=0.0522P
+ AD=0.0759P PS=0.65U PD=0.8U
* device instance $770 r0 *1 28.89,41.245 sky130_fd_pr__nfet_01v8
M$770 97 94 695 695 sky130_fd_pr__nfet_01v8 L=0.15U W=0.42U AS=0.1092P
+ AD=0.0609P PS=1.36U PD=0.71U
* device instance $771 r0 *1 29.33,41.245 sky130_fd_pr__nfet_01v8
M$771 722 695 97 97 sky130_fd_pr__nfet_01v8 L=0.15U W=0.42U AS=0.0609P
+ AD=0.0756P PS=0.71U PD=0.78U
* device instance $772 r0 *1 29.84,41.245 sky130_fd_pr__nfet_01v8
M$772 694 696 722 722 sky130_fd_pr__nfet_01v8 L=0.15U W=0.42U AS=0.0756P
+ AD=0.1446P PS=0.78U PD=1.18U
* device instance $773 r0 *1 31.72,41.245 sky130_fd_pr__nfet_01v8
M$773 97 698 723 723 sky130_fd_pr__nfet_01v8 L=0.15U W=0.42U AS=0.0759P
+ AD=0.12095P PS=0.8U PD=1.085U
* device instance $774 r0 *1 32.315,41.355 sky130_fd_pr__nfet_01v8
M$774 698 697 97 97 sky130_fd_pr__nfet_01v8 L=0.15U W=0.64U AS=0.12095P
+ AD=0.1664P PS=1.085U PD=1.8U
* device instance $775 r0 *1 33.74,41.215 sky130_fd_pr__nfet_01v8
M$775 699 693 724 724 sky130_fd_pr__nfet_01v8 L=0.15U W=0.36U AS=0.0678P
+ AD=0.0684P PS=0.755U PD=0.74U
* device instance $776 r0 *1 34.27,41.215 sky130_fd_pr__nfet_01v8
M$776 725 692 699 699 sky130_fd_pr__nfet_01v8 L=0.15U W=0.36U AS=0.0684P
+ AD=0.066P PS=0.74U PD=0.745U
* device instance $777 r0 *1 33.255,41.245 sky130_fd_pr__nfet_01v8
M$777 724 698 97 97 sky130_fd_pr__nfet_01v8 L=0.15U W=0.42U AS=0.1092P
+ AD=0.0678P PS=1.36U PD=0.755U
* device instance $778 r0 *1 34.745,41.245 sky130_fd_pr__nfet_01v8
M$778 97 696 725 725 sky130_fd_pr__nfet_01v8 L=0.15U W=0.42U AS=0.066P
+ AD=0.1092P PS=0.745U PD=1.36U
* device instance $779 r0 *1 35.435,40.355 sky130_fd_pr__nfet_01v8
M$779 637 661 97 97 sky130_fd_pr__nfet_01v8 L=0.15U W=1.68U AS=0.2877P
+ AD=0.2352P PS=3.47U PD=2.8U
* device instance $783 r0 *1 37.155,40.355 sky130_fd_pr__nfet_01v8
M$783 298 637 97 97 sky130_fd_pr__nfet_01v8 L=0.15U W=6.72U AS=0.93975P
+ AD=0.99225P PS=11.195U PD=11.865U
* device instance $799 r0 *1 35.685,41.245 sky130_fd_pr__nfet_01v8
M$799 97 699 696 696 sky130_fd_pr__nfet_01v8 L=0.15U W=0.42U AS=0.1092P
+ AD=0.10025P PS=1.36U PD=0.985U
* device instance $800 r0 *1 36.17,41.36 sky130_fd_pr__nfet_01v8
M$800 651 699 97 97 sky130_fd_pr__nfet_01v8 L=0.15U W=0.65U AS=0.10025P
+ AD=0.182P PS=0.985U PD=1.86U
* device instance $801 r0 *1 44.63,41.36 sky130_fd_pr__nfet_01v8
M$801 734 651 97 97 sky130_fd_pr__nfet_01v8 L=0.15U W=0.65U AS=0.169P
+ AD=0.118625P PS=1.82U PD=1.015U
* device instance $802 r0 *1 45.145,41.36 sky130_fd_pr__nfet_01v8
M$802 97 372 734 734 sky130_fd_pr__nfet_01v8 L=0.15U W=0.65U AS=0.118625P
+ AD=0.089375P PS=1.015U PD=0.925U
* device instance $803 r0 *1 45.57,41.36 sky130_fd_pr__nfet_01v8
M$803 734 728 97 97 sky130_fd_pr__nfet_01v8 L=0.15U W=0.65U AS=0.089375P
+ AD=0.08775P PS=0.925U PD=0.92U
* device instance $804 r0 *1 45.99,41.36 sky130_fd_pr__nfet_01v8
M$804 97 1134 734 734 sky130_fd_pr__nfet_01v8 L=0.15U W=0.65U AS=0.08775P
+ AD=0.169P PS=0.92U PD=1.82U
* device instance $805 r0 *1 49.23,41.36 sky130_fd_pr__nfet_01v8
M$805 733 734 97 97 sky130_fd_pr__nfet_01v8 L=0.15U W=0.65U AS=0.169P
+ AD=0.08775P PS=1.82U PD=0.92U
* device instance $806 r0 *1 49.65,41.36 sky130_fd_pr__nfet_01v8
M$806 732 700 733 733 sky130_fd_pr__nfet_01v8 L=0.15U W=0.65U AS=0.08775P
+ AD=0.10725P PS=0.92U PD=0.98U
* device instance $807 r0 *1 50.13,41.36 sky130_fd_pr__nfet_01v8
M$807 896 409 732 732 sky130_fd_pr__nfet_01v8 L=0.15U W=0.65U AS=0.10725P
+ AD=0.169P PS=0.98U PD=1.82U
* device instance $808 r0 *1 57.61,41.36 sky130_fd_pr__nfet_01v8
M$808 731 729 730 730 sky130_fd_pr__nfet_01v8 L=0.15U W=0.65U AS=0.169P
+ AD=0.06825P PS=1.82U PD=0.86U
* device instance $809 r0 *1 57.97,41.36 sky130_fd_pr__nfet_01v8
M$809 97 639 731 731 sky130_fd_pr__nfet_01v8 L=0.15U W=0.65U AS=0.06825P
+ AD=0.08775P PS=0.86U PD=0.92U
* device instance $810 r0 *1 58.39,41.36 sky130_fd_pr__nfet_01v8
M$810 701 639 97 97 sky130_fd_pr__nfet_01v8 L=0.15U W=0.65U AS=0.08775P
+ AD=0.169P PS=0.92U PD=1.82U
* device instance $811 r0 *1 59.33,41.36 sky130_fd_pr__nfet_01v8
M$811 701 729 97 97 sky130_fd_pr__nfet_01v8 L=0.15U W=0.65U AS=0.169P
+ AD=0.08775P PS=1.82U PD=0.92U
* device instance $812 r0 *1 59.75,41.36 sky130_fd_pr__nfet_01v8
M$812 735 730 701 701 sky130_fd_pr__nfet_01v8 L=0.15U W=0.65U AS=0.08775P
+ AD=0.195P PS=0.92U PD=1.9U
* device instance $813 r0 *1 60.73,41.245 sky130_fd_pr__nfet_01v8
M$813 97 979 702 702 sky130_fd_pr__nfet_01v8 L=0.15U W=0.42U AS=0.1092P
+ AD=0.0567P PS=1.36U PD=0.69U
* device instance $814 r0 *1 61.15,41.245 sky130_fd_pr__nfet_01v8
M$814 703 702 97 97 sky130_fd_pr__nfet_01v8 L=0.15U W=0.42U AS=0.0567P
+ AD=0.1092P PS=0.69U PD=1.36U
* device instance $815 r0 *1 62.09,41.245 sky130_fd_pr__nfet_01v8
M$815 721 571 704 704 sky130_fd_pr__nfet_01v8 L=0.15U W=0.42U AS=0.1092P
+ AD=0.0441P PS=1.36U PD=0.63U
* device instance $816 r0 *1 62.45,41.245 sky130_fd_pr__nfet_01v8
M$816 97 303 721 721 sky130_fd_pr__nfet_01v8 L=0.15U W=0.42U AS=0.0441P
+ AD=0.1092P PS=0.63U PD=1.36U
* device instance $817 r0 *1 65.25,41.215 sky130_fd_pr__nfet_01v8
M$817 707 702 704 704 sky130_fd_pr__nfet_01v8 L=0.15U W=0.36U AS=0.1446P
+ AD=0.0522P PS=1.18U PD=0.65U
* device instance $818 r0 *1 65.69,41.215 sky130_fd_pr__nfet_01v8
M$818 717 703 707 707 sky130_fd_pr__nfet_01v8 L=0.15U W=0.36U AS=0.0522P
+ AD=0.0759P PS=0.65U PD=0.8U
* device instance $819 r0 *1 63.39,41.245 sky130_fd_pr__nfet_01v8
M$819 97 303 705 705 sky130_fd_pr__nfet_01v8 L=0.15U W=0.42U AS=0.1092P
+ AD=0.0609P PS=1.36U PD=0.71U
* device instance $820 r0 *1 63.83,41.245 sky130_fd_pr__nfet_01v8
M$820 719 705 97 97 sky130_fd_pr__nfet_01v8 L=0.15U W=0.42U AS=0.0609P
+ AD=0.0756P PS=0.71U PD=0.78U
* device instance $821 r0 *1 64.34,41.245 sky130_fd_pr__nfet_01v8
M$821 704 706 719 719 sky130_fd_pr__nfet_01v8 L=0.15U W=0.42U AS=0.0756P
+ AD=0.1446P PS=0.78U PD=1.18U
* device instance $822 r0 *1 66.22,41.245 sky130_fd_pr__nfet_01v8
M$822 97 708 717 717 sky130_fd_pr__nfet_01v8 L=0.15U W=0.42U AS=0.0759P
+ AD=0.12095P PS=0.8U PD=1.085U
* device instance $823 r0 *1 66.815,41.355 sky130_fd_pr__nfet_01v8
M$823 708 707 97 97 sky130_fd_pr__nfet_01v8 L=0.15U W=0.64U AS=0.12095P
+ AD=0.1664P PS=1.085U PD=1.8U
* device instance $824 r0 *1 68.24,41.215 sky130_fd_pr__nfet_01v8
M$824 709 703 716 716 sky130_fd_pr__nfet_01v8 L=0.15U W=0.36U AS=0.0678P
+ AD=0.0684P PS=0.755U PD=0.74U
* device instance $825 r0 *1 68.77,41.215 sky130_fd_pr__nfet_01v8
M$825 715 702 709 709 sky130_fd_pr__nfet_01v8 L=0.15U W=0.36U AS=0.0684P
+ AD=0.066P PS=0.74U PD=0.745U
* device instance $826 r0 *1 67.755,41.245 sky130_fd_pr__nfet_01v8
M$826 716 708 97 97 sky130_fd_pr__nfet_01v8 L=0.15U W=0.42U AS=0.1092P
+ AD=0.0678P PS=1.36U PD=0.755U
* device instance $827 r0 *1 69.245,41.245 sky130_fd_pr__nfet_01v8
M$827 97 706 715 715 sky130_fd_pr__nfet_01v8 L=0.15U W=0.42U AS=0.066P
+ AD=0.1092P PS=0.745U PD=1.36U
* device instance $828 r0 *1 70.185,41.245 sky130_fd_pr__nfet_01v8
M$828 97 709 706 706 sky130_fd_pr__nfet_01v8 L=0.15U W=0.42U AS=0.1092P
+ AD=0.10025P PS=1.36U PD=0.985U
* device instance $829 r0 *1 70.67,41.36 sky130_fd_pr__nfet_01v8
M$829 652 709 97 97 sky130_fd_pr__nfet_01v8 L=0.15U W=0.65U AS=0.10025P
+ AD=0.182P PS=0.985U PD=1.86U
* device instance $830 r0 *1 7.83,46.8 sky130_fd_pr__nfet_01v8
M$830 97 867 832 832 sky130_fd_pr__nfet_01v8 L=0.15U W=0.65U AS=0.169P
+ AD=0.10725P PS=1.82U PD=0.98U
* device instance $831 r0 *1 8.31,46.8 sky130_fd_pr__nfet_01v8
M$831 855 833 97 97 sky130_fd_pr__nfet_01v8 L=0.15U W=0.65U AS=0.10725P
+ AD=0.06825P PS=0.98U PD=0.86U
* device instance $832 r0 *1 8.67,46.8 sky130_fd_pr__nfet_01v8
M$832 832 92 855 855 sky130_fd_pr__nfet_01v8 L=0.15U W=0.65U AS=0.06825P
+ AD=0.169P PS=0.86U PD=1.82U
* device instance $833 r0 *1 9.21,45.795 sky130_fd_pr__nfet_01v8
M$833 97 681 755 755 sky130_fd_pr__nfet_01v8 L=0.15U W=0.42U AS=0.1092P
+ AD=0.0567P PS=1.36U PD=0.69U
* device instance $834 r0 *1 9.63,45.795 sky130_fd_pr__nfet_01v8
M$834 756 755 97 97 sky130_fd_pr__nfet_01v8 L=0.15U W=0.42U AS=0.0567P
+ AD=0.1092P PS=0.69U PD=1.36U
* device instance $835 r0 *1 9.61,46.8 sky130_fd_pr__nfet_01v8
M$835 856 157 832 832 sky130_fd_pr__nfet_01v8 L=0.15U W=0.65U AS=0.169P
+ AD=0.10725P PS=1.82U PD=0.98U
* device instance $836 r0 *1 10.09,46.8 sky130_fd_pr__nfet_01v8
M$836 97 868 856 856 sky130_fd_pr__nfet_01v8 L=0.15U W=0.65U AS=0.10725P
+ AD=0.102375P PS=0.98U PD=0.965U
* device instance $837 r0 *1 10.555,46.8 sky130_fd_pr__nfet_01v8
M$837 873 832 97 97 sky130_fd_pr__nfet_01v8 L=0.15U W=0.65U AS=0.102375P
+ AD=0.169P PS=0.965U PD=1.82U
* device instance $838 r0 *1 10.57,45.795 sky130_fd_pr__nfet_01v8
M$838 816 591 757 757 sky130_fd_pr__nfet_01v8 L=0.15U W=0.42U AS=0.1092P
+ AD=0.0441P PS=1.36U PD=0.63U
* device instance $839 r0 *1 10.93,45.795 sky130_fd_pr__nfet_01v8
M$839 97 303 816 816 sky130_fd_pr__nfet_01v8 L=0.15U W=0.42U AS=0.0441P
+ AD=0.1092P PS=0.63U PD=1.36U
* device instance $840 r0 *1 11.51,46.8 sky130_fd_pr__nfet_01v8
M$840 97 869 835 835 sky130_fd_pr__nfet_01v8 L=0.15U W=0.65U AS=0.169P
+ AD=0.169P PS=1.82U PD=1.82U
* device instance $841 r0 *1 11.87,45.795 sky130_fd_pr__nfet_01v8
M$841 97 303 758 758 sky130_fd_pr__nfet_01v8 L=0.15U W=0.42U AS=0.1092P
+ AD=0.0609P PS=1.36U PD=0.71U
* device instance $842 r0 *1 12.31,45.795 sky130_fd_pr__nfet_01v8
M$842 818 758 97 97 sky130_fd_pr__nfet_01v8 L=0.15U W=0.42U AS=0.0609P
+ AD=0.0756P PS=0.71U PD=0.78U
* device instance $843 r0 *1 12.82,45.795 sky130_fd_pr__nfet_01v8
M$843 757 762 818 818 sky130_fd_pr__nfet_01v8 L=0.15U W=0.42U AS=0.0756P
+ AD=0.1446P PS=0.78U PD=1.18U
* device instance $844 r0 *1 13.73,45.825 sky130_fd_pr__nfet_01v8
M$844 759 755 757 757 sky130_fd_pr__nfet_01v8 L=0.15U W=0.36U AS=0.1446P
+ AD=0.0522P PS=1.18U PD=0.65U
* device instance $845 r0 *1 14.17,45.825 sky130_fd_pr__nfet_01v8
M$845 759 756 820 820 sky130_fd_pr__nfet_01v8 L=0.15U W=0.36U AS=0.0759P
+ AD=0.0522P PS=0.8U PD=0.65U
* device instance $846 r0 *1 14.7,45.795 sky130_fd_pr__nfet_01v8
M$846 820 760 97 97 sky130_fd_pr__nfet_01v8 L=0.15U W=0.42U AS=0.12095P
+ AD=0.0759P PS=1.085U PD=0.8U
* device instance $847 r0 *1 15.295,45.685 sky130_fd_pr__nfet_01v8
M$847 760 759 97 97 sky130_fd_pr__nfet_01v8 L=0.15U W=0.64U AS=0.12095P
+ AD=0.1664P PS=1.085U PD=1.8U
* device instance $848 r0 *1 12.45,46.8 sky130_fd_pr__nfet_01v8
M$848 593 835 834 834 sky130_fd_pr__nfet_01v8 L=0.15U W=2.6U AS=0.43225P
+ AD=0.355875P PS=4.58U PD=3.695U
* device instance $852 r0 *1 14.145,46.8 sky130_fd_pr__nfet_01v8
M$852 97 836 834 834 sky130_fd_pr__nfet_01v8 L=0.15U W=2.6U AS=0.355875P
+ AD=0.51675P PS=3.695U PD=4.84U
* device instance $856 r0 *1 16.235,45.795 sky130_fd_pr__nfet_01v8
M$856 821 760 97 97 sky130_fd_pr__nfet_01v8 L=0.15U W=0.42U AS=0.1092P
+ AD=0.0678P PS=1.36U PD=0.755U
* device instance $857 r0 *1 16.72,45.825 sky130_fd_pr__nfet_01v8
M$857 761 756 821 821 sky130_fd_pr__nfet_01v8 L=0.15U W=0.36U AS=0.0678P
+ AD=0.0684P PS=0.755U PD=0.74U
* device instance $858 r0 *1 17.25,45.825 sky130_fd_pr__nfet_01v8
M$858 761 755 822 822 sky130_fd_pr__nfet_01v8 L=0.15U W=0.36U AS=0.066P
+ AD=0.0684P PS=0.745U PD=0.74U
* device instance $859 r0 *1 17.725,45.795 sky130_fd_pr__nfet_01v8
M$859 97 762 822 822 sky130_fd_pr__nfet_01v8 L=0.15U W=0.42U AS=0.066P
+ AD=0.1092P PS=0.745U PD=1.36U
* device instance $860 r0 *1 18.665,45.795 sky130_fd_pr__nfet_01v8
M$860 762 761 97 97 sky130_fd_pr__nfet_01v8 L=0.15U W=0.42U AS=0.10025P
+ AD=0.1092P PS=0.985U PD=1.36U
* device instance $861 r0 *1 19.15,45.68 sky130_fd_pr__nfet_01v8
M$861 594 761 97 97 sky130_fd_pr__nfet_01v8 L=0.15U W=0.65U AS=0.10025P
+ AD=0.182P PS=0.985U PD=1.86U
* device instance $862 r0 *1 25.77,46.685 sky130_fd_pr__nfet_01v8
M$862 97 681 837 837 sky130_fd_pr__nfet_01v8 L=0.15U W=0.42U AS=0.1092P
+ AD=0.0567P PS=1.36U PD=0.69U
* device instance $863 r0 *1 26.19,46.685 sky130_fd_pr__nfet_01v8
M$863 870 837 97 97 sky130_fd_pr__nfet_01v8 L=0.15U W=0.42U AS=0.0567P
+ AD=0.1092P PS=0.69U PD=1.36U
* device instance $864 r0 *1 26.23,45.68 sky130_fd_pr__nfet_01v8
M$864 97 763 727 727 sky130_fd_pr__nfet_01v8 L=0.15U W=0.65U AS=0.169P
+ AD=0.11285P PS=1.82U PD=1.045U
* device instance $865 r0 *1 26.775,45.795 sky130_fd_pr__nfet_01v8
M$865 823 64 97 97 sky130_fd_pr__nfet_01v8 L=0.15U W=0.42U AS=0.11285P
+ AD=0.0693P PS=1.045U PD=0.75U
* device instance $866 r0 *1 27.255,45.795 sky130_fd_pr__nfet_01v8
M$866 763 794 823 823 sky130_fd_pr__nfet_01v8 L=0.15U W=0.42U AS=0.0693P
+ AD=0.09975P PS=0.75U PD=0.895U
* device instance $867 r0 *1 27.88,45.795 sky130_fd_pr__nfet_01v8
M$867 824 597 763 763 sky130_fd_pr__nfet_01v8 L=0.15U W=0.42U AS=0.09975P
+ AD=0.0693P PS=0.895U PD=0.75U
* device instance $868 r0 *1 28.36,45.795 sky130_fd_pr__nfet_01v8
M$868 97 812 824 824 sky130_fd_pr__nfet_01v8 L=0.15U W=0.42U AS=0.0693P
+ AD=0.1449P PS=0.75U PD=1.11U
* device instance $869 r0 *1 29.2,45.795 sky130_fd_pr__nfet_01v8
M$869 812 64 97 97 sky130_fd_pr__nfet_01v8 L=0.15U W=0.42U AS=0.1449P
+ AD=0.1092P PS=1.11U PD=1.36U
* device instance $870 r0 *1 27.13,46.685 sky130_fd_pr__nfet_01v8
M$870 857 635 838 838 sky130_fd_pr__nfet_01v8 L=0.15U W=0.42U AS=0.1092P
+ AD=0.0441P PS=1.36U PD=0.63U
* device instance $871 r0 *1 27.49,46.685 sky130_fd_pr__nfet_01v8
M$871 97 303 857 857 sky130_fd_pr__nfet_01v8 L=0.15U W=0.42U AS=0.0441P
+ AD=0.1092P PS=0.63U PD=1.36U
* device instance $872 r0 *1 30.29,46.655 sky130_fd_pr__nfet_01v8
M$872 841 837 838 838 sky130_fd_pr__nfet_01v8 L=0.15U W=0.36U AS=0.1446P
+ AD=0.0522P PS=1.18U PD=0.65U
* device instance $873 r0 *1 30.73,46.655 sky130_fd_pr__nfet_01v8
M$873 859 870 841 841 sky130_fd_pr__nfet_01v8 L=0.15U W=0.36U AS=0.0522P
+ AD=0.0759P PS=0.65U PD=0.8U
* device instance $874 r0 *1 28.43,46.685 sky130_fd_pr__nfet_01v8
M$874 97 303 839 839 sky130_fd_pr__nfet_01v8 L=0.15U W=0.42U AS=0.1092P
+ AD=0.0609P PS=1.36U PD=0.71U
* device instance $875 r0 *1 28.87,46.685 sky130_fd_pr__nfet_01v8
M$875 858 839 97 97 sky130_fd_pr__nfet_01v8 L=0.15U W=0.42U AS=0.0609P
+ AD=0.0756P PS=0.71U PD=0.78U
* device instance $876 r0 *1 29.38,46.685 sky130_fd_pr__nfet_01v8
M$876 838 840 858 858 sky130_fd_pr__nfet_01v8 L=0.15U W=0.42U AS=0.0756P
+ AD=0.1446P PS=0.78U PD=1.18U
* device instance $877 r0 *1 31.26,46.685 sky130_fd_pr__nfet_01v8
M$877 97 842 859 859 sky130_fd_pr__nfet_01v8 L=0.15U W=0.42U AS=0.0759P
+ AD=0.12095P PS=0.8U PD=1.085U
* device instance $878 r0 *1 31.855,46.795 sky130_fd_pr__nfet_01v8
M$878 842 841 97 97 sky130_fd_pr__nfet_01v8 L=0.15U W=0.64U AS=0.12095P
+ AD=0.1664P PS=1.085U PD=1.8U
* device instance $879 r0 *1 33.28,46.655 sky130_fd_pr__nfet_01v8
M$879 843 870 860 860 sky130_fd_pr__nfet_01v8 L=0.15U W=0.36U AS=0.0678P
+ AD=0.0684P PS=0.755U PD=0.74U
* device instance $880 r0 *1 33.81,46.655 sky130_fd_pr__nfet_01v8
M$880 861 837 843 843 sky130_fd_pr__nfet_01v8 L=0.15U W=0.36U AS=0.0684P
+ AD=0.066P PS=0.74U PD=0.745U
* device instance $881 r0 *1 32.795,46.685 sky130_fd_pr__nfet_01v8
M$881 860 842 97 97 sky130_fd_pr__nfet_01v8 L=0.15U W=0.42U AS=0.1092P
+ AD=0.0678P PS=1.36U PD=0.755U
* device instance $882 r0 *1 34.285,46.685 sky130_fd_pr__nfet_01v8
M$882 97 840 861 861 sky130_fd_pr__nfet_01v8 L=0.15U W=0.42U AS=0.066P
+ AD=0.1092P PS=0.745U PD=1.36U
* device instance $883 r0 *1 33.59,45.795 sky130_fd_pr__nfet_01v8
M$883 97 681 764 764 sky130_fd_pr__nfet_01v8 L=0.15U W=0.42U AS=0.1092P
+ AD=0.0567P PS=1.36U PD=0.69U
* device instance $884 r0 *1 34.01,45.795 sky130_fd_pr__nfet_01v8
M$884 765 764 97 97 sky130_fd_pr__nfet_01v8 L=0.15U W=0.42U AS=0.0567P
+ AD=0.1092P PS=0.69U PD=1.36U
* device instance $885 r0 *1 34.95,45.795 sky130_fd_pr__nfet_01v8
M$885 828 795 766 766 sky130_fd_pr__nfet_01v8 L=0.15U W=0.42U AS=0.1092P
+ AD=0.0441P PS=1.36U PD=0.63U
* device instance $886 r0 *1 35.31,45.795 sky130_fd_pr__nfet_01v8
M$886 97 94 828 828 sky130_fd_pr__nfet_01v8 L=0.15U W=0.42U AS=0.0441P
+ AD=0.1092P PS=0.63U PD=1.36U
* device instance $887 r0 *1 35.225,46.685 sky130_fd_pr__nfet_01v8
M$887 97 843 840 840 sky130_fd_pr__nfet_01v8 L=0.15U W=0.42U AS=0.1092P
+ AD=0.10025P PS=1.36U PD=0.985U
* device instance $888 r0 *1 35.71,46.8 sky130_fd_pr__nfet_01v8
M$888 597 843 97 97 sky130_fd_pr__nfet_01v8 L=0.15U W=0.65U AS=0.10025P
+ AD=0.182P PS=0.985U PD=1.86U
* device instance $889 r0 *1 36.25,45.795 sky130_fd_pr__nfet_01v8
M$889 97 94 767 767 sky130_fd_pr__nfet_01v8 L=0.15U W=0.42U AS=0.1092P
+ AD=0.0609P PS=1.36U PD=0.71U
* device instance $890 r0 *1 36.69,45.795 sky130_fd_pr__nfet_01v8
M$890 830 767 97 97 sky130_fd_pr__nfet_01v8 L=0.15U W=0.42U AS=0.0609P
+ AD=0.0756P PS=0.71U PD=0.78U
* device instance $891 r0 *1 37.2,45.795 sky130_fd_pr__nfet_01v8
M$891 766 771 830 830 sky130_fd_pr__nfet_01v8 L=0.15U W=0.42U AS=0.0756P
+ AD=0.1446P PS=0.78U PD=1.18U
* device instance $892 r0 *1 38.11,45.825 sky130_fd_pr__nfet_01v8
M$892 768 764 766 766 sky130_fd_pr__nfet_01v8 L=0.15U W=0.36U AS=0.1446P
+ AD=0.0522P PS=1.18U PD=0.65U
* device instance $893 r0 *1 38.55,45.825 sky130_fd_pr__nfet_01v8
M$893 768 765 831 831 sky130_fd_pr__nfet_01v8 L=0.15U W=0.36U AS=0.0759P
+ AD=0.0522P PS=0.8U PD=0.65U
* device instance $894 r0 *1 39.08,45.795 sky130_fd_pr__nfet_01v8
M$894 831 769 97 97 sky130_fd_pr__nfet_01v8 L=0.15U W=0.42U AS=0.12095P
+ AD=0.0759P PS=1.085U PD=0.8U
* device instance $895 r0 *1 39.675,45.685 sky130_fd_pr__nfet_01v8
M$895 769 768 97 97 sky130_fd_pr__nfet_01v8 L=0.15U W=0.64U AS=0.12095P
+ AD=0.1664P PS=1.085U PD=1.8U
* device instance $896 r0 *1 40.615,45.795 sky130_fd_pr__nfet_01v8
M$896 829 769 97 97 sky130_fd_pr__nfet_01v8 L=0.15U W=0.42U AS=0.1092P
+ AD=0.0678P PS=1.36U PD=0.755U
* device instance $897 r0 *1 41.1,45.825 sky130_fd_pr__nfet_01v8
M$897 770 765 829 829 sky130_fd_pr__nfet_01v8 L=0.15U W=0.36U AS=0.0678P
+ AD=0.0684P PS=0.755U PD=0.74U
* device instance $898 r0 *1 41.63,45.825 sky130_fd_pr__nfet_01v8
M$898 770 764 827 827 sky130_fd_pr__nfet_01v8 L=0.15U W=0.36U AS=0.066P
+ AD=0.0684P PS=0.745U PD=0.74U
* device instance $899 r0 *1 42.105,45.795 sky130_fd_pr__nfet_01v8
M$899 97 771 827 827 sky130_fd_pr__nfet_01v8 L=0.15U W=0.42U AS=0.066P
+ AD=0.1092P PS=0.745U PD=1.36U
* device instance $900 r0 *1 40.98,46.685 sky130_fd_pr__nfet_01v8
M$900 97 776 844 844 sky130_fd_pr__nfet_01v8 L=0.15U W=0.42U AS=0.1113P
+ AD=0.0588P PS=1.37U PD=0.7U
* device instance $901 r0 *1 41.41,46.685 sky130_fd_pr__nfet_01v8
M$901 844 64 97 97 sky130_fd_pr__nfet_01v8 L=0.15U W=0.42U AS=0.0588P
+ AD=0.0588P PS=0.7U PD=0.7U
* device instance $902 r0 *1 41.84,46.685 sky130_fd_pr__nfet_01v8
M$902 795 845 844 844 sky130_fd_pr__nfet_01v8 L=0.15U W=0.42U AS=0.0588P
+ AD=0.1113P PS=0.7U PD=1.37U
* device instance $903 r0 *1 43.045,45.795 sky130_fd_pr__nfet_01v8
M$903 771 770 97 97 sky130_fd_pr__nfet_01v8 L=0.15U W=0.42U AS=0.10025P
+ AD=0.1092P PS=0.985U PD=1.36U
* device instance $904 r0 *1 43.53,45.68 sky130_fd_pr__nfet_01v8
M$904 728 770 97 97 sky130_fd_pr__nfet_01v8 L=0.15U W=0.65U AS=0.10025P
+ AD=0.182P PS=0.985U PD=1.86U
* device instance $905 r0 *1 44.63,46.685 sky130_fd_pr__nfet_01v8
M$905 97 979 846 846 sky130_fd_pr__nfet_01v8 L=0.15U W=0.42U AS=0.1092P
+ AD=0.0567P PS=1.36U PD=0.69U
* device instance $906 r0 *1 45.05,46.685 sky130_fd_pr__nfet_01v8
M$906 871 846 97 97 sky130_fd_pr__nfet_01v8 L=0.15U W=0.42U AS=0.0567P
+ AD=0.1092P PS=0.69U PD=1.36U
* device instance $907 r0 *1 44.63,45.68 sky130_fd_pr__nfet_01v8
M$907 97 796 772 772 sky130_fd_pr__nfet_01v8 L=0.15U W=0.65U AS=0.169P
+ AD=0.10725P PS=1.82U PD=0.98U
* device instance $908 r0 *1 45.11,45.68 sky130_fd_pr__nfet_01v8
M$908 826 728 97 97 sky130_fd_pr__nfet_01v8 L=0.15U W=0.65U AS=0.10725P
+ AD=0.06825P PS=0.98U PD=0.86U
* device instance $909 r0 *1 45.47,45.68 sky130_fd_pr__nfet_01v8
M$909 772 92 826 826 sky130_fd_pr__nfet_01v8 L=0.15U W=0.65U AS=0.06825P
+ AD=0.169P PS=0.86U PD=1.82U
* device instance $910 r0 *1 45.99,46.685 sky130_fd_pr__nfet_01v8
M$910 862 774 847 847 sky130_fd_pr__nfet_01v8 L=0.15U W=0.42U AS=0.1092P
+ AD=0.0441P PS=1.36U PD=0.63U
* device instance $911 r0 *1 46.35,46.685 sky130_fd_pr__nfet_01v8
M$911 97 303 862 862 sky130_fd_pr__nfet_01v8 L=0.15U W=0.42U AS=0.0441P
+ AD=0.1092P PS=0.63U PD=1.36U
* device instance $912 r0 *1 46.41,45.68 sky130_fd_pr__nfet_01v8
M$912 825 134 772 772 sky130_fd_pr__nfet_01v8 L=0.15U W=0.65U AS=0.169P
+ AD=0.10725P PS=1.82U PD=0.98U
* device instance $913 r0 *1 46.89,45.68 sky130_fd_pr__nfet_01v8
M$913 97 735 825 825 sky130_fd_pr__nfet_01v8 L=0.15U W=0.65U AS=0.10725P
+ AD=0.102375P PS=0.98U PD=0.965U
* device instance $914 r0 *1 47.355,45.68 sky130_fd_pr__nfet_01v8
M$914 774 772 97 97 sky130_fd_pr__nfet_01v8 L=0.15U W=0.65U AS=0.102375P
+ AD=0.169P PS=0.965U PD=1.82U
* device instance $915 r0 *1 49.15,46.655 sky130_fd_pr__nfet_01v8
M$915 850 846 847 847 sky130_fd_pr__nfet_01v8 L=0.15U W=0.36U AS=0.1446P
+ AD=0.0522P PS=1.18U PD=0.65U
* device instance $916 r0 *1 49.59,46.655 sky130_fd_pr__nfet_01v8
M$916 864 871 850 850 sky130_fd_pr__nfet_01v8 L=0.15U W=0.36U AS=0.0522P
+ AD=0.0759P PS=0.65U PD=0.8U
* device instance $917 r0 *1 47.29,46.685 sky130_fd_pr__nfet_01v8
M$917 97 303 848 848 sky130_fd_pr__nfet_01v8 L=0.15U W=0.42U AS=0.1092P
+ AD=0.0609P PS=1.36U PD=0.71U
* device instance $918 r0 *1 47.73,46.685 sky130_fd_pr__nfet_01v8
M$918 863 848 97 97 sky130_fd_pr__nfet_01v8 L=0.15U W=0.42U AS=0.0609P
+ AD=0.0756P PS=0.71U PD=0.78U
* device instance $919 r0 *1 48.24,46.685 sky130_fd_pr__nfet_01v8
M$919 847 849 863 863 sky130_fd_pr__nfet_01v8 L=0.15U W=0.42U AS=0.0756P
+ AD=0.1446P PS=0.78U PD=1.18U
* device instance $920 r0 *1 50.12,46.685 sky130_fd_pr__nfet_01v8
M$920 97 851 864 864 sky130_fd_pr__nfet_01v8 L=0.15U W=0.42U AS=0.0759P
+ AD=0.12095P PS=0.8U PD=1.085U
* device instance $921 r0 *1 50.715,46.795 sky130_fd_pr__nfet_01v8
M$921 851 850 97 97 sky130_fd_pr__nfet_01v8 L=0.15U W=0.64U AS=0.12095P
+ AD=0.1664P PS=1.085U PD=1.8U
* device instance $922 r0 *1 48.725,45.795 sky130_fd_pr__nfet_01v8
M$922 97 797 776 776 sky130_fd_pr__nfet_01v8 L=0.15U W=0.42U AS=0.1092P
+ AD=0.1197P PS=1.36U PD=1.41U
* device instance $923 r0 *1 49.69,45.68 sky130_fd_pr__nfet_01v8
M$923 662 776 97 97 sky130_fd_pr__nfet_01v8 L=0.15U W=0.65U AS=0.169P
+ AD=0.08775P PS=1.82U PD=0.92U
* device instance $924 r0 *1 50.11,45.68 sky130_fd_pr__nfet_01v8
M$924 97 728 662 662 sky130_fd_pr__nfet_01v8 L=0.15U W=0.65U AS=0.08775P
+ AD=0.169P PS=0.92U PD=1.82U
* device instance $925 r0 *1 51.305,45.795 sky130_fd_pr__nfet_01v8
M$925 798 728 97 97 sky130_fd_pr__nfet_01v8 L=0.15U W=0.42U AS=0.10025P
+ AD=0.1092P PS=0.985U PD=1.36U
* device instance $926 r0 *1 51.79,45.68 sky130_fd_pr__nfet_01v8
M$926 799 797 97 97 sky130_fd_pr__nfet_01v8 L=0.15U W=0.65U AS=0.10025P
+ AD=0.08775P PS=0.985U PD=0.92U
* device instance $927 r0 *1 52.21,45.68 sky130_fd_pr__nfet_01v8
M$927 97 798 799 799 sky130_fd_pr__nfet_01v8 L=0.15U W=0.65U AS=0.08775P
+ AD=0.169P PS=0.92U PD=1.82U
* device instance $928 r0 *1 52.14,46.655 sky130_fd_pr__nfet_01v8
M$928 852 871 865 865 sky130_fd_pr__nfet_01v8 L=0.15U W=0.36U AS=0.0678P
+ AD=0.0684P PS=0.755U PD=0.74U
* device instance $929 r0 *1 52.67,46.655 sky130_fd_pr__nfet_01v8
M$929 866 846 852 852 sky130_fd_pr__nfet_01v8 L=0.15U W=0.36U AS=0.0684P
+ AD=0.066P PS=0.74U PD=0.745U
* device instance $930 r0 *1 51.655,46.685 sky130_fd_pr__nfet_01v8
M$930 865 851 97 97 sky130_fd_pr__nfet_01v8 L=0.15U W=0.42U AS=0.1092P
+ AD=0.0678P PS=1.36U PD=0.755U
* device instance $931 r0 *1 53.145,46.685 sky130_fd_pr__nfet_01v8
M$931 97 849 866 866 sky130_fd_pr__nfet_01v8 L=0.15U W=0.42U AS=0.066P
+ AD=0.1092P PS=0.745U PD=1.36U
* device instance $932 r0 *1 54.085,46.685 sky130_fd_pr__nfet_01v8
M$932 97 852 849 849 sky130_fd_pr__nfet_01v8 L=0.15U W=0.42U AS=0.1092P
+ AD=0.10025P PS=1.36U PD=0.985U
* device instance $933 r0 *1 54.57,46.8 sky130_fd_pr__nfet_01v8
M$933 797 852 97 97 sky130_fd_pr__nfet_01v8 L=0.15U W=0.65U AS=0.10025P
+ AD=0.182P PS=0.985U PD=1.86U
* device instance $934 r0 *1 56.59,45.68 sky130_fd_pr__nfet_01v8
M$934 729 799 97 97 sky130_fd_pr__nfet_01v8 L=0.15U W=0.65U AS=0.169P
+ AD=0.08775P PS=1.82U PD=0.92U
* device instance $935 r0 *1 57.01,45.68 sky130_fd_pr__nfet_01v8
M$935 97 662 729 729 sky130_fd_pr__nfet_01v8 L=0.15U W=0.65U AS=0.08775P
+ AD=0.169P PS=0.92U PD=1.82U
* device instance $936 r0 *1 61.19,45.68 sky130_fd_pr__nfet_01v8
M$936 700 569 97 97 sky130_fd_pr__nfet_01v8 L=0.15U W=0.65U AS=0.169P
+ AD=0.08775P PS=1.82U PD=0.92U
* device instance $937 r0 *1 61.61,45.68 sky130_fd_pr__nfet_01v8
M$937 97 985 700 700 sky130_fd_pr__nfet_01v8 L=0.15U W=0.65U AS=0.08775P
+ AD=0.169P PS=0.92U PD=1.82U
* device instance $938 r0 *1 61.65,46.8 sky130_fd_pr__nfet_01v8
M$938 97 641 853 853 sky130_fd_pr__nfet_01v8 L=0.15U W=0.65U AS=0.169P
+ AD=0.08775P PS=1.82U PD=0.92U
* device instance $939 r0 *1 62.07,46.8 sky130_fd_pr__nfet_01v8
M$939 854 853 97 97 sky130_fd_pr__nfet_01v8 L=0.15U W=1.95U AS=0.26325P
+ AD=0.3445P PS=2.76U PD=3.66U
* device instance $942 r0 *1 64.87,45.795 sky130_fd_pr__nfet_01v8
M$942 97 979 777 777 sky130_fd_pr__nfet_01v8 L=0.15U W=0.42U AS=0.1092P
+ AD=0.0567P PS=1.36U PD=0.69U
* device instance $943 r0 *1 65.29,45.795 sky130_fd_pr__nfet_01v8
M$943 778 777 97 97 sky130_fd_pr__nfet_01v8 L=0.15U W=0.42U AS=0.0567P
+ AD=0.1092P PS=0.69U PD=1.36U
* device instance $944 r0 *1 66.23,45.795 sky130_fd_pr__nfet_01v8
M$944 819 643 779 779 sky130_fd_pr__nfet_01v8 L=0.15U W=0.42U AS=0.1092P
+ AD=0.0441P PS=1.36U PD=0.63U
* device instance $945 r0 *1 66.59,45.795 sky130_fd_pr__nfet_01v8
M$945 97 410 819 819 sky130_fd_pr__nfet_01v8 L=0.15U W=0.42U AS=0.0441P
+ AD=0.1092P PS=0.63U PD=1.36U
* device instance $946 r0 *1 67.53,45.795 sky130_fd_pr__nfet_01v8
M$946 97 410 780 780 sky130_fd_pr__nfet_01v8 L=0.15U W=0.42U AS=0.1092P
+ AD=0.0609P PS=1.36U PD=0.71U
* device instance $947 r0 *1 67.97,45.795 sky130_fd_pr__nfet_01v8
M$947 817 780 97 97 sky130_fd_pr__nfet_01v8 L=0.15U W=0.42U AS=0.0609P
+ AD=0.0756P PS=0.71U PD=0.78U
* device instance $948 r0 *1 68.48,45.795 sky130_fd_pr__nfet_01v8
M$948 779 784 817 817 sky130_fd_pr__nfet_01v8 L=0.15U W=0.42U AS=0.0756P
+ AD=0.1446P PS=0.78U PD=1.18U
* device instance $949 r0 *1 69.39,45.825 sky130_fd_pr__nfet_01v8
M$949 781 777 779 779 sky130_fd_pr__nfet_01v8 L=0.15U W=0.36U AS=0.1446P
+ AD=0.0522P PS=1.18U PD=0.65U
* device instance $950 r0 *1 69.83,45.825 sky130_fd_pr__nfet_01v8
M$950 781 778 815 815 sky130_fd_pr__nfet_01v8 L=0.15U W=0.36U AS=0.0759P
+ AD=0.0522P PS=0.8U PD=0.65U
* device instance $951 r0 *1 70.36,45.795 sky130_fd_pr__nfet_01v8
M$951 815 782 97 97 sky130_fd_pr__nfet_01v8 L=0.15U W=0.42U AS=0.12095P
+ AD=0.0759P PS=1.085U PD=0.8U
* device instance $952 r0 *1 70.955,45.685 sky130_fd_pr__nfet_01v8
M$952 782 781 97 97 sky130_fd_pr__nfet_01v8 L=0.15U W=0.64U AS=0.12095P
+ AD=0.1664P PS=1.085U PD=1.8U
* device instance $953 r0 *1 71.895,45.795 sky130_fd_pr__nfet_01v8
M$953 814 782 97 97 sky130_fd_pr__nfet_01v8 L=0.15U W=0.42U AS=0.1092P
+ AD=0.0678P PS=1.36U PD=0.755U
* device instance $954 r0 *1 72.38,45.825 sky130_fd_pr__nfet_01v8
M$954 783 778 814 814 sky130_fd_pr__nfet_01v8 L=0.15U W=0.36U AS=0.0678P
+ AD=0.0684P PS=0.755U PD=0.74U
* device instance $955 r0 *1 72.91,45.825 sky130_fd_pr__nfet_01v8
M$955 783 777 813 813 sky130_fd_pr__nfet_01v8 L=0.15U W=0.36U AS=0.066P
+ AD=0.0684P PS=0.745U PD=0.74U
* device instance $956 r0 *1 73.385,45.795 sky130_fd_pr__nfet_01v8
M$956 97 784 813 813 sky130_fd_pr__nfet_01v8 L=0.15U W=0.42U AS=0.066P
+ AD=0.1092P PS=0.745U PD=1.36U
* device instance $957 r0 *1 74.325,45.795 sky130_fd_pr__nfet_01v8
M$957 784 783 97 97 sky130_fd_pr__nfet_01v8 L=0.15U W=0.42U AS=0.10025P
+ AD=0.1092P PS=0.985U PD=1.36U
* device instance $958 r0 *1 74.81,45.68 sky130_fd_pr__nfet_01v8
M$958 569 783 97 97 sky130_fd_pr__nfet_01v8 L=0.15U W=0.65U AS=0.10025P
+ AD=0.182P PS=0.985U PD=1.86U
* device instance $959 r0 *1 2.77,52.125 sky130_fd_pr__nfet_01v8
M$959 97 681 930 930 sky130_fd_pr__nfet_01v8 L=0.15U W=0.42U AS=0.1092P
+ AD=0.0567P PS=1.36U PD=0.69U
* device instance $960 r0 *1 3.19,52.125 sky130_fd_pr__nfet_01v8
M$960 931 930 97 97 sky130_fd_pr__nfet_01v8 L=0.15U W=0.42U AS=0.0567P
+ AD=0.1092P PS=0.69U PD=1.36U
* device instance $961 r0 *1 4.13,52.125 sky130_fd_pr__nfet_01v8
M$961 948 888 932 932 sky130_fd_pr__nfet_01v8 L=0.15U W=0.42U AS=0.1092P
+ AD=0.0441P PS=1.36U PD=0.63U
* device instance $962 r0 *1 4.49,52.125 sky130_fd_pr__nfet_01v8
M$962 97 94 948 948 sky130_fd_pr__nfet_01v8 L=0.15U W=0.42U AS=0.0441P
+ AD=0.1092P PS=0.63U PD=1.36U
* device instance $963 r0 *1 4.68,51.235 sky130_fd_pr__nfet_01v8
M$963 920 886 887 887 sky130_fd_pr__nfet_01v8 L=0.15U W=0.42U AS=0.1113P
+ AD=0.0441P PS=1.37U PD=0.63U
* device instance $964 r0 *1 5.04,51.235 sky130_fd_pr__nfet_01v8
M$964 97 115 920 920 sky130_fd_pr__nfet_01v8 L=0.15U W=0.42U AS=0.0441P
+ AD=0.0966P PS=0.63U PD=0.88U
* device instance $965 r0 *1 5.65,51.235 sky130_fd_pr__nfet_01v8
M$965 867 887 97 97 sky130_fd_pr__nfet_01v8 L=0.15U W=0.42U AS=0.0966P
+ AD=0.1113P PS=0.88U PD=1.37U
* device instance $966 r0 *1 7.29,52.095 sky130_fd_pr__nfet_01v8
M$966 935 930 932 932 sky130_fd_pr__nfet_01v8 L=0.15U W=0.36U AS=0.1446P
+ AD=0.0522P PS=1.18U PD=0.65U
* device instance $967 r0 *1 7.73,52.095 sky130_fd_pr__nfet_01v8
M$967 950 931 935 935 sky130_fd_pr__nfet_01v8 L=0.15U W=0.36U AS=0.0522P
+ AD=0.0759P PS=0.65U PD=0.8U
* device instance $968 r0 *1 5.43,52.125 sky130_fd_pr__nfet_01v8
M$968 97 94 933 933 sky130_fd_pr__nfet_01v8 L=0.15U W=0.42U AS=0.1092P
+ AD=0.0609P PS=1.36U PD=0.71U
* device instance $969 r0 *1 5.87,52.125 sky130_fd_pr__nfet_01v8
M$969 949 933 97 97 sky130_fd_pr__nfet_01v8 L=0.15U W=0.42U AS=0.0609P
+ AD=0.0756P PS=0.71U PD=0.78U
* device instance $970 r0 *1 6.38,52.125 sky130_fd_pr__nfet_01v8
M$970 932 934 949 949 sky130_fd_pr__nfet_01v8 L=0.15U W=0.42U AS=0.0756P
+ AD=0.1446P PS=0.78U PD=1.18U
* device instance $971 r0 *1 8.26,52.125 sky130_fd_pr__nfet_01v8
M$971 97 936 950 950 sky130_fd_pr__nfet_01v8 L=0.15U W=0.42U AS=0.0759P
+ AD=0.12095P PS=0.8U PD=1.085U
* device instance $972 r0 *1 8.855,52.235 sky130_fd_pr__nfet_01v8
M$972 936 935 97 97 sky130_fd_pr__nfet_01v8 L=0.15U W=0.64U AS=0.12095P
+ AD=0.1664P PS=1.085U PD=1.8U
* device instance $973 r0 *1 6.91,51.12 sky130_fd_pr__nfet_01v8
M$973 97 889 888 888 sky130_fd_pr__nfet_01v8 L=0.15U W=0.65U AS=0.169P
+ AD=0.11285P PS=1.82U PD=1.045U
* device instance $974 r0 *1 7.455,51.235 sky130_fd_pr__nfet_01v8
M$974 921 64 97 97 sky130_fd_pr__nfet_01v8 L=0.15U W=0.42U AS=0.11285P
+ AD=0.0693P PS=1.045U PD=0.75U
* device instance $975 r0 *1 7.935,51.235 sky130_fd_pr__nfet_01v8
M$975 889 915 921 921 sky130_fd_pr__nfet_01v8 L=0.15U W=0.42U AS=0.0693P
+ AD=0.09975P PS=0.75U PD=0.895U
* device instance $976 r0 *1 8.56,51.235 sky130_fd_pr__nfet_01v8
M$976 922 916 889 889 sky130_fd_pr__nfet_01v8 L=0.15U W=0.42U AS=0.09975P
+ AD=0.0693P PS=0.895U PD=0.75U
* device instance $977 r0 *1 9.04,51.235 sky130_fd_pr__nfet_01v8
M$977 97 917 922 922 sky130_fd_pr__nfet_01v8 L=0.15U W=0.42U AS=0.0693P
+ AD=0.1449P PS=0.75U PD=1.11U
* device instance $978 r0 *1 9.88,51.235 sky130_fd_pr__nfet_01v8
M$978 917 64 97 97 sky130_fd_pr__nfet_01v8 L=0.15U W=0.42U AS=0.1449P
+ AD=0.1092P PS=1.11U PD=1.36U
* device instance $979 r0 *1 10.28,52.095 sky130_fd_pr__nfet_01v8
M$979 937 931 951 951 sky130_fd_pr__nfet_01v8 L=0.15U W=0.36U AS=0.0678P
+ AD=0.0684P PS=0.755U PD=0.74U
* device instance $980 r0 *1 10.81,52.095 sky130_fd_pr__nfet_01v8
M$980 952 930 937 937 sky130_fd_pr__nfet_01v8 L=0.15U W=0.36U AS=0.0684P
+ AD=0.066P PS=0.74U PD=0.745U
* device instance $981 r0 *1 9.795,52.125 sky130_fd_pr__nfet_01v8
M$981 951 936 97 97 sky130_fd_pr__nfet_01v8 L=0.15U W=0.42U AS=0.1092P
+ AD=0.0678P PS=1.36U PD=0.755U
* device instance $982 r0 *1 11.285,52.125 sky130_fd_pr__nfet_01v8
M$982 97 934 952 952 sky130_fd_pr__nfet_01v8 L=0.15U W=0.42U AS=0.066P
+ AD=0.1092P PS=0.745U PD=1.36U
* device instance $983 r0 *1 11.09,51.12 sky130_fd_pr__nfet_01v8
M$983 890 833 97 97 sky130_fd_pr__nfet_01v8 L=0.15U W=0.65U AS=0.169P
+ AD=0.08775P PS=1.82U PD=0.92U
* device instance $984 r0 *1 11.51,51.12 sky130_fd_pr__nfet_01v8
M$984 97 916 890 890 sky130_fd_pr__nfet_01v8 L=0.15U W=0.65U AS=0.08775P
+ AD=0.08775P PS=0.92U PD=0.92U
* device instance $985 r0 *1 11.93,51.12 sky130_fd_pr__nfet_01v8
M$985 924 916 97 97 sky130_fd_pr__nfet_01v8 L=0.15U W=0.65U AS=0.08775P
+ AD=0.08775P PS=0.92U PD=0.92U
* device instance $986 r0 *1 12.35,51.12 sky130_fd_pr__nfet_01v8
M$986 868 833 924 924 sky130_fd_pr__nfet_01v8 L=0.15U W=0.65U AS=0.08775P
+ AD=0.25025P PS=0.92U PD=1.42U
* device instance $987 r0 *1 13.27,51.12 sky130_fd_pr__nfet_01v8
M$987 97 890 868 868 sky130_fd_pr__nfet_01v8 L=0.15U W=0.65U AS=0.25025P
+ AD=0.208P PS=1.42U PD=1.94U
* device instance $988 r0 *1 12.225,52.125 sky130_fd_pr__nfet_01v8
M$988 97 937 934 934 sky130_fd_pr__nfet_01v8 L=0.15U W=0.42U AS=0.1092P
+ AD=0.10025P PS=1.36U PD=0.985U
* device instance $989 r0 *1 12.71,52.24 sky130_fd_pr__nfet_01v8
M$989 836 937 97 97 sky130_fd_pr__nfet_01v8 L=0.15U W=0.65U AS=0.10025P
+ AD=0.182P PS=0.985U PD=1.86U
* device instance $990 r0 *1 13.81,52.24 sky130_fd_pr__nfet_01v8
M$990 97 869 938 938 sky130_fd_pr__nfet_01v8 L=0.15U W=0.65U AS=0.169P
+ AD=0.08775P PS=1.82U PD=0.92U
* device instance $991 r0 *1 14.23,52.24 sky130_fd_pr__nfet_01v8
M$991 916 938 97 97 sky130_fd_pr__nfet_01v8 L=0.15U W=2.6U AS=0.351P
+ AD=0.43225P PS=3.68U PD=4.58U
* device instance $995 r0 *1 17.03,52.24 sky130_fd_pr__nfet_01v8
M$995 97 836 939 939 sky130_fd_pr__nfet_01v8 L=0.15U W=0.65U AS=0.169P
+ AD=0.08775P PS=1.82U PD=0.92U
* device instance $996 r0 *1 17.45,52.24 sky130_fd_pr__nfet_01v8
M$996 833 939 97 97 sky130_fd_pr__nfet_01v8 L=0.15U W=2.6U AS=0.351P
+ AD=0.43225P PS=3.68U PD=4.58U
* device instance $1000 r0 *1 21.19,51.12 sky130_fd_pr__nfet_01v8
M$1000 918 833 97 97 sky130_fd_pr__nfet_01v8 L=0.15U W=2.6U AS=0.44525P
+ AD=0.351P PS=4.62U PD=3.68U
* device instance $1004 r0 *1 22.87,51.12 sky130_fd_pr__nfet_01v8
M$1004 918 893 97 97 sky130_fd_pr__nfet_01v8 L=0.15U W=2.6U AS=0.351P AD=0.52P
+ PS=3.68U PD=4.2U
* device instance $1008 r0 *1 25.07,51.12 sky130_fd_pr__nfet_01v8
M$1008 918 896 97 97 sky130_fd_pr__nfet_01v8 L=0.15U W=2.6U AS=0.52P AD=0.351P
+ PS=4.2U PD=3.68U
* device instance $1012 r0 *1 26.75,51.12 sky130_fd_pr__nfet_01v8
M$1012 918 362 97 97 sky130_fd_pr__nfet_01v8 L=0.15U W=2.6U AS=0.351P
+ AD=0.43225P PS=3.68U PD=4.58U
* device instance $1016 r0 *1 23.935,52.125 sky130_fd_pr__nfet_01v8
M$1016 940 298 97 97 sky130_fd_pr__nfet_01v8 L=0.15U W=1.68U AS=0.2877P
+ AD=0.2352P PS=3.47U PD=2.8U
* device instance $1020 r0 *1 25.655,52.125 sky130_fd_pr__nfet_01v8
M$1020 681 940 97 97 sky130_fd_pr__nfet_01v8 L=0.15U W=6.72U AS=0.93975P
+ AD=0.99225P PS=11.195U PD=11.865U
* device instance $1036 r0 *1 43.32,51.235 sky130_fd_pr__nfet_01v8
M$1036 929 897 898 898 sky130_fd_pr__nfet_01v8 L=0.15U W=0.42U AS=0.1113P
+ AD=0.0441P PS=1.37U PD=0.63U
* device instance $1037 r0 *1 43.68,51.235 sky130_fd_pr__nfet_01v8
M$1037 97 115 929 929 sky130_fd_pr__nfet_01v8 L=0.15U W=0.42U AS=0.0441P
+ AD=0.0966P PS=0.63U PD=0.88U
* device instance $1038 r0 *1 44.29,51.235 sky130_fd_pr__nfet_01v8
M$1038 796 898 97 97 sky130_fd_pr__nfet_01v8 L=0.15U W=0.42U AS=0.0966P
+ AD=0.1113P PS=0.88U PD=1.37U
* device instance $1039 r0 *1 56.13,52.24 sky130_fd_pr__nfet_01v8
M$1039 97 941 942 942 sky130_fd_pr__nfet_01v8 L=0.15U W=0.65U AS=0.169P
+ AD=0.08775P PS=1.82U PD=0.92U
* device instance $1040 r0 *1 56.55,52.24 sky130_fd_pr__nfet_01v8
M$1040 942 799 97 97 sky130_fd_pr__nfet_01v8 L=0.15U W=0.65U AS=0.08775P
+ AD=0.08775P PS=0.92U PD=0.92U
* device instance $1041 r0 *1 56.97,52.24 sky130_fd_pr__nfet_01v8
M$1041 97 980 942 942 sky130_fd_pr__nfet_01v8 L=0.15U W=0.65U AS=0.08775P
+ AD=0.26P PS=0.92U PD=1.45U
* device instance $1042 r0 *1 57.92,52.24 sky130_fd_pr__nfet_01v8
M$1042 943 942 97 97 sky130_fd_pr__nfet_01v8 L=0.15U W=2.6U AS=0.52325P
+ AD=0.468P PS=4.21U PD=4.69U
* device instance $1046 r0 *1 60.27,52.24 sky130_fd_pr__nfet_01v8
M$1046 97 854 944 944 sky130_fd_pr__nfet_01v8 L=0.15U W=0.65U AS=0.169P
+ AD=0.08775P PS=1.82U PD=0.92U
* device instance $1047 r0 *1 60.69,52.24 sky130_fd_pr__nfet_01v8
M$1047 941 944 97 97 sky130_fd_pr__nfet_01v8 L=0.15U W=2.6U AS=0.351P
+ AD=0.43225P PS=3.68U PD=4.58U
* device instance $1051 r0 *1 64.87,51.235 sky130_fd_pr__nfet_01v8
M$1051 97 979 899 899 sky130_fd_pr__nfet_01v8 L=0.15U W=0.42U AS=0.1092P
+ AD=0.0567P PS=1.36U PD=0.69U
* device instance $1052 r0 *1 65.29,51.235 sky130_fd_pr__nfet_01v8
M$1052 900 899 97 97 sky130_fd_pr__nfet_01v8 L=0.15U W=0.42U AS=0.0567P
+ AD=0.1092P PS=0.69U PD=1.36U
* device instance $1053 r0 *1 66.23,51.235 sky130_fd_pr__nfet_01v8
M$1053 928 902 901 901 sky130_fd_pr__nfet_01v8 L=0.15U W=0.42U AS=0.1092P
+ AD=0.0441P PS=1.36U PD=0.63U
* device instance $1054 r0 *1 66.59,51.235 sky130_fd_pr__nfet_01v8
M$1054 97 410 928 928 sky130_fd_pr__nfet_01v8 L=0.15U W=0.42U AS=0.0441P
+ AD=0.1092P PS=0.63U PD=1.36U
* device instance $1055 r0 *1 67.53,51.235 sky130_fd_pr__nfet_01v8
M$1055 97 410 903 903 sky130_fd_pr__nfet_01v8 L=0.15U W=0.42U AS=0.1092P
+ AD=0.0609P PS=1.36U PD=0.71U
* device instance $1056 r0 *1 67.97,51.235 sky130_fd_pr__nfet_01v8
M$1056 927 903 97 97 sky130_fd_pr__nfet_01v8 L=0.15U W=0.42U AS=0.0609P
+ AD=0.0756P PS=0.71U PD=0.78U
* device instance $1057 r0 *1 68.48,51.235 sky130_fd_pr__nfet_01v8
M$1057 901 907 927 927 sky130_fd_pr__nfet_01v8 L=0.15U W=0.42U AS=0.0756P
+ AD=0.1446P PS=0.78U PD=1.18U
* device instance $1058 r0 *1 69.39,51.265 sky130_fd_pr__nfet_01v8
M$1058 904 899 901 901 sky130_fd_pr__nfet_01v8 L=0.15U W=0.36U AS=0.1446P
+ AD=0.0522P PS=1.18U PD=0.65U
* device instance $1059 r0 *1 69.83,51.265 sky130_fd_pr__nfet_01v8
M$1059 904 900 926 926 sky130_fd_pr__nfet_01v8 L=0.15U W=0.36U AS=0.0759P
+ AD=0.0522P PS=0.8U PD=0.65U
* device instance $1060 r0 *1 70.36,51.235 sky130_fd_pr__nfet_01v8
M$1060 926 905 97 97 sky130_fd_pr__nfet_01v8 L=0.15U W=0.42U AS=0.12095P
+ AD=0.0759P PS=1.085U PD=0.8U
* device instance $1061 r0 *1 70.955,51.125 sky130_fd_pr__nfet_01v8
M$1061 905 904 97 97 sky130_fd_pr__nfet_01v8 L=0.15U W=0.64U AS=0.12095P
+ AD=0.1664P PS=1.085U PD=1.8U
* device instance $1062 r0 *1 68.175,52.125 sky130_fd_pr__nfet_01v8
M$1062 954 64 97 97 sky130_fd_pr__nfet_01v8 L=0.15U W=0.42U AS=0.11285P
+ AD=0.0693P PS=1.045U PD=0.75U
* device instance $1063 r0 *1 68.655,52.125 sky130_fd_pr__nfet_01v8
M$1063 945 946 954 954 sky130_fd_pr__nfet_01v8 L=0.15U W=0.42U AS=0.0693P
+ AD=0.09975P PS=0.75U PD=0.895U
* device instance $1064 r0 *1 69.28,52.125 sky130_fd_pr__nfet_01v8
M$1064 953 955 945 945 sky130_fd_pr__nfet_01v8 L=0.15U W=0.42U AS=0.09975P
+ AD=0.0693P PS=0.895U PD=0.75U
* device instance $1065 r0 *1 69.76,52.125 sky130_fd_pr__nfet_01v8
M$1065 97 947 953 953 sky130_fd_pr__nfet_01v8 L=0.15U W=0.42U AS=0.0693P
+ AD=0.1449P PS=0.75U PD=1.11U
* device instance $1066 r0 *1 70.6,52.125 sky130_fd_pr__nfet_01v8
M$1066 947 64 97 97 sky130_fd_pr__nfet_01v8 L=0.15U W=0.42U AS=0.1449P
+ AD=0.1092P PS=1.11U PD=1.36U
* device instance $1067 r0 *1 67.63,52.24 sky130_fd_pr__nfet_01v8
M$1067 97 945 902 902 sky130_fd_pr__nfet_01v8 L=0.15U W=0.65U AS=0.169P
+ AD=0.11285P PS=1.82U PD=1.045U
* device instance $1068 r0 *1 71.895,51.235 sky130_fd_pr__nfet_01v8
M$1068 925 905 97 97 sky130_fd_pr__nfet_01v8 L=0.15U W=0.42U AS=0.1092P
+ AD=0.0678P PS=1.36U PD=0.755U
* device instance $1069 r0 *1 72.38,51.265 sky130_fd_pr__nfet_01v8
M$1069 906 900 925 925 sky130_fd_pr__nfet_01v8 L=0.15U W=0.36U AS=0.0678P
+ AD=0.0684P PS=0.755U PD=0.74U
* device instance $1070 r0 *1 72.91,51.265 sky130_fd_pr__nfet_01v8
M$1070 906 899 923 923 sky130_fd_pr__nfet_01v8 L=0.15U W=0.36U AS=0.066P
+ AD=0.0684P PS=0.745U PD=0.74U
* device instance $1071 r0 *1 73.385,51.235 sky130_fd_pr__nfet_01v8
M$1071 97 907 923 923 sky130_fd_pr__nfet_01v8 L=0.15U W=0.42U AS=0.066P
+ AD=0.1092P PS=0.745U PD=1.36U
* device instance $1072 r0 *1 74.325,51.235 sky130_fd_pr__nfet_01v8
M$1072 907 906 97 97 sky130_fd_pr__nfet_01v8 L=0.15U W=0.42U AS=0.10025P
+ AD=0.1092P PS=0.985U PD=1.36U
* device instance $1073 r0 *1 74.81,51.12 sky130_fd_pr__nfet_01v8
M$1073 985 906 97 97 sky130_fd_pr__nfet_01v8 L=0.15U W=0.65U AS=0.10025P
+ AD=0.182P PS=0.985U PD=1.86U
* device instance $1074 r0 *1 9.21,56.675 sky130_fd_pr__nfet_01v8
M$1074 97 681 965 965 sky130_fd_pr__nfet_01v8 L=0.15U W=0.42U AS=0.1092P
+ AD=0.0567P PS=1.36U PD=0.69U
* device instance $1075 r0 *1 9.63,56.675 sky130_fd_pr__nfet_01v8
M$1075 966 965 97 97 sky130_fd_pr__nfet_01v8 L=0.15U W=0.42U AS=0.0567P
+ AD=0.1092P PS=0.69U PD=1.36U
* device instance $1076 r0 *1 10.57,56.675 sky130_fd_pr__nfet_01v8
M$1076 1004 873 967 967 sky130_fd_pr__nfet_01v8 L=0.15U W=0.42U AS=0.1092P
+ AD=0.0441P PS=1.36U PD=0.63U
* device instance $1077 r0 *1 10.93,56.675 sky130_fd_pr__nfet_01v8
M$1077 97 303 1004 1004 sky130_fd_pr__nfet_01v8 L=0.15U W=0.42U AS=0.0441P
+ AD=0.1092P PS=0.63U PD=1.36U
* device instance $1078 r0 *1 11.87,56.675 sky130_fd_pr__nfet_01v8
M$1078 97 303 968 968 sky130_fd_pr__nfet_01v8 L=0.15U W=0.42U AS=0.1092P
+ AD=0.0609P PS=1.36U PD=0.71U
* device instance $1079 r0 *1 12.31,56.675 sky130_fd_pr__nfet_01v8
M$1079 1005 968 97 97 sky130_fd_pr__nfet_01v8 L=0.15U W=0.42U AS=0.0609P
+ AD=0.0756P PS=0.71U PD=0.78U
* device instance $1080 r0 *1 12.82,56.675 sky130_fd_pr__nfet_01v8
M$1080 967 972 1005 1005 sky130_fd_pr__nfet_01v8 L=0.15U W=0.42U AS=0.0756P
+ AD=0.1446P PS=0.78U PD=1.18U
* device instance $1081 r0 *1 13.73,56.705 sky130_fd_pr__nfet_01v8
M$1081 969 965 967 967 sky130_fd_pr__nfet_01v8 L=0.15U W=0.36U AS=0.1446P
+ AD=0.0522P PS=1.18U PD=0.65U
* device instance $1082 r0 *1 14.17,56.705 sky130_fd_pr__nfet_01v8
M$1082 969 966 1006 1006 sky130_fd_pr__nfet_01v8 L=0.15U W=0.36U AS=0.0759P
+ AD=0.0522P PS=0.8U PD=0.65U
* device instance $1083 r0 *1 14.7,56.675 sky130_fd_pr__nfet_01v8
M$1083 1006 970 97 97 sky130_fd_pr__nfet_01v8 L=0.15U W=0.42U AS=0.12095P
+ AD=0.0759P PS=1.085U PD=0.8U
* device instance $1084 r0 *1 15.295,56.565 sky130_fd_pr__nfet_01v8
M$1084 970 969 97 97 sky130_fd_pr__nfet_01v8 L=0.15U W=0.64U AS=0.12095P
+ AD=0.1664P PS=1.085U PD=1.8U
* device instance $1085 r0 *1 16.235,56.675 sky130_fd_pr__nfet_01v8
M$1085 1008 970 97 97 sky130_fd_pr__nfet_01v8 L=0.15U W=0.42U AS=0.1092P
+ AD=0.0678P PS=1.36U PD=0.755U
* device instance $1086 r0 *1 16.72,56.705 sky130_fd_pr__nfet_01v8
M$1086 971 966 1008 1008 sky130_fd_pr__nfet_01v8 L=0.15U W=0.36U AS=0.0678P
+ AD=0.0684P PS=0.755U PD=0.74U
* device instance $1087 r0 *1 17.25,56.705 sky130_fd_pr__nfet_01v8
M$1087 971 965 1009 1009 sky130_fd_pr__nfet_01v8 L=0.15U W=0.36U AS=0.066P
+ AD=0.0684P PS=0.745U PD=0.74U
* device instance $1088 r0 *1 17.725,56.675 sky130_fd_pr__nfet_01v8
M$1088 97 972 1009 1009 sky130_fd_pr__nfet_01v8 L=0.15U W=0.42U AS=0.066P
+ AD=0.1092P PS=0.745U PD=1.36U
* device instance $1089 r0 *1 18.665,56.675 sky130_fd_pr__nfet_01v8
M$1089 972 971 97 97 sky130_fd_pr__nfet_01v8 L=0.15U W=0.42U AS=0.10025P
+ AD=0.1092P PS=0.985U PD=1.36U
* device instance $1090 r0 *1 19.15,56.56 sky130_fd_pr__nfet_01v8
M$1090 869 971 97 97 sky130_fd_pr__nfet_01v8 L=0.15U W=0.65U AS=0.10025P
+ AD=0.182P PS=0.985U PD=1.86U
* device instance $1091 r0 *1 28.305,56.675 sky130_fd_pr__nfet_01v8
M$1091 973 893 97 97 sky130_fd_pr__nfet_01v8 L=0.15U W=0.42U AS=0.10025P
+ AD=0.1092P PS=0.985U PD=1.36U
* device instance $1092 r0 *1 28.79,56.56 sky130_fd_pr__nfet_01v8
M$1092 976 993 97 97 sky130_fd_pr__nfet_01v8 L=0.15U W=0.65U AS=0.10025P
+ AD=0.08775P PS=0.985U PD=0.92U
* device instance $1093 r0 *1 29.21,56.56 sky130_fd_pr__nfet_01v8
M$1093 97 973 976 976 sky130_fd_pr__nfet_01v8 L=0.15U W=0.65U AS=0.08775P
+ AD=0.169P PS=0.92U PD=1.82U
* device instance $1094 r0 *1 30.85,56.56 sky130_fd_pr__nfet_01v8
M$1094 999 994 97 97 sky130_fd_pr__nfet_01v8 L=0.15U W=2.6U AS=0.44525P
+ AD=0.351P PS=4.62U PD=3.68U
* device instance $1098 r0 *1 32.53,56.56 sky130_fd_pr__nfet_01v8
M$1098 999 115 97 97 sky130_fd_pr__nfet_01v8 L=0.15U W=2.6U AS=0.351P
+ AD=0.43225P PS=3.68U PD=4.58U
* device instance $1101 r0 *1 33.79,56.56 sky130_fd_pr__nfet_01v8
M$1101 97 976 999 999 sky130_fd_pr__nfet_01v8 L=0.15U W=2.6U AS=0.351P
+ AD=0.351P PS=3.68U PD=3.68U
* device instance $1106 r0 *1 43.26,56.675 sky130_fd_pr__nfet_01v8
M$1106 977 979 97 97 sky130_fd_pr__nfet_01v8 L=0.15U W=0.84U AS=0.1701P
+ AD=0.168P PS=2.07U PD=2.06U
* device instance $1108 r0 *1 44.635,56.675 sky130_fd_pr__nfet_01v8
M$1108 978 298 97 97 sky130_fd_pr__nfet_01v8 L=0.15U W=1.68U AS=0.2877P
+ AD=0.2352P PS=3.47U PD=2.8U
* device instance $1112 r0 *1 46.355,56.675 sky130_fd_pr__nfet_01v8
M$1112 979 978 97 97 sky130_fd_pr__nfet_01v8 L=0.15U W=6.72U AS=0.93975P
+ AD=0.99225P PS=11.195U PD=11.865U
* device instance $1128 r0 *1 59.38,56.675 sky130_fd_pr__nfet_01v8
M$1128 97 799 1000 1000 sky130_fd_pr__nfet_01v8 L=0.15U W=0.42U AS=0.1113P
+ AD=0.0588P PS=1.37U PD=0.7U
* device instance $1129 r0 *1 59.81,56.675 sky130_fd_pr__nfet_01v8
M$1129 1000 941 97 97 sky130_fd_pr__nfet_01v8 L=0.15U W=0.42U AS=0.0588P
+ AD=0.0588P PS=0.7U PD=0.7U
* device instance $1130 r0 *1 60.24,56.675 sky130_fd_pr__nfet_01v8
M$1130 995 980 1000 1000 sky130_fd_pr__nfet_01v8 L=0.15U W=0.42U AS=0.0588P
+ AD=0.1113P PS=0.7U PD=1.37U
* device instance $1131 r0 *1 62.115,56.56 sky130_fd_pr__nfet_01v8
M$1131 1007 943 981 981 sky130_fd_pr__nfet_01v8 L=0.15U W=0.65U AS=0.17225P
+ AD=0.06825P PS=1.83U PD=0.86U
* device instance $1132 r0 *1 62.475,56.56 sky130_fd_pr__nfet_01v8
M$1132 97 995 1007 1007 sky130_fd_pr__nfet_01v8 L=0.15U W=0.65U AS=0.06825P
+ AD=0.138125P PS=0.86U PD=1.075U
* device instance $1133 r0 *1 63.05,56.56 sky130_fd_pr__nfet_01v8
M$1133 996 981 97 97 sky130_fd_pr__nfet_01v8 L=0.15U W=2.6U AS=0.411125P
+ AD=0.45825P PS=3.865U PD=4.66U
* device instance $1137 r0 *1 65.745,56.675 sky130_fd_pr__nfet_01v8
M$1137 97 986 980 980 sky130_fd_pr__nfet_01v8 L=0.15U W=0.42U AS=0.1092P
+ AD=0.1197P PS=1.36U PD=1.41U
* device instance $1138 r0 *1 66.71,56.445 sky130_fd_pr__nfet_01v8
M$1138 97 985 982 982 sky130_fd_pr__nfet_01v8 L=0.15U W=0.42U AS=0.1092P
+ AD=0.10025P PS=1.36U PD=0.985U
* device instance $1139 r0 *1 67.195,56.56 sky130_fd_pr__nfet_01v8
M$1139 1003 955 97 97 sky130_fd_pr__nfet_01v8 L=0.15U W=0.65U AS=0.10025P
+ AD=0.08775P PS=0.985U PD=0.92U
* device instance $1140 r0 *1 67.615,56.56 sky130_fd_pr__nfet_01v8
M$1140 983 982 1003 1003 sky130_fd_pr__nfet_01v8 L=0.15U W=0.65U AS=0.08775P
+ AD=0.169P PS=0.92U PD=1.82U
* device instance $1141 r0 *1 69.11,56.56 sky130_fd_pr__nfet_01v8
M$1141 1002 955 984 984 sky130_fd_pr__nfet_01v8 L=0.15U W=0.65U AS=0.169P
+ AD=0.06825P PS=1.82U PD=0.86U
* device instance $1142 r0 *1 69.47,56.56 sky130_fd_pr__nfet_01v8
M$1142 97 985 1002 1002 sky130_fd_pr__nfet_01v8 L=0.15U W=0.65U AS=0.06825P
+ AD=0.08775P PS=0.86U PD=0.92U
* device instance $1143 r0 *1 69.89,56.56 sky130_fd_pr__nfet_01v8
M$1143 1001 985 97 97 sky130_fd_pr__nfet_01v8 L=0.15U W=0.65U AS=0.08775P
+ AD=0.169P PS=0.92U PD=1.82U
* device instance $1144 r0 *1 70.83,56.56 sky130_fd_pr__nfet_01v8
M$1144 1001 955 97 97 sky130_fd_pr__nfet_01v8 L=0.15U W=0.65U AS=0.169P
+ AD=0.08775P PS=1.82U PD=0.92U
* device instance $1145 r0 *1 71.25,56.56 sky130_fd_pr__nfet_01v8
M$1145 986 984 1001 1001 sky130_fd_pr__nfet_01v8 L=0.15U W=0.65U AS=0.08775P
+ AD=0.195P PS=0.92U PD=1.9U
* device instance $1146 r0 *1 15.665,62 sky130_fd_pr__nfet_01v8
M$1146 97 1046 1047 1047 sky130_fd_pr__nfet_01v8 L=0.15U W=0.65U AS=0.169P
+ AD=0.105625P PS=1.82U PD=0.975U
* device instance $1147 r0 *1 16.14,62 sky130_fd_pr__nfet_01v8
M$1147 64 1047 97 97 sky130_fd_pr__nfet_01v8 L=0.15U W=2.6U AS=0.37375P
+ AD=0.453375P PS=3.75U PD=4.645U
* device instance $1151 r0 *1 20.73,62 sky130_fd_pr__nfet_01v8
M$1151 1049 1101 97 97 sky130_fd_pr__nfet_01v8 L=0.15U W=2.6U AS=0.44525P
+ AD=0.351P PS=4.62U PD=3.68U
* device instance $1155 r0 *1 22.41,62 sky130_fd_pr__nfet_01v8
M$1155 1049 1010 97 97 sky130_fd_pr__nfet_01v8 L=0.15U W=2.6U AS=0.351P
+ AD=0.43225P PS=3.68U PD=4.58U
* device instance $1159 r0 *1 24.85,62 sky130_fd_pr__nfet_01v8
M$1159 97 1049 1050 1050 sky130_fd_pr__nfet_01v8 L=0.15U W=1.95U AS=0.3445P
+ AD=0.26325P PS=3.66U PD=2.76U
* device instance $1162 r0 *1 26.11,62 sky130_fd_pr__nfet_01v8
M$1162 94 1050 97 97 sky130_fd_pr__nfet_01v8 L=0.15U W=5.2U AS=0.702P
+ AD=0.78325P PS=7.36U PD=8.26U
* device instance $1170 r0 *1 24.87,57.68 sky130_fd_pr__nfet_01v8
M$1170 1010 64 97 97 sky130_fd_pr__nfet_01v8 L=0.15U W=1.3U AS=0.2665P
+ AD=0.1755P PS=2.77U PD=1.84U
* device instance $1172 r0 *1 25.71,57.68 sky130_fd_pr__nfet_01v8
M$1172 1010 976 97 97 sky130_fd_pr__nfet_01v8 L=0.15U W=1.3U AS=0.1755P
+ AD=0.25675P PS=1.84U PD=2.74U
* device instance $1174 r0 *1 27.09,57.68 sky130_fd_pr__nfet_01v8
M$1174 1010 1015 97 97 sky130_fd_pr__nfet_01v8 L=0.15U W=1.3U AS=0.25675P
+ AD=0.25675P PS=2.74U PD=2.74U
* device instance $1176 r0 *1 28.65,57.68 sky130_fd_pr__nfet_01v8
M$1176 97 115 1012 1012 sky130_fd_pr__nfet_01v8 L=0.15U W=0.65U AS=0.19825P
+ AD=0.08775P PS=1.91U PD=0.92U
* device instance $1177 r0 *1 29.07,57.68 sky130_fd_pr__nfet_01v8
M$1177 92 1011 97 97 sky130_fd_pr__nfet_01v8 L=0.15U W=2.6U AS=0.351P
+ AD=0.43225P PS=3.68U PD=4.58U
* device instance $1181 r0 *1 31.27,57.68 sky130_fd_pr__nfet_01v8
M$1181 1011 1012 1013 1013 sky130_fd_pr__nfet_01v8 L=0.15U W=1.3U AS=0.25675P
+ AD=0.1755P PS=2.74U PD=1.84U
* device instance $1183 r0 *1 32.11,57.68 sky130_fd_pr__nfet_01v8
M$1183 97 1015 1013 1013 sky130_fd_pr__nfet_01v8 L=0.15U W=1.3U AS=0.1755P
+ AD=0.1755P PS=1.84U PD=1.84U
* device instance $1185 r0 *1 32.95,57.68 sky130_fd_pr__nfet_01v8
M$1185 97 976 1013 1013 sky130_fd_pr__nfet_01v8 L=0.15U W=1.3U AS=0.1755P
+ AD=0.26975P PS=1.84U PD=2.78U
* device instance $1187 r0 *1 32.21,62 sky130_fd_pr__nfet_01v8
M$1187 1051 976 97 97 sky130_fd_pr__nfet_01v8 L=0.15U W=0.65U AS=0.169P
+ AD=0.08775P PS=1.82U PD=0.92U
* device instance $1188 r0 *1 32.63,62 sky130_fd_pr__nfet_01v8
M$1188 97 1073 1051 1051 sky130_fd_pr__nfet_01v8 L=0.15U W=0.65U AS=0.08775P
+ AD=0.169P PS=0.92U PD=1.82U
* device instance $1189 r0 *1 33.825,62.115 sky130_fd_pr__nfet_01v8
M$1189 1074 993 97 97 sky130_fd_pr__nfet_01v8 L=0.15U W=0.42U AS=0.10025P
+ AD=0.1092P PS=0.985U PD=1.36U
* device instance $1190 r0 *1 34.31,62 sky130_fd_pr__nfet_01v8
M$1190 1073 893 97 97 sky130_fd_pr__nfet_01v8 L=0.15U W=0.65U AS=0.10025P
+ AD=0.08775P PS=0.985U PD=0.92U
* device instance $1191 r0 *1 34.73,62 sky130_fd_pr__nfet_01v8
M$1191 97 1074 1073 1073 sky130_fd_pr__nfet_01v8 L=0.15U W=0.65U AS=0.08775P
+ AD=0.169P PS=0.92U PD=1.82U
* device instance $1192 r0 *1 34.97,57.68 sky130_fd_pr__nfet_01v8
M$1192 97 994 1014 1014 sky130_fd_pr__nfet_01v8 L=0.15U W=0.65U AS=0.169P
+ AD=0.08775P PS=1.82U PD=0.92U
* device instance $1193 r0 *1 35.39,57.68 sky130_fd_pr__nfet_01v8
M$1193 1015 1014 97 97 sky130_fd_pr__nfet_01v8 L=0.15U W=2.6U AS=0.351P
+ AD=0.43225P PS=3.68U PD=4.58U
* device instance $1197 r0 *1 37.99,57.68 sky130_fd_pr__nfet_01v8
M$1197 1016 999 97 97 sky130_fd_pr__nfet_01v8 L=0.15U W=1.3U AS=0.25675P
+ AD=0.1755P PS=2.74U PD=1.84U
* device instance $1199 r0 *1 38.83,57.68 sky130_fd_pr__nfet_01v8
M$1199 157 1016 97 97 sky130_fd_pr__nfet_01v8 L=0.15U W=3.9U AS=0.5265P
+ AD=0.60775P PS=5.52U PD=6.42U
* device instance $1205 r0 *1 40.03,62 sky130_fd_pr__nfet_01v8
M$1205 97 1052 1083 1083 sky130_fd_pr__nfet_01v8 L=0.15U W=1.3U AS=0.25675P
+ AD=0.1755P PS=2.74U PD=1.84U
* device instance $1207 r0 *1 40.87,62 sky130_fd_pr__nfet_01v8
M$1207 1085 1033 1083 1083 sky130_fd_pr__nfet_01v8 L=0.15U W=1.3U AS=0.1755P
+ AD=0.25675P PS=1.84U PD=2.74U
* device instance $1209 r0 *1 42.23,62 sky130_fd_pr__nfet_01v8
M$1209 1085 1054 1075 1075 sky130_fd_pr__nfet_01v8 L=0.15U W=1.3U AS=0.25675P
+ AD=0.18525P PS=2.74U PD=1.87U
* device instance $1211 r0 *1 43.1,62 sky130_fd_pr__nfet_01v8
M$1211 97 1073 1075 1075 sky130_fd_pr__nfet_01v8 L=0.15U W=1.3U AS=0.18525P
+ AD=0.25675P PS=1.87U PD=2.09U
* device instance $1213 r0 *1 44.19,62 sky130_fd_pr__nfet_01v8
M$1213 97 1076 1075 1075 sky130_fd_pr__nfet_01v8 L=0.15U W=1.3U AS=0.25675P
+ AD=0.25675P PS=2.09U PD=2.74U
* device instance $1215 r0 *1 42.79,57.68 sky130_fd_pr__nfet_01v8
M$1215 1018 1017 97 97 sky130_fd_pr__nfet_01v8 L=0.15U W=0.65U AS=0.169P
+ AD=0.08775P PS=1.82U PD=0.92U
* device instance $1216 r0 *1 43.21,57.68 sky130_fd_pr__nfet_01v8
M$1216 97 1019 1018 1018 sky130_fd_pr__nfet_01v8 L=0.15U W=0.65U AS=0.08775P
+ AD=0.169P PS=0.92U PD=1.82U
* device instance $1217 r0 *1 45.57,62 sky130_fd_pr__nfet_01v8
M$1217 1019 1054 97 97 sky130_fd_pr__nfet_01v8 L=0.15U W=0.65U AS=0.17225P
+ AD=0.091P PS=1.83U PD=0.93U
* device instance $1218 r0 *1 46,62 sky130_fd_pr__nfet_01v8
M$1218 1096 1052 1019 1019 sky130_fd_pr__nfet_01v8 L=0.15U W=0.65U AS=0.091P
+ AD=0.095875P PS=0.93U PD=0.945U
* device instance $1219 r0 *1 46.445,62 sky130_fd_pr__nfet_01v8
M$1219 97 1077 1096 1096 sky130_fd_pr__nfet_01v8 L=0.15U W=0.65U AS=0.095875P
+ AD=0.17225P PS=0.945U PD=1.83U
* device instance $1220 r0 *1 46.47,57.68 sky130_fd_pr__nfet_01v8
M$1220 97 999 1020 1020 sky130_fd_pr__nfet_01v8 L=0.15U W=0.65U AS=0.169P
+ AD=0.08775P PS=1.82U PD=0.92U
* device instance $1221 r0 *1 46.89,57.68 sky130_fd_pr__nfet_01v8
M$1221 1021 1020 97 97 sky130_fd_pr__nfet_01v8 L=0.15U W=2.6U AS=0.351P
+ AD=0.43225P PS=3.68U PD=4.58U
* device instance $1225 r0 *1 49.69,62 sky130_fd_pr__nfet_01v8
M$1225 97 1052 1084 1084 sky130_fd_pr__nfet_01v8 L=0.15U W=1.3U AS=0.25675P
+ AD=0.1755P PS=2.74U PD=1.84U
* device instance $1227 r0 *1 50.53,62 sky130_fd_pr__nfet_01v8
M$1227 1086 1077 1084 1084 sky130_fd_pr__nfet_01v8 L=0.15U W=1.3U AS=0.1755P
+ AD=0.25675P PS=1.84U PD=2.74U
* device instance $1229 r0 *1 51.15,57.68 sky130_fd_pr__nfet_01v8
M$1229 1022 854 97 97 sky130_fd_pr__nfet_01v8 L=0.15U W=2.6U AS=0.44525P
+ AD=0.351P PS=4.62U PD=3.68U
* device instance $1233 r0 *1 52.83,57.68 sky130_fd_pr__nfet_01v8
M$1233 1022 799 97 97 sky130_fd_pr__nfet_01v8 L=0.15U W=2.6U AS=0.351P
+ AD=0.3575P PS=3.68U PD=3.7U
* device instance $1237 r0 *1 54.53,57.68 sky130_fd_pr__nfet_01v8
M$1237 1022 980 97 97 sky130_fd_pr__nfet_01v8 L=0.15U W=2.6U AS=0.3575P
+ AD=0.44525P PS=3.7U PD=4.62U
* device instance $1241 r0 *1 51.89,62 sky130_fd_pr__nfet_01v8
M$1241 1086 1054 1058 1058 sky130_fd_pr__nfet_01v8 L=0.15U W=1.3U AS=0.2665P
+ AD=0.2145P PS=2.77U PD=1.96U
* device instance $1243 r0 *1 52.85,62 sky130_fd_pr__nfet_01v8
M$1243 97 1076 1058 1058 sky130_fd_pr__nfet_01v8 L=0.15U W=1.3U AS=0.23075P
+ AD=0.28275P PS=2.01U PD=2.82U
* device instance $1245 r0 *1 56.77,57.68 sky130_fd_pr__nfet_01v8
M$1245 1022 983 1023 1023 sky130_fd_pr__nfet_01v8 L=0.15U W=2.6U AS=0.44525P
+ AD=0.351P PS=4.62U PD=3.68U
* device instance $1249 r0 *1 58.45,57.68 sky130_fd_pr__nfet_01v8
M$1249 1033 1024 1023 1023 sky130_fd_pr__nfet_01v8 L=0.15U W=2.6U AS=0.351P
+ AD=0.44525P PS=3.68U PD=4.62U
* device instance $1253 r0 *1 60.73,57.68 sky130_fd_pr__nfet_01v8
M$1253 97 1025 1026 1026 sky130_fd_pr__nfet_01v8 L=0.15U W=0.65U AS=0.169P
+ AD=0.10725P PS=1.82U PD=0.98U
* device instance $1254 r0 *1 61.21,57.68 sky130_fd_pr__nfet_01v8
M$1254 1030 985 97 97 sky130_fd_pr__nfet_01v8 L=0.15U W=0.65U AS=0.10725P
+ AD=0.06825P PS=0.98U PD=0.86U
* device instance $1255 r0 *1 61.57,57.68 sky130_fd_pr__nfet_01v8
M$1255 1026 92 1030 1030 sky130_fd_pr__nfet_01v8 L=0.15U W=0.65U AS=0.06825P
+ AD=0.169P PS=0.86U PD=1.82U
* device instance $1256 r0 *1 62.51,57.68 sky130_fd_pr__nfet_01v8
M$1256 1029 1021 1026 1026 sky130_fd_pr__nfet_01v8 L=0.15U W=0.65U AS=0.169P
+ AD=0.10725P PS=1.82U PD=0.98U
* device instance $1257 r0 *1 62.99,57.68 sky130_fd_pr__nfet_01v8
M$1257 97 996 1029 1029 sky130_fd_pr__nfet_01v8 L=0.15U W=0.65U AS=0.10725P
+ AD=0.102375P PS=0.98U PD=0.965U
* device instance $1258 r0 *1 63.455,57.68 sky130_fd_pr__nfet_01v8
M$1258 1027 1026 97 97 sky130_fd_pr__nfet_01v8 L=0.15U W=0.65U AS=0.102375P
+ AD=0.169P PS=0.965U PD=1.82U
* device instance $1259 r0 *1 64.43,57.68 sky130_fd_pr__nfet_01v8
M$1259 1028 943 97 97 sky130_fd_pr__nfet_01v8 L=0.15U W=0.65U AS=0.169P
+ AD=0.08775P PS=1.82U PD=0.92U
* device instance $1260 r0 *1 64.85,57.68 sky130_fd_pr__nfet_01v8
M$1260 1039 983 1028 1028 sky130_fd_pr__nfet_01v8 L=0.15U W=0.65U AS=0.08775P
+ AD=0.169P PS=0.92U PD=1.82U
* device instance $1261 r0 *1 72.945,62.115 sky130_fd_pr__nfet_01v8
M$1261 1066 1065 97 97 sky130_fd_pr__nfet_01v8 L=0.15U W=0.42U AS=0.10025P
+ AD=0.1092P PS=0.985U PD=1.36U
* device instance $1262 r0 *1 73.43,62 sky130_fd_pr__nfet_01v8
M$1262 955 1065 97 97 sky130_fd_pr__nfet_01v8 L=0.15U W=0.65U AS=0.10025P
+ AD=0.182P PS=0.985U PD=1.86U
* device instance $1263 r0 *1 8.245,63.005 sky130_fd_pr__nfet_01v8
M$1263 97 1128 1185 1185 sky130_fd_pr__nfet_01v8 L=0.15U W=0.42U AS=0.1092P
+ AD=0.1197P PS=1.36U PD=1.41U
* device instance $1264 r0 *1 9.21,63.12 sky130_fd_pr__nfet_01v8
M$1264 1098 1129 1097 1097 sky130_fd_pr__nfet_01v8 L=0.15U W=0.65U AS=0.169P
+ AD=0.092625P PS=1.82U PD=0.935U
* device instance $1265 r0 *1 9.645,63.12 sky130_fd_pr__nfet_01v8
M$1265 1097 1128 1098 1098 sky130_fd_pr__nfet_01v8 L=0.15U W=0.65U AS=0.092625P
+ AD=0.115375P PS=0.935U PD=1.005U
* device instance $1266 r0 *1 10.15,63.12 sky130_fd_pr__nfet_01v8
M$1266 97 1099 1097 1097 sky130_fd_pr__nfet_01v8 L=0.15U W=0.65U AS=0.115375P
+ AD=0.08775P PS=1.005U PD=0.92U
* device instance $1267 r0 *1 10.57,63.12 sky130_fd_pr__nfet_01v8
M$1267 1097 918 97 97 sky130_fd_pr__nfet_01v8 L=0.15U W=0.65U AS=0.08775P
+ AD=0.169P PS=0.92U PD=1.82U
* device instance $1268 r0 *1 9.67,62.115 sky130_fd_pr__nfet_01v8
M$1268 97 681 1041 1041 sky130_fd_pr__nfet_01v8 L=0.15U W=0.42U AS=0.1092P
+ AD=0.0567P PS=1.36U PD=0.69U
* device instance $1269 r0 *1 10.09,62.115 sky130_fd_pr__nfet_01v8
M$1269 1042 1041 97 97 sky130_fd_pr__nfet_01v8 L=0.15U W=0.42U AS=0.0567P
+ AD=0.1092P PS=0.69U PD=1.36U
* device instance $1270 r0 *1 11.03,62.115 sky130_fd_pr__nfet_01v8
M$1270 1043 1072 97 97 sky130_fd_pr__nfet_01v8 L=0.15U W=0.42U AS=0.1092P
+ AD=0.066P PS=1.36U PD=0.745U
* device instance $1271 r0 *1 11.505,62.145 sky130_fd_pr__nfet_01v8
M$1271 1044 1041 1043 1043 sky130_fd_pr__nfet_01v8 L=0.15U W=0.36U AS=0.066P
+ AD=0.0594P PS=0.745U PD=0.69U
* device instance $1272 r0 *1 11.985,62.145 sky130_fd_pr__nfet_01v8
M$1272 1044 1042 1090 1090 sky130_fd_pr__nfet_01v8 L=0.15U W=0.36U AS=0.0687P
+ AD=0.0594P PS=0.76U PD=0.69U
* device instance $1273 r0 *1 12.475,62.115 sky130_fd_pr__nfet_01v8
M$1273 1090 1045 97 97 sky130_fd_pr__nfet_01v8 L=0.15U W=0.42U AS=0.1493P
+ AD=0.0687P PS=1.22U PD=0.76U
* device instance $1274 r0 *1 13.205,62.005 sky130_fd_pr__nfet_01v8
M$1274 1045 1044 97 97 sky130_fd_pr__nfet_01v8 L=0.15U W=0.64U AS=0.1493P
+ AD=0.0989P PS=1.22U PD=0.995U
* device instance $1275 r0 *1 13.71,62.145 sky130_fd_pr__nfet_01v8
M$1275 1046 1042 1045 1045 sky130_fd_pr__nfet_01v8 L=0.15U W=0.36U AS=0.0989P
+ AD=0.0657P PS=0.995U PD=0.725U
* device instance $1276 r0 *1 14.225,62.145 sky130_fd_pr__nfet_01v8
M$1276 1046 1041 1092 1092 sky130_fd_pr__nfet_01v8 L=0.15U W=0.36U AS=0.066P
+ AD=0.0657P PS=0.745U PD=0.725U
* device instance $1277 r0 *1 14.7,62.115 sky130_fd_pr__nfet_01v8
M$1277 97 1047 1092 1092 sky130_fd_pr__nfet_01v8 L=0.15U W=0.42U AS=0.066P
+ AD=0.1197P PS=0.745U PD=1.41U
* device instance $1278 r0 *1 11.53,63.12 sky130_fd_pr__nfet_01v8
M$1278 1120 1130 97 97 sky130_fd_pr__nfet_01v8 L=0.15U W=0.65U AS=0.169P
+ AD=0.08775P PS=1.82U PD=0.92U
* device instance $1279 r0 *1 11.95,63.12 sky130_fd_pr__nfet_01v8
M$1279 115 1100 1120 1120 sky130_fd_pr__nfet_01v8 L=0.15U W=0.65U AS=0.08775P
+ AD=0.169P PS=0.92U PD=1.82U
* device instance $1280 r0 *1 13.305,63.005 sky130_fd_pr__nfet_01v8
M$1280 97 64 1100 1100 sky130_fd_pr__nfet_01v8 L=0.15U W=0.42U AS=0.1092P
+ AD=0.1197P PS=1.36U PD=1.41U
* device instance $1281 r0 *1 17.05,63.12 sky130_fd_pr__nfet_01v8
M$1281 1101 1130 97 97 sky130_fd_pr__nfet_01v8 L=0.15U W=2.6U AS=0.44525P
+ AD=0.351P PS=4.62U PD=3.68U
* device instance $1285 r0 *1 18.73,63.12 sky130_fd_pr__nfet_01v8
M$1285 1101 64 97 97 sky130_fd_pr__nfet_01v8 L=0.15U W=2.6U AS=0.351P
+ AD=0.43225P PS=3.68U PD=4.58U
* device instance $1289 r0 *1 22.255,63.12 sky130_fd_pr__nfet_01v8
M$1289 303 1101 97 97 sky130_fd_pr__nfet_01v8 L=0.15U W=5.2U AS=0.78325P
+ AD=0.78325P PS=8.26U PD=8.26U
* device instance $1297 r0 *1 26.49,63.12 sky130_fd_pr__nfet_01v8
M$1297 1102 1049 97 97 sky130_fd_pr__nfet_01v8 L=0.15U W=1.3U AS=0.25675P
+ AD=0.1755P PS=2.74U PD=1.84U
* device instance $1299 r0 *1 27.33,63.12 sky130_fd_pr__nfet_01v8
M$1299 410 1102 97 97 sky130_fd_pr__nfet_01v8 L=0.15U W=3.9U AS=0.5265P
+ AD=0.60775P PS=5.52U PD=6.42U
* device instance $1305 r0 *1 30.37,63.005 sky130_fd_pr__nfet_01v8
M$1305 97 681 1103 1103 sky130_fd_pr__nfet_01v8 L=0.15U W=0.42U AS=0.1092P
+ AD=0.0567P PS=1.36U PD=0.69U
* device instance $1306 r0 *1 30.79,63.005 sky130_fd_pr__nfet_01v8
M$1306 1105 1103 97 97 sky130_fd_pr__nfet_01v8 L=0.15U W=0.42U AS=0.0567P
+ AD=0.1092P PS=0.69U PD=1.36U
* device instance $1307 r0 *1 31.73,63.005 sky130_fd_pr__nfet_01v8
M$1307 1121 1104 1106 1106 sky130_fd_pr__nfet_01v8 L=0.15U W=0.42U AS=0.1092P
+ AD=0.0441P PS=1.36U PD=0.63U
* device instance $1308 r0 *1 32.09,63.005 sky130_fd_pr__nfet_01v8
M$1308 97 303 1121 1121 sky130_fd_pr__nfet_01v8 L=0.15U W=0.42U AS=0.0441P
+ AD=0.1092P PS=0.63U PD=1.36U
* device instance $1309 r0 *1 34.89,62.975 sky130_fd_pr__nfet_01v8
M$1309 1109 1103 1106 1106 sky130_fd_pr__nfet_01v8 L=0.15U W=0.36U AS=0.1446P
+ AD=0.0522P PS=1.18U PD=0.65U
* device instance $1310 r0 *1 35.33,62.975 sky130_fd_pr__nfet_01v8
M$1310 1124 1105 1109 1109 sky130_fd_pr__nfet_01v8 L=0.15U W=0.36U AS=0.0522P
+ AD=0.0759P PS=0.65U PD=0.8U
* device instance $1311 r0 *1 33.03,63.005 sky130_fd_pr__nfet_01v8
M$1311 97 303 1107 1107 sky130_fd_pr__nfet_01v8 L=0.15U W=0.42U AS=0.1092P
+ AD=0.0609P PS=1.36U PD=0.71U
* device instance $1312 r0 *1 33.47,63.005 sky130_fd_pr__nfet_01v8
M$1312 1123 1107 97 97 sky130_fd_pr__nfet_01v8 L=0.15U W=0.42U AS=0.0609P
+ AD=0.0756P PS=0.71U PD=0.78U
* device instance $1313 r0 *1 33.98,63.005 sky130_fd_pr__nfet_01v8
M$1313 1106 1108 1123 1123 sky130_fd_pr__nfet_01v8 L=0.15U W=0.42U AS=0.0756P
+ AD=0.1446P PS=0.78U PD=1.18U
* device instance $1314 r0 *1 35.86,63.005 sky130_fd_pr__nfet_01v8
M$1314 97 1110 1124 1124 sky130_fd_pr__nfet_01v8 L=0.15U W=0.42U AS=0.0759P
+ AD=0.12095P PS=0.8U PD=1.085U
* device instance $1315 r0 *1 36.455,63.115 sky130_fd_pr__nfet_01v8
M$1315 1110 1109 97 97 sky130_fd_pr__nfet_01v8 L=0.15U W=0.64U AS=0.12095P
+ AD=0.1664P PS=1.085U PD=1.8U
* device instance $1316 r0 *1 37.88,62.975 sky130_fd_pr__nfet_01v8
M$1316 1111 1105 1125 1125 sky130_fd_pr__nfet_01v8 L=0.15U W=0.36U AS=0.0678P
+ AD=0.0684P PS=0.755U PD=0.74U
* device instance $1317 r0 *1 38.41,62.975 sky130_fd_pr__nfet_01v8
M$1317 1126 1103 1111 1111 sky130_fd_pr__nfet_01v8 L=0.15U W=0.36U AS=0.0684P
+ AD=0.066P PS=0.74U PD=0.745U
* device instance $1318 r0 *1 37.395,63.005 sky130_fd_pr__nfet_01v8
M$1318 1125 1110 97 97 sky130_fd_pr__nfet_01v8 L=0.15U W=0.42U AS=0.1092P
+ AD=0.0678P PS=1.36U PD=0.755U
* device instance $1319 r0 *1 38.885,63.005 sky130_fd_pr__nfet_01v8
M$1319 97 1108 1126 1126 sky130_fd_pr__nfet_01v8 L=0.15U W=0.42U AS=0.066P
+ AD=0.1092P PS=0.745U PD=1.36U
* device instance $1320 r0 *1 39.825,63.005 sky130_fd_pr__nfet_01v8
M$1320 97 1111 1108 1108 sky130_fd_pr__nfet_01v8 L=0.15U W=0.42U AS=0.1092P
+ AD=0.10025P PS=1.36U PD=0.985U
* device instance $1321 r0 *1 40.31,63.12 sky130_fd_pr__nfet_01v8
M$1321 993 1111 97 97 sky130_fd_pr__nfet_01v8 L=0.15U W=0.65U AS=0.10025P
+ AD=0.182P PS=0.985U PD=1.86U
* device instance $1322 r0 *1 41.41,63.12 sky130_fd_pr__nfet_01v8
M$1322 97 1075 1112 1112 sky130_fd_pr__nfet_01v8 L=0.15U W=0.65U AS=0.169P
+ AD=0.08775P PS=1.82U PD=0.92U
* device instance $1323 r0 *1 41.83,63.12 sky130_fd_pr__nfet_01v8
M$1323 994 1112 97 97 sky130_fd_pr__nfet_01v8 L=0.15U W=2.6U AS=0.351P
+ AD=0.43225P PS=3.68U PD=4.58U
* device instance $1327 r0 *1 45.65,63.12 sky130_fd_pr__nfet_01v8
M$1327 1127 1134 1113 1113 sky130_fd_pr__nfet_01v8 L=0.15U W=0.65U AS=0.169P
+ AD=0.06825P PS=1.82U PD=0.86U
* device instance $1328 r0 *1 46.01,63.12 sky130_fd_pr__nfet_01v8
M$1328 97 1114 1127 1127 sky130_fd_pr__nfet_01v8 L=0.15U W=0.65U AS=0.06825P
+ AD=0.08775P PS=0.86U PD=0.92U
* device instance $1329 r0 *1 46.43,63.12 sky130_fd_pr__nfet_01v8
M$1329 1115 1114 97 97 sky130_fd_pr__nfet_01v8 L=0.15U W=0.65U AS=0.08775P
+ AD=0.169P PS=0.92U PD=1.82U
* device instance $1330 r0 *1 47.37,63.12 sky130_fd_pr__nfet_01v8
M$1330 1115 1134 97 97 sky130_fd_pr__nfet_01v8 L=0.15U W=0.65U AS=0.169P
+ AD=0.08775P PS=1.82U PD=0.92U
* device instance $1331 r0 *1 47.79,63.12 sky130_fd_pr__nfet_01v8
M$1331 1054 1113 1115 1115 sky130_fd_pr__nfet_01v8 L=0.15U W=0.65U AS=0.08775P
+ AD=0.195P PS=0.92U PD=1.9U
* device instance $1332 r0 *1 47.39,62.115 sky130_fd_pr__nfet_01v8
M$1332 1095 1054 1078 1078 sky130_fd_pr__nfet_01v8 L=0.15U W=0.42U AS=0.1092P
+ AD=0.0441P PS=1.36U PD=0.63U
* device instance $1333 r0 *1 47.75,62.115 sky130_fd_pr__nfet_01v8
M$1333 1094 1052 1095 1095 sky130_fd_pr__nfet_01v8 L=0.15U W=0.42U AS=0.0441P
+ AD=0.0441P PS=0.63U PD=0.63U
* device instance $1334 r0 *1 48.11,62.115 sky130_fd_pr__nfet_01v8
M$1334 1094 1077 97 97 sky130_fd_pr__nfet_01v8 L=0.15U W=0.42U AS=0.13165P
+ AD=0.0441P PS=1.14U PD=0.63U
* device instance $1335 r0 *1 48.75,62 sky130_fd_pr__nfet_01v8
M$1335 1017 1078 97 97 sky130_fd_pr__nfet_01v8 L=0.15U W=0.65U AS=0.13165P
+ AD=0.169P PS=1.14U PD=1.82U
* device instance $1336 r0 *1 48.77,63.12 sky130_fd_pr__nfet_01v8
M$1336 97 1033 1116 1116 sky130_fd_pr__nfet_01v8 L=0.15U W=0.65U AS=0.169P
+ AD=0.08775P PS=1.82U PD=0.92U
* device instance $1337 r0 *1 49.19,63.12 sky130_fd_pr__nfet_01v8
M$1337 1077 1116 97 97 sky130_fd_pr__nfet_01v8 L=0.15U W=2.6U AS=0.351P
+ AD=0.43225P PS=3.68U PD=4.58U
* device instance $1341 r0 *1 51.765,63.005 sky130_fd_pr__nfet_01v8
M$1341 97 1114 1117 1117 sky130_fd_pr__nfet_01v8 L=0.15U W=0.42U AS=0.1092P
+ AD=0.10025P PS=1.36U PD=0.985U
* device instance $1342 r0 *1 52.25,63.12 sky130_fd_pr__nfet_01v8
M$1342 1076 1134 97 97 sky130_fd_pr__nfet_01v8 L=0.15U W=0.65U AS=0.10025P
+ AD=0.08775P PS=0.985U PD=0.92U
* device instance $1343 r0 *1 52.67,63.12 sky130_fd_pr__nfet_01v8
M$1343 97 1117 1076 1076 sky130_fd_pr__nfet_01v8 L=0.15U W=0.65U AS=0.08775P
+ AD=0.169P PS=0.92U PD=1.82U
* device instance $1344 r0 *1 63.49,62.115 sky130_fd_pr__nfet_01v8
M$1344 97 979 1059 1059 sky130_fd_pr__nfet_01v8 L=0.15U W=0.42U AS=0.1092P
+ AD=0.0567P PS=1.36U PD=0.69U
* device instance $1345 r0 *1 63.91,62.115 sky130_fd_pr__nfet_01v8
M$1345 1060 1059 97 97 sky130_fd_pr__nfet_01v8 L=0.15U W=0.42U AS=0.0567P
+ AD=0.1092P PS=0.69U PD=1.36U
* device instance $1346 r0 *1 64.85,62.115 sky130_fd_pr__nfet_01v8
M$1346 1093 1027 1061 1061 sky130_fd_pr__nfet_01v8 L=0.15U W=0.42U AS=0.1092P
+ AD=0.0441P PS=1.36U PD=0.63U
* device instance $1347 r0 *1 65.21,62.115 sky130_fd_pr__nfet_01v8
M$1347 97 303 1093 1093 sky130_fd_pr__nfet_01v8 L=0.15U W=0.42U AS=0.0441P
+ AD=0.1092P PS=0.63U PD=1.36U
* device instance $1348 r0 *1 64.41,63.235 sky130_fd_pr__nfet_01v8
M$1348 1118 1131 97 97 sky130_fd_pr__nfet_01v8 L=0.15U W=0.42U AS=0.10025P
+ AD=0.1092P PS=0.985U PD=1.36U
* device instance $1349 r0 *1 64.895,63.12 sky130_fd_pr__nfet_01v8
M$1349 1122 1132 97 97 sky130_fd_pr__nfet_01v8 L=0.15U W=0.65U AS=0.10025P
+ AD=0.08775P PS=0.985U PD=0.92U
* device instance $1350 r0 *1 65.315,63.12 sky130_fd_pr__nfet_01v8
M$1350 1052 1118 1122 1122 sky130_fd_pr__nfet_01v8 L=0.15U W=0.65U AS=0.08775P
+ AD=0.169P PS=0.92U PD=1.82U
* device instance $1351 r0 *1 66.15,62.115 sky130_fd_pr__nfet_01v8
M$1351 97 303 1062 1062 sky130_fd_pr__nfet_01v8 L=0.15U W=0.42U AS=0.1092P
+ AD=0.0609P PS=1.36U PD=0.71U
* device instance $1352 r0 *1 66.59,62.115 sky130_fd_pr__nfet_01v8
M$1352 1091 1062 97 97 sky130_fd_pr__nfet_01v8 L=0.15U W=0.42U AS=0.0609P
+ AD=0.0756P PS=0.71U PD=0.78U
* device instance $1353 r0 *1 67.1,62.115 sky130_fd_pr__nfet_01v8
M$1353 1061 1066 1091 1091 sky130_fd_pr__nfet_01v8 L=0.15U W=0.42U AS=0.0756P
+ AD=0.1446P PS=0.78U PD=1.18U
* device instance $1354 r0 *1 68.01,62.145 sky130_fd_pr__nfet_01v8
M$1354 1063 1059 1061 1061 sky130_fd_pr__nfet_01v8 L=0.15U W=0.36U AS=0.1446P
+ AD=0.0522P PS=1.18U PD=0.65U
* device instance $1355 r0 *1 68.45,62.145 sky130_fd_pr__nfet_01v8
M$1355 1063 1060 1089 1089 sky130_fd_pr__nfet_01v8 L=0.15U W=0.36U AS=0.0759P
+ AD=0.0522P PS=0.8U PD=0.65U
* device instance $1356 r0 *1 68.98,62.115 sky130_fd_pr__nfet_01v8
M$1356 1089 1064 97 97 sky130_fd_pr__nfet_01v8 L=0.15U W=0.42U AS=0.12095P
+ AD=0.0759P PS=1.085U PD=0.8U
* device instance $1357 r0 *1 69.575,62.005 sky130_fd_pr__nfet_01v8
M$1357 1064 1063 97 97 sky130_fd_pr__nfet_01v8 L=0.15U W=0.64U AS=0.12095P
+ AD=0.1664P PS=1.085U PD=1.8U
* device instance $1358 r0 *1 66.71,63.12 sky130_fd_pr__nfet_01v8
M$1358 97 1132 1119 1119 sky130_fd_pr__nfet_01v8 L=0.15U W=0.65U AS=0.169P
+ AD=0.08775P PS=1.82U PD=0.92U
* device instance $1359 r0 *1 67.13,63.12 sky130_fd_pr__nfet_01v8
M$1359 374 1119 97 97 sky130_fd_pr__nfet_01v8 L=0.15U W=2.6U AS=0.351P
+ AD=0.43225P PS=3.68U PD=4.58U
* device instance $1363 r0 *1 70.515,62.115 sky130_fd_pr__nfet_01v8
M$1363 1088 1064 97 97 sky130_fd_pr__nfet_01v8 L=0.15U W=0.42U AS=0.1092P
+ AD=0.0678P PS=1.36U PD=0.755U
* device instance $1364 r0 *1 71,62.145 sky130_fd_pr__nfet_01v8
M$1364 1065 1060 1088 1088 sky130_fd_pr__nfet_01v8 L=0.15U W=0.36U AS=0.0678P
+ AD=0.0684P PS=0.755U PD=0.74U
* device instance $1365 r0 *1 71.53,62.145 sky130_fd_pr__nfet_01v8
M$1365 1065 1059 1087 1087 sky130_fd_pr__nfet_01v8 L=0.15U W=0.36U AS=0.066P
+ AD=0.0684P PS=0.745U PD=0.74U
* device instance $1366 r0 *1 72.005,62.115 sky130_fd_pr__nfet_01v8
M$1366 97 1066 1087 1087 sky130_fd_pr__nfet_01v8 L=0.15U W=0.42U AS=0.066P
+ AD=0.1092P PS=0.745U PD=1.36U
* device instance $1367 r0 *1 5.09,67.44 sky130_fd_pr__nfet_01v8
M$1367 1207 1144 97 97 sky130_fd_pr__nfet_01v8 L=0.15U W=0.65U AS=0.169P
+ AD=0.08775P PS=1.82U PD=0.92U
* device instance $1368 r0 *1 5.51,67.44 sky130_fd_pr__nfet_01v8
M$1368 1129 64 1207 1207 sky130_fd_pr__nfet_01v8 L=0.15U W=0.65U AS=0.08775P
+ AD=0.169P PS=0.92U PD=1.82U
* device instance $1369 r0 *1 8.78,67.555 sky130_fd_pr__nfet_01v8
M$1369 97 1100 1202 1202 sky130_fd_pr__nfet_01v8 L=0.15U W=0.42U AS=0.1113P
+ AD=0.0588P PS=1.37U PD=0.7U
* device instance $1370 r0 *1 9.21,67.555 sky130_fd_pr__nfet_01v8
M$1370 1202 1144 97 97 sky130_fd_pr__nfet_01v8 L=0.15U W=0.42U AS=0.0588P
+ AD=0.0588P PS=0.7U PD=0.7U
* device instance $1371 r0 *1 9.64,67.555 sky130_fd_pr__nfet_01v8
M$1371 1072 1145 1202 1202 sky130_fd_pr__nfet_01v8 L=0.15U W=0.42U AS=0.0588P
+ AD=0.1113P PS=0.7U PD=1.37U
* device instance $1372 r0 *1 10.61,67.44 sky130_fd_pr__nfet_01v8
M$1372 1210 1185 97 97 sky130_fd_pr__nfet_01v8 L=0.15U W=0.65U AS=0.169P
+ AD=0.08775P PS=1.82U PD=0.92U
* device instance $1373 r0 *1 11.03,67.44 sky130_fd_pr__nfet_01v8
M$1373 1099 1130 1210 1210 sky130_fd_pr__nfet_01v8 L=0.15U W=0.65U AS=0.08775P
+ AD=0.169P PS=0.92U PD=1.82U
* device instance $1374 r0 *1 12.04,67.44 sky130_fd_pr__nfet_01v8
M$1374 97 1186 1146 1146 sky130_fd_pr__nfet_01v8 L=0.15U W=0.65U AS=0.2145P
+ AD=0.167375P PS=1.96U PD=1.165U
* device instance $1375 r0 *1 12.705,67.44 sky130_fd_pr__nfet_01v8
M$1375 1212 918 97 97 sky130_fd_pr__nfet_01v8 L=0.15U W=0.65U AS=0.167375P
+ AD=0.0975P PS=1.165U PD=0.95U
* device instance $1376 r0 *1 13.155,67.44 sky130_fd_pr__nfet_01v8
M$1376 1213 1185 1212 1212 sky130_fd_pr__nfet_01v8 L=0.15U W=0.65U AS=0.0975P
+ AD=0.14625P PS=0.95U PD=1.1U
* device instance $1377 r0 *1 13.755,67.44 sky130_fd_pr__nfet_01v8
M$1377 1186 1130 1213 1213 sky130_fd_pr__nfet_01v8 L=0.15U W=0.65U AS=0.14625P
+ AD=0.143P PS=1.1U PD=1.09U
* device instance $1378 r0 *1 14.345,67.44 sky130_fd_pr__nfet_01v8
M$1378 1214 1145 1186 1186 sky130_fd_pr__nfet_01v8 L=0.15U W=0.65U AS=0.143P
+ AD=0.06825P PS=1.09U PD=0.86U
* device instance $1379 r0 *1 14.705,67.44 sky130_fd_pr__nfet_01v8
M$1379 97 1187 1214 1214 sky130_fd_pr__nfet_01v8 L=0.15U W=0.65U AS=0.06825P
+ AD=0.17225P PS=0.86U PD=1.83U
* device instance $1380 r0 *1 15.83,67.415 sky130_fd_pr__nfet_01v8
M$1380 1216 1187 1148 1148 sky130_fd_pr__nfet_01v8 L=0.15U W=0.42U AS=0.1176P
+ AD=0.0567P PS=1.4U PD=0.69U
* device instance $1381 r0 *1 16.25,67.415 sky130_fd_pr__nfet_01v8
M$1381 1216 1101 97 97 sky130_fd_pr__nfet_01v8 L=0.15U W=0.42U AS=0.1118P
+ AD=0.0567P PS=1.04U PD=0.69U
* device instance $1382 r0 *1 16.79,67.44 sky130_fd_pr__nfet_01v8
M$1382 1229 1148 97 97 sky130_fd_pr__nfet_01v8 L=0.15U W=0.65U AS=0.1118P
+ AD=0.182P PS=1.04U PD=1.86U
* device instance $1383 r0 *1 24.46,67.555 sky130_fd_pr__nfet_01v8
M$1383 1220 1188 1149 1149 sky130_fd_pr__nfet_01v8 L=0.15U W=0.42U AS=0.1113P
+ AD=0.0441P PS=1.37U PD=0.63U
* device instance $1384 r0 *1 24.82,67.555 sky130_fd_pr__nfet_01v8
M$1384 97 115 1220 1220 sky130_fd_pr__nfet_01v8 L=0.15U W=0.42U AS=0.0441P
+ AD=0.0966P PS=0.63U PD=0.88U
* device instance $1385 r0 *1 25.43,67.555 sky130_fd_pr__nfet_01v8
M$1385 1150 1149 97 97 sky130_fd_pr__nfet_01v8 L=0.15U W=0.42U AS=0.0966P
+ AD=0.1113P PS=0.88U PD=1.37U
* device instance $1386 r0 *1 26.69,67.44 sky130_fd_pr__nfet_01v8
M$1386 97 1150 1151 1151 sky130_fd_pr__nfet_01v8 L=0.15U W=0.65U AS=0.169P
+ AD=0.10725P PS=1.82U PD=0.98U
* device instance $1387 r0 *1 27.17,67.44 sky130_fd_pr__nfet_01v8
M$1387 1222 893 97 97 sky130_fd_pr__nfet_01v8 L=0.15U W=0.65U AS=0.10725P
+ AD=0.06825P PS=0.98U PD=0.86U
* device instance $1388 r0 *1 27.53,67.44 sky130_fd_pr__nfet_01v8
M$1388 1151 92 1222 1222 sky130_fd_pr__nfet_01v8 L=0.15U W=0.65U AS=0.06825P
+ AD=0.169P PS=0.86U PD=1.82U
* device instance $1389 r0 *1 28.47,67.44 sky130_fd_pr__nfet_01v8
M$1389 1224 1154 1151 1151 sky130_fd_pr__nfet_01v8 L=0.15U W=0.65U AS=0.169P
+ AD=0.10725P PS=1.82U PD=0.98U
* device instance $1390 r0 *1 28.95,67.44 sky130_fd_pr__nfet_01v8
M$1390 97 999 1224 1224 sky130_fd_pr__nfet_01v8 L=0.15U W=0.65U AS=0.10725P
+ AD=0.102375P PS=0.98U PD=0.965U
* device instance $1391 r0 *1 29.415,67.44 sky130_fd_pr__nfet_01v8
M$1391 1104 1151 97 97 sky130_fd_pr__nfet_01v8 L=0.15U W=0.65U AS=0.102375P
+ AD=0.169P PS=0.965U PD=1.82U
* device instance $1392 r0 *1 32.31,67.44 sky130_fd_pr__nfet_01v8
M$1392 1226 1058 1155 1155 sky130_fd_pr__nfet_01v8 L=0.15U W=0.65U AS=0.169P
+ AD=0.06825P PS=1.82U PD=0.86U
* device instance $1393 r0 *1 32.67,67.44 sky130_fd_pr__nfet_01v8
M$1393 97 1051 1226 1226 sky130_fd_pr__nfet_01v8 L=0.15U W=0.65U AS=0.06825P
+ AD=0.08775P PS=0.86U PD=0.92U
* device instance $1394 r0 *1 33.09,67.44 sky130_fd_pr__nfet_01v8
M$1394 1203 1051 97 97 sky130_fd_pr__nfet_01v8 L=0.15U W=0.65U AS=0.08775P
+ AD=0.169P PS=0.92U PD=1.82U
* device instance $1395 r0 *1 34.03,67.44 sky130_fd_pr__nfet_01v8
M$1395 1203 1058 97 97 sky130_fd_pr__nfet_01v8 L=0.15U W=0.65U AS=0.169P
+ AD=0.08775P PS=1.82U PD=0.92U
* device instance $1396 r0 *1 34.45,67.44 sky130_fd_pr__nfet_01v8
M$1396 1154 1155 1203 1203 sky130_fd_pr__nfet_01v8 L=0.15U W=0.65U AS=0.08775P
+ AD=0.195P PS=0.92U PD=1.9U
* device instance $1397 r0 *1 36.81,67.44 sky130_fd_pr__nfet_01v8
M$1397 97 1189 1156 1156 sky130_fd_pr__nfet_01v8 L=0.15U W=0.65U AS=0.169P
+ AD=0.10725P PS=1.82U PD=0.98U
* device instance $1398 r0 *1 37.29,67.44 sky130_fd_pr__nfet_01v8
M$1398 1228 1134 97 97 sky130_fd_pr__nfet_01v8 L=0.15U W=0.65U AS=0.10725P
+ AD=0.06825P PS=0.98U PD=0.86U
* device instance $1399 r0 *1 37.65,67.44 sky130_fd_pr__nfet_01v8
M$1399 1156 92 1228 1228 sky130_fd_pr__nfet_01v8 L=0.15U W=0.65U AS=0.06825P
+ AD=0.169P PS=0.86U PD=1.82U
* device instance $1400 r0 *1 38.59,67.44 sky130_fd_pr__nfet_01v8
M$1400 1227 1190 1156 1156 sky130_fd_pr__nfet_01v8 L=0.15U W=0.65U AS=0.169P
+ AD=0.10725P PS=1.82U PD=0.98U
* device instance $1401 r0 *1 39.07,67.44 sky130_fd_pr__nfet_01v8
M$1401 97 1018 1227 1227 sky130_fd_pr__nfet_01v8 L=0.15U W=0.65U AS=0.10725P
+ AD=0.102375P PS=0.98U PD=0.965U
* device instance $1402 r0 *1 39.535,67.44 sky130_fd_pr__nfet_01v8
M$1402 1204 1156 97 97 sky130_fd_pr__nfet_01v8 L=0.15U W=0.65U AS=0.102375P
+ AD=0.169P PS=0.965U PD=1.82U
* device instance $1403 r0 *1 40.49,67.555 sky130_fd_pr__nfet_01v8
M$1403 97 979 1159 1159 sky130_fd_pr__nfet_01v8 L=0.15U W=0.42U AS=0.1092P
+ AD=0.0567P PS=1.36U PD=0.69U
* device instance $1404 r0 *1 40.91,67.555 sky130_fd_pr__nfet_01v8
M$1404 1160 1159 97 97 sky130_fd_pr__nfet_01v8 L=0.15U W=0.42U AS=0.0567P
+ AD=0.1092P PS=0.69U PD=1.36U
* device instance $1405 r0 *1 41.85,67.555 sky130_fd_pr__nfet_01v8
M$1405 1225 1191 1161 1161 sky130_fd_pr__nfet_01v8 L=0.15U W=0.42U AS=0.1092P
+ AD=0.0441P PS=1.36U PD=0.63U
* device instance $1406 r0 *1 42.21,67.555 sky130_fd_pr__nfet_01v8
M$1406 97 410 1225 1225 sky130_fd_pr__nfet_01v8 L=0.15U W=0.42U AS=0.0441P
+ AD=0.1092P PS=0.63U PD=1.36U
* device instance $1407 r0 *1 43.15,67.555 sky130_fd_pr__nfet_01v8
M$1407 97 410 1162 1162 sky130_fd_pr__nfet_01v8 L=0.15U W=0.42U AS=0.1092P
+ AD=0.0609P PS=1.36U PD=0.71U
* device instance $1408 r0 *1 43.59,67.555 sky130_fd_pr__nfet_01v8
M$1408 1223 1162 97 97 sky130_fd_pr__nfet_01v8 L=0.15U W=0.42U AS=0.0609P
+ AD=0.0756P PS=0.71U PD=0.78U
* device instance $1409 r0 *1 44.1,67.555 sky130_fd_pr__nfet_01v8
M$1409 1161 1166 1223 1223 sky130_fd_pr__nfet_01v8 L=0.15U W=0.42U AS=0.0756P
+ AD=0.1446P PS=0.78U PD=1.18U
* device instance $1410 r0 *1 45.01,67.585 sky130_fd_pr__nfet_01v8
M$1410 1163 1159 1161 1161 sky130_fd_pr__nfet_01v8 L=0.15U W=0.36U AS=0.1446P
+ AD=0.0522P PS=1.18U PD=0.65U
* device instance $1411 r0 *1 45.45,67.585 sky130_fd_pr__nfet_01v8
M$1411 1163 1160 1221 1221 sky130_fd_pr__nfet_01v8 L=0.15U W=0.36U AS=0.0759P
+ AD=0.0522P PS=0.8U PD=0.65U
* device instance $1412 r0 *1 45.98,67.555 sky130_fd_pr__nfet_01v8
M$1412 1221 1164 97 97 sky130_fd_pr__nfet_01v8 L=0.15U W=0.42U AS=0.12095P
+ AD=0.0759P PS=1.085U PD=0.8U
* device instance $1413 r0 *1 46.575,67.445 sky130_fd_pr__nfet_01v8
M$1413 1164 1163 97 97 sky130_fd_pr__nfet_01v8 L=0.15U W=0.64U AS=0.12095P
+ AD=0.1664P PS=1.085U PD=1.8U
* device instance $1414 r0 *1 47.515,67.555 sky130_fd_pr__nfet_01v8
M$1414 1219 1164 97 97 sky130_fd_pr__nfet_01v8 L=0.15U W=0.42U AS=0.1092P
+ AD=0.0678P PS=1.36U PD=0.755U
* device instance $1415 r0 *1 48,67.585 sky130_fd_pr__nfet_01v8
M$1415 1165 1160 1219 1219 sky130_fd_pr__nfet_01v8 L=0.15U W=0.36U AS=0.0678P
+ AD=0.0684P PS=0.755U PD=0.74U
* device instance $1416 r0 *1 48.53,67.585 sky130_fd_pr__nfet_01v8
M$1416 1165 1159 1218 1218 sky130_fd_pr__nfet_01v8 L=0.15U W=0.36U AS=0.066P
+ AD=0.0684P PS=0.745U PD=0.74U
* device instance $1417 r0 *1 49.005,67.555 sky130_fd_pr__nfet_01v8
M$1417 97 1166 1218 1218 sky130_fd_pr__nfet_01v8 L=0.15U W=0.42U AS=0.066P
+ AD=0.1092P PS=0.745U PD=1.36U
* device instance $1418 r0 *1 49.945,67.555 sky130_fd_pr__nfet_01v8
M$1418 1166 1165 97 97 sky130_fd_pr__nfet_01v8 L=0.15U W=0.42U AS=0.10025P
+ AD=0.1092P PS=0.985U PD=1.36U
* device instance $1419 r0 *1 50.43,67.44 sky130_fd_pr__nfet_01v8
M$1419 1134 1165 97 97 sky130_fd_pr__nfet_01v8 L=0.15U W=0.65U AS=0.10025P
+ AD=0.182P PS=0.985U PD=1.86U
* device instance $1420 r0 *1 60.34,67.555 sky130_fd_pr__nfet_01v8
M$1420 1217 1024 1167 1167 sky130_fd_pr__nfet_01v8 L=0.15U W=0.42U AS=0.1113P
+ AD=0.0441P PS=1.37U PD=0.63U
* device instance $1421 r0 *1 60.7,67.555 sky130_fd_pr__nfet_01v8
M$1421 97 1052 1217 1217 sky130_fd_pr__nfet_01v8 L=0.15U W=0.42U AS=0.0441P
+ AD=0.0966P PS=0.63U PD=0.88U
* device instance $1422 r0 *1 61.31,67.555 sky130_fd_pr__nfet_01v8
M$1422 1168 1167 97 97 sky130_fd_pr__nfet_01v8 L=0.15U W=0.42U AS=0.0966P
+ AD=0.1113P PS=0.88U PD=1.37U
* device instance $1423 r0 *1 62.61,67.44 sky130_fd_pr__nfet_01v8
M$1423 1169 1039 97 97 sky130_fd_pr__nfet_01v8 L=0.15U W=0.65U AS=0.169P
+ AD=0.08775P PS=1.82U PD=0.92U
* device instance $1424 r0 *1 63.03,67.44 sky130_fd_pr__nfet_01v8
M$1424 97 1168 1169 1169 sky130_fd_pr__nfet_01v8 L=0.15U W=0.65U AS=0.08775P
+ AD=0.08775P PS=0.92U PD=0.92U
* device instance $1425 r0 *1 63.45,67.44 sky130_fd_pr__nfet_01v8
M$1425 1215 1168 97 97 sky130_fd_pr__nfet_01v8 L=0.15U W=0.65U AS=0.08775P
+ AD=0.08775P PS=0.92U PD=0.92U
* device instance $1426 r0 *1 63.87,67.44 sky130_fd_pr__nfet_01v8
M$1426 1192 1039 1215 1215 sky130_fd_pr__nfet_01v8 L=0.15U W=0.65U AS=0.08775P
+ AD=0.25025P PS=0.92U PD=1.42U
* device instance $1427 r0 *1 64.79,67.44 sky130_fd_pr__nfet_01v8
M$1427 97 1169 1192 1192 sky130_fd_pr__nfet_01v8 L=0.15U W=0.65U AS=0.25025P
+ AD=0.208P PS=1.42U PD=1.94U
* device instance $1428 r0 *1 65.79,67.555 sky130_fd_pr__nfet_01v8
M$1428 97 979 1171 1171 sky130_fd_pr__nfet_01v8 L=0.15U W=0.42U AS=0.1092P
+ AD=0.0567P PS=1.36U PD=0.69U
* device instance $1429 r0 *1 66.21,67.555 sky130_fd_pr__nfet_01v8
M$1429 1172 1171 97 97 sky130_fd_pr__nfet_01v8 L=0.15U W=0.42U AS=0.0567P
+ AD=0.1092P PS=0.69U PD=1.36U
* device instance $1430 r0 *1 67.15,67.555 sky130_fd_pr__nfet_01v8
M$1430 1211 1193 1173 1173 sky130_fd_pr__nfet_01v8 L=0.15U W=0.42U AS=0.1092P
+ AD=0.0441P PS=1.36U PD=0.63U
* device instance $1431 r0 *1 67.51,67.555 sky130_fd_pr__nfet_01v8
M$1431 97 410 1211 1211 sky130_fd_pr__nfet_01v8 L=0.15U W=0.42U AS=0.0441P
+ AD=0.1092P PS=0.63U PD=1.36U
* device instance $1432 r0 *1 68.45,67.555 sky130_fd_pr__nfet_01v8
M$1432 97 410 1174 1174 sky130_fd_pr__nfet_01v8 L=0.15U W=0.42U AS=0.1092P
+ AD=0.0609P PS=1.36U PD=0.71U
* device instance $1433 r0 *1 68.89,67.555 sky130_fd_pr__nfet_01v8
M$1433 1209 1174 97 97 sky130_fd_pr__nfet_01v8 L=0.15U W=0.42U AS=0.0609P
+ AD=0.0756P PS=0.71U PD=0.78U
* device instance $1434 r0 *1 69.4,67.555 sky130_fd_pr__nfet_01v8
M$1434 1173 1178 1209 1209 sky130_fd_pr__nfet_01v8 L=0.15U W=0.42U AS=0.0756P
+ AD=0.1446P PS=0.78U PD=1.18U
* device instance $1435 r0 *1 70.31,67.585 sky130_fd_pr__nfet_01v8
M$1435 1175 1171 1173 1173 sky130_fd_pr__nfet_01v8 L=0.15U W=0.36U AS=0.1446P
+ AD=0.0522P PS=1.18U PD=0.65U
* device instance $1436 r0 *1 70.75,67.585 sky130_fd_pr__nfet_01v8
M$1436 1175 1172 1208 1208 sky130_fd_pr__nfet_01v8 L=0.15U W=0.36U AS=0.0759P
+ AD=0.0522P PS=0.8U PD=0.65U
* device instance $1437 r0 *1 71.28,67.555 sky130_fd_pr__nfet_01v8
M$1437 1208 1176 97 97 sky130_fd_pr__nfet_01v8 L=0.15U W=0.42U AS=0.12095P
+ AD=0.0759P PS=1.085U PD=0.8U
* device instance $1438 r0 *1 71.875,67.445 sky130_fd_pr__nfet_01v8
M$1438 1176 1175 97 97 sky130_fd_pr__nfet_01v8 L=0.15U W=0.64U AS=0.12095P
+ AD=0.1664P PS=1.085U PD=1.8U
* device instance $1439 r0 *1 72.815,67.555 sky130_fd_pr__nfet_01v8
M$1439 1206 1176 97 97 sky130_fd_pr__nfet_01v8 L=0.15U W=0.42U AS=0.1092P
+ AD=0.0678P PS=1.36U PD=0.755U
* device instance $1440 r0 *1 73.3,67.585 sky130_fd_pr__nfet_01v8
M$1440 1177 1172 1206 1206 sky130_fd_pr__nfet_01v8 L=0.15U W=0.36U AS=0.0678P
+ AD=0.0684P PS=0.755U PD=0.74U
* device instance $1441 r0 *1 73.83,67.585 sky130_fd_pr__nfet_01v8
M$1441 1177 1171 1205 1205 sky130_fd_pr__nfet_01v8 L=0.15U W=0.36U AS=0.066P
+ AD=0.0684P PS=0.745U PD=0.74U
* device instance $1442 r0 *1 74.305,67.555 sky130_fd_pr__nfet_01v8
M$1442 97 1178 1205 1205 sky130_fd_pr__nfet_01v8 L=0.15U W=0.42U AS=0.066P
+ AD=0.1092P PS=0.745U PD=1.36U
* device instance $1443 r0 *1 75.245,67.555 sky130_fd_pr__nfet_01v8
M$1443 1178 1177 97 97 sky130_fd_pr__nfet_01v8 L=0.15U W=0.42U AS=0.10025P
+ AD=0.1092P PS=0.985U PD=1.36U
* device instance $1444 r0 *1 75.73,67.44 sky130_fd_pr__nfet_01v8
M$1444 1132 1177 97 97 sky130_fd_pr__nfet_01v8 L=0.15U W=0.65U AS=0.10025P
+ AD=0.182P PS=0.985U PD=1.86U
* device instance $1445 r0 *1 5.555,68.56 sky130_fd_pr__nfet_01v8
M$1445 1280 1201 97 97 sky130_fd_pr__nfet_01v8 L=0.15U W=0.65U AS=0.18525P
+ AD=0.089375P PS=1.87U PD=0.925U
* device instance $1446 r0 *1 5.98,68.56 sky130_fd_pr__nfet_01v8
M$1446 1145 1229 1280 1280 sky130_fd_pr__nfet_01v8 L=0.15U W=0.65U AS=0.089375P
+ AD=0.091P PS=0.925U PD=0.93U
* device instance $1447 r0 *1 6.41,68.56 sky130_fd_pr__nfet_01v8
M$1447 1282 1229 1145 1145 sky130_fd_pr__nfet_01v8 L=0.15U W=0.65U AS=0.091P
+ AD=0.06825P PS=0.93U PD=0.86U
* device instance $1448 r0 *1 6.77,68.56 sky130_fd_pr__nfet_01v8
M$1448 97 1201 1282 1282 sky130_fd_pr__nfet_01v8 L=0.15U W=0.65U AS=0.06825P
+ AD=0.10725P PS=0.86U PD=0.98U
* device instance $1449 r0 *1 7.25,68.56 sky130_fd_pr__nfet_01v8
M$1449 1145 1128 97 97 sky130_fd_pr__nfet_01v8 L=0.15U W=1.3U AS=0.195P
+ AD=0.34775P PS=1.9U PD=3.02U
* device instance $1451 r0 *1 8.75,68.445 sky130_fd_pr__nfet_01v8
M$1451 97 681 1230 1230 sky130_fd_pr__nfet_01v8 L=0.15U W=0.42U AS=0.1092P
+ AD=0.0567P PS=1.36U PD=0.69U
* device instance $1452 r0 *1 9.17,68.445 sky130_fd_pr__nfet_01v8
M$1452 1231 1230 97 97 sky130_fd_pr__nfet_01v8 L=0.15U W=0.42U AS=0.0567P
+ AD=0.1092P PS=0.69U PD=1.36U
* device instance $1453 r0 *1 10.67,68.415 sky130_fd_pr__nfet_01v8
M$1453 1233 1230 1232 1232 sky130_fd_pr__nfet_01v8 L=0.15U W=0.36U AS=0.0813P
+ AD=0.0621P PS=0.83U PD=0.705U
* device instance $1454 r0 *1 11.165,68.415 sky130_fd_pr__nfet_01v8
M$1454 1258 1231 1233 1233 sky130_fd_pr__nfet_01v8 L=0.15U W=0.36U AS=0.0621P
+ AD=0.0696P PS=0.705U PD=0.765U
* device instance $1455 r0 *1 12.76,68.415 sky130_fd_pr__nfet_01v8
M$1455 1235 1231 1234 1234 sky130_fd_pr__nfet_01v8 L=0.15U W=0.36U AS=0.0989P
+ AD=0.0684P PS=0.995U PD=0.74U
* device instance $1456 r0 *1 13.29,68.415 sky130_fd_pr__nfet_01v8
M$1456 1259 1230 1235 1235 sky130_fd_pr__nfet_01v8 L=0.15U W=0.36U AS=0.0684P
+ AD=0.066P PS=0.74U PD=0.745U
* device instance $1457 r0 *1 10.11,68.445 sky130_fd_pr__nfet_01v8
M$1457 1232 1146 97 97 sky130_fd_pr__nfet_01v8 L=0.15U W=0.42U AS=0.1092P
+ AD=0.0813P PS=1.36U PD=0.83U
* device instance $1458 r0 *1 11.66,68.445 sky130_fd_pr__nfet_01v8
M$1458 97 1234 1258 1258 sky130_fd_pr__nfet_01v8 L=0.15U W=0.42U AS=0.0696P
+ AD=0.12095P PS=0.765U PD=1.085U
* device instance $1459 r0 *1 13.765,68.445 sky130_fd_pr__nfet_01v8
M$1459 97 1236 1259 1259 sky130_fd_pr__nfet_01v8 L=0.15U W=0.42U AS=0.066P
+ AD=0.1092P PS=0.745U PD=1.36U
* device instance $1460 r0 *1 12.255,68.555 sky130_fd_pr__nfet_01v8
M$1460 1234 1233 97 97 sky130_fd_pr__nfet_01v8 L=0.15U W=0.64U AS=0.12095P
+ AD=0.0989P PS=1.085U PD=0.995U
* device instance $1461 r0 *1 14.71,68.56 sky130_fd_pr__nfet_01v8
M$1461 97 1235 1236 1236 sky130_fd_pr__nfet_01v8 L=0.15U W=0.65U AS=0.169P
+ AD=0.08775P PS=1.82U PD=0.92U
* device instance $1462 r0 *1 15.13,68.56 sky130_fd_pr__nfet_01v8
M$1462 1187 1236 97 97 sky130_fd_pr__nfet_01v8 L=0.15U W=0.65U AS=0.08775P
+ AD=0.169P PS=0.92U PD=1.82U
* device instance $1463 r0 *1 22.09,68.445 sky130_fd_pr__nfet_01v8
M$1463 97 681 1237 1237 sky130_fd_pr__nfet_01v8 L=0.15U W=0.42U AS=0.1092P
+ AD=0.0567P PS=1.36U PD=0.69U
* device instance $1464 r0 *1 22.51,68.445 sky130_fd_pr__nfet_01v8
M$1464 1238 1237 97 97 sky130_fd_pr__nfet_01v8 L=0.15U W=0.42U AS=0.0567P
+ AD=0.1092P PS=0.69U PD=1.36U
* device instance $1465 r0 *1 23.45,68.445 sky130_fd_pr__nfet_01v8
M$1465 1262 1274 1239 1239 sky130_fd_pr__nfet_01v8 L=0.15U W=0.42U AS=0.1092P
+ AD=0.0441P PS=1.36U PD=0.63U
* device instance $1466 r0 *1 23.81,68.445 sky130_fd_pr__nfet_01v8
M$1466 97 410 1262 1262 sky130_fd_pr__nfet_01v8 L=0.15U W=0.42U AS=0.0441P
+ AD=0.1092P PS=0.63U PD=1.36U
* device instance $1467 r0 *1 26.61,68.415 sky130_fd_pr__nfet_01v8
M$1467 1241 1237 1239 1239 sky130_fd_pr__nfet_01v8 L=0.15U W=0.36U AS=0.1446P
+ AD=0.0522P PS=1.18U PD=0.65U
* device instance $1468 r0 *1 27.05,68.415 sky130_fd_pr__nfet_01v8
M$1468 1264 1238 1241 1241 sky130_fd_pr__nfet_01v8 L=0.15U W=0.36U AS=0.0522P
+ AD=0.0759P PS=0.65U PD=0.8U
* device instance $1469 r0 *1 24.75,68.445 sky130_fd_pr__nfet_01v8
M$1469 97 410 1240 1240 sky130_fd_pr__nfet_01v8 L=0.15U W=0.42U AS=0.1092P
+ AD=0.0609P PS=1.36U PD=0.71U
* device instance $1470 r0 *1 25.19,68.445 sky130_fd_pr__nfet_01v8
M$1470 1263 1240 97 97 sky130_fd_pr__nfet_01v8 L=0.15U W=0.42U AS=0.0609P
+ AD=0.0756P PS=0.71U PD=0.78U
* device instance $1471 r0 *1 25.7,68.445 sky130_fd_pr__nfet_01v8
M$1471 1239 1275 1263 1263 sky130_fd_pr__nfet_01v8 L=0.15U W=0.42U AS=0.0756P
+ AD=0.1446P PS=0.78U PD=1.18U
* device instance $1472 r0 *1 27.58,68.445 sky130_fd_pr__nfet_01v8
M$1472 97 1242 1264 1264 sky130_fd_pr__nfet_01v8 L=0.15U W=0.42U AS=0.0759P
+ AD=0.12095P PS=0.8U PD=1.085U
* device instance $1473 r0 *1 28.175,68.555 sky130_fd_pr__nfet_01v8
M$1473 1242 1241 97 97 sky130_fd_pr__nfet_01v8 L=0.15U W=0.64U AS=0.12095P
+ AD=0.1664P PS=1.085U PD=1.8U
* device instance $1474 r0 *1 29.6,68.415 sky130_fd_pr__nfet_01v8
M$1474 1243 1238 1265 1265 sky130_fd_pr__nfet_01v8 L=0.15U W=0.36U AS=0.0678P
+ AD=0.0684P PS=0.755U PD=0.74U
* device instance $1475 r0 *1 30.13,68.415 sky130_fd_pr__nfet_01v8
M$1475 1266 1237 1243 1243 sky130_fd_pr__nfet_01v8 L=0.15U W=0.36U AS=0.0684P
+ AD=0.066P PS=0.74U PD=0.745U
* device instance $1476 r0 *1 29.115,68.445 sky130_fd_pr__nfet_01v8
M$1476 1265 1242 97 97 sky130_fd_pr__nfet_01v8 L=0.15U W=0.42U AS=0.1092P
+ AD=0.0678P PS=1.36U PD=0.755U
* device instance $1477 r0 *1 30.605,68.445 sky130_fd_pr__nfet_01v8
M$1477 97 1275 1266 1266 sky130_fd_pr__nfet_01v8 L=0.15U W=0.42U AS=0.066P
+ AD=0.1092P PS=0.745U PD=1.36U
* device instance $1478 r0 *1 31.545,68.445 sky130_fd_pr__nfet_01v8
M$1478 97 1243 1275 1275 sky130_fd_pr__nfet_01v8 L=0.15U W=0.42U AS=0.1092P
+ AD=0.10025P PS=1.36U PD=0.985U
* device instance $1479 r0 *1 32.03,68.56 sky130_fd_pr__nfet_01v8
M$1479 893 1243 97 97 sky130_fd_pr__nfet_01v8 L=0.15U W=0.65U AS=0.10025P
+ AD=0.182P PS=0.985U PD=1.86U
* device instance $1480 r0 *1 33.13,68.56 sky130_fd_pr__nfet_01v8
M$1480 97 999 1244 1244 sky130_fd_pr__nfet_01v8 L=0.15U W=0.65U AS=0.169P
+ AD=0.08775P PS=1.82U PD=0.92U
* device instance $1481 r0 *1 33.55,68.56 sky130_fd_pr__nfet_01v8
M$1481 1190 1244 97 97 sky130_fd_pr__nfet_01v8 L=0.15U W=2.6U AS=0.351P
+ AD=0.43225P PS=3.68U PD=4.58U
* device instance $1485 r0 *1 40.51,68.56 sky130_fd_pr__nfet_01v8
M$1485 1285 1276 97 97 sky130_fd_pr__nfet_01v8 L=0.15U W=0.65U AS=0.169P
+ AD=0.08775P PS=1.82U PD=0.92U
* device instance $1486 r0 *1 40.93,68.56 sky130_fd_pr__nfet_01v8
M$1486 845 64 1285 1285 sky130_fd_pr__nfet_01v8 L=0.15U W=0.65U AS=0.08775P
+ AD=0.169P PS=0.92U PD=1.82U
* device instance $1487 r0 *1 41.94,68.445 sky130_fd_pr__nfet_01v8
M$1487 1267 1286 1245 1245 sky130_fd_pr__nfet_01v8 L=0.15U W=0.42U AS=0.1113P
+ AD=0.0441P PS=1.37U PD=0.63U
* device instance $1488 r0 *1 42.3,68.445 sky130_fd_pr__nfet_01v8
M$1488 97 115 1267 1267 sky130_fd_pr__nfet_01v8 L=0.15U W=0.42U AS=0.0441P
+ AD=0.0966P PS=0.63U PD=0.88U
* device instance $1489 r0 *1 42.91,68.445 sky130_fd_pr__nfet_01v8
M$1489 1189 1245 97 97 sky130_fd_pr__nfet_01v8 L=0.15U W=0.42U AS=0.0966P
+ AD=0.1113P PS=0.88U PD=1.37U
* device instance $1490 r0 *1 44.63,68.445 sky130_fd_pr__nfet_01v8
M$1490 97 979 1246 1246 sky130_fd_pr__nfet_01v8 L=0.15U W=0.42U AS=0.1092P
+ AD=0.0567P PS=1.36U PD=0.69U
* device instance $1491 r0 *1 45.05,68.445 sky130_fd_pr__nfet_01v8
M$1491 1247 1246 97 97 sky130_fd_pr__nfet_01v8 L=0.15U W=0.42U AS=0.0567P
+ AD=0.1092P PS=0.69U PD=1.36U
* device instance $1492 r0 *1 45.99,68.445 sky130_fd_pr__nfet_01v8
M$1492 1269 1204 1248 1248 sky130_fd_pr__nfet_01v8 L=0.15U W=0.42U AS=0.1092P
+ AD=0.0441P PS=1.36U PD=0.63U
* device instance $1493 r0 *1 46.35,68.445 sky130_fd_pr__nfet_01v8
M$1493 97 303 1269 1269 sky130_fd_pr__nfet_01v8 L=0.15U W=0.42U AS=0.0441P
+ AD=0.1092P PS=0.63U PD=1.36U
* device instance $1494 r0 *1 49.15,68.415 sky130_fd_pr__nfet_01v8
M$1494 1250 1246 1248 1248 sky130_fd_pr__nfet_01v8 L=0.15U W=0.36U AS=0.1446P
+ AD=0.0522P PS=1.18U PD=0.65U
* device instance $1495 r0 *1 49.59,68.415 sky130_fd_pr__nfet_01v8
M$1495 1271 1247 1250 1250 sky130_fd_pr__nfet_01v8 L=0.15U W=0.36U AS=0.0522P
+ AD=0.0759P PS=0.65U PD=0.8U
* device instance $1496 r0 *1 47.29,68.445 sky130_fd_pr__nfet_01v8
M$1496 97 303 1249 1249 sky130_fd_pr__nfet_01v8 L=0.15U W=0.42U AS=0.1092P
+ AD=0.0609P PS=1.36U PD=0.71U
* device instance $1497 r0 *1 47.73,68.445 sky130_fd_pr__nfet_01v8
M$1497 1270 1249 97 97 sky130_fd_pr__nfet_01v8 L=0.15U W=0.42U AS=0.0609P
+ AD=0.0756P PS=0.71U PD=0.78U
* device instance $1498 r0 *1 48.24,68.445 sky130_fd_pr__nfet_01v8
M$1498 1248 1277 1270 1270 sky130_fd_pr__nfet_01v8 L=0.15U W=0.42U AS=0.0756P
+ AD=0.1446P PS=0.78U PD=1.18U
* device instance $1499 r0 *1 50.12,68.445 sky130_fd_pr__nfet_01v8
M$1499 97 1251 1271 1271 sky130_fd_pr__nfet_01v8 L=0.15U W=0.42U AS=0.0759P
+ AD=0.12095P PS=0.8U PD=1.085U
* device instance $1500 r0 *1 50.715,68.555 sky130_fd_pr__nfet_01v8
M$1500 1251 1250 97 97 sky130_fd_pr__nfet_01v8 L=0.15U W=0.64U AS=0.12095P
+ AD=0.1664P PS=1.085U PD=1.8U
* device instance $1501 r0 *1 52.14,68.415 sky130_fd_pr__nfet_01v8
M$1501 1252 1247 1273 1273 sky130_fd_pr__nfet_01v8 L=0.15U W=0.36U AS=0.0678P
+ AD=0.0684P PS=0.755U PD=0.74U
* device instance $1502 r0 *1 52.67,68.415 sky130_fd_pr__nfet_01v8
M$1502 1272 1246 1252 1252 sky130_fd_pr__nfet_01v8 L=0.15U W=0.36U AS=0.0684P
+ AD=0.066P PS=0.74U PD=0.745U
* device instance $1503 r0 *1 51.655,68.445 sky130_fd_pr__nfet_01v8
M$1503 1273 1251 97 97 sky130_fd_pr__nfet_01v8 L=0.15U W=0.42U AS=0.1092P
+ AD=0.0678P PS=1.36U PD=0.755U
* device instance $1504 r0 *1 53.145,68.445 sky130_fd_pr__nfet_01v8
M$1504 97 1277 1272 1272 sky130_fd_pr__nfet_01v8 L=0.15U W=0.42U AS=0.066P
+ AD=0.1092P PS=0.745U PD=1.36U
* device instance $1505 r0 *1 54.085,68.445 sky130_fd_pr__nfet_01v8
M$1505 97 1252 1277 1277 sky130_fd_pr__nfet_01v8 L=0.15U W=0.42U AS=0.1092P
+ AD=0.10025P PS=1.36U PD=0.985U
* device instance $1506 r0 *1 54.57,68.56 sky130_fd_pr__nfet_01v8
M$1506 1114 1252 97 97 sky130_fd_pr__nfet_01v8 L=0.15U W=0.65U AS=0.10025P
+ AD=0.182P PS=0.985U PD=1.86U
* device instance $1507 r0 *1 57.12,68.445 sky130_fd_pr__nfet_01v8
M$1507 1268 1287 1253 1253 sky130_fd_pr__nfet_01v8 L=0.15U W=0.42U AS=0.1113P
+ AD=0.0441P PS=1.37U PD=0.63U
* device instance $1508 r0 *1 57.48,68.445 sky130_fd_pr__nfet_01v8
M$1508 97 115 1268 1268 sky130_fd_pr__nfet_01v8 L=0.15U W=0.42U AS=0.0441P
+ AD=0.0966P PS=0.63U PD=0.88U
* device instance $1509 r0 *1 58.09,68.445 sky130_fd_pr__nfet_01v8
M$1509 1025 1253 97 97 sky130_fd_pr__nfet_01v8 L=0.15U W=0.42U AS=0.0966P
+ AD=0.1113P PS=0.88U PD=1.37U
* device instance $1510 r0 *1 60.27,68.56 sky130_fd_pr__nfet_01v8
M$1510 97 1278 1254 1254 sky130_fd_pr__nfet_01v8 L=0.15U W=0.65U AS=0.169P
+ AD=0.10725P PS=1.82U PD=0.98U
* device instance $1511 r0 *1 60.75,68.56 sky130_fd_pr__nfet_01v8
M$1511 1284 1279 97 97 sky130_fd_pr__nfet_01v8 L=0.15U W=0.65U AS=0.10725P
+ AD=0.06825P PS=0.98U PD=0.86U
* device instance $1512 r0 *1 61.11,68.56 sky130_fd_pr__nfet_01v8
M$1512 1254 92 1284 1284 sky130_fd_pr__nfet_01v8 L=0.15U W=0.65U AS=0.06825P
+ AD=0.169P PS=0.86U PD=1.82U
* device instance $1513 r0 *1 62.05,68.56 sky130_fd_pr__nfet_01v8
M$1513 1283 1021 1254 1254 sky130_fd_pr__nfet_01v8 L=0.15U W=0.65U AS=0.169P
+ AD=0.10725P PS=1.82U PD=0.98U
* device instance $1514 r0 *1 62.53,68.56 sky130_fd_pr__nfet_01v8
M$1514 97 1192 1283 1283 sky130_fd_pr__nfet_01v8 L=0.15U W=0.65U AS=0.10725P
+ AD=0.102375P PS=0.98U PD=0.965U
* device instance $1515 r0 *1 62.995,68.56 sky130_fd_pr__nfet_01v8
M$1515 1289 1254 97 97 sky130_fd_pr__nfet_01v8 L=0.15U W=0.65U AS=0.102375P
+ AD=0.169P PS=0.965U PD=1.82U
* device instance $1516 r0 *1 63.95,68.675 sky130_fd_pr__nfet_01v8
M$1516 1255 1132 97 97 sky130_fd_pr__nfet_01v8 L=0.15U W=0.42U AS=0.10025P
+ AD=0.1092P PS=0.985U PD=1.36U
* device instance $1517 r0 *1 64.435,68.56 sky130_fd_pr__nfet_01v8
M$1517 1281 1131 97 97 sky130_fd_pr__nfet_01v8 L=0.15U W=0.65U AS=0.10025P
+ AD=0.08775P PS=0.985U PD=0.92U
* device instance $1518 r0 *1 64.855,68.56 sky130_fd_pr__nfet_01v8
M$1518 1024 1255 1281 1281 sky130_fd_pr__nfet_01v8 L=0.15U W=0.65U AS=0.08775P
+ AD=0.169P PS=0.92U PD=1.82U
* device instance $1519 r0 *1 68.175,68.445 sky130_fd_pr__nfet_01v8
M$1519 1261 64 97 97 sky130_fd_pr__nfet_01v8 L=0.15U W=0.42U AS=0.11285P
+ AD=0.0693P PS=1.045U PD=0.75U
* device instance $1520 r0 *1 68.655,68.445 sky130_fd_pr__nfet_01v8
M$1520 1256 1290 1261 1261 sky130_fd_pr__nfet_01v8 L=0.15U W=0.42U AS=0.0693P
+ AD=0.09975P PS=0.75U PD=0.895U
* device instance $1521 r0 *1 69.28,68.445 sky130_fd_pr__nfet_01v8
M$1521 1260 1131 1256 1256 sky130_fd_pr__nfet_01v8 L=0.15U W=0.42U AS=0.09975P
+ AD=0.0693P PS=0.895U PD=0.75U
* device instance $1522 r0 *1 69.76,68.445 sky130_fd_pr__nfet_01v8
M$1522 97 1257 1260 1260 sky130_fd_pr__nfet_01v8 L=0.15U W=0.42U AS=0.0693P
+ AD=0.1449P PS=0.75U PD=1.11U
* device instance $1523 r0 *1 70.6,68.445 sky130_fd_pr__nfet_01v8
M$1523 1257 64 97 97 sky130_fd_pr__nfet_01v8 L=0.15U W=0.42U AS=0.1449P
+ AD=0.1092P PS=1.11U PD=1.36U
* device instance $1524 r0 *1 67.63,68.56 sky130_fd_pr__nfet_01v8
M$1524 97 1256 1193 1193 sky130_fd_pr__nfet_01v8 L=0.15U W=0.65U AS=0.169P
+ AD=0.11285P PS=1.82U PD=1.045U
* device instance $1525 r0 *1 8.29,72.995 sky130_fd_pr__nfet_01v8
M$1525 97 681 1307 1307 sky130_fd_pr__nfet_01v8 L=0.15U W=0.42U AS=0.1092P
+ AD=0.0567P PS=1.36U PD=0.69U
* device instance $1526 r0 *1 8.71,72.995 sky130_fd_pr__nfet_01v8
M$1526 1308 1307 97 97 sky130_fd_pr__nfet_01v8 L=0.15U W=0.42U AS=0.0567P
+ AD=0.1092P PS=0.69U PD=1.36U
* device instance $1527 r0 *1 9.65,72.995 sky130_fd_pr__nfet_01v8
M$1527 1309 1098 97 97 sky130_fd_pr__nfet_01v8 L=0.15U W=0.42U AS=0.1092P
+ AD=0.0813P PS=1.36U PD=0.83U
* device instance $1528 r0 *1 10.21,73.025 sky130_fd_pr__nfet_01v8
M$1528 1310 1307 1309 1309 sky130_fd_pr__nfet_01v8 L=0.15U W=0.36U AS=0.0813P
+ AD=0.0621P PS=0.83U PD=0.705U
* device instance $1529 r0 *1 10.705,73.025 sky130_fd_pr__nfet_01v8
M$1529 1310 1308 1344 1344 sky130_fd_pr__nfet_01v8 L=0.15U W=0.36U AS=0.0696P
+ AD=0.0621P PS=0.765U PD=0.705U
* device instance $1530 r0 *1 11.2,72.995 sky130_fd_pr__nfet_01v8
M$1530 1344 1311 97 97 sky130_fd_pr__nfet_01v8 L=0.15U W=0.42U AS=0.12095P
+ AD=0.0696P PS=1.085U PD=0.765U
* device instance $1531 r0 *1 11.795,72.885 sky130_fd_pr__nfet_01v8
M$1531 1311 1310 97 97 sky130_fd_pr__nfet_01v8 L=0.15U W=0.64U AS=0.12095P
+ AD=0.0989P PS=1.085U PD=0.995U
* device instance $1532 r0 *1 12.3,73.025 sky130_fd_pr__nfet_01v8
M$1532 1312 1308 1311 1311 sky130_fd_pr__nfet_01v8 L=0.15U W=0.36U AS=0.0989P
+ AD=0.0684P PS=0.995U PD=0.74U
* device instance $1533 r0 *1 12.83,73.025 sky130_fd_pr__nfet_01v8
M$1533 1312 1307 1346 1346 sky130_fd_pr__nfet_01v8 L=0.15U W=0.36U AS=0.066P
+ AD=0.0684P PS=0.745U PD=0.74U
* device instance $1534 r0 *1 13.305,72.995 sky130_fd_pr__nfet_01v8
M$1534 97 1313 1346 1346 sky130_fd_pr__nfet_01v8 L=0.15U W=0.42U AS=0.066P
+ AD=0.1092P PS=0.745U PD=1.36U
* device instance $1535 r0 *1 14.25,72.88 sky130_fd_pr__nfet_01v8
M$1535 97 1312 1313 1313 sky130_fd_pr__nfet_01v8 L=0.15U W=0.65U AS=0.169P
+ AD=0.08775P PS=1.82U PD=0.92U
* device instance $1536 r0 *1 14.67,72.88 sky130_fd_pr__nfet_01v8
M$1536 1130 1313 97 97 sky130_fd_pr__nfet_01v8 L=0.15U W=0.65U AS=0.08775P
+ AD=0.169P PS=0.92U PD=1.82U
* device instance $1537 r0 *1 26.23,72.88 sky130_fd_pr__nfet_01v8
M$1537 97 1314 1274 1274 sky130_fd_pr__nfet_01v8 L=0.15U W=0.65U AS=0.169P
+ AD=0.11285P PS=1.82U PD=1.045U
* device instance $1538 r0 *1 26.775,72.995 sky130_fd_pr__nfet_01v8
M$1538 1351 64 97 97 sky130_fd_pr__nfet_01v8 L=0.15U W=0.42U AS=0.11285P
+ AD=0.0693P PS=1.045U PD=0.75U
* device instance $1539 r0 *1 27.255,72.995 sky130_fd_pr__nfet_01v8
M$1539 1314 1315 1351 1351 sky130_fd_pr__nfet_01v8 L=0.15U W=0.42U AS=0.0693P
+ AD=0.09975P PS=0.75U PD=0.895U
* device instance $1540 r0 *1 27.88,72.995 sky130_fd_pr__nfet_01v8
M$1540 1352 993 1314 1314 sky130_fd_pr__nfet_01v8 L=0.15U W=0.42U AS=0.09975P
+ AD=0.0693P PS=0.895U PD=0.75U
* device instance $1541 r0 *1 28.36,72.995 sky130_fd_pr__nfet_01v8
M$1541 97 1339 1352 1352 sky130_fd_pr__nfet_01v8 L=0.15U W=0.42U AS=0.0693P
+ AD=0.1449P PS=0.75U PD=1.11U
* device instance $1542 r0 *1 29.2,72.995 sky130_fd_pr__nfet_01v8
M$1542 1339 64 97 97 sky130_fd_pr__nfet_01v8 L=0.15U W=0.42U AS=0.1449P
+ AD=0.1092P PS=1.11U PD=1.36U
* device instance $1543 r0 *1 44.63,72.88 sky130_fd_pr__nfet_01v8
M$1543 97 1316 1191 1191 sky130_fd_pr__nfet_01v8 L=0.15U W=0.65U AS=0.169P
+ AD=0.11285P PS=1.82U PD=1.045U
* device instance $1544 r0 *1 45.175,72.995 sky130_fd_pr__nfet_01v8
M$1544 1350 64 97 97 sky130_fd_pr__nfet_01v8 L=0.15U W=0.42U AS=0.11285P
+ AD=0.0693P PS=1.045U PD=0.75U
* device instance $1545 r0 *1 45.655,72.995 sky130_fd_pr__nfet_01v8
M$1545 1316 1317 1350 1350 sky130_fd_pr__nfet_01v8 L=0.15U W=0.42U AS=0.0693P
+ AD=0.09975P PS=0.75U PD=0.895U
* device instance $1546 r0 *1 46.28,72.995 sky130_fd_pr__nfet_01v8
M$1546 1349 1114 1316 1316 sky130_fd_pr__nfet_01v8 L=0.15U W=0.42U AS=0.09975P
+ AD=0.0693P PS=0.895U PD=0.75U
* device instance $1547 r0 *1 46.76,72.995 sky130_fd_pr__nfet_01v8
M$1547 97 1340 1349 1349 sky130_fd_pr__nfet_01v8 L=0.15U W=0.42U AS=0.0693P
+ AD=0.1449P PS=0.75U PD=1.11U
* device instance $1548 r0 *1 47.6,72.995 sky130_fd_pr__nfet_01v8
M$1548 1340 64 97 97 sky130_fd_pr__nfet_01v8 L=0.15U W=0.42U AS=0.1449P
+ AD=0.1092P PS=1.11U PD=1.36U
* device instance $1549 r0 *1 58.5,72.995 sky130_fd_pr__nfet_01v8
M$1549 1348 1318 1319 1319 sky130_fd_pr__nfet_01v8 L=0.15U W=0.42U AS=0.1113P
+ AD=0.0441P PS=1.37U PD=0.63U
* device instance $1550 r0 *1 58.86,72.995 sky130_fd_pr__nfet_01v8
M$1550 97 115 1348 1348 sky130_fd_pr__nfet_01v8 L=0.15U W=0.42U AS=0.0441P
+ AD=0.0966P PS=0.63U PD=0.88U
* device instance $1551 r0 *1 59.47,72.995 sky130_fd_pr__nfet_01v8
M$1551 1278 1319 97 97 sky130_fd_pr__nfet_01v8 L=0.15U W=0.42U AS=0.0966P
+ AD=0.1113P PS=0.88U PD=1.37U
* device instance $1552 r0 *1 60.73,72.995 sky130_fd_pr__nfet_01v8
M$1552 97 979 1320 1320 sky130_fd_pr__nfet_01v8 L=0.15U W=0.42U AS=0.1092P
+ AD=0.0567P PS=1.36U PD=0.69U
* device instance $1553 r0 *1 61.15,72.995 sky130_fd_pr__nfet_01v8
M$1553 1321 1320 97 97 sky130_fd_pr__nfet_01v8 L=0.15U W=0.42U AS=0.0567P
+ AD=0.1092P PS=0.69U PD=1.36U
* device instance $1554 r0 *1 62.09,72.995 sky130_fd_pr__nfet_01v8
M$1554 1347 1289 1322 1322 sky130_fd_pr__nfet_01v8 L=0.15U W=0.42U AS=0.1092P
+ AD=0.0441P PS=1.36U PD=0.63U
* device instance $1555 r0 *1 62.45,72.995 sky130_fd_pr__nfet_01v8
M$1555 97 303 1347 1347 sky130_fd_pr__nfet_01v8 L=0.15U W=0.42U AS=0.0441P
+ AD=0.1092P PS=0.63U PD=1.36U
* device instance $1556 r0 *1 63.39,72.995 sky130_fd_pr__nfet_01v8
M$1556 97 303 1323 1323 sky130_fd_pr__nfet_01v8 L=0.15U W=0.42U AS=0.1092P
+ AD=0.0609P PS=1.36U PD=0.71U
* device instance $1557 r0 *1 63.83,72.995 sky130_fd_pr__nfet_01v8
M$1557 1345 1323 97 97 sky130_fd_pr__nfet_01v8 L=0.15U W=0.42U AS=0.0609P
+ AD=0.0756P PS=0.71U PD=0.78U
* device instance $1558 r0 *1 64.34,72.995 sky130_fd_pr__nfet_01v8
M$1558 1322 1327 1345 1345 sky130_fd_pr__nfet_01v8 L=0.15U W=0.42U AS=0.0756P
+ AD=0.1446P PS=0.78U PD=1.18U
* device instance $1559 r0 *1 65.25,73.025 sky130_fd_pr__nfet_01v8
M$1559 1324 1320 1322 1322 sky130_fd_pr__nfet_01v8 L=0.15U W=0.36U AS=0.1446P
+ AD=0.0522P PS=1.18U PD=0.65U
* device instance $1560 r0 *1 65.69,73.025 sky130_fd_pr__nfet_01v8
M$1560 1324 1321 1343 1343 sky130_fd_pr__nfet_01v8 L=0.15U W=0.36U AS=0.0759P
+ AD=0.0522P PS=0.8U PD=0.65U
* device instance $1561 r0 *1 66.22,72.995 sky130_fd_pr__nfet_01v8
M$1561 1343 1325 97 97 sky130_fd_pr__nfet_01v8 L=0.15U W=0.42U AS=0.12095P
+ AD=0.0759P PS=1.085U PD=0.8U
* device instance $1562 r0 *1 66.815,72.885 sky130_fd_pr__nfet_01v8
M$1562 1325 1324 97 97 sky130_fd_pr__nfet_01v8 L=0.15U W=0.64U AS=0.12095P
+ AD=0.1664P PS=1.085U PD=1.8U
* device instance $1563 r0 *1 65.79,74 sky130_fd_pr__nfet_01v8
M$1563 97 1132 1353 1353 sky130_fd_pr__nfet_01v8 L=0.15U W=0.65U AS=0.169P
+ AD=0.08775P PS=1.82U PD=0.92U
* device instance $1564 r0 *1 66.21,74 sky130_fd_pr__nfet_01v8
M$1564 1279 1353 97 97 sky130_fd_pr__nfet_01v8 L=0.15U W=2.6U AS=0.351P
+ AD=0.43225P PS=3.68U PD=4.58U
* device instance $1568 r0 *1 67.755,72.995 sky130_fd_pr__nfet_01v8
M$1568 1342 1325 97 97 sky130_fd_pr__nfet_01v8 L=0.15U W=0.42U AS=0.1092P
+ AD=0.0678P PS=1.36U PD=0.755U
* device instance $1569 r0 *1 68.24,73.025 sky130_fd_pr__nfet_01v8
M$1569 1326 1321 1342 1342 sky130_fd_pr__nfet_01v8 L=0.15U W=0.36U AS=0.0678P
+ AD=0.0684P PS=0.755U PD=0.74U
* device instance $1570 r0 *1 68.77,73.025 sky130_fd_pr__nfet_01v8
M$1570 1326 1320 1341 1341 sky130_fd_pr__nfet_01v8 L=0.15U W=0.36U AS=0.066P
+ AD=0.0684P PS=0.745U PD=0.74U
* device instance $1571 r0 *1 69.245,72.995 sky130_fd_pr__nfet_01v8
M$1571 97 1327 1341 1341 sky130_fd_pr__nfet_01v8 L=0.15U W=0.42U AS=0.066P
+ AD=0.1092P PS=0.745U PD=1.36U
* device instance $1572 r0 *1 70.185,72.995 sky130_fd_pr__nfet_01v8
M$1572 1327 1326 97 97 sky130_fd_pr__nfet_01v8 L=0.15U W=0.42U AS=0.10025P
+ AD=0.1092P PS=0.985U PD=1.36U
* device instance $1573 r0 *1 70.67,72.88 sky130_fd_pr__nfet_01v8
M$1573 1131 1326 97 97 sky130_fd_pr__nfet_01v8 L=0.15U W=0.65U AS=0.10025P
+ AD=0.182P PS=0.985U PD=1.86U
* device instance $1574 r0 *1 14.525,4.885 sky130_fd_pr__pfet_01v8
M$1574 8 11 37 37 sky130_fd_pr__pfet_01v8 L=0.15U W=0.64U AS=0.154P AD=0.1728P
+ PS=1.335U PD=1.82U
* device instance $1575 r0 *1 15.01,4.705 sky130_fd_pr__pfet_01v8
M$1575 12 11 37 37 sky130_fd_pr__pfet_01v8 L=0.15U W=1U AS=0.154P AD=0.28P
+ PS=1.335U PD=2.56U
* device instance $1576 r0 *1 70.185,4.885 sky130_fd_pr__pfet_01v8
M$1576 16 19 37 37 sky130_fd_pr__pfet_01v8 L=0.15U W=0.64U AS=0.154P AD=0.1728P
+ PS=1.335U PD=1.82U
* device instance $1577 r0 *1 70.67,4.705 sky130_fd_pr__pfet_01v8
M$1577 20 19 37 37 sky130_fd_pr__pfet_01v8 L=0.15U W=1U AS=0.154P AD=0.28P
+ PS=1.335U PD=2.56U
* device instance $1578 r0 *1 5.07,4.855 sky130_fd_pr__pfet_01v8
M$1578 37 31 5 5 sky130_fd_pr__pfet_01v8 L=0.15U W=0.64U AS=0.1664P AD=0.0864P
+ PS=1.8U PD=0.91U
* device instance $1579 r0 *1 5.49,4.855 sky130_fd_pr__pfet_01v8
M$1579 6 5 37 37 sky130_fd_pr__pfet_01v8 L=0.15U W=0.64U AS=0.0864P AD=0.1664P
+ PS=0.91U PD=1.8U
* device instance $1580 r0 *1 6.43,4.885 sky130_fd_pr__pfet_01v8
M$1580 38 32 7 7 sky130_fd_pr__pfet_01v8 L=0.15U W=0.64U AS=0.1664P AD=0.0672P
+ PS=1.8U PD=0.85U
* device instance $1581 r0 *1 6.79,4.885 sky130_fd_pr__pfet_01v8
M$1581 37 33 38 38 sky130_fd_pr__pfet_01v8 L=0.15U W=0.64U AS=0.0672P
+ AD=0.1664P PS=0.85U PD=1.8U
* device instance $1582 r0 *1 7.73,4.885 sky130_fd_pr__pfet_01v8
M$1582 37 94 33 33 sky130_fd_pr__pfet_01v8 L=0.15U W=0.64U AS=0.1664P
+ AD=0.0928P PS=1.8U PD=0.93U
* device instance $1583 r0 *1 8.17,4.885 sky130_fd_pr__pfet_01v8
M$1583 41 94 37 37 sky130_fd_pr__pfet_01v8 L=0.15U W=0.64U AS=0.0928P
+ AD=0.1152P PS=0.93U PD=1U
* device instance $1584 r0 *1 8.68,4.885 sky130_fd_pr__pfet_01v8
M$1584 7 8 41 41 sky130_fd_pr__pfet_01v8 L=0.15U W=0.64U AS=0.1152P AD=0.15985P
+ PS=1U PD=1.265U
* device instance $1585 r0 *1 9.455,4.995 sky130_fd_pr__pfet_01v8
M$1585 9 6 7 7 sky130_fd_pr__pfet_01v8 L=0.15U W=0.42U AS=0.15985P AD=0.06405P
+ PS=1.265U PD=0.725U
* device instance $1586 r0 *1 9.91,4.995 sky130_fd_pr__pfet_01v8
M$1586 42 5 9 9 sky130_fd_pr__pfet_01v8 L=0.15U W=0.42U AS=0.06405P AD=0.07665P
+ PS=0.725U PD=0.785U
* device instance $1587 r0 *1 10.425,4.995 sky130_fd_pr__pfet_01v8
M$1587 42 10 37 37 sky130_fd_pr__pfet_01v8 L=0.15U W=0.42U AS=0.178875P
+ AD=0.07665P PS=1.26U PD=0.785U
* device instance $1588 r0 *1 11.085,4.83 sky130_fd_pr__pfet_01v8
M$1588 10 9 37 37 sky130_fd_pr__pfet_01v8 L=0.15U W=0.75U AS=0.178875P
+ AD=0.195P PS=1.26U PD=2.02U
* device instance $1589 r0 *1 60.73,4.855 sky130_fd_pr__pfet_01v8
M$1589 37 34 13 13 sky130_fd_pr__pfet_01v8 L=0.15U W=0.64U AS=0.1664P
+ AD=0.0864P PS=1.8U PD=0.91U
* device instance $1590 r0 *1 61.15,4.855 sky130_fd_pr__pfet_01v8
M$1590 14 13 37 37 sky130_fd_pr__pfet_01v8 L=0.15U W=0.64U AS=0.0864P
+ AD=0.1664P PS=0.91U PD=1.8U
* device instance $1591 r0 *1 62.09,4.885 sky130_fd_pr__pfet_01v8
M$1591 47 35 15 15 sky130_fd_pr__pfet_01v8 L=0.15U W=0.64U AS=0.1664P
+ AD=0.0672P PS=1.8U PD=0.85U
* device instance $1592 r0 *1 62.45,4.885 sky130_fd_pr__pfet_01v8
M$1592 37 36 47 47 sky130_fd_pr__pfet_01v8 L=0.15U W=0.64U AS=0.0672P
+ AD=0.1664P PS=0.85U PD=1.8U
* device instance $1593 r0 *1 63.39,4.885 sky130_fd_pr__pfet_01v8
M$1593 37 303 36 36 sky130_fd_pr__pfet_01v8 L=0.15U W=0.64U AS=0.1664P
+ AD=0.0928P PS=1.8U PD=0.93U
* device instance $1594 r0 *1 63.83,4.885 sky130_fd_pr__pfet_01v8
M$1594 45 303 37 37 sky130_fd_pr__pfet_01v8 L=0.15U W=0.64U AS=0.0928P
+ AD=0.1152P PS=0.93U PD=1U
* device instance $1595 r0 *1 64.34,4.885 sky130_fd_pr__pfet_01v8
M$1595 15 16 45 45 sky130_fd_pr__pfet_01v8 L=0.15U W=0.64U AS=0.1152P
+ AD=0.15985P PS=1U PD=1.265U
* device instance $1596 r0 *1 65.115,4.995 sky130_fd_pr__pfet_01v8
M$1596 17 14 15 15 sky130_fd_pr__pfet_01v8 L=0.15U W=0.42U AS=0.15985P
+ AD=0.06405P PS=1.265U PD=0.725U
* device instance $1597 r0 *1 65.57,4.995 sky130_fd_pr__pfet_01v8
M$1597 43 13 17 17 sky130_fd_pr__pfet_01v8 L=0.15U W=0.42U AS=0.06405P
+ AD=0.07665P PS=0.725U PD=0.785U
* device instance $1598 r0 *1 66.085,4.995 sky130_fd_pr__pfet_01v8
M$1598 43 18 37 37 sky130_fd_pr__pfet_01v8 L=0.15U W=0.42U AS=0.178875P
+ AD=0.07665P PS=1.26U PD=0.785U
* device instance $1599 r0 *1 66.745,4.83 sky130_fd_pr__pfet_01v8
M$1599 18 17 37 37 sky130_fd_pr__pfet_01v8 L=0.15U W=0.75U AS=0.178875P
+ AD=0.195P PS=1.26U PD=2.02U
* device instance $1600 r0 *1 6.89,5.995 sky130_fd_pr__pfet_01v8
M$1600 80 51 50 50 sky130_fd_pr__pfet_01v8 L=0.15U W=0.64U AS=0.1664P
+ AD=0.0672P PS=1.8U PD=0.85U
* device instance $1601 r0 *1 7.25,5.995 sky130_fd_pr__pfet_01v8
M$1601 37 52 80 80 sky130_fd_pr__pfet_01v8 L=0.15U W=0.64U AS=0.0672P
+ AD=0.1664P PS=0.85U PD=1.8U
* device instance $1602 r0 *1 9.915,5.885 sky130_fd_pr__pfet_01v8
M$1602 53 49 50 50 sky130_fd_pr__pfet_01v8 L=0.15U W=0.42U AS=0.15985P
+ AD=0.06405P PS=1.265U PD=0.725U
* device instance $1603 r0 *1 10.37,5.885 sky130_fd_pr__pfet_01v8
M$1603 84 48 53 53 sky130_fd_pr__pfet_01v8 L=0.15U W=0.42U AS=0.06405P
+ AD=0.07665P PS=0.725U PD=0.785U
* device instance $1604 r0 *1 10.885,5.885 sky130_fd_pr__pfet_01v8
M$1604 37 54 84 84 sky130_fd_pr__pfet_01v8 L=0.15U W=0.42U AS=0.07665P
+ AD=0.178875P PS=0.785U PD=1.26U
* device instance $1605 r0 *1 8.19,5.995 sky130_fd_pr__pfet_01v8
M$1605 37 303 52 52 sky130_fd_pr__pfet_01v8 L=0.15U W=0.64U AS=0.1664P
+ AD=0.0928P PS=1.8U PD=0.93U
* device instance $1606 r0 *1 8.63,5.995 sky130_fd_pr__pfet_01v8
M$1606 82 303 37 37 sky130_fd_pr__pfet_01v8 L=0.15U W=0.64U AS=0.0928P
+ AD=0.1152P PS=0.93U PD=1U
* device instance $1607 r0 *1 9.14,5.995 sky130_fd_pr__pfet_01v8
M$1607 50 56 82 82 sky130_fd_pr__pfet_01v8 L=0.15U W=0.64U AS=0.1152P
+ AD=0.15985P PS=1U PD=1.265U
* device instance $1608 r0 *1 11.545,6.05 sky130_fd_pr__pfet_01v8
M$1608 54 53 37 37 sky130_fd_pr__pfet_01v8 L=0.15U W=0.75U AS=0.178875P
+ AD=0.195P PS=1.26U PD=2.02U
* device instance $1609 r0 *1 12.025,4.995 sky130_fd_pr__pfet_01v8
M$1609 44 10 37 37 sky130_fd_pr__pfet_01v8 L=0.15U W=0.42U AS=0.1092P
+ AD=0.06405P PS=1.36U PD=0.725U
* device instance $1610 r0 *1 12.48,4.995 sky130_fd_pr__pfet_01v8
M$1610 11 5 44 44 sky130_fd_pr__pfet_01v8 L=0.15U W=0.42U AS=0.06405P
+ AD=0.0567P PS=0.725U PD=0.69U
* device instance $1611 r0 *1 12.9,4.995 sky130_fd_pr__pfet_01v8
M$1611 46 6 11 11 sky130_fd_pr__pfet_01v8 L=0.15U W=0.42U AS=0.0567P AD=0.0882P
+ PS=0.69U PD=0.84U
* device instance $1612 r0 *1 13.47,4.995 sky130_fd_pr__pfet_01v8
M$1612 37 8 46 46 sky130_fd_pr__pfet_01v8 L=0.15U W=0.42U AS=0.0882P AD=0.1113P
+ PS=0.84U PD=1.37U
* device instance $1613 r0 *1 12.485,5.885 sky130_fd_pr__pfet_01v8
M$1613 85 54 37 37 sky130_fd_pr__pfet_01v8 L=0.15U W=0.42U AS=0.1092P
+ AD=0.06405P PS=1.36U PD=0.725U
* device instance $1614 r0 *1 12.94,5.885 sky130_fd_pr__pfet_01v8
M$1614 55 48 85 85 sky130_fd_pr__pfet_01v8 L=0.15U W=0.42U AS=0.06405P
+ AD=0.0567P PS=0.725U PD=0.69U
* device instance $1615 r0 *1 13.36,5.885 sky130_fd_pr__pfet_01v8
M$1615 86 49 55 55 sky130_fd_pr__pfet_01v8 L=0.15U W=0.42U AS=0.0567P
+ AD=0.0882P PS=0.69U PD=0.84U
* device instance $1616 r0 *1 13.93,5.885 sky130_fd_pr__pfet_01v8
M$1616 37 56 86 86 sky130_fd_pr__pfet_01v8 L=0.15U W=0.42U AS=0.0882P
+ AD=0.1113P PS=0.84U PD=1.37U
* device instance $1617 r0 *1 14.985,5.995 sky130_fd_pr__pfet_01v8
M$1617 37 55 56 56 sky130_fd_pr__pfet_01v8 L=0.15U W=0.64U AS=0.1728P AD=0.154P
+ PS=1.82U PD=1.335U
* device instance $1618 r0 *1 15.47,6.175 sky130_fd_pr__pfet_01v8
M$1618 57 55 37 37 sky130_fd_pr__pfet_01v8 L=0.15U W=1U AS=0.154P AD=0.28P
+ PS=1.335U PD=2.56U
* device instance $1619 r0 *1 23.47,6.175 sky130_fd_pr__pfet_01v8
M$1619 59 91 58 58 sky130_fd_pr__pfet_01v8 L=0.15U W=1U AS=0.26P AD=0.135P
+ PS=2.52U PD=1.27U
* device instance $1620 r0 *1 23.89,6.175 sky130_fd_pr__pfet_01v8
M$1620 60 219 59 59 sky130_fd_pr__pfet_01v8 L=0.15U W=1U AS=0.135P AD=0.135P
+ PS=1.27U PD=1.27U
* device instance $1621 r0 *1 24.31,6.175 sky130_fd_pr__pfet_01v8
M$1621 59 92 60 60 sky130_fd_pr__pfet_01v8 L=0.15U W=1U AS=0.135P AD=0.26P
+ PS=1.27U PD=2.52U
* device instance $1622 r0 *1 25.25,6.175 sky130_fd_pr__pfet_01v8
M$1622 60 157 37 37 sky130_fd_pr__pfet_01v8 L=0.15U W=1U AS=0.26P AD=0.165P
+ PS=2.52U PD=1.33U
* device instance $1623 r0 *1 25.73,6.175 sky130_fd_pr__pfet_01v8
M$1623 37 93 60 60 sky130_fd_pr__pfet_01v8 L=0.15U W=1U AS=0.165P AD=0.1575P
+ PS=1.33U PD=1.315U
* device instance $1624 r0 *1 26.195,6.175 sky130_fd_pr__pfet_01v8
M$1624 62 58 37 37 sky130_fd_pr__pfet_01v8 L=0.15U W=1U AS=0.1575P AD=0.26P
+ PS=1.315U PD=2.52U
* device instance $1625 r0 *1 27.665,5.995 sky130_fd_pr__pfet_01v8
M$1625 90 63 37 37 sky130_fd_pr__pfet_01v8 L=0.15U W=0.64U AS=0.1696P
+ AD=0.0768P PS=1.81U PD=0.88U
* device instance $1626 r0 *1 28.055,5.995 sky130_fd_pr__pfet_01v8
M$1626 61 64 90 90 sky130_fd_pr__pfet_01v8 L=0.15U W=0.64U AS=0.0768P
+ AD=0.0896P PS=0.88U PD=0.92U
* device instance $1627 r0 *1 28.485,5.995 sky130_fd_pr__pfet_01v8
M$1627 37 65 61 61 sky130_fd_pr__pfet_01v8 L=0.15U W=0.64U AS=0.0896P
+ AD=0.1824P PS=0.92U PD=1.85U
* device instance $1628 r0 *1 44.67,6.175 sky130_fd_pr__pfet_01v8
M$1628 95 67 66 66 sky130_fd_pr__pfet_01v8 L=0.15U W=1U AS=0.26P AD=0.135P
+ PS=2.52U PD=1.27U
* device instance $1629 r0 *1 45.09,6.175 sky130_fd_pr__pfet_01v8
M$1629 37 68 95 95 sky130_fd_pr__pfet_01v8 L=0.15U W=1U AS=0.135P AD=0.135P
+ PS=1.27U PD=1.27U
* device instance $1630 r0 *1 45.51,6.175 sky130_fd_pr__pfet_01v8
M$1630 69 68 37 37 sky130_fd_pr__pfet_01v8 L=0.15U W=1U AS=0.135P AD=0.135P
+ PS=1.27U PD=1.27U
* device instance $1631 r0 *1 45.93,6.175 sky130_fd_pr__pfet_01v8
M$1631 37 67 69 69 sky130_fd_pr__pfet_01v8 L=0.15U W=1U AS=0.135P AD=0.26P
+ PS=1.27U PD=2.52U
* device instance $1632 r0 *1 46.87,6.175 sky130_fd_pr__pfet_01v8
M$1632 70 66 69 69 sky130_fd_pr__pfet_01v8 L=0.15U W=1U AS=0.26P AD=0.3P
+ PS=2.52U PD=2.6U
* device instance $1633 r0 *1 66.23,5.995 sky130_fd_pr__pfet_01v8
M$1633 89 74 73 73 sky130_fd_pr__pfet_01v8 L=0.15U W=0.64U AS=0.1664P
+ AD=0.0672P PS=1.8U PD=0.85U
* device instance $1634 r0 *1 66.59,5.995 sky130_fd_pr__pfet_01v8
M$1634 37 75 89 89 sky130_fd_pr__pfet_01v8 L=0.15U W=0.64U AS=0.0672P
+ AD=0.1664P PS=0.85U PD=1.8U
* device instance $1635 r0 *1 69.255,5.885 sky130_fd_pr__pfet_01v8
M$1635 76 72 73 73 sky130_fd_pr__pfet_01v8 L=0.15U W=0.42U AS=0.15985P
+ AD=0.06405P PS=1.265U PD=0.725U
* device instance $1636 r0 *1 69.71,5.885 sky130_fd_pr__pfet_01v8
M$1636 87 71 76 76 sky130_fd_pr__pfet_01v8 L=0.15U W=0.42U AS=0.06405P
+ AD=0.07665P PS=0.725U PD=0.785U
* device instance $1637 r0 *1 70.225,5.885 sky130_fd_pr__pfet_01v8
M$1637 37 77 87 87 sky130_fd_pr__pfet_01v8 L=0.15U W=0.42U AS=0.07665P
+ AD=0.178875P PS=0.785U PD=1.26U
* device instance $1638 r0 *1 67.53,5.995 sky130_fd_pr__pfet_01v8
M$1638 37 94 75 75 sky130_fd_pr__pfet_01v8 L=0.15U W=0.64U AS=0.1664P
+ AD=0.0928P PS=1.8U PD=0.93U
* device instance $1639 r0 *1 67.97,5.995 sky130_fd_pr__pfet_01v8
M$1639 88 94 37 37 sky130_fd_pr__pfet_01v8 L=0.15U W=0.64U AS=0.0928P
+ AD=0.1152P PS=0.93U PD=1U
* device instance $1640 r0 *1 68.48,5.995 sky130_fd_pr__pfet_01v8
M$1640 73 79 88 88 sky130_fd_pr__pfet_01v8 L=0.15U W=0.64U AS=0.1152P
+ AD=0.15985P PS=1U PD=1.265U
* device instance $1641 r0 *1 70.885,6.05 sky130_fd_pr__pfet_01v8
M$1641 77 76 37 37 sky130_fd_pr__pfet_01v8 L=0.15U W=0.75U AS=0.178875P
+ AD=0.195P PS=1.26U PD=2.02U
* device instance $1642 r0 *1 67.685,4.995 sky130_fd_pr__pfet_01v8
M$1642 40 18 37 37 sky130_fd_pr__pfet_01v8 L=0.15U W=0.42U AS=0.1092P
+ AD=0.06405P PS=1.36U PD=0.725U
* device instance $1643 r0 *1 68.14,4.995 sky130_fd_pr__pfet_01v8
M$1643 19 13 40 40 sky130_fd_pr__pfet_01v8 L=0.15U W=0.42U AS=0.06405P
+ AD=0.0567P PS=0.725U PD=0.69U
* device instance $1644 r0 *1 68.56,4.995 sky130_fd_pr__pfet_01v8
M$1644 39 14 19 19 sky130_fd_pr__pfet_01v8 L=0.15U W=0.42U AS=0.0567P
+ AD=0.0882P PS=0.69U PD=0.84U
* device instance $1645 r0 *1 69.13,4.995 sky130_fd_pr__pfet_01v8
M$1645 37 16 39 39 sky130_fd_pr__pfet_01v8 L=0.15U W=0.42U AS=0.0882P
+ AD=0.1113P PS=0.84U PD=1.37U
* device instance $1646 r0 *1 71.825,5.885 sky130_fd_pr__pfet_01v8
M$1646 83 77 37 37 sky130_fd_pr__pfet_01v8 L=0.15U W=0.42U AS=0.1092P
+ AD=0.06405P PS=1.36U PD=0.725U
* device instance $1647 r0 *1 72.28,5.885 sky130_fd_pr__pfet_01v8
M$1647 78 71 83 83 sky130_fd_pr__pfet_01v8 L=0.15U W=0.42U AS=0.06405P
+ AD=0.0567P PS=0.725U PD=0.69U
* device instance $1648 r0 *1 72.7,5.885 sky130_fd_pr__pfet_01v8
M$1648 81 72 78 78 sky130_fd_pr__pfet_01v8 L=0.15U W=0.42U AS=0.0567P
+ AD=0.0882P PS=0.69U PD=0.84U
* device instance $1649 r0 *1 73.27,5.885 sky130_fd_pr__pfet_01v8
M$1649 37 79 81 81 sky130_fd_pr__pfet_01v8 L=0.15U W=0.42U AS=0.0882P
+ AD=0.1113P PS=0.84U PD=1.37U
* device instance $1650 r0 *1 74.325,5.995 sky130_fd_pr__pfet_01v8
M$1650 37 78 79 79 sky130_fd_pr__pfet_01v8 L=0.15U W=0.64U AS=0.1728P AD=0.154P
+ PS=1.82U PD=1.335U
* device instance $1651 r0 *1 74.81,6.175 sky130_fd_pr__pfet_01v8
M$1651 161 78 37 37 sky130_fd_pr__pfet_01v8 L=0.15U W=1U AS=0.154P AD=0.28P
+ PS=1.335U PD=2.56U
* device instance $1652 r0 *1 5.53,6.025 sky130_fd_pr__pfet_01v8
M$1652 37 31 48 48 sky130_fd_pr__pfet_01v8 L=0.15U W=0.64U AS=0.1664P
+ AD=0.0864P PS=1.8U PD=0.91U
* device instance $1653 r0 *1 5.95,6.025 sky130_fd_pr__pfet_01v8
M$1653 49 48 37 37 sky130_fd_pr__pfet_01v8 L=0.15U W=0.64U AS=0.0864P
+ AD=0.1664P PS=0.91U PD=1.8U
* device instance $1654 r0 *1 9.21,10.145 sky130_fd_pr__pfet_01v8
M$1654 165 112 113 113 sky130_fd_pr__pfet_01v8 L=0.15U W=1U AS=0.26P AD=0.135P
+ PS=2.52U PD=1.27U
* device instance $1655 r0 *1 9.63,10.145 sky130_fd_pr__pfet_01v8
M$1655 162 12 165 165 sky130_fd_pr__pfet_01v8 L=0.15U W=1U AS=0.135P AD=0.135P
+ PS=1.27U PD=1.27U
* device instance $1656 r0 *1 10.05,10.145 sky130_fd_pr__pfet_01v8
M$1656 165 92 162 162 sky130_fd_pr__pfet_01v8 L=0.15U W=1U AS=0.135P AD=0.26P
+ PS=1.27U PD=2.52U
* device instance $1657 r0 *1 10.99,10.145 sky130_fd_pr__pfet_01v8
M$1657 162 157 37 37 sky130_fd_pr__pfet_01v8 L=0.15U W=1U AS=0.26P AD=0.165P
+ PS=2.52U PD=1.33U
* device instance $1658 r0 *1 11.47,10.145 sky130_fd_pr__pfet_01v8
M$1658 37 158 162 162 sky130_fd_pr__pfet_01v8 L=0.15U W=1U AS=0.165P AD=0.1575P
+ PS=1.33U PD=1.315U
* device instance $1659 r0 *1 11.935,10.145 sky130_fd_pr__pfet_01v8
M$1659 51 113 37 37 sky130_fd_pr__pfet_01v8 L=0.15U W=1U AS=0.1575P AD=0.26P
+ PS=1.315U PD=2.52U
* device instance $1660 r0 *1 25.31,10.295 sky130_fd_pr__pfet_01v8
M$1660 37 31 116 116 sky130_fd_pr__pfet_01v8 L=0.15U W=0.64U AS=0.1664P
+ AD=0.0864P PS=1.8U PD=0.91U
* device instance $1661 r0 *1 25.73,10.295 sky130_fd_pr__pfet_01v8
M$1661 117 116 37 37 sky130_fd_pr__pfet_01v8 L=0.15U W=0.64U AS=0.0864P
+ AD=0.1664P PS=0.91U PD=1.8U
* device instance $1662 r0 *1 26.67,10.325 sky130_fd_pr__pfet_01v8
M$1662 173 61 118 118 sky130_fd_pr__pfet_01v8 L=0.15U W=0.64U AS=0.1664P
+ AD=0.0672P PS=1.8U PD=0.85U
* device instance $1663 r0 *1 27.03,10.325 sky130_fd_pr__pfet_01v8
M$1663 37 119 173 173 sky130_fd_pr__pfet_01v8 L=0.15U W=0.64U AS=0.0672P
+ AD=0.1664P PS=0.85U PD=1.8U
* device instance $1664 r0 *1 27.97,10.325 sky130_fd_pr__pfet_01v8
M$1664 37 94 119 119 sky130_fd_pr__pfet_01v8 L=0.15U W=0.64U AS=0.1664P
+ AD=0.0928P PS=1.8U PD=0.93U
* device instance $1665 r0 *1 28.41,10.325 sky130_fd_pr__pfet_01v8
M$1665 174 94 37 37 sky130_fd_pr__pfet_01v8 L=0.15U W=0.64U AS=0.0928P
+ AD=0.1152P PS=0.93U PD=1U
* device instance $1666 r0 *1 28.92,10.325 sky130_fd_pr__pfet_01v8
M$1666 118 120 174 174 sky130_fd_pr__pfet_01v8 L=0.15U W=0.64U AS=0.1152P
+ AD=0.15985P PS=1U PD=1.265U
* device instance $1667 r0 *1 29.695,10.435 sky130_fd_pr__pfet_01v8
M$1667 121 117 118 118 sky130_fd_pr__pfet_01v8 L=0.15U W=0.42U AS=0.15985P
+ AD=0.06405P PS=1.265U PD=0.725U
* device instance $1668 r0 *1 30.15,10.435 sky130_fd_pr__pfet_01v8
M$1668 177 116 121 121 sky130_fd_pr__pfet_01v8 L=0.15U W=0.42U AS=0.06405P
+ AD=0.07665P PS=0.725U PD=0.785U
* device instance $1669 r0 *1 30.665,10.435 sky130_fd_pr__pfet_01v8
M$1669 177 122 37 37 sky130_fd_pr__pfet_01v8 L=0.15U W=0.42U AS=0.178875P
+ AD=0.07665P PS=1.26U PD=0.785U
* device instance $1670 r0 *1 31.325,10.27 sky130_fd_pr__pfet_01v8
M$1670 122 121 37 37 sky130_fd_pr__pfet_01v8 L=0.15U W=0.75U AS=0.178875P
+ AD=0.195P PS=1.26U PD=2.02U
* device instance $1671 r0 *1 34.765,10.325 sky130_fd_pr__pfet_01v8
M$1671 120 123 37 37 sky130_fd_pr__pfet_01v8 L=0.15U W=0.64U AS=0.154P
+ AD=0.1728P PS=1.335U PD=1.82U
* device instance $1672 r0 *1 35.25,10.145 sky130_fd_pr__pfet_01v8
M$1672 219 123 37 37 sky130_fd_pr__pfet_01v8 L=0.15U W=1U AS=0.154P AD=0.28P
+ PS=1.335U PD=2.56U
* device instance $1673 r0 *1 47.475,10.24 sky130_fd_pr__pfet_01v8
M$1673 172 64 37 37 sky130_fd_pr__pfet_01v8 L=0.15U W=0.42U AS=0.15835P
+ AD=0.07665P PS=1.395U PD=0.785U
* device instance $1674 r0 *1 47.99,10.24 sky130_fd_pr__pfet_01v8
M$1674 127 128 172 172 sky130_fd_pr__pfet_01v8 L=0.15U W=0.42U AS=0.07665P
+ AD=0.1932P PS=0.785U PD=1.34U
* device instance $1675 r0 *1 49.06,10.24 sky130_fd_pr__pfet_01v8
M$1675 171 129 127 127 sky130_fd_pr__pfet_01v8 L=0.15U W=0.42U AS=0.1932P
+ AD=0.0441P PS=1.34U PD=0.63U
* device instance $1676 r0 *1 49.42,10.24 sky130_fd_pr__pfet_01v8
M$1676 37 130 171 171 sky130_fd_pr__pfet_01v8 L=0.15U W=0.42U AS=0.0441P
+ AD=0.0693P PS=0.63U PD=0.75U
* device instance $1677 r0 *1 49.9,10.24 sky130_fd_pr__pfet_01v8
M$1677 130 64 37 37 sky130_fd_pr__pfet_01v8 L=0.15U W=0.42U AS=0.0693P
+ AD=0.1176P PS=0.75U PD=1.4U
* device instance $1678 r0 *1 46.93,10.145 sky130_fd_pr__pfet_01v8
M$1678 37 127 126 126 sky130_fd_pr__pfet_01v8 L=0.15U W=1U AS=0.26P AD=0.15835P
+ PS=2.52U PD=1.395U
* device instance $1679 r0 *1 59.81,10.145 sky130_fd_pr__pfet_01v8
M$1679 168 132 133 133 sky130_fd_pr__pfet_01v8 L=0.15U W=1U AS=0.26P AD=0.135P
+ PS=2.52U PD=1.27U
* device instance $1680 r0 *1 60.23,10.145 sky130_fd_pr__pfet_01v8
M$1680 164 161 168 168 sky130_fd_pr__pfet_01v8 L=0.15U W=1U AS=0.135P AD=0.135P
+ PS=1.27U PD=1.27U
* device instance $1681 r0 *1 60.65,10.145 sky130_fd_pr__pfet_01v8
M$1681 168 92 164 164 sky130_fd_pr__pfet_01v8 L=0.15U W=1U AS=0.135P AD=0.26P
+ PS=1.27U PD=2.52U
* device instance $1682 r0 *1 61.59,10.145 sky130_fd_pr__pfet_01v8
M$1682 164 134 37 37 sky130_fd_pr__pfet_01v8 L=0.15U W=1U AS=0.26P AD=0.165P
+ PS=2.52U PD=1.33U
* device instance $1683 r0 *1 62.07,10.145 sky130_fd_pr__pfet_01v8
M$1683 37 4 164 164 sky130_fd_pr__pfet_01v8 L=0.15U W=1U AS=0.165P AD=0.1575P
+ PS=1.33U PD=1.315U
* device instance $1684 r0 *1 62.535,10.145 sky130_fd_pr__pfet_01v8
M$1684 35 133 37 37 sky130_fd_pr__pfet_01v8 L=0.15U W=1U AS=0.1575P AD=0.26P
+ PS=1.315U PD=2.52U
* device instance $1685 r0 *1 64.87,6.025 sky130_fd_pr__pfet_01v8
M$1685 37 34 71 71 sky130_fd_pr__pfet_01v8 L=0.15U W=0.64U AS=0.1664P
+ AD=0.0864P PS=1.8U PD=0.91U
* device instance $1686 r0 *1 65.29,6.025 sky130_fd_pr__pfet_01v8
M$1686 72 71 37 37 sky130_fd_pr__pfet_01v8 L=0.15U W=0.64U AS=0.0864P
+ AD=0.1664P PS=0.91U PD=1.8U
* device instance $1687 r0 *1 68.175,10.24 sky130_fd_pr__pfet_01v8
M$1687 170 64 37 37 sky130_fd_pr__pfet_01v8 L=0.15U W=0.42U AS=0.15835P
+ AD=0.07665P PS=1.395U PD=0.785U
* device instance $1688 r0 *1 68.69,10.24 sky130_fd_pr__pfet_01v8
M$1688 135 20 170 170 sky130_fd_pr__pfet_01v8 L=0.15U W=0.42U AS=0.07665P
+ AD=0.1932P PS=0.785U PD=1.34U
* device instance $1689 r0 *1 69.76,10.24 sky130_fd_pr__pfet_01v8
M$1689 169 136 135 135 sky130_fd_pr__pfet_01v8 L=0.15U W=0.42U AS=0.1932P
+ AD=0.0441P PS=1.34U PD=0.63U
* device instance $1690 r0 *1 70.12,10.24 sky130_fd_pr__pfet_01v8
M$1690 37 137 169 169 sky130_fd_pr__pfet_01v8 L=0.15U W=0.42U AS=0.0441P
+ AD=0.0693P PS=0.63U PD=0.75U
* device instance $1691 r0 *1 70.6,10.24 sky130_fd_pr__pfet_01v8
M$1691 137 64 37 37 sky130_fd_pr__pfet_01v8 L=0.15U W=0.42U AS=0.0693P
+ AD=0.1176P PS=0.75U PD=1.4U
* device instance $1692 r0 *1 67.63,10.145 sky130_fd_pr__pfet_01v8
M$1692 37 135 74 74 sky130_fd_pr__pfet_01v8 L=0.15U W=1U AS=0.26P AD=0.15835P
+ PS=2.52U PD=1.395U
* device instance $1693 r0 *1 6.98,10.435 sky130_fd_pr__pfet_01v8
M$1693 111 156 37 37 sky130_fd_pr__pfet_01v8 L=0.15U W=0.42U AS=0.1113P
+ AD=0.0609P PS=1.37U PD=0.71U
* device instance $1694 r0 *1 7.42,10.435 sky130_fd_pr__pfet_01v8
M$1694 111 115 37 37 sky130_fd_pr__pfet_01v8 L=0.15U W=0.42U AS=0.1841P
+ AD=0.0609P PS=1.26U PD=0.71U
* device instance $1695 r0 *1 8.19,10.325 sky130_fd_pr__pfet_01v8
M$1695 112 111 37 37 sky130_fd_pr__pfet_01v8 L=0.15U W=0.64U AS=0.1841P
+ AD=0.1696P PS=1.26U PD=1.81U
* device instance $1696 r0 *1 8.375,11.52 sky130_fd_pr__pfet_01v8
M$1696 223 64 37 37 sky130_fd_pr__pfet_01v8 L=0.15U W=0.42U AS=0.15835P
+ AD=0.07665P PS=1.395U PD=0.785U
* device instance $1697 r0 *1 8.89,11.52 sky130_fd_pr__pfet_01v8
M$1697 178 57 223 223 sky130_fd_pr__pfet_01v8 L=0.15U W=0.42U AS=0.07665P
+ AD=0.1932P PS=0.785U PD=1.34U
* device instance $1698 r0 *1 9.96,11.52 sky130_fd_pr__pfet_01v8
M$1698 224 217 178 178 sky130_fd_pr__pfet_01v8 L=0.15U W=0.42U AS=0.1932P
+ AD=0.0441P PS=1.34U PD=0.63U
* device instance $1699 r0 *1 10.32,11.52 sky130_fd_pr__pfet_01v8
M$1699 37 233 224 224 sky130_fd_pr__pfet_01v8 L=0.15U W=0.42U AS=0.0441P
+ AD=0.0693P PS=0.63U PD=0.75U
* device instance $1700 r0 *1 10.8,11.52 sky130_fd_pr__pfet_01v8
M$1700 233 64 37 37 sky130_fd_pr__pfet_01v8 L=0.15U W=0.42U AS=0.0693P
+ AD=0.1176P PS=0.75U PD=1.4U
* device instance $1701 r0 *1 7.83,11.615 sky130_fd_pr__pfet_01v8
M$1701 37 178 32 32 sky130_fd_pr__pfet_01v8 L=0.15U W=1U AS=0.26P AD=0.15835P
+ PS=2.52U PD=1.395U
* device instance $1702 r0 *1 12.47,11.615 sky130_fd_pr__pfet_01v8
M$1702 179 218 37 37 sky130_fd_pr__pfet_01v8 L=0.15U W=1U AS=0.3P AD=0.135P
+ PS=2.6U PD=1.27U
* device instance $1703 r0 *1 12.89,11.615 sky130_fd_pr__pfet_01v8
M$1703 37 180 179 179 sky130_fd_pr__pfet_01v8 L=0.15U W=1U AS=0.135P AD=0.365P
+ PS=1.27U PD=1.73U
* device instance $1704 r0 *1 13.77,11.615 sky130_fd_pr__pfet_01v8
M$1704 225 180 37 37 sky130_fd_pr__pfet_01v8 L=0.15U W=1U AS=0.365P AD=0.105P
+ PS=1.73U PD=1.21U
* device instance $1705 r0 *1 14.13,11.615 sky130_fd_pr__pfet_01v8
M$1705 158 218 225 225 sky130_fd_pr__pfet_01v8 L=0.15U W=1U AS=0.105P AD=0.165P
+ PS=1.21U PD=1.33U
* device instance $1706 r0 *1 14.61,11.615 sky130_fd_pr__pfet_01v8
M$1706 37 179 158 158 sky130_fd_pr__pfet_01v8 L=0.15U W=1U AS=0.165P AD=0.36P
+ PS=1.33U PD=2.72U
* device instance $1707 r0 *1 15.69,11.615 sky130_fd_pr__pfet_01v8
M$1707 226 57 181 181 sky130_fd_pr__pfet_01v8 L=0.15U W=1U AS=0.26P AD=0.135P
+ PS=2.52U PD=1.27U
* device instance $1708 r0 *1 16.11,11.615 sky130_fd_pr__pfet_01v8
M$1708 37 12 226 226 sky130_fd_pr__pfet_01v8 L=0.15U W=1U AS=0.135P AD=0.135P
+ PS=1.27U PD=1.27U
* device instance $1709 r0 *1 16.53,11.615 sky130_fd_pr__pfet_01v8
M$1709 182 12 37 37 sky130_fd_pr__pfet_01v8 L=0.15U W=1U AS=0.135P AD=0.135P
+ PS=1.27U PD=1.27U
* device instance $1710 r0 *1 16.95,11.615 sky130_fd_pr__pfet_01v8
M$1710 37 57 182 182 sky130_fd_pr__pfet_01v8 L=0.15U W=1U AS=0.135P AD=0.26P
+ PS=1.27U PD=2.52U
* device instance $1711 r0 *1 17.89,11.615 sky130_fd_pr__pfet_01v8
M$1711 218 181 182 182 sky130_fd_pr__pfet_01v8 L=0.15U W=1U AS=0.26P AD=0.3P
+ PS=2.52U PD=2.6U
* device instance $1712 r0 *1 20.69,11.435 sky130_fd_pr__pfet_01v8
M$1712 228 62 185 185 sky130_fd_pr__pfet_01v8 L=0.15U W=0.64U AS=0.1664P
+ AD=0.0672P PS=1.8U PD=0.85U
* device instance $1713 r0 *1 21.05,11.435 sky130_fd_pr__pfet_01v8
M$1713 37 186 228 228 sky130_fd_pr__pfet_01v8 L=0.15U W=0.64U AS=0.0672P
+ AD=0.1664P PS=0.85U PD=1.8U
* device instance $1714 r0 *1 23.715,11.325 sky130_fd_pr__pfet_01v8
M$1714 187 184 185 185 sky130_fd_pr__pfet_01v8 L=0.15U W=0.42U AS=0.15985P
+ AD=0.06405P PS=1.265U PD=0.725U
* device instance $1715 r0 *1 24.17,11.325 sky130_fd_pr__pfet_01v8
M$1715 211 183 187 187 sky130_fd_pr__pfet_01v8 L=0.15U W=0.42U AS=0.06405P
+ AD=0.07665P PS=0.725U PD=0.785U
* device instance $1716 r0 *1 24.685,11.325 sky130_fd_pr__pfet_01v8
M$1716 37 188 211 211 sky130_fd_pr__pfet_01v8 L=0.15U W=0.42U AS=0.07665P
+ AD=0.178875P PS=0.785U PD=1.26U
* device instance $1717 r0 *1 21.99,11.435 sky130_fd_pr__pfet_01v8
M$1717 37 303 186 186 sky130_fd_pr__pfet_01v8 L=0.15U W=0.64U AS=0.1664P
+ AD=0.0928P PS=1.8U PD=0.93U
* device instance $1718 r0 *1 22.43,11.435 sky130_fd_pr__pfet_01v8
M$1718 229 303 37 37 sky130_fd_pr__pfet_01v8 L=0.15U W=0.64U AS=0.0928P
+ AD=0.1152P PS=0.93U PD=1U
* device instance $1719 r0 *1 22.94,11.435 sky130_fd_pr__pfet_01v8
M$1719 185 190 229 229 sky130_fd_pr__pfet_01v8 L=0.15U W=0.64U AS=0.1152P
+ AD=0.15985P PS=1U PD=1.265U
* device instance $1720 r0 *1 25.345,11.49 sky130_fd_pr__pfet_01v8
M$1720 188 187 37 37 sky130_fd_pr__pfet_01v8 L=0.15U W=0.75U AS=0.178875P
+ AD=0.195P PS=1.26U PD=2.02U
* device instance $1721 r0 *1 23.08,10.435 sky130_fd_pr__pfet_01v8
M$1721 114 159 37 37 sky130_fd_pr__pfet_01v8 L=0.15U W=0.42U AS=0.1113P
+ AD=0.0609P PS=1.37U PD=0.71U
* device instance $1722 r0 *1 23.52,10.435 sky130_fd_pr__pfet_01v8
M$1722 114 115 37 37 sky130_fd_pr__pfet_01v8 L=0.15U W=0.42U AS=0.1841P
+ AD=0.0609P PS=1.26U PD=0.71U
* device instance $1723 r0 *1 24.29,10.325 sky130_fd_pr__pfet_01v8
M$1723 91 114 37 37 sky130_fd_pr__pfet_01v8 L=0.15U W=0.64U AS=0.1841P
+ AD=0.1696P PS=1.26U PD=1.81U
* device instance $1724 r0 *1 26.285,11.325 sky130_fd_pr__pfet_01v8
M$1724 212 188 37 37 sky130_fd_pr__pfet_01v8 L=0.15U W=0.42U AS=0.1092P
+ AD=0.06405P PS=1.36U PD=0.725U
* device instance $1725 r0 *1 26.74,11.325 sky130_fd_pr__pfet_01v8
M$1725 189 183 212 212 sky130_fd_pr__pfet_01v8 L=0.15U W=0.42U AS=0.06405P
+ AD=0.0567P PS=0.725U PD=0.69U
* device instance $1726 r0 *1 27.16,11.325 sky130_fd_pr__pfet_01v8
M$1726 213 184 189 189 sky130_fd_pr__pfet_01v8 L=0.15U W=0.42U AS=0.0567P
+ AD=0.0882P PS=0.69U PD=0.84U
* device instance $1727 r0 *1 27.73,11.325 sky130_fd_pr__pfet_01v8
M$1727 37 190 213 213 sky130_fd_pr__pfet_01v8 L=0.15U W=0.42U AS=0.0882P
+ AD=0.1113P PS=0.84U PD=1.37U
* device instance $1728 r0 *1 28.785,11.435 sky130_fd_pr__pfet_01v8
M$1728 37 189 190 190 sky130_fd_pr__pfet_01v8 L=0.15U W=0.64U AS=0.1728P
+ AD=0.154P PS=1.82U PD=1.335U
* device instance $1729 r0 *1 29.27,11.615 sky130_fd_pr__pfet_01v8
M$1729 191 189 37 37 sky130_fd_pr__pfet_01v8 L=0.15U W=1U AS=0.154P AD=0.28P
+ PS=1.335U PD=2.56U
* device instance $1730 r0 *1 30.85,11.615 sky130_fd_pr__pfet_01v8
M$1730 65 1 37 37 sky130_fd_pr__pfet_01v8 L=0.15U W=1U AS=0.26P AD=0.135P
+ PS=2.52U PD=1.27U
* device instance $1731 r0 *1 31.27,11.615 sky130_fd_pr__pfet_01v8
M$1731 37 64 65 65 sky130_fd_pr__pfet_01v8 L=0.15U W=1U AS=0.135P AD=0.26P
+ PS=1.27U PD=2.52U
* device instance $1732 r0 *1 32.21,11.535 sky130_fd_pr__pfet_01v8
M$1732 63 191 37 37 sky130_fd_pr__pfet_01v8 L=0.15U W=1.68U AS=0.3318P
+ AD=0.3486P PS=3.31U PD=3.35U
* device instance $1734 r0 *1 32.265,10.435 sky130_fd_pr__pfet_01v8
M$1734 176 122 37 37 sky130_fd_pr__pfet_01v8 L=0.15U W=0.42U AS=0.1092P
+ AD=0.06405P PS=1.36U PD=0.725U
* device instance $1735 r0 *1 32.72,10.435 sky130_fd_pr__pfet_01v8
M$1735 123 116 176 176 sky130_fd_pr__pfet_01v8 L=0.15U W=0.42U AS=0.06405P
+ AD=0.0567P PS=0.725U PD=0.69U
* device instance $1736 r0 *1 33.14,10.435 sky130_fd_pr__pfet_01v8
M$1736 175 117 123 123 sky130_fd_pr__pfet_01v8 L=0.15U W=0.42U AS=0.0567P
+ AD=0.0882P PS=0.69U PD=0.84U
* device instance $1737 r0 *1 33.71,10.435 sky130_fd_pr__pfet_01v8
M$1737 37 120 175 175 sky130_fd_pr__pfet_01v8 L=0.15U W=0.42U AS=0.0882P
+ AD=0.1113P PS=0.84U PD=1.37U
* device instance $1738 r0 *1 33.605,11.615 sky130_fd_pr__pfet_01v8
M$1738 192 219 37 37 sky130_fd_pr__pfet_01v8 L=0.15U W=2U AS=0.44P AD=0.3P
+ PS=3.88U PD=2.6U
* device instance $1739 r0 *1 34.035,11.615 sky130_fd_pr__pfet_01v8
M$1739 67 63 192 192 sky130_fd_pr__pfet_01v8 L=0.15U W=2U AS=0.28P AD=0.315P
+ PS=2.56U PD=2.63U
* device instance $1742 r0 *1 35.435,11.615 sky130_fd_pr__pfet_01v8
M$1742 67 260 37 37 sky130_fd_pr__pfet_01v8 L=0.15U W=2U AS=0.3P AD=0.405P
+ PS=2.6U PD=3.81U
* device instance $1744 r0 *1 37.34,10.435 sky130_fd_pr__pfet_01v8
M$1744 124 163 37 37 sky130_fd_pr__pfet_01v8 L=0.15U W=0.42U AS=0.1113P
+ AD=0.0609P PS=1.37U PD=0.71U
* device instance $1745 r0 *1 37.78,10.435 sky130_fd_pr__pfet_01v8
M$1745 124 115 37 37 sky130_fd_pr__pfet_01v8 L=0.15U W=0.42U AS=0.1841P
+ AD=0.0609P PS=1.26U PD=0.71U
* device instance $1746 r0 *1 38.55,10.325 sky130_fd_pr__pfet_01v8
M$1746 166 124 37 37 sky130_fd_pr__pfet_01v8 L=0.15U W=0.64U AS=0.1841P
+ AD=0.1696P PS=1.26U PD=1.81U
* device instance $1747 r0 *1 40.95,11.615 sky130_fd_pr__pfet_01v8
M$1747 194 167 193 193 sky130_fd_pr__pfet_01v8 L=0.15U W=1U AS=0.26P AD=0.135P
+ PS=2.52U PD=1.27U
* device instance $1748 r0 *1 41.37,11.615 sky130_fd_pr__pfet_01v8
M$1748 196 195 194 194 sky130_fd_pr__pfet_01v8 L=0.15U W=1U AS=0.135P AD=0.135P
+ PS=1.27U PD=1.27U
* device instance $1749 r0 *1 41.79,11.615 sky130_fd_pr__pfet_01v8
M$1749 194 92 196 196 sky130_fd_pr__pfet_01v8 L=0.15U W=1U AS=0.135P AD=0.26P
+ PS=1.27U PD=2.52U
* device instance $1750 r0 *1 42.73,11.615 sky130_fd_pr__pfet_01v8
M$1750 196 134 37 37 sky130_fd_pr__pfet_01v8 L=0.15U W=1U AS=0.26P AD=0.165P
+ PS=2.52U PD=1.33U
* device instance $1751 r0 *1 43.21,11.615 sky130_fd_pr__pfet_01v8
M$1751 37 70 196 196 sky130_fd_pr__pfet_01v8 L=0.15U W=1U AS=0.165P AD=0.1575P
+ PS=1.33U PD=1.315U
* device instance $1752 r0 *1 43.675,11.615 sky130_fd_pr__pfet_01v8
M$1752 197 193 37 37 sky130_fd_pr__pfet_01v8 L=0.15U W=1U AS=0.1575P AD=0.26P
+ PS=1.315U PD=2.52U
* device instance $1753 r0 *1 44.7,10.435 sky130_fd_pr__pfet_01v8
M$1753 125 160 37 37 sky130_fd_pr__pfet_01v8 L=0.15U W=0.42U AS=0.1113P
+ AD=0.0609P PS=1.37U PD=0.71U
* device instance $1754 r0 *1 45.14,10.435 sky130_fd_pr__pfet_01v8
M$1754 125 115 37 37 sky130_fd_pr__pfet_01v8 L=0.15U W=0.42U AS=0.1841P
+ AD=0.0609P PS=1.26U PD=0.71U
* device instance $1755 r0 *1 45.91,10.325 sky130_fd_pr__pfet_01v8
M$1755 167 125 37 37 sky130_fd_pr__pfet_01v8 L=0.15U W=0.64U AS=0.1841P
+ AD=0.1696P PS=1.26U PD=1.81U
* device instance $1756 r0 *1 48.29,11.435 sky130_fd_pr__pfet_01v8
M$1756 232 126 200 200 sky130_fd_pr__pfet_01v8 L=0.15U W=0.64U AS=0.1664P
+ AD=0.0672P PS=1.8U PD=0.85U
* device instance $1757 r0 *1 48.65,11.435 sky130_fd_pr__pfet_01v8
M$1757 37 201 232 232 sky130_fd_pr__pfet_01v8 L=0.15U W=0.64U AS=0.0672P
+ AD=0.1664P PS=0.85U PD=1.8U
* device instance $1758 r0 *1 51.315,11.325 sky130_fd_pr__pfet_01v8
M$1758 202 199 200 200 sky130_fd_pr__pfet_01v8 L=0.15U W=0.42U AS=0.15985P
+ AD=0.06405P PS=1.265U PD=0.725U
* device instance $1759 r0 *1 51.77,11.325 sky130_fd_pr__pfet_01v8
M$1759 216 198 202 202 sky130_fd_pr__pfet_01v8 L=0.15U W=0.42U AS=0.06405P
+ AD=0.07665P PS=0.725U PD=0.785U
* device instance $1760 r0 *1 52.285,11.325 sky130_fd_pr__pfet_01v8
M$1760 37 203 216 216 sky130_fd_pr__pfet_01v8 L=0.15U W=0.42U AS=0.07665P
+ AD=0.178875P PS=0.785U PD=1.26U
* device instance $1761 r0 *1 49.59,11.435 sky130_fd_pr__pfet_01v8
M$1761 37 94 201 201 sky130_fd_pr__pfet_01v8 L=0.15U W=0.64U AS=0.1664P
+ AD=0.0928P PS=1.8U PD=0.93U
* device instance $1762 r0 *1 50.03,11.435 sky130_fd_pr__pfet_01v8
M$1762 231 94 37 37 sky130_fd_pr__pfet_01v8 L=0.15U W=0.64U AS=0.0928P
+ AD=0.1152P PS=0.93U PD=1U
* device instance $1763 r0 *1 50.54,11.435 sky130_fd_pr__pfet_01v8
M$1763 200 205 231 231 sky130_fd_pr__pfet_01v8 L=0.15U W=0.64U AS=0.1152P
+ AD=0.15985P PS=1U PD=1.265U
* device instance $1764 r0 *1 52.945,11.49 sky130_fd_pr__pfet_01v8
M$1764 203 202 37 37 sky130_fd_pr__pfet_01v8 L=0.15U W=0.75U AS=0.178875P
+ AD=0.195P PS=1.26U PD=2.02U
* device instance $1765 r0 *1 53.885,11.325 sky130_fd_pr__pfet_01v8
M$1765 215 203 37 37 sky130_fd_pr__pfet_01v8 L=0.15U W=0.42U AS=0.1092P
+ AD=0.06405P PS=1.36U PD=0.725U
* device instance $1766 r0 *1 54.34,11.325 sky130_fd_pr__pfet_01v8
M$1766 204 198 215 215 sky130_fd_pr__pfet_01v8 L=0.15U W=0.42U AS=0.06405P
+ AD=0.0567P PS=0.725U PD=0.69U
* device instance $1767 r0 *1 54.76,11.325 sky130_fd_pr__pfet_01v8
M$1767 214 199 204 204 sky130_fd_pr__pfet_01v8 L=0.15U W=0.42U AS=0.0567P
+ AD=0.0882P PS=0.69U PD=0.84U
* device instance $1768 r0 *1 55.33,11.325 sky130_fd_pr__pfet_01v8
M$1768 37 205 214 214 sky130_fd_pr__pfet_01v8 L=0.15U W=0.42U AS=0.0882P
+ AD=0.1113P PS=0.84U PD=1.37U
* device instance $1769 r0 *1 56.385,11.435 sky130_fd_pr__pfet_01v8
M$1769 37 204 205 205 sky130_fd_pr__pfet_01v8 L=0.15U W=0.64U AS=0.1728P
+ AD=0.154P PS=1.82U PD=1.335U
* device instance $1770 r0 *1 56.87,11.615 sky130_fd_pr__pfet_01v8
M$1770 195 204 37 37 sky130_fd_pr__pfet_01v8 L=0.15U W=1U AS=0.154P AD=0.28P
+ PS=1.335U PD=2.56U
* device instance $1771 r0 *1 57.58,10.435 sky130_fd_pr__pfet_01v8
M$1771 131 3 37 37 sky130_fd_pr__pfet_01v8 L=0.15U W=0.42U AS=0.1113P
+ AD=0.0609P PS=1.37U PD=0.71U
* device instance $1772 r0 *1 58.02,10.435 sky130_fd_pr__pfet_01v8
M$1772 131 115 37 37 sky130_fd_pr__pfet_01v8 L=0.15U W=0.42U AS=0.1841P
+ AD=0.0609P PS=1.26U PD=0.71U
* device instance $1773 r0 *1 58.79,10.325 sky130_fd_pr__pfet_01v8
M$1773 132 131 37 37 sky130_fd_pr__pfet_01v8 L=0.15U W=0.64U AS=0.1841P
+ AD=0.1696P PS=1.26U PD=1.81U
* device instance $1774 r0 *1 61.69,11.615 sky130_fd_pr__pfet_01v8
M$1774 230 220 206 206 sky130_fd_pr__pfet_01v8 L=0.15U W=1U AS=0.26P AD=0.135P
+ PS=2.52U PD=1.27U
* device instance $1775 r0 *1 62.11,11.615 sky130_fd_pr__pfet_01v8
M$1775 37 221 230 230 sky130_fd_pr__pfet_01v8 L=0.15U W=1U AS=0.135P AD=0.135P
+ PS=1.27U PD=1.27U
* device instance $1776 r0 *1 62.53,11.615 sky130_fd_pr__pfet_01v8
M$1776 207 221 37 37 sky130_fd_pr__pfet_01v8 L=0.15U W=1U AS=0.135P AD=0.135P
+ PS=1.27U PD=1.27U
* device instance $1777 r0 *1 62.95,11.615 sky130_fd_pr__pfet_01v8
M$1777 37 220 207 207 sky130_fd_pr__pfet_01v8 L=0.15U W=1U AS=0.135P AD=0.26P
+ PS=1.27U PD=2.52U
* device instance $1778 r0 *1 63.89,11.615 sky130_fd_pr__pfet_01v8
M$1778 4 206 207 207 sky130_fd_pr__pfet_01v8 L=0.15U W=1U AS=0.26P AD=0.3P
+ PS=2.52U PD=2.6U
* device instance $1779 r0 *1 66.29,11.615 sky130_fd_pr__pfet_01v8
M$1779 227 20 208 208 sky130_fd_pr__pfet_01v8 L=0.15U W=1U AS=0.26P AD=0.135P
+ PS=2.52U PD=1.27U
* device instance $1780 r0 *1 66.71,11.615 sky130_fd_pr__pfet_01v8
M$1780 37 161 227 227 sky130_fd_pr__pfet_01v8 L=0.15U W=1U AS=0.135P AD=0.135P
+ PS=1.27U PD=1.27U
* device instance $1781 r0 *1 67.13,11.615 sky130_fd_pr__pfet_01v8
M$1781 209 161 37 37 sky130_fd_pr__pfet_01v8 L=0.15U W=1U AS=0.135P AD=0.135P
+ PS=1.27U PD=1.27U
* device instance $1782 r0 *1 67.55,11.615 sky130_fd_pr__pfet_01v8
M$1782 37 20 209 209 sky130_fd_pr__pfet_01v8 L=0.15U W=1U AS=0.135P AD=0.26P
+ PS=1.27U PD=2.52U
* device instance $1783 r0 *1 68.49,11.615 sky130_fd_pr__pfet_01v8
M$1783 221 208 209 209 sky130_fd_pr__pfet_01v8 L=0.15U W=1U AS=0.26P AD=0.3P
+ PS=2.52U PD=2.6U
* device instance $1784 r0 *1 69.47,11.905 sky130_fd_pr__pfet_01v8
M$1784 222 161 37 37 sky130_fd_pr__pfet_01v8 L=0.15U W=0.42U AS=0.14575P
+ AD=0.1092P PS=1.335U PD=1.36U
* device instance $1785 r0 *1 69.955,11.615 sky130_fd_pr__pfet_01v8
M$1785 210 20 37 37 sky130_fd_pr__pfet_01v8 L=0.15U W=1U AS=0.14575P AD=0.135P
+ PS=1.335U PD=1.27U
* device instance $1786 r0 *1 70.375,11.615 sky130_fd_pr__pfet_01v8
M$1786 37 222 210 210 sky130_fd_pr__pfet_01v8 L=0.15U W=1U AS=0.135P AD=0.265P
+ PS=1.27U PD=2.53U
* device instance $1787 r0 *1 12.67,15.295 sky130_fd_pr__pfet_01v8
M$1787 37 57 256 256 sky130_fd_pr__pfet_01v8 L=0.15U W=0.42U AS=0.1092P
+ AD=0.1573P PS=1.36U PD=1.39U
* device instance $1788 r0 *1 13.21,15.585 sky130_fd_pr__pfet_01v8
M$1788 286 12 37 37 sky130_fd_pr__pfet_01v8 L=0.15U W=1U AS=0.1573P AD=0.105P
+ PS=1.39U PD=1.21U
* device instance $1789 r0 *1 13.57,15.585 sky130_fd_pr__pfet_01v8
M$1789 283 256 286 286 sky130_fd_pr__pfet_01v8 L=0.15U W=1U AS=0.105P AD=0.26P
+ PS=1.21U PD=2.52U
* device instance $1790 r0 *1 13.82,17.055 sky130_fd_pr__pfet_01v8
M$1790 37 295 294 294 sky130_fd_pr__pfet_01v8 L=0.15U W=1U AS=0.26P AD=0.26P
+ PS=2.52U PD=2.52U
* device instance $1791 r0 *1 14.73,15.665 sky130_fd_pr__pfet_01v8
M$1791 257 218 37 37 sky130_fd_pr__pfet_01v8 L=0.15U W=1.68U AS=0.3318P
+ AD=0.3486P PS=3.31U PD=3.35U
* device instance $1793 r0 *1 14.76,17.055 sky130_fd_pr__pfet_01v8
M$1793 296 283 295 295 sky130_fd_pr__pfet_01v8 L=0.15U W=1U AS=0.26P AD=0.1375P
+ PS=2.52U PD=1.275U
* device instance $1794 r0 *1 15.185,17.055 sky130_fd_pr__pfet_01v8
M$1794 37 180 296 296 sky130_fd_pr__pfet_01v8 L=0.15U W=1U AS=0.1375P AD=0.14P
+ PS=1.275U PD=1.28U
* device instance $1795 r0 *1 15.615,17.055 sky130_fd_pr__pfet_01v8
M$1795 296 257 37 37 sky130_fd_pr__pfet_01v8 L=0.15U W=1U AS=0.14P AD=0.265P
+ PS=1.28U PD=2.53U
* device instance $1796 r0 *1 19.33,11.465 sky130_fd_pr__pfet_01v8
M$1796 37 31 183 183 sky130_fd_pr__pfet_01v8 L=0.15U W=0.64U AS=0.1664P
+ AD=0.0864P PS=1.8U PD=0.91U
* device instance $1797 r0 *1 19.75,11.465 sky130_fd_pr__pfet_01v8
M$1797 184 183 37 37 sky130_fd_pr__pfet_01v8 L=0.15U W=0.64U AS=0.0864P
+ AD=0.1664P PS=0.91U PD=1.8U
* device instance $1798 r0 *1 28.57,15.585 sky130_fd_pr__pfet_01v8
M$1798 258 191 37 37 sky130_fd_pr__pfet_01v8 L=0.15U W=1U AS=0.3P AD=0.135P
+ PS=2.6U PD=1.27U
* device instance $1799 r0 *1 28.99,15.585 sky130_fd_pr__pfet_01v8
M$1799 37 219 258 258 sky130_fd_pr__pfet_01v8 L=0.15U W=1U AS=0.135P AD=0.365P
+ PS=1.27U PD=1.73U
* device instance $1800 r0 *1 29.87,15.585 sky130_fd_pr__pfet_01v8
M$1800 287 219 37 37 sky130_fd_pr__pfet_01v8 L=0.15U W=1U AS=0.365P AD=0.105P
+ PS=1.73U PD=1.21U
* device instance $1801 r0 *1 30.23,15.585 sky130_fd_pr__pfet_01v8
M$1801 263 191 287 287 sky130_fd_pr__pfet_01v8 L=0.15U W=1U AS=0.105P AD=0.165P
+ PS=1.21U PD=1.33U
* device instance $1802 r0 *1 30.71,15.585 sky130_fd_pr__pfet_01v8
M$1802 37 258 263 263 sky130_fd_pr__pfet_01v8 L=0.15U W=1U AS=0.165P AD=0.36P
+ PS=1.33U PD=2.72U
* device instance $1803 r0 *1 31.99,15.295 sky130_fd_pr__pfet_01v8
M$1803 37 260 262 262 sky130_fd_pr__pfet_01v8 L=0.15U W=0.42U AS=0.1092P
+ AD=0.1573P PS=1.36U PD=1.39U
* device instance $1804 r0 *1 32.53,15.585 sky130_fd_pr__pfet_01v8
M$1804 288 261 37 37 sky130_fd_pr__pfet_01v8 L=0.15U W=1U AS=0.1573P AD=0.105P
+ PS=1.39U PD=1.21U
* device instance $1805 r0 *1 32.89,15.585 sky130_fd_pr__pfet_01v8
M$1805 93 262 288 288 sky130_fd_pr__pfet_01v8 L=0.15U W=1U AS=0.105P AD=0.26P
+ PS=1.21U PD=2.52U
* device instance $1806 r0 *1 34.05,15.585 sky130_fd_pr__pfet_01v8
M$1806 260 263 37 37 sky130_fd_pr__pfet_01v8 L=0.15U W=2U AS=0.395P AD=0.27P
+ PS=3.79U PD=2.54U
* device instance $1808 r0 *1 34.89,15.585 sky130_fd_pr__pfet_01v8
M$1808 260 265 37 37 sky130_fd_pr__pfet_01v8 L=0.15U W=2U AS=0.27P AD=0.395P
+ PS=2.54U PD=3.79U
* device instance $1810 r0 *1 34.07,17.055 sky130_fd_pr__pfet_01v8
M$1810 297 263 261 261 sky130_fd_pr__pfet_01v8 L=0.15U W=1U AS=0.265P AD=0.14P
+ PS=2.53U PD=1.28U
* device instance $1811 r0 *1 34.5,17.055 sky130_fd_pr__pfet_01v8
M$1811 37 265 297 297 sky130_fd_pr__pfet_01v8 L=0.15U W=1U AS=0.14P AD=0.1475P
+ PS=1.28U PD=1.295U
* device instance $1812 r0 *1 34.945,17.055 sky130_fd_pr__pfet_01v8
M$1812 297 267 37 37 sky130_fd_pr__pfet_01v8 L=0.15U W=1U AS=0.1475P AD=0.265P
+ PS=1.295U PD=2.53U
* device instance $1813 r0 *1 35.89,17.055 sky130_fd_pr__pfet_01v8
M$1813 312 63 272 272 sky130_fd_pr__pfet_01v8 L=0.15U W=1U AS=0.26P AD=0.105P
+ PS=2.52U PD=1.21U
* device instance $1814 r0 *1 36.25,17.055 sky130_fd_pr__pfet_01v8
M$1814 37 219 312 312 sky130_fd_pr__pfet_01v8 L=0.15U W=1U AS=0.105P AD=0.26P
+ PS=1.21U PD=2.52U
* device instance $1815 r0 *1 36.25,15.585 sky130_fd_pr__pfet_01v8
M$1815 260 267 37 37 sky130_fd_pr__pfet_01v8 L=0.15U W=2U AS=0.395P AD=0.445P
+ PS=3.79U PD=3.89U
* device instance $1817 r0 *1 37.73,15.585 sky130_fd_pr__pfet_01v8
M$1817 284 265 37 37 sky130_fd_pr__pfet_01v8 L=0.15U W=2U AS=0.395P AD=0.27P
+ PS=3.79U PD=2.54U
* device instance $1819 r0 *1 38.57,15.585 sky130_fd_pr__pfet_01v8
M$1819 284 269 37 37 sky130_fd_pr__pfet_01v8 L=0.15U W=2U AS=0.275P AD=0.285P
+ PS=2.55U PD=2.57U
* device instance $1821 r0 *1 39.44,15.585 sky130_fd_pr__pfet_01v8
M$1821 284 263 37 37 sky130_fd_pr__pfet_01v8 L=0.15U W=2U AS=0.28P AD=0.395P
+ PS=2.56U PD=3.79U
* device instance $1823 r0 *1 40.8,15.585 sky130_fd_pr__pfet_01v8
M$1823 284 272 285 285 sky130_fd_pr__pfet_01v8 L=0.15U W=2U AS=0.395P AD=0.395P
+ PS=3.79U PD=2.79U
* device instance $1825 r0 *1 41.89,15.585 sky130_fd_pr__pfet_01v8
M$1825 271 273 285 285 sky130_fd_pr__pfet_01v8 L=0.15U W=2U AS=0.395P AD=0.395P
+ PS=2.79U PD=3.79U
* device instance $1827 r0 *1 45.33,15.295 sky130_fd_pr__pfet_01v8
M$1827 37 128 274 274 sky130_fd_pr__pfet_01v8 L=0.15U W=0.42U AS=0.1092P
+ AD=0.1573P PS=1.36U PD=1.39U
* device instance $1828 r0 *1 45.87,15.585 sky130_fd_pr__pfet_01v8
M$1828 291 195 37 37 sky130_fd_pr__pfet_01v8 L=0.15U W=1U AS=0.1573P AD=0.105P
+ PS=1.39U PD=1.21U
* device instance $1829 r0 *1 46.23,15.585 sky130_fd_pr__pfet_01v8
M$1829 273 274 291 291 sky130_fd_pr__pfet_01v8 L=0.15U W=1U AS=0.105P AD=0.26P
+ PS=1.21U PD=2.52U
* device instance $1830 r0 *1 45.53,16.875 sky130_fd_pr__pfet_01v8
M$1830 313 197 301 301 sky130_fd_pr__pfet_01v8 L=0.15U W=0.64U AS=0.1664P
+ AD=0.0672P PS=1.8U PD=0.85U
* device instance $1831 r0 *1 45.89,16.875 sky130_fd_pr__pfet_01v8
M$1831 37 302 313 313 sky130_fd_pr__pfet_01v8 L=0.15U W=0.64U AS=0.0672P
+ AD=0.1664P PS=0.85U PD=1.8U
* device instance $1832 r0 *1 48.555,16.765 sky130_fd_pr__pfet_01v8
M$1832 304 300 301 301 sky130_fd_pr__pfet_01v8 L=0.15U W=0.42U AS=0.15985P
+ AD=0.06405P PS=1.265U PD=0.725U
* device instance $1833 r0 *1 49.01,16.765 sky130_fd_pr__pfet_01v8
M$1833 315 299 304 304 sky130_fd_pr__pfet_01v8 L=0.15U W=0.42U AS=0.06405P
+ AD=0.07665P PS=0.725U PD=0.785U
* device instance $1834 r0 *1 49.525,16.765 sky130_fd_pr__pfet_01v8
M$1834 37 305 315 315 sky130_fd_pr__pfet_01v8 L=0.15U W=0.42U AS=0.07665P
+ AD=0.178875P PS=0.785U PD=1.26U
* device instance $1835 r0 *1 46.83,16.875 sky130_fd_pr__pfet_01v8
M$1835 37 303 302 302 sky130_fd_pr__pfet_01v8 L=0.15U W=0.64U AS=0.1664P
+ AD=0.0928P PS=1.8U PD=0.93U
* device instance $1836 r0 *1 47.27,16.875 sky130_fd_pr__pfet_01v8
M$1836 314 303 37 37 sky130_fd_pr__pfet_01v8 L=0.15U W=0.64U AS=0.0928P
+ AD=0.1152P PS=0.93U PD=1U
* device instance $1837 r0 *1 47.78,16.875 sky130_fd_pr__pfet_01v8
M$1837 301 307 314 314 sky130_fd_pr__pfet_01v8 L=0.15U W=0.64U AS=0.1152P
+ AD=0.15985P PS=1U PD=1.265U
* device instance $1838 r0 *1 50.185,16.93 sky130_fd_pr__pfet_01v8
M$1838 305 304 37 37 sky130_fd_pr__pfet_01v8 L=0.15U W=0.75U AS=0.178875P
+ AD=0.195P PS=1.26U PD=2.02U
* device instance $1839 r0 *1 46.93,11.465 sky130_fd_pr__pfet_01v8
M$1839 37 34 198 198 sky130_fd_pr__pfet_01v8 L=0.15U W=0.64U AS=0.1664P
+ AD=0.0864P PS=1.8U PD=0.91U
* device instance $1840 r0 *1 47.35,11.465 sky130_fd_pr__pfet_01v8
M$1840 199 198 37 37 sky130_fd_pr__pfet_01v8 L=0.15U W=0.64U AS=0.0864P
+ AD=0.1664P PS=0.91U PD=1.8U
* device instance $1841 r0 *1 47.39,15.585 sky130_fd_pr__pfet_01v8
M$1841 292 275 68 68 sky130_fd_pr__pfet_01v8 L=0.15U W=1U AS=0.26P AD=0.105P
+ PS=2.52U PD=1.21U
* device instance $1842 r0 *1 47.75,15.585 sky130_fd_pr__pfet_01v8
M$1842 37 273 292 292 sky130_fd_pr__pfet_01v8 L=0.15U W=1U AS=0.105P AD=0.26P
+ PS=1.21U PD=2.52U
* device instance $1843 r0 *1 50.39,15.295 sky130_fd_pr__pfet_01v8
M$1843 37 195 276 276 sky130_fd_pr__pfet_01v8 L=0.15U W=0.42U AS=0.1092P
+ AD=0.1573P PS=1.36U PD=1.39U
* device instance $1844 r0 *1 50.93,15.585 sky130_fd_pr__pfet_01v8
M$1844 293 128 37 37 sky130_fd_pr__pfet_01v8 L=0.15U W=1U AS=0.1573P AD=0.105P
+ PS=1.39U PD=1.21U
* device instance $1845 r0 *1 51.29,15.585 sky130_fd_pr__pfet_01v8
M$1845 275 276 293 293 sky130_fd_pr__pfet_01v8 L=0.15U W=1U AS=0.105P AD=0.26P
+ PS=1.21U PD=2.52U
* device instance $1846 r0 *1 51.125,16.765 sky130_fd_pr__pfet_01v8
M$1846 316 305 37 37 sky130_fd_pr__pfet_01v8 L=0.15U W=0.42U AS=0.1092P
+ AD=0.06405P PS=1.36U PD=0.725U
* device instance $1847 r0 *1 51.58,16.765 sky130_fd_pr__pfet_01v8
M$1847 306 299 316 316 sky130_fd_pr__pfet_01v8 L=0.15U W=0.42U AS=0.06405P
+ AD=0.0567P PS=0.725U PD=0.69U
* device instance $1848 r0 *1 52,16.765 sky130_fd_pr__pfet_01v8
M$1848 317 300 306 306 sky130_fd_pr__pfet_01v8 L=0.15U W=0.42U AS=0.0567P
+ AD=0.0882P PS=0.69U PD=0.84U
* device instance $1849 r0 *1 52.57,16.765 sky130_fd_pr__pfet_01v8
M$1849 37 307 317 317 sky130_fd_pr__pfet_01v8 L=0.15U W=0.42U AS=0.0882P
+ AD=0.1113P PS=0.84U PD=1.37U
* device instance $1850 r0 *1 53.625,16.875 sky130_fd_pr__pfet_01v8
M$1850 37 306 307 307 sky130_fd_pr__pfet_01v8 L=0.15U W=0.64U AS=0.1728P
+ AD=0.154P PS=1.82U PD=1.335U
* device instance $1851 r0 *1 54.11,17.055 sky130_fd_pr__pfet_01v8
M$1851 128 306 37 37 sky130_fd_pr__pfet_01v8 L=0.15U W=1U AS=0.154P AD=0.28P
+ PS=1.335U PD=2.56U
* device instance $1852 r0 *1 57.715,15.295 sky130_fd_pr__pfet_01v8
M$1852 290 275 277 277 sky130_fd_pr__pfet_01v8 L=0.15U W=0.42U AS=0.1092P
+ AD=0.0441P PS=1.36U PD=0.63U
* device instance $1853 r0 *1 58.075,15.295 sky130_fd_pr__pfet_01v8
M$1853 37 271 290 290 sky130_fd_pr__pfet_01v8 L=0.15U W=0.42U AS=0.0441P
+ AD=0.14575P PS=0.63U PD=1.335U
* device instance $1854 r0 *1 58.56,15.585 sky130_fd_pr__pfet_01v8
M$1854 278 277 37 37 sky130_fd_pr__pfet_01v8 L=0.15U W=1U AS=0.14575P AD=0.34P
+ PS=1.335U PD=2.68U
* device instance $1855 r0 *1 59.93,17.055 sky130_fd_pr__pfet_01v8
M$1855 37 221 309 309 sky130_fd_pr__pfet_01v8 L=0.15U W=2U AS=0.395P AD=0.27P
+ PS=3.79U PD=2.54U
* device instance $1857 r0 *1 60.77,17.055 sky130_fd_pr__pfet_01v8
M$1857 310 271 309 309 sky130_fd_pr__pfet_01v8 L=0.15U W=2U AS=0.27P AD=0.395P
+ PS=2.54U PD=3.79U
* device instance $1859 r0 *1 62.13,17.055 sky130_fd_pr__pfet_01v8
M$1859 310 275 308 308 sky130_fd_pr__pfet_01v8 L=0.15U W=2U AS=0.395P AD=0.27P
+ PS=3.79U PD=2.54U
* device instance $1861 r0 *1 62.97,17.055 sky130_fd_pr__pfet_01v8
M$1861 37 210 308 308 sky130_fd_pr__pfet_01v8 L=0.15U W=2U AS=0.44P AD=0.51P
+ PS=2.88U PD=3.02U
* device instance $1863 r0 *1 64.29,17.055 sky130_fd_pr__pfet_01v8
M$1863 37 311 308 308 sky130_fd_pr__pfet_01v8 L=0.15U W=2U AS=0.34P AD=0.395P
+ PS=2.68U PD=3.79U
* device instance $1865 r0 *1 63.545,15.765 sky130_fd_pr__pfet_01v8
M$1865 289 221 37 37 sky130_fd_pr__pfet_01v8 L=0.15U W=0.64U AS=0.1696P
+ AD=0.0768P PS=1.81U PD=0.88U
* device instance $1866 r0 *1 63.935,15.765 sky130_fd_pr__pfet_01v8
M$1866 280 278 289 289 sky130_fd_pr__pfet_01v8 L=0.15U W=0.64U AS=0.0768P
+ AD=0.0896P PS=0.88U PD=0.92U
* device instance $1867 r0 *1 64.365,15.765 sky130_fd_pr__pfet_01v8
M$1867 37 210 280 280 sky130_fd_pr__pfet_01v8 L=0.15U W=0.64U AS=0.0896P
+ AD=0.1824P PS=0.92U PD=1.85U
* device instance $1868 r0 *1 65.33,15.585 sky130_fd_pr__pfet_01v8
M$1868 37 278 281 281 sky130_fd_pr__pfet_01v8 L=0.15U W=1U AS=0.26P AD=0.135P
+ PS=2.52U PD=1.27U
* device instance $1869 r0 *1 65.75,15.585 sky130_fd_pr__pfet_01v8
M$1869 220 281 37 37 sky130_fd_pr__pfet_01v8 L=0.15U W=4U AS=0.54P AD=0.665P
+ PS=5.08U PD=6.33U
* device instance $1873 r0 *1 17.03,21.025 sky130_fd_pr__pfet_01v8
M$1873 37 341 327 327 sky130_fd_pr__pfet_01v8 L=0.15U W=1U AS=0.26P AD=0.135P
+ PS=2.52U PD=1.27U
* device instance $1874 r0 *1 17.45,21.025 sky130_fd_pr__pfet_01v8
M$1874 180 327 37 37 sky130_fd_pr__pfet_01v8 L=0.15U W=4U AS=0.54P AD=0.665P
+ PS=5.08U PD=6.33U
* device instance $1878 r0 *1 19.79,21.025 sky130_fd_pr__pfet_01v8
M$1878 37 341 345 345 sky130_fd_pr__pfet_01v8 L=0.15U W=4U AS=0.665P AD=0.54P
+ PS=6.33U PD=5.08U
* device instance $1881 r0 *1 21.05,21.025 sky130_fd_pr__pfet_01v8
M$1881 345 257 37 37 sky130_fd_pr__pfet_01v8 L=0.15U W=4U AS=0.54P AD=0.54P
+ PS=5.08U PD=5.08U
* device instance $1886 r0 *1 23.15,21.025 sky130_fd_pr__pfet_01v8
M$1886 346 330 345 345 sky130_fd_pr__pfet_01v8 L=0.15U W=2U AS=0.27P AD=0.27P
+ PS=2.54U PD=2.54U
* device instance $1888 r0 *1 23.99,21.025 sky130_fd_pr__pfet_01v8
M$1888 349 330 345 345 sky130_fd_pr__pfet_01v8 L=0.15U W=1U AS=0.135P AD=0.15P
+ PS=1.27U PD=1.3U
* device instance $1889 r0 *1 24.44,21.025 sky130_fd_pr__pfet_01v8
M$1889 329 283 349 349 sky130_fd_pr__pfet_01v8 L=0.15U W=1U AS=0.15P AD=0.14P
+ PS=1.3U PD=1.28U
* device instance $1890 r0 *1 24.87,21.025 sky130_fd_pr__pfet_01v8
M$1890 346 283 329 329 sky130_fd_pr__pfet_01v8 L=0.15U W=2U AS=0.28P AD=0.29P
+ PS=2.56U PD=2.58U
* device instance $1892 r0 *1 25.75,21.025 sky130_fd_pr__pfet_01v8
M$1892 350 283 329 329 sky130_fd_pr__pfet_01v8 L=0.15U W=1U AS=0.15P AD=0.155P
+ PS=1.3U PD=1.31U
* device instance $1893 r0 *1 26.21,21.025 sky130_fd_pr__pfet_01v8
M$1893 345 330 350 350 sky130_fd_pr__pfet_01v8 L=0.15U W=1U AS=0.155P AD=0.26P
+ PS=1.31U PD=2.52U
* device instance $1894 r0 *1 27.155,21.025 sky130_fd_pr__pfet_01v8
M$1894 331 298 37 37 sky130_fd_pr__pfet_01v8 L=0.15U W=4U AS=0.685P AD=0.56P
+ PS=6.37U PD=5.12U
* device instance $1898 r0 *1 28.875,21.025 sky130_fd_pr__pfet_01v8
M$1898 31 331 37 37 sky130_fd_pr__pfet_01v8 L=0.15U W=16U AS=2.2375P AD=2.3625P
+ PS=20.475U PD=21.725U
* device instance $1914 r0 *1 36.35,21.025 sky130_fd_pr__pfet_01v8
M$1914 37 269 332 332 sky130_fd_pr__pfet_01v8 L=0.15U W=1U AS=0.26P AD=0.135P
+ PS=2.52U PD=1.27U
* device instance $1915 r0 *1 36.77,21.025 sky130_fd_pr__pfet_01v8
M$1915 267 332 37 37 sky130_fd_pr__pfet_01v8 L=0.15U W=4U AS=0.54P AD=0.665P
+ PS=5.08U PD=6.33U
* device instance $1919 r0 *1 44.17,16.905 sky130_fd_pr__pfet_01v8
M$1919 37 34 299 299 sky130_fd_pr__pfet_01v8 L=0.15U W=0.64U AS=0.1664P
+ AD=0.0864P PS=1.8U PD=0.91U
* device instance $1920 r0 *1 44.59,16.905 sky130_fd_pr__pfet_01v8
M$1920 300 299 37 37 sky130_fd_pr__pfet_01v8 L=0.15U W=0.64U AS=0.0864P
+ AD=0.1664P PS=0.91U PD=1.8U
* device instance $1921 r0 *1 46.475,21.025 sky130_fd_pr__pfet_01v8
M$1921 333 298 37 37 sky130_fd_pr__pfet_01v8 L=0.15U W=4U AS=0.685P AD=0.56P
+ PS=6.37U PD=5.12U
* device instance $1925 r0 *1 48.195,21.025 sky130_fd_pr__pfet_01v8
M$1925 34 333 37 37 sky130_fd_pr__pfet_01v8 L=0.15U W=16U AS=2.2375P AD=2.3625P
+ PS=20.475U PD=21.725U
* device instance $1941 r0 *1 63.51,21.025 sky130_fd_pr__pfet_01v8
M$1941 334 342 37 37 sky130_fd_pr__pfet_01v8 L=0.15U W=1U AS=0.26P AD=0.135P
+ PS=2.52U PD=1.27U
* device instance $1942 r0 *1 63.93,21.025 sky130_fd_pr__pfet_01v8
M$1942 37 311 334 334 sky130_fd_pr__pfet_01v8 L=0.15U W=1U AS=0.135P AD=0.26P
+ PS=1.27U PD=2.52U
* device instance $1943 r0 *1 64.91,21.025 sky130_fd_pr__pfet_01v8
M$1943 335 280 37 37 sky130_fd_pr__pfet_01v8 L=0.15U W=1U AS=0.3P AD=0.135P
+ PS=2.6U PD=1.27U
* device instance $1944 r0 *1 65.33,21.025 sky130_fd_pr__pfet_01v8
M$1944 37 334 335 335 sky130_fd_pr__pfet_01v8 L=0.15U W=1U AS=0.135P AD=0.365P
+ PS=1.27U PD=1.73U
* device instance $1945 r0 *1 66.21,21.025 sky130_fd_pr__pfet_01v8
M$1945 351 334 37 37 sky130_fd_pr__pfet_01v8 L=0.15U W=1U AS=0.365P AD=0.105P
+ PS=1.73U PD=1.21U
* device instance $1946 r0 *1 66.57,21.025 sky130_fd_pr__pfet_01v8
M$1946 347 280 351 351 sky130_fd_pr__pfet_01v8 L=0.15U W=1U AS=0.105P AD=0.165P
+ PS=1.21U PD=1.33U
* device instance $1947 r0 *1 67.05,21.025 sky130_fd_pr__pfet_01v8
M$1947 37 335 347 347 sky130_fd_pr__pfet_01v8 L=0.15U W=1U AS=0.165P AD=0.36P
+ PS=1.33U PD=2.72U
* device instance $1948 r0 *1 68.33,20.735 sky130_fd_pr__pfet_01v8
M$1948 37 343 337 337 sky130_fd_pr__pfet_01v8 L=0.15U W=0.42U AS=0.1092P
+ AD=0.1573P PS=1.36U PD=1.39U
* device instance $1949 r0 *1 68.87,21.025 sky130_fd_pr__pfet_01v8
M$1949 348 344 37 37 sky130_fd_pr__pfet_01v8 L=0.15U W=1U AS=0.1573P AD=0.105P
+ PS=1.39U PD=1.21U
* device instance $1950 r0 *1 69.23,21.025 sky130_fd_pr__pfet_01v8
M$1950 338 337 348 348 sky130_fd_pr__pfet_01v8 L=0.15U W=1U AS=0.105P AD=0.26P
+ PS=1.21U PD=2.52U
* device instance $1951 r0 *1 6.98,22.205 sky130_fd_pr__pfet_01v8
M$1951 353 352 37 37 sky130_fd_pr__pfet_01v8 L=0.15U W=0.42U AS=0.1113P
+ AD=0.0609P PS=1.37U PD=0.71U
* device instance $1952 r0 *1 7.42,22.205 sky130_fd_pr__pfet_01v8
M$1952 37 115 353 353 sky130_fd_pr__pfet_01v8 L=0.15U W=0.42U AS=0.0609P
+ AD=0.1841P PS=0.71U PD=1.26U
* device instance $1953 r0 *1 8.19,22.315 sky130_fd_pr__pfet_01v8
M$1953 354 353 37 37 sky130_fd_pr__pfet_01v8 L=0.15U W=0.64U AS=0.1841P
+ AD=0.1696P PS=1.26U PD=1.81U
* device instance $1954 r0 *1 9.21,22.495 sky130_fd_pr__pfet_01v8
M$1954 356 354 355 355 sky130_fd_pr__pfet_01v8 L=0.15U W=1U AS=0.26P AD=0.135P
+ PS=2.52U PD=1.27U
* device instance $1955 r0 *1 9.63,22.495 sky130_fd_pr__pfet_01v8
M$1955 357 399 356 356 sky130_fd_pr__pfet_01v8 L=0.15U W=1U AS=0.135P AD=0.135P
+ PS=1.27U PD=1.27U
* device instance $1956 r0 *1 10.05,22.495 sky130_fd_pr__pfet_01v8
M$1956 356 92 357 357 sky130_fd_pr__pfet_01v8 L=0.15U W=1U AS=0.135P AD=0.26P
+ PS=1.27U PD=2.52U
* device instance $1957 r0 *1 10.99,22.495 sky130_fd_pr__pfet_01v8
M$1957 357 157 37 37 sky130_fd_pr__pfet_01v8 L=0.15U W=1U AS=0.26P AD=0.165P
+ PS=2.52U PD=1.33U
* device instance $1958 r0 *1 11.47,22.495 sky130_fd_pr__pfet_01v8
M$1958 37 360 357 357 sky130_fd_pr__pfet_01v8 L=0.15U W=1U AS=0.165P AD=0.1575P
+ PS=1.33U PD=1.315U
* device instance $1959 r0 *1 11.935,22.495 sky130_fd_pr__pfet_01v8
M$1959 411 355 37 37 sky130_fd_pr__pfet_01v8 L=0.15U W=1U AS=0.1575P AD=0.26P
+ PS=1.315U PD=2.52U
* device instance $1960 r0 *1 12.93,22.495 sky130_fd_pr__pfet_01v8
M$1960 404 400 358 358 sky130_fd_pr__pfet_01v8 L=0.15U W=1U AS=0.26P AD=0.135P
+ PS=2.52U PD=1.27U
* device instance $1961 r0 *1 13.35,22.495 sky130_fd_pr__pfet_01v8
M$1961 37 294 404 404 sky130_fd_pr__pfet_01v8 L=0.15U W=1U AS=0.135P AD=0.135P
+ PS=1.27U PD=1.27U
* device instance $1962 r0 *1 13.77,22.495 sky130_fd_pr__pfet_01v8
M$1962 359 294 37 37 sky130_fd_pr__pfet_01v8 L=0.15U W=1U AS=0.135P AD=0.135P
+ PS=1.27U PD=1.27U
* device instance $1963 r0 *1 14.19,22.495 sky130_fd_pr__pfet_01v8
M$1963 37 400 359 359 sky130_fd_pr__pfet_01v8 L=0.15U W=1U AS=0.135P AD=0.26P
+ PS=1.27U PD=2.52U
* device instance $1964 r0 *1 15.13,22.495 sky130_fd_pr__pfet_01v8
M$1964 360 358 359 359 sky130_fd_pr__pfet_01v8 L=0.15U W=1U AS=0.26P AD=0.3P
+ PS=2.52U PD=2.6U
* device instance $1965 r0 *1 17.49,22.785 sky130_fd_pr__pfet_01v8
M$1965 405 408 361 361 sky130_fd_pr__pfet_01v8 L=0.15U W=0.42U AS=0.1092P
+ AD=0.0693P PS=1.36U PD=0.75U
* device instance $1966 r0 *1 17.97,22.785 sky130_fd_pr__pfet_01v8
M$1966 406 12 405 405 sky130_fd_pr__pfet_01v8 L=0.15U W=0.42U AS=0.0693P
+ AD=0.0441P PS=0.75U PD=0.63U
* device instance $1967 r0 *1 18.33,22.785 sky130_fd_pr__pfet_01v8
M$1967 407 399 406 406 sky130_fd_pr__pfet_01v8 L=0.15U W=0.42U AS=0.0441P
+ AD=0.0693P PS=0.63U PD=0.75U
* device instance $1968 r0 *1 18.81,22.785 sky130_fd_pr__pfet_01v8
M$1968 407 219 37 37 sky130_fd_pr__pfet_01v8 L=0.15U W=0.42U AS=0.14825P
+ AD=0.0693P PS=1.34U PD=0.75U
* device instance $1969 r0 *1 19.3,22.495 sky130_fd_pr__pfet_01v8
M$1969 362 361 37 37 sky130_fd_pr__pfet_01v8 L=0.15U W=1U AS=0.14825P AD=0.27P
+ PS=1.34U PD=2.54U
* device instance $1970 r0 *1 27.195,22.495 sky130_fd_pr__pfet_01v8
M$1970 363 31 37 37 sky130_fd_pr__pfet_01v8 L=0.15U W=6U AS=1.005P AD=1.045P
+ PS=9.01U PD=9.09U
* device instance $1976 r0 *1 41.41,22.345 sky130_fd_pr__pfet_01v8
M$1976 37 34 364 364 sky130_fd_pr__pfet_01v8 L=0.15U W=0.64U AS=0.1664P
+ AD=0.0864P PS=1.8U PD=0.91U
* device instance $1977 r0 *1 41.83,22.345 sky130_fd_pr__pfet_01v8
M$1977 365 364 37 37 sky130_fd_pr__pfet_01v8 L=0.15U W=0.64U AS=0.0864P
+ AD=0.1664P PS=0.91U PD=1.8U
* device instance $1978 r0 *1 42.77,22.315 sky130_fd_pr__pfet_01v8
M$1978 392 401 366 366 sky130_fd_pr__pfet_01v8 L=0.15U W=0.64U AS=0.1664P
+ AD=0.0672P PS=1.8U PD=0.85U
* device instance $1979 r0 *1 43.13,22.315 sky130_fd_pr__pfet_01v8
M$1979 37 367 392 392 sky130_fd_pr__pfet_01v8 L=0.15U W=0.64U AS=0.0672P
+ AD=0.1664P PS=0.85U PD=1.8U
* device instance $1980 r0 *1 45.795,22.205 sky130_fd_pr__pfet_01v8
M$1980 368 365 366 366 sky130_fd_pr__pfet_01v8 L=0.15U W=0.42U AS=0.15985P
+ AD=0.06405P PS=1.265U PD=0.725U
* device instance $1981 r0 *1 46.25,22.205 sky130_fd_pr__pfet_01v8
M$1981 395 364 368 368 sky130_fd_pr__pfet_01v8 L=0.15U W=0.42U AS=0.06405P
+ AD=0.07665P PS=0.725U PD=0.785U
* device instance $1982 r0 *1 46.765,22.205 sky130_fd_pr__pfet_01v8
M$1982 37 369 395 395 sky130_fd_pr__pfet_01v8 L=0.15U W=0.42U AS=0.07665P
+ AD=0.178875P PS=0.785U PD=1.26U
* device instance $1983 r0 *1 44.07,22.315 sky130_fd_pr__pfet_01v8
M$1983 37 94 367 367 sky130_fd_pr__pfet_01v8 L=0.15U W=0.64U AS=0.1664P
+ AD=0.0928P PS=1.8U PD=0.93U
* device instance $1984 r0 *1 44.51,22.315 sky130_fd_pr__pfet_01v8
M$1984 394 94 37 37 sky130_fd_pr__pfet_01v8 L=0.15U W=0.64U AS=0.0928P
+ AD=0.1152P PS=0.93U PD=1U
* device instance $1985 r0 *1 45.02,22.315 sky130_fd_pr__pfet_01v8
M$1985 366 371 394 394 sky130_fd_pr__pfet_01v8 L=0.15U W=0.64U AS=0.1152P
+ AD=0.15985P PS=1U PD=1.265U
* device instance $1986 r0 *1 47.425,22.37 sky130_fd_pr__pfet_01v8
M$1986 369 368 37 37 sky130_fd_pr__pfet_01v8 L=0.15U W=0.75U AS=0.178875P
+ AD=0.195P PS=1.26U PD=2.02U
* device instance $1987 r0 *1 48.365,22.205 sky130_fd_pr__pfet_01v8
M$1987 397 369 37 37 sky130_fd_pr__pfet_01v8 L=0.15U W=0.42U AS=0.1092P
+ AD=0.06405P PS=1.36U PD=0.725U
* device instance $1988 r0 *1 48.82,22.205 sky130_fd_pr__pfet_01v8
M$1988 370 364 397 397 sky130_fd_pr__pfet_01v8 L=0.15U W=0.42U AS=0.06405P
+ AD=0.0567P PS=0.725U PD=0.69U
* device instance $1989 r0 *1 49.24,22.205 sky130_fd_pr__pfet_01v8
M$1989 398 365 370 370 sky130_fd_pr__pfet_01v8 L=0.15U W=0.42U AS=0.0567P
+ AD=0.0882P PS=0.69U PD=0.84U
* device instance $1990 r0 *1 49.81,22.205 sky130_fd_pr__pfet_01v8
M$1990 37 371 398 398 sky130_fd_pr__pfet_01v8 L=0.15U W=0.42U AS=0.0882P
+ AD=0.1113P PS=0.84U PD=1.37U
* device instance $1991 r0 *1 50.865,22.315 sky130_fd_pr__pfet_01v8
M$1991 37 370 371 371 sky130_fd_pr__pfet_01v8 L=0.15U W=0.64U AS=0.1728P
+ AD=0.154P PS=1.82U PD=1.335U
* device instance $1992 r0 *1 51.35,22.495 sky130_fd_pr__pfet_01v8
M$1992 372 370 37 37 sky130_fd_pr__pfet_01v8 L=0.15U W=1U AS=0.154P AD=0.28P
+ PS=1.335U PD=2.56U
* device instance $1993 r0 *1 53.39,22.495 sky130_fd_pr__pfet_01v8
M$1993 37 374 373 373 sky130_fd_pr__pfet_01v8 L=0.15U W=2U AS=0.415P AD=0.27P
+ PS=3.83U PD=2.54U
* device instance $1995 r0 *1 54.23,22.495 sky130_fd_pr__pfet_01v8
M$1995 375 344 373 373 sky130_fd_pr__pfet_01v8 L=0.15U W=2U AS=0.27P AD=0.415P
+ PS=2.54U PD=3.83U
* device instance $1997 r0 *1 55.63,22.495 sky130_fd_pr__pfet_01v8
M$1997 375 161 376 376 sky130_fd_pr__pfet_01v8 L=0.15U W=2U AS=0.415P AD=0.27P
+ PS=3.83U PD=2.54U
* device instance $1999 r0 *1 56.47,22.495 sky130_fd_pr__pfet_01v8
M$1999 409 195 376 376 sky130_fd_pr__pfet_01v8 L=0.15U W=2U AS=0.27P AD=0.395P
+ PS=2.54U PD=3.79U
* device instance $2001 r0 *1 60.73,22.495 sky130_fd_pr__pfet_01v8
M$2001 378 402 377 377 sky130_fd_pr__pfet_01v8 L=0.15U W=1U AS=0.26P AD=0.135P
+ PS=2.52U PD=1.27U
* device instance $2002 r0 *1 61.15,22.495 sky130_fd_pr__pfet_01v8
M$2002 379 344 378 378 sky130_fd_pr__pfet_01v8 L=0.15U W=1U AS=0.135P AD=0.135P
+ PS=1.27U PD=1.27U
* device instance $2003 r0 *1 61.57,22.495 sky130_fd_pr__pfet_01v8
M$2003 378 92 379 379 sky130_fd_pr__pfet_01v8 L=0.15U W=1U AS=0.135P AD=0.26P
+ PS=1.27U PD=2.52U
* device instance $2004 r0 *1 62.51,22.495 sky130_fd_pr__pfet_01v8
M$2004 379 134 37 37 sky130_fd_pr__pfet_01v8 L=0.15U W=1U AS=0.26P AD=0.165P
+ PS=2.52U PD=1.33U
* device instance $2005 r0 *1 62.99,22.495 sky130_fd_pr__pfet_01v8
M$2005 37 347 379 379 sky130_fd_pr__pfet_01v8 L=0.15U W=1U AS=0.165P AD=0.1575P
+ PS=1.33U PD=1.315U
* device instance $2006 r0 *1 63.455,22.495 sky130_fd_pr__pfet_01v8
M$2006 380 377 37 37 sky130_fd_pr__pfet_01v8 L=0.15U W=1U AS=0.1575P AD=0.26P
+ PS=1.315U PD=2.52U
* device instance $2007 r0 *1 64.41,22.345 sky130_fd_pr__pfet_01v8
M$2007 37 34 381 381 sky130_fd_pr__pfet_01v8 L=0.15U W=0.64U AS=0.1664P
+ AD=0.0864P PS=1.8U PD=0.91U
* device instance $2008 r0 *1 64.83,22.345 sky130_fd_pr__pfet_01v8
M$2008 382 381 37 37 sky130_fd_pr__pfet_01v8 L=0.15U W=0.64U AS=0.0864P
+ AD=0.1664P PS=0.91U PD=1.8U
* device instance $2009 r0 *1 65.77,22.315 sky130_fd_pr__pfet_01v8
M$2009 396 403 383 383 sky130_fd_pr__pfet_01v8 L=0.15U W=0.64U AS=0.1664P
+ AD=0.0672P PS=1.8U PD=0.85U
* device instance $2010 r0 *1 66.13,22.315 sky130_fd_pr__pfet_01v8
M$2010 37 384 396 396 sky130_fd_pr__pfet_01v8 L=0.15U W=0.64U AS=0.0672P
+ AD=0.1664P PS=0.85U PD=1.8U
* device instance $2011 r0 *1 68.795,22.205 sky130_fd_pr__pfet_01v8
M$2011 385 382 383 383 sky130_fd_pr__pfet_01v8 L=0.15U W=0.42U AS=0.15985P
+ AD=0.06405P PS=1.265U PD=0.725U
* device instance $2012 r0 *1 69.25,22.205 sky130_fd_pr__pfet_01v8
M$2012 391 381 385 385 sky130_fd_pr__pfet_01v8 L=0.15U W=0.42U AS=0.06405P
+ AD=0.07665P PS=0.725U PD=0.785U
* device instance $2013 r0 *1 69.765,22.205 sky130_fd_pr__pfet_01v8
M$2013 37 386 391 391 sky130_fd_pr__pfet_01v8 L=0.15U W=0.42U AS=0.07665P
+ AD=0.178875P PS=0.785U PD=1.26U
* device instance $2014 r0 *1 67.07,22.315 sky130_fd_pr__pfet_01v8
M$2014 37 410 384 384 sky130_fd_pr__pfet_01v8 L=0.15U W=0.64U AS=0.1664P
+ AD=0.0928P PS=1.8U PD=0.93U
* device instance $2015 r0 *1 67.51,22.315 sky130_fd_pr__pfet_01v8
M$2015 393 410 37 37 sky130_fd_pr__pfet_01v8 L=0.15U W=0.64U AS=0.0928P
+ AD=0.1152P PS=0.93U PD=1U
* device instance $2016 r0 *1 68.02,22.315 sky130_fd_pr__pfet_01v8
M$2016 383 388 393 393 sky130_fd_pr__pfet_01v8 L=0.15U W=0.64U AS=0.1152P
+ AD=0.15985P PS=1U PD=1.265U
* device instance $2017 r0 *1 70.425,22.37 sky130_fd_pr__pfet_01v8
M$2017 386 385 37 37 sky130_fd_pr__pfet_01v8 L=0.15U W=0.75U AS=0.178875P
+ AD=0.195P PS=1.26U PD=2.02U
* device instance $2018 r0 *1 71.365,22.205 sky130_fd_pr__pfet_01v8
M$2018 390 386 37 37 sky130_fd_pr__pfet_01v8 L=0.15U W=0.42U AS=0.1092P
+ AD=0.06405P PS=1.36U PD=0.725U
* device instance $2019 r0 *1 71.82,22.205 sky130_fd_pr__pfet_01v8
M$2019 387 381 390 390 sky130_fd_pr__pfet_01v8 L=0.15U W=0.42U AS=0.06405P
+ AD=0.0567P PS=0.725U PD=0.69U
* device instance $2020 r0 *1 72.24,22.205 sky130_fd_pr__pfet_01v8
M$2020 389 382 387 387 sky130_fd_pr__pfet_01v8 L=0.15U W=0.42U AS=0.0567P
+ AD=0.0882P PS=0.69U PD=0.84U
* device instance $2021 r0 *1 72.81,22.205 sky130_fd_pr__pfet_01v8
M$2021 37 388 389 389 sky130_fd_pr__pfet_01v8 L=0.15U W=0.42U AS=0.0882P
+ AD=0.1113P PS=0.84U PD=1.37U
* device instance $2022 r0 *1 73.865,22.315 sky130_fd_pr__pfet_01v8
M$2022 37 387 388 388 sky130_fd_pr__pfet_01v8 L=0.15U W=0.64U AS=0.1728P
+ AD=0.154P PS=1.82U PD=1.335U
* device instance $2023 r0 *1 74.35,22.495 sky130_fd_pr__pfet_01v8
M$2023 344 387 37 37 sky130_fd_pr__pfet_01v8 L=0.15U W=1U AS=0.154P AD=0.28P
+ PS=1.335U PD=2.56U
* device instance $2024 r0 *1 4.61,26.615 sky130_fd_pr__pfet_01v8
M$2024 37 31 428 428 sky130_fd_pr__pfet_01v8 L=0.15U W=0.64U AS=0.1664P
+ AD=0.0864P PS=1.8U PD=0.91U
* device instance $2025 r0 *1 5.03,26.615 sky130_fd_pr__pfet_01v8
M$2025 429 428 37 37 sky130_fd_pr__pfet_01v8 L=0.15U W=0.64U AS=0.0864P
+ AD=0.1664P PS=0.91U PD=1.8U
* device instance $2026 r0 *1 5.97,26.645 sky130_fd_pr__pfet_01v8
M$2026 467 459 430 430 sky130_fd_pr__pfet_01v8 L=0.15U W=0.64U AS=0.1664P
+ AD=0.0672P PS=1.8U PD=0.85U
* device instance $2027 r0 *1 6.33,26.645 sky130_fd_pr__pfet_01v8
M$2027 37 460 467 467 sky130_fd_pr__pfet_01v8 L=0.15U W=0.64U AS=0.0672P
+ AD=0.1664P PS=0.85U PD=1.8U
* device instance $2028 r0 *1 7.27,26.645 sky130_fd_pr__pfet_01v8
M$2028 37 94 460 460 sky130_fd_pr__pfet_01v8 L=0.15U W=0.64U AS=0.1664P
+ AD=0.0928P PS=1.8U PD=0.93U
* device instance $2029 r0 *1 7.71,26.645 sky130_fd_pr__pfet_01v8
M$2029 469 94 37 37 sky130_fd_pr__pfet_01v8 L=0.15U W=0.64U AS=0.0928P
+ AD=0.1152P PS=0.93U PD=1U
* device instance $2030 r0 *1 8.22,26.645 sky130_fd_pr__pfet_01v8
M$2030 430 431 469 469 sky130_fd_pr__pfet_01v8 L=0.15U W=0.64U AS=0.1152P
+ AD=0.15985P PS=1U PD=1.265U
* device instance $2031 r0 *1 8.995,26.755 sky130_fd_pr__pfet_01v8
M$2031 432 429 430 430 sky130_fd_pr__pfet_01v8 L=0.15U W=0.42U AS=0.15985P
+ AD=0.06405P PS=1.265U PD=0.725U
* device instance $2032 r0 *1 9.45,26.755 sky130_fd_pr__pfet_01v8
M$2032 470 428 432 432 sky130_fd_pr__pfet_01v8 L=0.15U W=0.42U AS=0.06405P
+ AD=0.07665P PS=0.725U PD=0.785U
* device instance $2033 r0 *1 9.965,26.755 sky130_fd_pr__pfet_01v8
M$2033 470 433 37 37 sky130_fd_pr__pfet_01v8 L=0.15U W=0.42U AS=0.178875P
+ AD=0.07665P PS=1.26U PD=0.785U
* device instance $2034 r0 *1 10.625,26.59 sky130_fd_pr__pfet_01v8
M$2034 433 432 37 37 sky130_fd_pr__pfet_01v8 L=0.15U W=0.75U AS=0.178875P
+ AD=0.195P PS=1.26U PD=2.02U
* device instance $2035 r0 *1 14.065,26.645 sky130_fd_pr__pfet_01v8
M$2035 431 434 37 37 sky130_fd_pr__pfet_01v8 L=0.15U W=0.64U AS=0.154P
+ AD=0.1728P PS=1.335U PD=1.82U
* device instance $2036 r0 *1 14.55,26.465 sky130_fd_pr__pfet_01v8
M$2036 399 434 37 37 sky130_fd_pr__pfet_01v8 L=0.15U W=1U AS=0.154P AD=0.28P
+ PS=1.335U PD=2.56U
* device instance $2037 r0 *1 18.19,26.175 sky130_fd_pr__pfet_01v8
M$2037 37 399 435 435 sky130_fd_pr__pfet_01v8 L=0.15U W=0.42U AS=0.1092P
+ AD=0.1573P PS=1.36U PD=1.39U
* device instance $2038 r0 *1 18.73,26.465 sky130_fd_pr__pfet_01v8
M$2038 473 461 37 37 sky130_fd_pr__pfet_01v8 L=0.15U W=1U AS=0.1573P AD=0.105P
+ PS=1.39U PD=1.21U
* device instance $2039 r0 *1 19.09,26.465 sky130_fd_pr__pfet_01v8
M$2039 436 435 473 473 sky130_fd_pr__pfet_01v8 L=0.15U W=1U AS=0.105P AD=0.26P
+ PS=1.21U PD=2.52U
* device instance $2040 r0 *1 20.25,26.465 sky130_fd_pr__pfet_01v8
M$2040 474 436 400 400 sky130_fd_pr__pfet_01v8 L=0.15U W=1U AS=0.26P AD=0.105P
+ PS=2.52U PD=1.21U
* device instance $2041 r0 *1 20.61,26.465 sky130_fd_pr__pfet_01v8
M$2041 37 330 474 474 sky130_fd_pr__pfet_01v8 L=0.15U W=1U AS=0.105P AD=0.26P
+ PS=1.21U PD=2.52U
* device instance $2042 r0 *1 21.87,26.175 sky130_fd_pr__pfet_01v8
M$2042 37 461 437 437 sky130_fd_pr__pfet_01v8 L=0.15U W=0.42U AS=0.1092P
+ AD=0.1573P PS=1.36U PD=1.39U
* device instance $2043 r0 *1 22.41,26.465 sky130_fd_pr__pfet_01v8
M$2043 475 399 37 37 sky130_fd_pr__pfet_01v8 L=0.15U W=1U AS=0.1573P AD=0.105P
+ PS=1.39U PD=1.21U
* device instance $2044 r0 *1 22.77,26.465 sky130_fd_pr__pfet_01v8
M$2044 330 437 475 475 sky130_fd_pr__pfet_01v8 L=0.15U W=1U AS=0.105P AD=0.26P
+ PS=1.21U PD=2.52U
* device instance $2045 r0 *1 34.985,26.465 sky130_fd_pr__pfet_01v8
M$2045 37 440 439 439 sky130_fd_pr__pfet_01v8 L=0.15U W=2U AS=0.41P AD=0.27P
+ PS=3.82U PD=2.54U
* device instance $2047 r0 *1 35.825,26.465 sky130_fd_pr__pfet_01v8
M$2047 37 441 439 439 sky130_fd_pr__pfet_01v8 L=0.15U W=2U AS=0.27P AD=0.415P
+ PS=2.54U PD=3.83U
* device instance $2049 r0 *1 37.225,26.465 sky130_fd_pr__pfet_01v8
M$2049 37 441 465 465 sky130_fd_pr__pfet_01v8 L=0.15U W=2U AS=0.415P AD=0.27P
+ PS=3.83U PD=2.54U
* device instance $2051 r0 *1 38.065,26.465 sky130_fd_pr__pfet_01v8
M$2051 2 440 465 465 sky130_fd_pr__pfet_01v8 L=0.15U W=2U AS=0.2875P AD=0.4125P
+ PS=2.575U PD=3.825U
* device instance $2053 r0 *1 39.46,26.465 sky130_fd_pr__pfet_01v8
M$2053 2 439 37 37 sky130_fd_pr__pfet_01v8 L=0.15U W=2U AS=0.395P AD=0.415P
+ PS=3.79U PD=3.83U
* device instance $2055 r0 *1 46.47,26.465 sky130_fd_pr__pfet_01v8
M$2055 37 34 443 443 sky130_fd_pr__pfet_01v8 L=0.15U W=3U AS=0.53P AD=0.405P
+ PS=5.06U PD=3.81U
* device instance $2058 r0 *1 47.73,26.465 sky130_fd_pr__pfet_01v8
M$2058 444 443 37 37 sky130_fd_pr__pfet_01v8 L=0.15U W=6U AS=0.81P AD=0.81P
+ PS=7.62U PD=7.62U
* device instance $2064 r0 *1 50.25,26.465 sky130_fd_pr__pfet_01v8
M$2064 445 444 37 37 sky130_fd_pr__pfet_01v8 L=0.15U W=16U AS=2.16P AD=2.285P
+ PS=20.32U PD=21.57U
* device instance $2080 r0 *1 63.95,26.545 sky130_fd_pr__pfet_01v8
M$2080 311 338 37 37 sky130_fd_pr__pfet_01v8 L=0.15U W=1.68U AS=0.3318P
+ AD=0.3486P PS=3.31U PD=3.35U
* device instance $2082 r0 *1 65.33,26.175 sky130_fd_pr__pfet_01v8
M$2082 37 343 447 447 sky130_fd_pr__pfet_01v8 L=0.15U W=0.42U AS=0.1092P
+ AD=0.14575P PS=1.36U PD=1.335U
* device instance $2083 r0 *1 65.815,26.465 sky130_fd_pr__pfet_01v8
M$2083 342 344 37 37 sky130_fd_pr__pfet_01v8 L=0.15U W=1U AS=0.14575P AD=0.135P
+ PS=1.335U PD=1.27U
* device instance $2084 r0 *1 66.235,26.465 sky130_fd_pr__pfet_01v8
M$2084 37 447 342 342 sky130_fd_pr__pfet_01v8 L=0.15U W=1U AS=0.135P AD=0.265P
+ PS=1.27U PD=2.53U
* device instance $2085 r0 *1 68.175,26.56 sky130_fd_pr__pfet_01v8
M$2085 468 64 37 37 sky130_fd_pr__pfet_01v8 L=0.15U W=0.42U AS=0.15835P
+ AD=0.07665P PS=1.395U PD=0.785U
* device instance $2086 r0 *1 68.69,26.56 sky130_fd_pr__pfet_01v8
M$2086 448 343 468 468 sky130_fd_pr__pfet_01v8 L=0.15U W=0.42U AS=0.07665P
+ AD=0.1932P PS=0.785U PD=1.34U
* device instance $2087 r0 *1 69.76,26.56 sky130_fd_pr__pfet_01v8
M$2087 466 449 448 448 sky130_fd_pr__pfet_01v8 L=0.15U W=0.42U AS=0.1932P
+ AD=0.0441P PS=1.34U PD=0.63U
* device instance $2088 r0 *1 70.12,26.56 sky130_fd_pr__pfet_01v8
M$2088 37 450 466 466 sky130_fd_pr__pfet_01v8 L=0.15U W=0.42U AS=0.0441P
+ AD=0.0693P PS=0.63U PD=0.75U
* device instance $2089 r0 *1 70.6,26.56 sky130_fd_pr__pfet_01v8
M$2089 450 64 37 37 sky130_fd_pr__pfet_01v8 L=0.15U W=0.42U AS=0.0693P
+ AD=0.1176P PS=0.75U PD=1.4U
* device instance $2090 r0 *1 67.63,26.465 sky130_fd_pr__pfet_01v8
M$2090 37 448 403 403 sky130_fd_pr__pfet_01v8 L=0.15U W=1U AS=0.26P AD=0.15835P
+ PS=2.52U PD=1.395U
* device instance $2091 r0 *1 5.615,27.84 sky130_fd_pr__pfet_01v8
M$2091 499 64 37 37 sky130_fd_pr__pfet_01v8 L=0.15U W=0.42U AS=0.15835P
+ AD=0.07665P PS=1.395U PD=0.785U
* device instance $2092 r0 *1 6.13,27.84 sky130_fd_pr__pfet_01v8
M$2092 476 461 499 499 sky130_fd_pr__pfet_01v8 L=0.15U W=0.42U AS=0.07665P
+ AD=0.1932P PS=0.785U PD=1.34U
* device instance $2093 r0 *1 7.2,27.84 sky130_fd_pr__pfet_01v8
M$2093 500 464 476 476 sky130_fd_pr__pfet_01v8 L=0.15U W=0.42U AS=0.1932P
+ AD=0.0441P PS=1.34U PD=0.63U
* device instance $2094 r0 *1 7.56,27.84 sky130_fd_pr__pfet_01v8
M$2094 37 515 500 500 sky130_fd_pr__pfet_01v8 L=0.15U W=0.42U AS=0.0441P
+ AD=0.0693P PS=0.63U PD=0.75U
* device instance $2095 r0 *1 8.04,27.84 sky130_fd_pr__pfet_01v8
M$2095 515 64 37 37 sky130_fd_pr__pfet_01v8 L=0.15U W=0.42U AS=0.0693P
+ AD=0.1176P PS=0.75U PD=1.4U
* device instance $2096 r0 *1 5.07,27.935 sky130_fd_pr__pfet_01v8
M$2096 37 476 459 459 sky130_fd_pr__pfet_01v8 L=0.15U W=1U AS=0.26P AD=0.15835P
+ PS=2.52U PD=1.395U
* device instance $2097 r0 *1 10.57,27.755 sky130_fd_pr__pfet_01v8
M$2097 501 411 479 479 sky130_fd_pr__pfet_01v8 L=0.15U W=0.64U AS=0.1664P
+ AD=0.0672P PS=1.8U PD=0.85U
* device instance $2098 r0 *1 10.93,27.755 sky130_fd_pr__pfet_01v8
M$2098 37 480 501 501 sky130_fd_pr__pfet_01v8 L=0.15U W=0.64U AS=0.0672P
+ AD=0.1664P PS=0.85U PD=1.8U
* device instance $2099 r0 *1 11.565,26.755 sky130_fd_pr__pfet_01v8
M$2099 471 433 37 37 sky130_fd_pr__pfet_01v8 L=0.15U W=0.42U AS=0.1092P
+ AD=0.06405P PS=1.36U PD=0.725U
* device instance $2100 r0 *1 12.02,26.755 sky130_fd_pr__pfet_01v8
M$2100 434 428 471 471 sky130_fd_pr__pfet_01v8 L=0.15U W=0.42U AS=0.06405P
+ AD=0.0567P PS=0.725U PD=0.69U
* device instance $2101 r0 *1 12.44,26.755 sky130_fd_pr__pfet_01v8
M$2101 472 429 434 434 sky130_fd_pr__pfet_01v8 L=0.15U W=0.42U AS=0.0567P
+ AD=0.0882P PS=0.69U PD=0.84U
* device instance $2102 r0 *1 13.01,26.755 sky130_fd_pr__pfet_01v8
M$2102 37 431 472 472 sky130_fd_pr__pfet_01v8 L=0.15U W=0.42U AS=0.0882P
+ AD=0.1113P PS=0.84U PD=1.37U
* device instance $2103 r0 *1 13.595,27.645 sky130_fd_pr__pfet_01v8
M$2103 481 478 479 479 sky130_fd_pr__pfet_01v8 L=0.15U W=0.42U AS=0.15985P
+ AD=0.06405P PS=1.265U PD=0.725U
* device instance $2104 r0 *1 14.05,27.645 sky130_fd_pr__pfet_01v8
M$2104 503 477 481 481 sky130_fd_pr__pfet_01v8 L=0.15U W=0.42U AS=0.06405P
+ AD=0.07665P PS=0.725U PD=0.785U
* device instance $2105 r0 *1 14.565,27.645 sky130_fd_pr__pfet_01v8
M$2105 37 482 503 503 sky130_fd_pr__pfet_01v8 L=0.15U W=0.42U AS=0.07665P
+ AD=0.178875P PS=0.785U PD=1.26U
* device instance $2106 r0 *1 11.87,27.755 sky130_fd_pr__pfet_01v8
M$2106 37 303 480 480 sky130_fd_pr__pfet_01v8 L=0.15U W=0.64U AS=0.1664P
+ AD=0.0928P PS=1.8U PD=0.93U
* device instance $2107 r0 *1 12.31,27.755 sky130_fd_pr__pfet_01v8
M$2107 502 303 37 37 sky130_fd_pr__pfet_01v8 L=0.15U W=0.64U AS=0.0928P
+ AD=0.1152P PS=0.93U PD=1U
* device instance $2108 r0 *1 12.82,27.755 sky130_fd_pr__pfet_01v8
M$2108 479 484 502 502 sky130_fd_pr__pfet_01v8 L=0.15U W=0.64U AS=0.1152P
+ AD=0.15985P PS=1U PD=1.265U
* device instance $2109 r0 *1 15.225,27.81 sky130_fd_pr__pfet_01v8
M$2109 482 481 37 37 sky130_fd_pr__pfet_01v8 L=0.15U W=0.75U AS=0.178875P
+ AD=0.195P PS=1.26U PD=2.02U
* device instance $2110 r0 *1 16.165,27.645 sky130_fd_pr__pfet_01v8
M$2110 504 482 37 37 sky130_fd_pr__pfet_01v8 L=0.15U W=0.42U AS=0.1092P
+ AD=0.06405P PS=1.36U PD=0.725U
* device instance $2111 r0 *1 16.62,27.645 sky130_fd_pr__pfet_01v8
M$2111 483 477 504 504 sky130_fd_pr__pfet_01v8 L=0.15U W=0.42U AS=0.06405P
+ AD=0.0567P PS=0.725U PD=0.69U
* device instance $2112 r0 *1 17.04,27.645 sky130_fd_pr__pfet_01v8
M$2112 506 478 483 483 sky130_fd_pr__pfet_01v8 L=0.15U W=0.42U AS=0.0567P
+ AD=0.0882P PS=0.69U PD=0.84U
* device instance $2113 r0 *1 17.61,27.645 sky130_fd_pr__pfet_01v8
M$2113 37 484 506 506 sky130_fd_pr__pfet_01v8 L=0.15U W=0.42U AS=0.0882P
+ AD=0.1113P PS=0.84U PD=1.37U
* device instance $2114 r0 *1 18.665,27.755 sky130_fd_pr__pfet_01v8
M$2114 37 483 484 484 sky130_fd_pr__pfet_01v8 L=0.15U W=0.64U AS=0.1728P
+ AD=0.154P PS=1.82U PD=1.335U
* device instance $2115 r0 *1 19.15,27.935 sky130_fd_pr__pfet_01v8
M$2115 461 483 37 37 sky130_fd_pr__pfet_01v8 L=0.15U W=1U AS=0.154P AD=0.28P
+ PS=1.335U PD=2.56U
* device instance $2116 r0 *1 30.91,27.935 sky130_fd_pr__pfet_01v8
M$2116 37 329 485 485 sky130_fd_pr__pfet_01v8 L=0.15U W=4U AS=0.685P AD=0.54P
+ PS=6.37U PD=5.08U
* device instance $2120 r0 *1 32.59,27.935 sky130_fd_pr__pfet_01v8
M$2120 486 436 485 485 sky130_fd_pr__pfet_01v8 L=0.15U W=4U AS=0.54P AD=0.665P
+ PS=5.08U PD=6.33U
* device instance $2124 r0 *1 34.79,27.935 sky130_fd_pr__pfet_01v8
M$2124 486 535 269 269 sky130_fd_pr__pfet_01v8 L=0.15U W=4U AS=0.665P AD=0.55P
+ PS=6.33U PD=5.1U
* device instance $2128 r0 *1 36.49,27.935 sky130_fd_pr__pfet_01v8
M$2128 37 513 269 269 sky130_fd_pr__pfet_01v8 L=0.15U W=4U AS=0.55P AD=0.54P
+ PS=5.1U PD=5.08U
* device instance $2132 r0 *1 38.17,27.935 sky130_fd_pr__pfet_01v8
M$2132 37 487 269 269 sky130_fd_pr__pfet_01v8 L=0.15U W=4U AS=0.54P AD=0.665P
+ PS=5.08U PD=6.33U
* device instance $2136 r0 *1 41.87,28.225 sky130_fd_pr__pfet_01v8
M$2136 488 514 37 37 sky130_fd_pr__pfet_01v8 L=0.15U W=0.42U AS=0.14575P
+ AD=0.1092P PS=1.335U PD=1.36U
* device instance $2137 r0 *1 42.355,27.935 sky130_fd_pr__pfet_01v8
M$2137 265 372 37 37 sky130_fd_pr__pfet_01v8 L=0.15U W=1U AS=0.14575P AD=0.135P
+ PS=1.335U PD=1.27U
* device instance $2138 r0 *1 42.775,27.935 sky130_fd_pr__pfet_01v8
M$2138 37 488 265 265 sky130_fd_pr__pfet_01v8 L=0.15U W=1U AS=0.135P AD=0.265P
+ PS=1.27U PD=2.53U
* device instance $2139 r0 *1 44.715,27.84 sky130_fd_pr__pfet_01v8
M$2139 511 64 37 37 sky130_fd_pr__pfet_01v8 L=0.15U W=0.42U AS=0.15835P
+ AD=0.07665P PS=1.395U PD=0.785U
* device instance $2140 r0 *1 45.23,27.84 sky130_fd_pr__pfet_01v8
M$2140 489 514 511 511 sky130_fd_pr__pfet_01v8 L=0.15U W=0.42U AS=0.07665P
+ AD=0.1932P PS=0.785U PD=1.34U
* device instance $2141 r0 *1 46.3,27.84 sky130_fd_pr__pfet_01v8
M$2141 512 490 489 489 sky130_fd_pr__pfet_01v8 L=0.15U W=0.42U AS=0.1932P
+ AD=0.0441P PS=1.34U PD=0.63U
* device instance $2142 r0 *1 46.66,27.84 sky130_fd_pr__pfet_01v8
M$2142 37 517 512 512 sky130_fd_pr__pfet_01v8 L=0.15U W=0.42U AS=0.0441P
+ AD=0.0693P PS=0.63U PD=0.75U
* device instance $2143 r0 *1 47.14,27.84 sky130_fd_pr__pfet_01v8
M$2143 517 64 37 37 sky130_fd_pr__pfet_01v8 L=0.15U W=0.42U AS=0.0693P
+ AD=0.1176P PS=0.75U PD=1.4U
* device instance $2144 r0 *1 44.17,27.935 sky130_fd_pr__pfet_01v8
M$2144 37 489 401 401 sky130_fd_pr__pfet_01v8 L=0.15U W=1U AS=0.26P AD=0.15835P
+ PS=2.52U PD=1.395U
* device instance $2145 r0 *1 61.26,26.755 sky130_fd_pr__pfet_01v8
M$2145 446 462 37 37 sky130_fd_pr__pfet_01v8 L=0.15U W=0.42U AS=0.1113P
+ AD=0.0609P PS=1.37U PD=0.71U
* device instance $2146 r0 *1 61.7,26.755 sky130_fd_pr__pfet_01v8
M$2146 446 115 37 37 sky130_fd_pr__pfet_01v8 L=0.15U W=0.42U AS=0.1841P
+ AD=0.0609P PS=1.26U PD=0.71U
* device instance $2147 r0 *1 62.47,26.645 sky130_fd_pr__pfet_01v8
M$2147 402 446 37 37 sky130_fd_pr__pfet_01v8 L=0.15U W=0.64U AS=0.1841P
+ AD=0.1696P PS=1.26U PD=1.81U
* device instance $2148 r0 *1 62.09,27.755 sky130_fd_pr__pfet_01v8
M$2148 510 380 493 493 sky130_fd_pr__pfet_01v8 L=0.15U W=0.64U AS=0.1664P
+ AD=0.0672P PS=1.8U PD=0.85U
* device instance $2149 r0 *1 62.45,27.755 sky130_fd_pr__pfet_01v8
M$2149 37 494 510 510 sky130_fd_pr__pfet_01v8 L=0.15U W=0.64U AS=0.0672P
+ AD=0.1664P PS=0.85U PD=1.8U
* device instance $2150 r0 *1 65.115,27.645 sky130_fd_pr__pfet_01v8
M$2150 495 492 493 493 sky130_fd_pr__pfet_01v8 L=0.15U W=0.42U AS=0.15985P
+ AD=0.06405P PS=1.265U PD=0.725U
* device instance $2151 r0 *1 65.57,27.645 sky130_fd_pr__pfet_01v8
M$2151 508 491 495 495 sky130_fd_pr__pfet_01v8 L=0.15U W=0.42U AS=0.06405P
+ AD=0.07665P PS=0.725U PD=0.785U
* device instance $2152 r0 *1 66.085,27.645 sky130_fd_pr__pfet_01v8
M$2152 37 496 508 508 sky130_fd_pr__pfet_01v8 L=0.15U W=0.42U AS=0.07665P
+ AD=0.178875P PS=0.785U PD=1.26U
* device instance $2153 r0 *1 63.39,27.755 sky130_fd_pr__pfet_01v8
M$2153 37 303 494 494 sky130_fd_pr__pfet_01v8 L=0.15U W=0.64U AS=0.1664P
+ AD=0.0928P PS=1.8U PD=0.93U
* device instance $2154 r0 *1 63.83,27.755 sky130_fd_pr__pfet_01v8
M$2154 509 303 37 37 sky130_fd_pr__pfet_01v8 L=0.15U W=0.64U AS=0.0928P
+ AD=0.1152P PS=0.93U PD=1U
* device instance $2155 r0 *1 64.34,27.755 sky130_fd_pr__pfet_01v8
M$2155 493 498 509 509 sky130_fd_pr__pfet_01v8 L=0.15U W=0.64U AS=0.1152P
+ AD=0.15985P PS=1U PD=1.265U
* device instance $2156 r0 *1 66.745,27.81 sky130_fd_pr__pfet_01v8
M$2156 496 495 37 37 sky130_fd_pr__pfet_01v8 L=0.15U W=0.75U AS=0.178875P
+ AD=0.195P PS=1.26U PD=2.02U
* device instance $2157 r0 *1 67.685,27.645 sky130_fd_pr__pfet_01v8
M$2157 507 496 37 37 sky130_fd_pr__pfet_01v8 L=0.15U W=0.42U AS=0.1092P
+ AD=0.06405P PS=1.36U PD=0.725U
* device instance $2158 r0 *1 68.14,27.645 sky130_fd_pr__pfet_01v8
M$2158 497 491 507 507 sky130_fd_pr__pfet_01v8 L=0.15U W=0.42U AS=0.06405P
+ AD=0.0567P PS=0.725U PD=0.69U
* device instance $2159 r0 *1 68.56,27.645 sky130_fd_pr__pfet_01v8
M$2159 505 492 497 497 sky130_fd_pr__pfet_01v8 L=0.15U W=0.42U AS=0.0567P
+ AD=0.0882P PS=0.69U PD=0.84U
* device instance $2160 r0 *1 69.13,27.645 sky130_fd_pr__pfet_01v8
M$2160 37 498 505 505 sky130_fd_pr__pfet_01v8 L=0.15U W=0.42U AS=0.0882P
+ AD=0.1113P PS=0.84U PD=1.37U
* device instance $2161 r0 *1 70.185,27.755 sky130_fd_pr__pfet_01v8
M$2161 37 497 498 498 sky130_fd_pr__pfet_01v8 L=0.15U W=0.64U AS=0.1728P
+ AD=0.154P PS=1.82U PD=1.335U
* device instance $2162 r0 *1 70.67,27.935 sky130_fd_pr__pfet_01v8
M$2162 343 497 37 37 sky130_fd_pr__pfet_01v8 L=0.15U W=1U AS=0.154P AD=0.28P
+ PS=1.335U PD=2.56U
* device instance $2163 r0 *1 9.21,27.785 sky130_fd_pr__pfet_01v8
M$2163 37 31 477 477 sky130_fd_pr__pfet_01v8 L=0.15U W=0.64U AS=0.1664P
+ AD=0.0864P PS=1.8U PD=0.91U
* device instance $2164 r0 *1 9.63,27.785 sky130_fd_pr__pfet_01v8
M$2164 478 477 37 37 sky130_fd_pr__pfet_01v8 L=0.15U W=0.64U AS=0.0864P
+ AD=0.1664P PS=0.91U PD=1.8U
* device instance $2165 r0 *1 13.35,33.295 sky130_fd_pr__pfet_01v8
M$2165 579 554 37 37 sky130_fd_pr__pfet_01v8 L=0.15U W=1.68U AS=0.3318P
+ AD=0.3486P PS=3.31U PD=3.35U
* device instance $2167 r0 *1 26.285,32.085 sky130_fd_pr__pfet_01v8
M$2167 553 436 37 37 sky130_fd_pr__pfet_01v8 L=0.15U W=0.64U AS=0.1696P
+ AD=0.0768P PS=1.81U PD=0.88U
* device instance $2168 r0 *1 26.675,32.085 sky130_fd_pr__pfet_01v8
M$2168 545 329 553 553 sky130_fd_pr__pfet_01v8 L=0.15U W=0.64U AS=0.0768P
+ AD=0.0896P PS=0.88U PD=0.92U
* device instance $2169 r0 *1 27.105,32.085 sky130_fd_pr__pfet_01v8
M$2169 37 535 545 545 sky130_fd_pr__pfet_01v8 L=0.15U W=0.64U AS=0.0896P
+ AD=0.1824P PS=0.92U PD=1.85U
* device instance $2170 r0 *1 27.155,33.375 sky130_fd_pr__pfet_01v8
M$2170 555 546 37 37 sky130_fd_pr__pfet_01v8 L=0.15U W=1U AS=0.265P AD=0.14P
+ PS=2.53U PD=1.28U
* device instance $2171 r0 *1 27.585,33.375 sky130_fd_pr__pfet_01v8
M$2171 37 545 555 555 sky130_fd_pr__pfet_01v8 L=0.15U W=1U AS=0.14P AD=0.1775P
+ PS=1.28U PD=1.355U
* device instance $2172 r0 *1 28.09,33.375 sky130_fd_pr__pfet_01v8
M$2172 556 555 37 37 sky130_fd_pr__pfet_01v8 L=0.15U W=4U AS=0.5975P AD=0.705P
+ PS=5.195U PD=6.41U
* device instance $2176 r0 *1 28.08,31.615 sky130_fd_pr__pfet_01v8
M$2176 550 329 536 536 sky130_fd_pr__pfet_01v8 L=0.15U W=0.42U AS=0.1092P
+ AD=0.0441P PS=1.36U PD=0.63U
* device instance $2177 r0 *1 28.44,31.615 sky130_fd_pr__pfet_01v8
M$2177 551 436 550 550 sky130_fd_pr__pfet_01v8 L=0.15U W=0.42U AS=0.0441P
+ AD=0.0693P PS=0.63U PD=0.75U
* device instance $2178 r0 *1 28.92,31.615 sky130_fd_pr__pfet_01v8
M$2178 37 535 551 551 sky130_fd_pr__pfet_01v8 L=0.15U W=0.42U AS=0.0693P
+ AD=0.14825P PS=0.75U PD=1.34U
* device instance $2179 r0 *1 29.41,31.905 sky130_fd_pr__pfet_01v8
M$2179 546 536 37 37 sky130_fd_pr__pfet_01v8 L=0.15U W=1U AS=0.14825P AD=0.28P
+ PS=1.34U PD=2.56U
* device instance $2180 r0 *1 31.77,31.905 sky130_fd_pr__pfet_01v8
M$2180 441 546 37 37 sky130_fd_pr__pfet_01v8 L=0.15U W=1U AS=0.26P AD=0.135P
+ PS=2.52U PD=1.27U
* device instance $2181 r0 *1 32.19,31.905 sky130_fd_pr__pfet_01v8
M$2181 37 513 441 441 sky130_fd_pr__pfet_01v8 L=0.15U W=1U AS=0.135P AD=0.26P
+ PS=1.27U PD=2.52U
* device instance $2182 r0 *1 35.91,31.905 sky130_fd_pr__pfet_01v8
M$2182 440 265 37 37 sky130_fd_pr__pfet_01v8 L=0.15U W=1U AS=0.26P AD=0.135P
+ PS=2.52U PD=1.27U
* device instance $2183 r0 *1 36.33,31.905 sky130_fd_pr__pfet_01v8
M$2183 37 487 440 440 sky130_fd_pr__pfet_01v8 L=0.15U W=1U AS=0.135P AD=0.26P
+ PS=1.27U PD=2.52U
* device instance $2184 r0 *1 38.19,31.905 sky130_fd_pr__pfet_01v8
M$2184 547 166 537 537 sky130_fd_pr__pfet_01v8 L=0.15U W=1U AS=0.26P AD=0.135P
+ PS=2.52U PD=1.27U
* device instance $2185 r0 *1 38.61,31.905 sky130_fd_pr__pfet_01v8
M$2185 548 372 547 547 sky130_fd_pr__pfet_01v8 L=0.15U W=1U AS=0.135P AD=0.135P
+ PS=1.27U PD=1.27U
* device instance $2186 r0 *1 39.03,31.905 sky130_fd_pr__pfet_01v8
M$2186 547 92 548 548 sky130_fd_pr__pfet_01v8 L=0.15U W=1U AS=0.135P AD=0.26P
+ PS=1.27U PD=2.52U
* device instance $2187 r0 *1 39.97,31.905 sky130_fd_pr__pfet_01v8
M$2187 548 134 37 37 sky130_fd_pr__pfet_01v8 L=0.15U W=1U AS=0.26P AD=0.165P
+ PS=2.52U PD=1.33U
* device instance $2188 r0 *1 40.45,31.905 sky130_fd_pr__pfet_01v8
M$2188 37 2 548 548 sky130_fd_pr__pfet_01v8 L=0.15U W=1U AS=0.165P AD=0.1575P
+ PS=1.33U PD=1.315U
* device instance $2189 r0 *1 40.915,31.905 sky130_fd_pr__pfet_01v8
M$2189 549 537 37 37 sky130_fd_pr__pfet_01v8 L=0.15U W=1U AS=0.1575P AD=0.26P
+ PS=1.315U PD=2.52U
* device instance $2190 r0 *1 41.85,33.195 sky130_fd_pr__pfet_01v8
M$2190 573 549 559 559 sky130_fd_pr__pfet_01v8 L=0.15U W=0.64U AS=0.1664P
+ AD=0.0672P PS=1.8U PD=0.85U
* device instance $2191 r0 *1 42.21,33.195 sky130_fd_pr__pfet_01v8
M$2191 37 560 573 573 sky130_fd_pr__pfet_01v8 L=0.15U W=0.64U AS=0.0672P
+ AD=0.1664P PS=0.85U PD=1.8U
* device instance $2192 r0 *1 41.87,31.985 sky130_fd_pr__pfet_01v8
M$2192 487 538 37 37 sky130_fd_pr__pfet_01v8 L=0.15U W=1.68U AS=0.3318P
+ AD=0.3486P PS=3.31U PD=3.35U
* device instance $2194 r0 *1 44.875,33.085 sky130_fd_pr__pfet_01v8
M$2194 561 558 559 559 sky130_fd_pr__pfet_01v8 L=0.15U W=0.42U AS=0.15985P
+ AD=0.06405P PS=1.265U PD=0.725U
* device instance $2195 r0 *1 45.33,33.085 sky130_fd_pr__pfet_01v8
M$2195 575 557 561 561 sky130_fd_pr__pfet_01v8 L=0.15U W=0.42U AS=0.06405P
+ AD=0.07665P PS=0.725U PD=0.785U
* device instance $2196 r0 *1 45.845,33.085 sky130_fd_pr__pfet_01v8
M$2196 37 562 575 575 sky130_fd_pr__pfet_01v8 L=0.15U W=0.42U AS=0.07665P
+ AD=0.178875P PS=0.785U PD=1.26U
* device instance $2197 r0 *1 43.15,33.195 sky130_fd_pr__pfet_01v8
M$2197 37 303 560 560 sky130_fd_pr__pfet_01v8 L=0.15U W=0.64U AS=0.1664P
+ AD=0.0928P PS=1.8U PD=0.93U
* device instance $2198 r0 *1 43.59,33.195 sky130_fd_pr__pfet_01v8
M$2198 574 303 37 37 sky130_fd_pr__pfet_01v8 L=0.15U W=0.64U AS=0.0928P
+ AD=0.1152P PS=0.93U PD=1U
* device instance $2199 r0 *1 44.1,33.195 sky130_fd_pr__pfet_01v8
M$2199 559 564 574 574 sky130_fd_pr__pfet_01v8 L=0.15U W=0.64U AS=0.1152P
+ AD=0.15985P PS=1U PD=1.265U
* device instance $2200 r0 *1 46.505,33.25 sky130_fd_pr__pfet_01v8
M$2200 562 561 37 37 sky130_fd_pr__pfet_01v8 L=0.15U W=0.75U AS=0.178875P
+ AD=0.195P PS=1.26U PD=2.02U
* device instance $2201 r0 *1 44.87,31.615 sky130_fd_pr__pfet_01v8
M$2201 37 514 539 539 sky130_fd_pr__pfet_01v8 L=0.15U W=0.42U AS=0.1092P
+ AD=0.1573P PS=1.36U PD=1.39U
* device instance $2202 r0 *1 45.41,31.905 sky130_fd_pr__pfet_01v8
M$2202 552 372 37 37 sky130_fd_pr__pfet_01v8 L=0.15U W=1U AS=0.1573P AD=0.105P
+ PS=1.39U PD=1.21U
* device instance $2203 r0 *1 45.77,31.905 sky130_fd_pr__pfet_01v8
M$2203 538 539 552 552 sky130_fd_pr__pfet_01v8 L=0.15U W=1U AS=0.105P AD=0.26P
+ PS=1.21U PD=2.52U
* device instance $2204 r0 *1 47.19,31.905 sky130_fd_pr__pfet_01v8
M$2204 540 999 37 37 sky130_fd_pr__pfet_01v8 L=0.15U W=2U AS=0.395P AD=0.27P
+ PS=3.79U PD=2.54U
* device instance $2206 r0 *1 48.03,31.905 sky130_fd_pr__pfet_01v8
M$2206 134 540 37 37 sky130_fd_pr__pfet_01v8 L=0.15U W=6U AS=0.81P AD=0.935P
+ PS=7.62U PD=8.87U
* device instance $2212 r0 *1 47.445,33.085 sky130_fd_pr__pfet_01v8
M$2212 576 562 37 37 sky130_fd_pr__pfet_01v8 L=0.15U W=0.42U AS=0.1092P
+ AD=0.06405P PS=1.36U PD=0.725U
* device instance $2213 r0 *1 47.9,33.085 sky130_fd_pr__pfet_01v8
M$2213 563 557 576 576 sky130_fd_pr__pfet_01v8 L=0.15U W=0.42U AS=0.06405P
+ AD=0.0567P PS=0.725U PD=0.69U
* device instance $2214 r0 *1 48.32,33.085 sky130_fd_pr__pfet_01v8
M$2214 577 558 563 563 sky130_fd_pr__pfet_01v8 L=0.15U W=0.42U AS=0.0567P
+ AD=0.0882P PS=0.69U PD=0.84U
* device instance $2215 r0 *1 48.89,33.085 sky130_fd_pr__pfet_01v8
M$2215 37 564 577 577 sky130_fd_pr__pfet_01v8 L=0.15U W=0.42U AS=0.0882P
+ AD=0.1113P PS=0.84U PD=1.37U
* device instance $2216 r0 *1 49.945,33.195 sky130_fd_pr__pfet_01v8
M$2216 37 563 564 564 sky130_fd_pr__pfet_01v8 L=0.15U W=0.64U AS=0.1728P
+ AD=0.154P PS=1.82U PD=1.335U
* device instance $2217 r0 *1 50.43,33.375 sky130_fd_pr__pfet_01v8
M$2217 514 563 37 37 sky130_fd_pr__pfet_01v8 L=0.15U W=1U AS=0.154P AD=0.28P
+ PS=1.335U PD=2.56U
* device instance $2218 r0 *1 59.81,33.375 sky130_fd_pr__pfet_01v8
M$2218 37 308 565 565 sky130_fd_pr__pfet_01v8 L=0.15U W=1U AS=0.26P AD=0.135P
+ PS=2.52U PD=1.27U
* device instance $2219 r0 *1 60.23,33.375 sky130_fd_pr__pfet_01v8
M$2219 578 565 37 37 sky130_fd_pr__pfet_01v8 L=0.15U W=4U AS=0.54P AD=0.665P
+ PS=5.08U PD=6.33U
* device instance $2223 r0 *1 60.73,27.785 sky130_fd_pr__pfet_01v8
M$2223 37 34 491 491 sky130_fd_pr__pfet_01v8 L=0.15U W=0.64U AS=0.1664P
+ AD=0.0864P PS=1.8U PD=0.91U
* device instance $2224 r0 *1 61.15,27.785 sky130_fd_pr__pfet_01v8
M$2224 492 491 37 37 sky130_fd_pr__pfet_01v8 L=0.15U W=0.64U AS=0.0864P
+ AD=0.1664P PS=0.91U PD=1.8U
* device instance $2225 r0 *1 62.57,33.375 sky130_fd_pr__pfet_01v8
M$2225 568 566 567 567 sky130_fd_pr__pfet_01v8 L=0.15U W=1U AS=0.26P AD=0.135P
+ PS=2.52U PD=1.27U
* device instance $2226 r0 *1 62.99,33.375 sky130_fd_pr__pfet_01v8
M$2226 570 569 568 568 sky130_fd_pr__pfet_01v8 L=0.15U W=1U AS=0.135P AD=0.135P
+ PS=1.27U PD=1.27U
* device instance $2227 r0 *1 63.41,33.375 sky130_fd_pr__pfet_01v8
M$2227 568 92 570 570 sky130_fd_pr__pfet_01v8 L=0.15U W=1U AS=0.135P AD=0.26P
+ PS=1.27U PD=2.52U
* device instance $2228 r0 *1 64.35,33.375 sky130_fd_pr__pfet_01v8
M$2228 570 157 37 37 sky130_fd_pr__pfet_01v8 L=0.15U W=1U AS=0.26P AD=0.165P
+ PS=2.52U PD=1.33U
* device instance $2229 r0 *1 64.83,33.375 sky130_fd_pr__pfet_01v8
M$2229 37 572 570 570 sky130_fd_pr__pfet_01v8 L=0.15U W=1U AS=0.165P AD=0.1575P
+ PS=1.33U PD=1.315U
* device instance $2230 r0 *1 65.295,33.375 sky130_fd_pr__pfet_01v8
M$2230 571 567 37 37 sky130_fd_pr__pfet_01v8 L=0.15U W=1U AS=0.1575P AD=0.26P
+ PS=1.315U PD=2.52U
* device instance $2231 r0 *1 8.75,37.345 sky130_fd_pr__pfet_01v8
M$2231 615 588 589 589 sky130_fd_pr__pfet_01v8 L=0.15U W=1U AS=0.26P AD=0.135P
+ PS=2.52U PD=1.27U
* device instance $2232 r0 *1 9.17,37.345 sky130_fd_pr__pfet_01v8
M$2232 616 408 615 615 sky130_fd_pr__pfet_01v8 L=0.15U W=1U AS=0.135P AD=0.135P
+ PS=1.27U PD=1.27U
* device instance $2233 r0 *1 9.59,37.345 sky130_fd_pr__pfet_01v8
M$2233 615 92 616 616 sky130_fd_pr__pfet_01v8 L=0.15U W=1U AS=0.135P AD=0.26P
+ PS=1.27U PD=2.52U
* device instance $2234 r0 *1 10.53,37.345 sky130_fd_pr__pfet_01v8
M$2234 616 157 37 37 sky130_fd_pr__pfet_01v8 L=0.15U W=1U AS=0.26P AD=0.165P
+ PS=2.52U PD=1.33U
* device instance $2235 r0 *1 11.01,37.345 sky130_fd_pr__pfet_01v8
M$2235 37 590 616 616 sky130_fd_pr__pfet_01v8 L=0.15U W=1U AS=0.165P AD=0.1575P
+ PS=1.33U PD=1.315U
* device instance $2236 r0 *1 11.475,37.345 sky130_fd_pr__pfet_01v8
M$2236 591 589 37 37 sky130_fd_pr__pfet_01v8 L=0.15U W=1U AS=0.1575P AD=0.26P
+ PS=1.315U PD=2.52U
* device instance $2237 r0 *1 12.53,37.525 sky130_fd_pr__pfet_01v8
M$2237 619 579 592 592 sky130_fd_pr__pfet_01v8 L=0.15U W=0.64U AS=0.1664P
+ AD=0.0672P PS=1.8U PD=0.85U
* device instance $2238 r0 *1 12.89,37.525 sky130_fd_pr__pfet_01v8
M$2238 37 593 619 619 sky130_fd_pr__pfet_01v8 L=0.15U W=0.64U AS=0.0672P
+ AD=0.0864P PS=0.85U PD=0.91U
* device instance $2239 r0 *1 13.31,37.525 sky130_fd_pr__pfet_01v8
M$2239 620 593 37 37 sky130_fd_pr__pfet_01v8 L=0.15U W=0.64U AS=0.0864P
+ AD=0.0672P PS=0.91U PD=0.85U
* device instance $2240 r0 *1 13.67,37.525 sky130_fd_pr__pfet_01v8
M$2240 592 594 620 620 sky130_fd_pr__pfet_01v8 L=0.15U W=0.64U AS=0.0672P
+ AD=0.0864P PS=0.85U PD=0.91U
* device instance $2241 r0 *1 14.09,37.525 sky130_fd_pr__pfet_01v8
M$2241 621 594 592 592 sky130_fd_pr__pfet_01v8 L=0.15U W=0.64U AS=0.0864P
+ AD=0.0672P PS=0.91U PD=0.85U
* device instance $2242 r0 *1 14.45,37.525 sky130_fd_pr__pfet_01v8
M$2242 621 579 37 37 sky130_fd_pr__pfet_01v8 L=0.15U W=0.64U AS=0.237P
+ AD=0.0672P PS=1.6U PD=0.85U
* device instance $2243 r0 *1 15.2,37.345 sky130_fd_pr__pfet_01v8
M$2243 341 592 37 37 sky130_fd_pr__pfet_01v8 L=0.15U W=2U AS=0.372P AD=0.405P
+ PS=2.87U PD=3.81U
* device instance $2245 r0 *1 31.29,37.425 sky130_fd_pr__pfet_01v8
M$2245 535 595 37 37 sky130_fd_pr__pfet_01v8 L=0.15U W=1.68U AS=0.3318P
+ AD=0.3486P PS=3.31U PD=3.35U
* device instance $2247 r0 *1 34.05,37.055 sky130_fd_pr__pfet_01v8
M$2247 37 651 596 596 sky130_fd_pr__pfet_01v8 L=0.15U W=0.42U AS=0.1092P
+ AD=0.14575P PS=1.36U PD=1.335U
* device instance $2248 r0 *1 34.535,37.345 sky130_fd_pr__pfet_01v8
M$2248 513 597 37 37 sky130_fd_pr__pfet_01v8 L=0.15U W=1U AS=0.14575P AD=0.135P
+ PS=1.335U PD=1.27U
* device instance $2249 r0 *1 34.955,37.345 sky130_fd_pr__pfet_01v8
M$2249 37 596 513 513 sky130_fd_pr__pfet_01v8 L=0.15U W=1U AS=0.135P AD=0.265P
+ PS=1.27U PD=2.53U
* device instance $2250 r0 *1 40.49,33.225 sky130_fd_pr__pfet_01v8
M$2250 37 34 557 557 sky130_fd_pr__pfet_01v8 L=0.15U W=0.64U AS=0.1664P
+ AD=0.0864P PS=1.8U PD=0.91U
* device instance $2251 r0 *1 40.91,33.225 sky130_fd_pr__pfet_01v8
M$2251 558 557 37 37 sky130_fd_pr__pfet_01v8 L=0.15U W=0.64U AS=0.0864P
+ AD=0.1664P PS=0.91U PD=1.8U
* device instance $2252 r0 *1 59.42,37.635 sky130_fd_pr__pfet_01v8
M$2252 598 599 37 37 sky130_fd_pr__pfet_01v8 L=0.15U W=0.42U AS=0.1113P
+ AD=0.0609P PS=1.37U PD=0.71U
* device instance $2253 r0 *1 59.86,37.635 sky130_fd_pr__pfet_01v8
M$2253 598 115 37 37 sky130_fd_pr__pfet_01v8 L=0.15U W=0.42U AS=0.1841P
+ AD=0.0609P PS=1.26U PD=0.71U
* device instance $2254 r0 *1 60.63,37.525 sky130_fd_pr__pfet_01v8
M$2254 566 598 37 37 sky130_fd_pr__pfet_01v8 L=0.15U W=0.64U AS=0.1841P
+ AD=0.1696P PS=1.26U PD=1.81U
* device instance $2255 r0 *1 61.67,37.345 sky130_fd_pr__pfet_01v8
M$2255 600 578 37 37 sky130_fd_pr__pfet_01v8 L=0.15U W=1U AS=0.26P AD=0.135P
+ PS=2.52U PD=1.27U
* device instance $2256 r0 *1 62.09,37.345 sky130_fd_pr__pfet_01v8
M$2256 37 342 600 600 sky130_fd_pr__pfet_01v8 L=0.15U W=1U AS=0.135P AD=0.26P
+ PS=1.27U PD=2.52U
* device instance $2257 r0 *1 63.07,37.345 sky130_fd_pr__pfet_01v8
M$2257 601 600 37 37 sky130_fd_pr__pfet_01v8 L=0.15U W=1U AS=0.3P AD=0.135P
+ PS=2.6U PD=1.27U
* device instance $2258 r0 *1 63.49,37.345 sky130_fd_pr__pfet_01v8
M$2258 37 602 601 601 sky130_fd_pr__pfet_01v8 L=0.15U W=1U AS=0.135P AD=0.365P
+ PS=1.27U PD=1.73U
* device instance $2259 r0 *1 64.37,37.345 sky130_fd_pr__pfet_01v8
M$2259 618 602 37 37 sky130_fd_pr__pfet_01v8 L=0.15U W=1U AS=0.365P AD=0.105P
+ PS=1.73U PD=1.21U
* device instance $2260 r0 *1 64.73,37.345 sky130_fd_pr__pfet_01v8
M$2260 572 600 618 618 sky130_fd_pr__pfet_01v8 L=0.15U W=1U AS=0.105P AD=0.165P
+ PS=1.21U PD=1.33U
* device instance $2261 r0 *1 65.21,37.345 sky130_fd_pr__pfet_01v8
M$2261 37 601 572 572 sky130_fd_pr__pfet_01v8 L=0.15U W=1U AS=0.165P AD=0.36P
+ PS=1.33U PD=2.72U
* device instance $2262 r0 *1 66.49,37.055 sky130_fd_pr__pfet_01v8
M$2262 37 652 604 604 sky130_fd_pr__pfet_01v8 L=0.15U W=0.42U AS=0.1092P
+ AD=0.1573P PS=1.36U PD=1.39U
* device instance $2263 r0 *1 67.03,37.345 sky130_fd_pr__pfet_01v8
M$2263 617 569 37 37 sky130_fd_pr__pfet_01v8 L=0.15U W=1U AS=0.1573P AD=0.105P
+ PS=1.39U PD=1.21U
* device instance $2264 r0 *1 67.39,37.345 sky130_fd_pr__pfet_01v8
M$2264 605 604 617 617 sky130_fd_pr__pfet_01v8 L=0.15U W=1U AS=0.105P AD=0.26P
+ PS=1.21U PD=2.52U
* device instance $2265 r0 *1 4.68,38.525 sky130_fd_pr__pfet_01v8
M$2265 623 622 37 37 sky130_fd_pr__pfet_01v8 L=0.15U W=0.42U AS=0.1113P
+ AD=0.0609P PS=1.37U PD=0.71U
* device instance $2266 r0 *1 5.12,38.525 sky130_fd_pr__pfet_01v8
M$2266 37 115 623 623 sky130_fd_pr__pfet_01v8 L=0.15U W=0.42U AS=0.0609P
+ AD=0.1841P PS=0.71U PD=1.26U
* device instance $2267 r0 *1 5.89,38.635 sky130_fd_pr__pfet_01v8
M$2267 588 623 37 37 sky130_fd_pr__pfet_01v8 L=0.15U W=0.64U AS=0.1841P
+ AD=0.1696P PS=1.26U PD=1.81U
* device instance $2268 r0 *1 7.455,38.72 sky130_fd_pr__pfet_01v8
M$2268 646 64 37 37 sky130_fd_pr__pfet_01v8 L=0.15U W=0.42U AS=0.15835P
+ AD=0.07665P PS=1.395U PD=0.785U
* device instance $2269 r0 *1 7.97,38.72 sky130_fd_pr__pfet_01v8
M$2269 625 594 646 646 sky130_fd_pr__pfet_01v8 L=0.15U W=0.42U AS=0.07665P
+ AD=0.1932P PS=0.785U PD=1.34U
* device instance $2270 r0 *1 9.04,38.72 sky130_fd_pr__pfet_01v8
M$2270 647 626 625 625 sky130_fd_pr__pfet_01v8 L=0.15U W=0.42U AS=0.1932P
+ AD=0.0441P PS=1.34U PD=0.63U
* device instance $2271 r0 *1 9.4,38.72 sky130_fd_pr__pfet_01v8
M$2271 37 658 647 647 sky130_fd_pr__pfet_01v8 L=0.15U W=0.42U AS=0.0441P
+ AD=0.0693P PS=0.63U PD=0.75U
* device instance $2272 r0 *1 9.88,38.72 sky130_fd_pr__pfet_01v8
M$2272 658 64 37 37 sky130_fd_pr__pfet_01v8 L=0.15U W=0.42U AS=0.0693P
+ AD=0.1176P PS=0.75U PD=1.4U
* device instance $2273 r0 *1 6.91,38.815 sky130_fd_pr__pfet_01v8
M$2273 37 625 624 624 sky130_fd_pr__pfet_01v8 L=0.15U W=1U AS=0.26P AD=0.15835P
+ PS=2.52U PD=1.395U
* device instance $2274 r0 *1 11.09,38.815 sky130_fd_pr__pfet_01v8
M$2274 627 629 37 37 sky130_fd_pr__pfet_01v8 L=0.15U W=1U AS=0.3P AD=0.135P
+ PS=2.6U PD=1.27U
* device instance $2275 r0 *1 11.51,38.815 sky130_fd_pr__pfet_01v8
M$2275 37 628 627 627 sky130_fd_pr__pfet_01v8 L=0.15U W=1U AS=0.135P AD=0.365P
+ PS=1.27U PD=1.73U
* device instance $2276 r0 *1 12.39,38.815 sky130_fd_pr__pfet_01v8
M$2276 655 628 37 37 sky130_fd_pr__pfet_01v8 L=0.15U W=1U AS=0.365P AD=0.105P
+ PS=1.73U PD=1.21U
* device instance $2277 r0 *1 12.75,38.815 sky130_fd_pr__pfet_01v8
M$2277 590 629 655 655 sky130_fd_pr__pfet_01v8 L=0.15U W=1U AS=0.105P AD=0.165P
+ PS=1.21U PD=1.33U
* device instance $2278 r0 *1 13.23,38.815 sky130_fd_pr__pfet_01v8
M$2278 37 627 590 590 sky130_fd_pr__pfet_01v8 L=0.15U W=1U AS=0.165P AD=0.36P
+ PS=1.33U PD=2.72U
* device instance $2279 r0 *1 14.31,38.815 sky130_fd_pr__pfet_01v8
M$2279 656 594 630 630 sky130_fd_pr__pfet_01v8 L=0.15U W=1U AS=0.26P AD=0.135P
+ PS=2.52U PD=1.27U
* device instance $2280 r0 *1 14.73,38.815 sky130_fd_pr__pfet_01v8
M$2280 37 408 656 656 sky130_fd_pr__pfet_01v8 L=0.15U W=1U AS=0.135P AD=0.135P
+ PS=1.27U PD=1.27U
* device instance $2281 r0 *1 15.15,38.815 sky130_fd_pr__pfet_01v8
M$2281 631 408 37 37 sky130_fd_pr__pfet_01v8 L=0.15U W=1U AS=0.135P AD=0.135P
+ PS=1.27U PD=1.27U
* device instance $2282 r0 *1 15.57,38.815 sky130_fd_pr__pfet_01v8
M$2282 37 594 631 631 sky130_fd_pr__pfet_01v8 L=0.15U W=1U AS=0.135P AD=0.26P
+ PS=1.27U PD=2.52U
* device instance $2283 r0 *1 16.51,38.815 sky130_fd_pr__pfet_01v8
M$2283 629 630 631 631 sky130_fd_pr__pfet_01v8 L=0.15U W=1U AS=0.26P AD=0.3P
+ PS=2.52U PD=2.6U
* device instance $2284 r0 *1 25.77,38.815 sky130_fd_pr__pfet_01v8
M$2284 633 650 632 632 sky130_fd_pr__pfet_01v8 L=0.15U W=1U AS=0.26P AD=0.135P
+ PS=2.52U PD=1.27U
* device instance $2285 r0 *1 26.19,38.815 sky130_fd_pr__pfet_01v8
M$2285 634 651 633 633 sky130_fd_pr__pfet_01v8 L=0.15U W=1U AS=0.135P AD=0.135P
+ PS=1.27U PD=1.27U
* device instance $2286 r0 *1 26.61,38.815 sky130_fd_pr__pfet_01v8
M$2286 633 92 634 634 sky130_fd_pr__pfet_01v8 L=0.15U W=1U AS=0.135P AD=0.26P
+ PS=1.27U PD=2.52U
* device instance $2287 r0 *1 27.55,38.815 sky130_fd_pr__pfet_01v8
M$2287 634 134 37 37 sky130_fd_pr__pfet_01v8 L=0.15U W=1U AS=0.26P AD=0.165P
+ PS=2.52U PD=1.33U
* device instance $2288 r0 *1 28.03,38.815 sky130_fd_pr__pfet_01v8
M$2288 37 556 634 634 sky130_fd_pr__pfet_01v8 L=0.15U W=1U AS=0.165P AD=0.1575P
+ PS=1.33U PD=1.315U
* device instance $2289 r0 *1 28.495,38.815 sky130_fd_pr__pfet_01v8
M$2289 635 632 37 37 sky130_fd_pr__pfet_01v8 L=0.15U W=1U AS=0.1575P AD=0.26P
+ PS=1.315U PD=2.52U
* device instance $2290 r0 *1 30.87,38.815 sky130_fd_pr__pfet_01v8
M$2290 636 597 37 37 sky130_fd_pr__pfet_01v8 L=0.15U W=1U AS=0.3P AD=0.135P
+ PS=2.6U PD=1.27U
* device instance $2291 r0 *1 31.29,38.815 sky130_fd_pr__pfet_01v8
M$2291 37 651 636 636 sky130_fd_pr__pfet_01v8 L=0.15U W=1U AS=0.135P AD=0.365P
+ PS=1.27U PD=1.73U
* device instance $2292 r0 *1 32.17,38.815 sky130_fd_pr__pfet_01v8
M$2292 657 651 37 37 sky130_fd_pr__pfet_01v8 L=0.15U W=1U AS=0.365P AD=0.105P
+ PS=1.73U PD=1.21U
* device instance $2293 r0 *1 32.53,38.815 sky130_fd_pr__pfet_01v8
M$2293 595 597 657 657 sky130_fd_pr__pfet_01v8 L=0.15U W=1U AS=0.105P AD=0.165P
+ PS=1.21U PD=1.33U
* device instance $2294 r0 *1 33.01,38.815 sky130_fd_pr__pfet_01v8
M$2294 37 636 595 595 sky130_fd_pr__pfet_01v8 L=0.15U W=1U AS=0.165P AD=0.36P
+ PS=1.33U PD=2.72U
* device instance $2295 r0 *1 35.435,38.815 sky130_fd_pr__pfet_01v8
M$2295 637 661 37 37 sky130_fd_pr__pfet_01v8 L=0.15U W=4U AS=0.685P AD=0.56P
+ PS=6.37U PD=5.12U
* device instance $2299 r0 *1 37.155,38.815 sky130_fd_pr__pfet_01v8
M$2299 298 637 37 37 sky130_fd_pr__pfet_01v8 L=0.15U W=16U AS=2.2375P
+ AD=2.3625P PS=20.475U PD=21.725U
* device instance $2315 r0 *1 55.67,38.815 sky130_fd_pr__pfet_01v8
M$2315 638 578 37 37 sky130_fd_pr__pfet_01v8 L=0.15U W=1U AS=0.26P AD=0.135P
+ PS=2.52U PD=1.27U
* device instance $2316 r0 *1 56.09,38.815 sky130_fd_pr__pfet_01v8
M$2316 37 342 638 638 sky130_fd_pr__pfet_01v8 L=0.15U W=1U AS=0.135P AD=0.1525P
+ PS=1.27U PD=1.305U
* device instance $2317 r0 *1 56.545,38.815 sky130_fd_pr__pfet_01v8
M$2317 638 602 37 37 sky130_fd_pr__pfet_01v8 L=0.15U W=1U AS=0.1525P AD=0.1625P
+ PS=1.305U PD=1.325U
* device instance $2318 r0 *1 57.02,38.815 sky130_fd_pr__pfet_01v8
M$2318 639 605 638 638 sky130_fd_pr__pfet_01v8 L=0.15U W=1U AS=0.1625P AD=0.27P
+ PS=1.325U PD=2.54U
* device instance $2319 r0 *1 59.35,38.815 sky130_fd_pr__pfet_01v8
M$2319 640 342 37 37 sky130_fd_pr__pfet_01v8 L=0.15U W=1U AS=0.26P AD=0.1375P
+ PS=2.52U PD=1.275U
* device instance $2320 r0 *1 59.775,38.815 sky130_fd_pr__pfet_01v8
M$2320 37 308 640 640 sky130_fd_pr__pfet_01v8 L=0.15U W=1U AS=0.1375P AD=0.14P
+ PS=1.275U PD=1.28U
* device instance $2321 r0 *1 60.205,38.815 sky130_fd_pr__pfet_01v8
M$2321 640 602 37 37 sky130_fd_pr__pfet_01v8 L=0.15U W=1U AS=0.14P AD=0.165P
+ PS=1.28U PD=1.33U
* device instance $2322 r0 *1 60.685,38.815 sky130_fd_pr__pfet_01v8
M$2322 654 605 640 640 sky130_fd_pr__pfet_01v8 L=0.15U W=1U AS=0.165P
+ AD=0.1725P PS=1.33U PD=1.345U
* device instance $2323 r0 *1 61.18,38.815 sky130_fd_pr__pfet_01v8
M$2323 641 662 654 654 sky130_fd_pr__pfet_01v8 L=0.15U W=1U AS=0.1725P AD=0.26P
+ PS=1.345U PD=2.52U
* device instance $2324 r0 *1 64.45,38.815 sky130_fd_pr__pfet_01v8
M$2324 642 652 37 37 sky130_fd_pr__pfet_01v8 L=0.15U W=1U AS=0.3P AD=0.135P
+ PS=2.6U PD=1.27U
* device instance $2325 r0 *1 64.87,38.815 sky130_fd_pr__pfet_01v8
M$2325 37 569 642 642 sky130_fd_pr__pfet_01v8 L=0.15U W=1U AS=0.135P AD=0.365P
+ PS=1.27U PD=1.73U
* device instance $2326 r0 *1 65.75,38.815 sky130_fd_pr__pfet_01v8
M$2326 653 569 37 37 sky130_fd_pr__pfet_01v8 L=0.15U W=1U AS=0.365P AD=0.105P
+ PS=1.73U PD=1.21U
* device instance $2327 r0 *1 66.11,38.815 sky130_fd_pr__pfet_01v8
M$2327 602 652 653 653 sky130_fd_pr__pfet_01v8 L=0.15U W=1U AS=0.105P AD=0.165P
+ PS=1.21U PD=1.33U
* device instance $2328 r0 *1 66.59,38.815 sky130_fd_pr__pfet_01v8
M$2328 37 642 602 602 sky130_fd_pr__pfet_01v8 L=0.15U W=1U AS=0.165P AD=0.36P
+ PS=1.33U PD=2.72U
* device instance $2329 r0 *1 68.635,38.72 sky130_fd_pr__pfet_01v8
M$2329 649 64 37 37 sky130_fd_pr__pfet_01v8 L=0.15U W=0.42U AS=0.15835P
+ AD=0.07665P PS=1.395U PD=0.785U
* device instance $2330 r0 *1 69.15,38.72 sky130_fd_pr__pfet_01v8
M$2330 644 652 649 649 sky130_fd_pr__pfet_01v8 L=0.15U W=0.42U AS=0.07665P
+ AD=0.1932P PS=0.785U PD=1.34U
* device instance $2331 r0 *1 70.22,38.72 sky130_fd_pr__pfet_01v8
M$2331 648 645 644 644 sky130_fd_pr__pfet_01v8 L=0.15U W=0.42U AS=0.1932P
+ AD=0.0441P PS=1.34U PD=0.63U
* device instance $2332 r0 *1 70.58,38.72 sky130_fd_pr__pfet_01v8
M$2332 37 664 648 648 sky130_fd_pr__pfet_01v8 L=0.15U W=0.42U AS=0.0441P
+ AD=0.0693P PS=0.63U PD=0.75U
* device instance $2333 r0 *1 71.06,38.72 sky130_fd_pr__pfet_01v8
M$2333 664 64 37 37 sky130_fd_pr__pfet_01v8 L=0.15U W=0.42U AS=0.0693P
+ AD=0.1176P PS=0.75U PD=1.4U
* device instance $2334 r0 *1 68.09,38.815 sky130_fd_pr__pfet_01v8
M$2334 37 644 643 643 sky130_fd_pr__pfet_01v8 L=0.15U W=1U AS=0.26P AD=0.15835P
+ PS=2.52U PD=1.395U
* device instance $2335 r0 *1 2.77,42.935 sky130_fd_pr__pfet_01v8
M$2335 37 681 680 680 sky130_fd_pr__pfet_01v8 L=0.15U W=0.64U AS=0.1664P
+ AD=0.0864P PS=1.8U PD=0.91U
* device instance $2336 r0 *1 3.19,42.935 sky130_fd_pr__pfet_01v8
M$2336 682 680 37 37 sky130_fd_pr__pfet_01v8 L=0.15U W=0.64U AS=0.0864P
+ AD=0.1664P PS=0.91U PD=1.8U
* device instance $2337 r0 *1 4.13,42.965 sky130_fd_pr__pfet_01v8
M$2337 737 624 683 683 sky130_fd_pr__pfet_01v8 L=0.15U W=0.64U AS=0.1664P
+ AD=0.0672P PS=1.8U PD=0.85U
* device instance $2338 r0 *1 4.49,42.965 sky130_fd_pr__pfet_01v8
M$2338 37 684 737 737 sky130_fd_pr__pfet_01v8 L=0.15U W=0.64U AS=0.0672P
+ AD=0.1664P PS=0.85U PD=1.8U
* device instance $2339 r0 *1 5.43,42.965 sky130_fd_pr__pfet_01v8
M$2339 37 94 684 684 sky130_fd_pr__pfet_01v8 L=0.15U W=0.64U AS=0.1664P
+ AD=0.0928P PS=1.8U PD=0.93U
* device instance $2340 r0 *1 5.87,42.965 sky130_fd_pr__pfet_01v8
M$2340 739 94 37 37 sky130_fd_pr__pfet_01v8 L=0.15U W=0.64U AS=0.0928P
+ AD=0.1152P PS=0.93U PD=1U
* device instance $2341 r0 *1 6.38,42.965 sky130_fd_pr__pfet_01v8
M$2341 683 685 739 739 sky130_fd_pr__pfet_01v8 L=0.15U W=0.64U AS=0.1152P
+ AD=0.15985P PS=1U PD=1.265U
* device instance $2342 r0 *1 7.155,43.075 sky130_fd_pr__pfet_01v8
M$2342 686 682 683 683 sky130_fd_pr__pfet_01v8 L=0.15U W=0.42U AS=0.15985P
+ AD=0.06405P PS=1.265U PD=0.725U
* device instance $2343 r0 *1 7.61,43.075 sky130_fd_pr__pfet_01v8
M$2343 742 680 686 686 sky130_fd_pr__pfet_01v8 L=0.15U W=0.42U AS=0.06405P
+ AD=0.07665P PS=0.725U PD=0.785U
* device instance $2344 r0 *1 8.125,43.075 sky130_fd_pr__pfet_01v8
M$2344 742 687 37 37 sky130_fd_pr__pfet_01v8 L=0.15U W=0.42U AS=0.178875P
+ AD=0.07665P PS=1.26U PD=0.785U
* device instance $2345 r0 *1 8.785,42.91 sky130_fd_pr__pfet_01v8
M$2345 687 686 37 37 sky130_fd_pr__pfet_01v8 L=0.15U W=0.75U AS=0.178875P
+ AD=0.195P PS=1.26U PD=2.02U
* device instance $2346 r0 *1 12.225,42.965 sky130_fd_pr__pfet_01v8
M$2346 685 688 37 37 sky130_fd_pr__pfet_01v8 L=0.15U W=0.64U AS=0.154P
+ AD=0.1728P PS=1.335U PD=1.82U
* device instance $2347 r0 *1 12.71,42.785 sky130_fd_pr__pfet_01v8
M$2347 554 688 37 37 sky130_fd_pr__pfet_01v8 L=0.15U W=1U AS=0.154P AD=0.28P
+ PS=1.335U PD=2.56U
* device instance $2348 r0 *1 13.81,42.785 sky130_fd_pr__pfet_01v8
M$2348 37 554 689 689 sky130_fd_pr__pfet_01v8 L=0.15U W=1U AS=0.26P AD=0.135P
+ PS=2.52U PD=1.27U
* device instance $2349 r0 *1 14.23,42.785 sky130_fd_pr__pfet_01v8
M$2349 408 689 37 37 sky130_fd_pr__pfet_01v8 L=0.15U W=4U AS=0.54P AD=0.665P
+ PS=5.08U PD=6.33U
* device instance $2353 r0 *1 17.03,42.785 sky130_fd_pr__pfet_01v8
M$2353 37 593 690 690 sky130_fd_pr__pfet_01v8 L=0.15U W=1U AS=0.26P AD=0.135P
+ PS=2.52U PD=1.27U
* device instance $2354 r0 *1 17.45,42.785 sky130_fd_pr__pfet_01v8
M$2354 628 690 37 37 sky130_fd_pr__pfet_01v8 L=0.15U W=4U AS=0.54P AD=0.665P
+ PS=5.08U PD=6.33U
* device instance $2358 r0 *1 26.23,42.935 sky130_fd_pr__pfet_01v8
M$2358 37 681 692 692 sky130_fd_pr__pfet_01v8 L=0.15U W=0.64U AS=0.1664P
+ AD=0.0864P PS=1.8U PD=0.91U
* device instance $2359 r0 *1 26.65,42.935 sky130_fd_pr__pfet_01v8
M$2359 693 692 37 37 sky130_fd_pr__pfet_01v8 L=0.15U W=0.64U AS=0.0864P
+ AD=0.1664P PS=0.91U PD=1.8U
* device instance $2360 r0 *1 27.59,42.965 sky130_fd_pr__pfet_01v8
M$2360 754 727 694 694 sky130_fd_pr__pfet_01v8 L=0.15U W=0.64U AS=0.1664P
+ AD=0.0672P PS=1.8U PD=0.85U
* device instance $2361 r0 *1 27.95,42.965 sky130_fd_pr__pfet_01v8
M$2361 37 695 754 754 sky130_fd_pr__pfet_01v8 L=0.15U W=0.64U AS=0.0672P
+ AD=0.1664P PS=0.85U PD=1.8U
* device instance $2362 r0 *1 28.89,42.965 sky130_fd_pr__pfet_01v8
M$2362 37 94 695 695 sky130_fd_pr__pfet_01v8 L=0.15U W=0.64U AS=0.1664P
+ AD=0.0928P PS=1.8U PD=0.93U
* device instance $2363 r0 *1 29.33,42.965 sky130_fd_pr__pfet_01v8
M$2363 753 94 37 37 sky130_fd_pr__pfet_01v8 L=0.15U W=0.64U AS=0.0928P
+ AD=0.1152P PS=0.93U PD=1U
* device instance $2364 r0 *1 29.84,42.965 sky130_fd_pr__pfet_01v8
M$2364 694 696 753 753 sky130_fd_pr__pfet_01v8 L=0.15U W=0.64U AS=0.1152P
+ AD=0.15985P PS=1U PD=1.265U
* device instance $2365 r0 *1 30.615,43.075 sky130_fd_pr__pfet_01v8
M$2365 697 693 694 694 sky130_fd_pr__pfet_01v8 L=0.15U W=0.42U AS=0.15985P
+ AD=0.06405P PS=1.265U PD=0.725U
* device instance $2366 r0 *1 31.07,43.075 sky130_fd_pr__pfet_01v8
M$2366 752 692 697 697 sky130_fd_pr__pfet_01v8 L=0.15U W=0.42U AS=0.06405P
+ AD=0.07665P PS=0.725U PD=0.785U
* device instance $2367 r0 *1 31.585,43.075 sky130_fd_pr__pfet_01v8
M$2367 752 698 37 37 sky130_fd_pr__pfet_01v8 L=0.15U W=0.42U AS=0.178875P
+ AD=0.07665P PS=1.26U PD=0.785U
* device instance $2368 r0 *1 32.245,42.91 sky130_fd_pr__pfet_01v8
M$2368 698 697 37 37 sky130_fd_pr__pfet_01v8 L=0.15U W=0.75U AS=0.178875P
+ AD=0.195P PS=1.26U PD=2.02U
* device instance $2369 r0 *1 35.685,42.965 sky130_fd_pr__pfet_01v8
M$2369 696 699 37 37 sky130_fd_pr__pfet_01v8 L=0.15U W=0.64U AS=0.154P
+ AD=0.1728P PS=1.335U PD=1.82U
* device instance $2370 r0 *1 36.17,42.785 sky130_fd_pr__pfet_01v8
M$2370 651 699 37 37 sky130_fd_pr__pfet_01v8 L=0.15U W=1U AS=0.154P AD=0.28P
+ PS=1.335U PD=2.56U
* device instance $2371 r0 *1 44.63,42.785 sky130_fd_pr__pfet_01v8
M$2371 749 651 734 734 sky130_fd_pr__pfet_01v8 L=0.15U W=1U AS=0.26P AD=0.13P
+ PS=2.52U PD=1.26U
* device instance $2372 r0 *1 45.04,42.785 sky130_fd_pr__pfet_01v8
M$2372 748 372 749 749 sky130_fd_pr__pfet_01v8 L=0.15U W=1U AS=0.13P AD=0.19P
+ PS=1.26U PD=1.38U
* device instance $2373 r0 *1 45.57,42.785 sky130_fd_pr__pfet_01v8
M$2373 747 728 748 748 sky130_fd_pr__pfet_01v8 L=0.15U W=1U AS=0.19P AD=0.135P
+ PS=1.38U PD=1.27U
* device instance $2374 r0 *1 45.99,42.785 sky130_fd_pr__pfet_01v8
M$2374 37 1134 747 747 sky130_fd_pr__pfet_01v8 L=0.15U W=1U AS=0.135P AD=0.26P
+ PS=1.27U PD=2.52U
* device instance $2375 r0 *1 49.23,42.785 sky130_fd_pr__pfet_01v8
M$2375 896 734 37 37 sky130_fd_pr__pfet_01v8 L=0.15U W=1U AS=0.26P AD=0.135P
+ PS=2.52U PD=1.27U
* device instance $2376 r0 *1 49.65,42.785 sky130_fd_pr__pfet_01v8
M$2376 37 700 896 896 sky130_fd_pr__pfet_01v8 L=0.15U W=1U AS=0.135P AD=0.165P
+ PS=1.27U PD=1.33U
* device instance $2377 r0 *1 50.13,42.785 sky130_fd_pr__pfet_01v8
M$2377 896 409 37 37 sky130_fd_pr__pfet_01v8 L=0.15U W=1U AS=0.165P AD=0.26P
+ PS=1.33U PD=2.52U
* device instance $2378 r0 *1 57.55,42.785 sky130_fd_pr__pfet_01v8
M$2378 730 729 37 37 sky130_fd_pr__pfet_01v8 L=0.15U W=1U AS=0.3P AD=0.135P
+ PS=2.6U PD=1.27U
* device instance $2379 r0 *1 57.97,42.785 sky130_fd_pr__pfet_01v8
M$2379 37 639 730 730 sky130_fd_pr__pfet_01v8 L=0.15U W=1U AS=0.135P AD=0.365P
+ PS=1.27U PD=1.73U
* device instance $2380 r0 *1 58.85,42.785 sky130_fd_pr__pfet_01v8
M$2380 746 639 37 37 sky130_fd_pr__pfet_01v8 L=0.15U W=1U AS=0.365P AD=0.105P
+ PS=1.73U PD=1.21U
* device instance $2381 r0 *1 59.21,42.785 sky130_fd_pr__pfet_01v8
M$2381 735 729 746 746 sky130_fd_pr__pfet_01v8 L=0.15U W=1U AS=0.105P AD=0.165P
+ PS=1.21U PD=1.33U
* device instance $2382 r0 *1 59.69,42.785 sky130_fd_pr__pfet_01v8
M$2382 37 730 735 735 sky130_fd_pr__pfet_01v8 L=0.15U W=1U AS=0.165P AD=0.36P
+ PS=1.33U PD=2.72U
* device instance $2383 r0 *1 60.73,42.935 sky130_fd_pr__pfet_01v8
M$2383 37 979 702 702 sky130_fd_pr__pfet_01v8 L=0.15U W=0.64U AS=0.1664P
+ AD=0.0864P PS=1.8U PD=0.91U
* device instance $2384 r0 *1 61.15,42.935 sky130_fd_pr__pfet_01v8
M$2384 703 702 37 37 sky130_fd_pr__pfet_01v8 L=0.15U W=0.64U AS=0.0864P
+ AD=0.1664P PS=0.91U PD=1.8U
* device instance $2385 r0 *1 62.09,42.965 sky130_fd_pr__pfet_01v8
M$2385 743 571 704 704 sky130_fd_pr__pfet_01v8 L=0.15U W=0.64U AS=0.1664P
+ AD=0.0672P PS=1.8U PD=0.85U
* device instance $2386 r0 *1 62.45,42.965 sky130_fd_pr__pfet_01v8
M$2386 37 705 743 743 sky130_fd_pr__pfet_01v8 L=0.15U W=0.64U AS=0.0672P
+ AD=0.1664P PS=0.85U PD=1.8U
* device instance $2387 r0 *1 63.39,42.965 sky130_fd_pr__pfet_01v8
M$2387 37 303 705 705 sky130_fd_pr__pfet_01v8 L=0.15U W=0.64U AS=0.1664P
+ AD=0.0928P PS=1.8U PD=0.93U
* device instance $2388 r0 *1 63.83,42.965 sky130_fd_pr__pfet_01v8
M$2388 741 303 37 37 sky130_fd_pr__pfet_01v8 L=0.15U W=0.64U AS=0.0928P
+ AD=0.1152P PS=0.93U PD=1U
* device instance $2389 r0 *1 64.34,42.965 sky130_fd_pr__pfet_01v8
M$2389 704 706 741 741 sky130_fd_pr__pfet_01v8 L=0.15U W=0.64U AS=0.1152P
+ AD=0.15985P PS=1U PD=1.265U
* device instance $2390 r0 *1 65.115,43.075 sky130_fd_pr__pfet_01v8
M$2390 707 703 704 704 sky130_fd_pr__pfet_01v8 L=0.15U W=0.42U AS=0.15985P
+ AD=0.06405P PS=1.265U PD=0.725U
* device instance $2391 r0 *1 65.57,43.075 sky130_fd_pr__pfet_01v8
M$2391 740 702 707 707 sky130_fd_pr__pfet_01v8 L=0.15U W=0.42U AS=0.06405P
+ AD=0.07665P PS=0.725U PD=0.785U
* device instance $2392 r0 *1 66.085,43.075 sky130_fd_pr__pfet_01v8
M$2392 740 708 37 37 sky130_fd_pr__pfet_01v8 L=0.15U W=0.42U AS=0.178875P
+ AD=0.07665P PS=1.26U PD=0.785U
* device instance $2393 r0 *1 66.745,42.91 sky130_fd_pr__pfet_01v8
M$2393 708 707 37 37 sky130_fd_pr__pfet_01v8 L=0.15U W=0.75U AS=0.178875P
+ AD=0.195P PS=1.26U PD=2.02U
* device instance $2394 r0 *1 70.185,42.965 sky130_fd_pr__pfet_01v8
M$2394 706 709 37 37 sky130_fd_pr__pfet_01v8 L=0.15U W=0.64U AS=0.154P
+ AD=0.1728P PS=1.335U PD=1.82U
* device instance $2395 r0 *1 70.67,42.785 sky130_fd_pr__pfet_01v8
M$2395 652 709 37 37 sky130_fd_pr__pfet_01v8 L=0.15U W=1U AS=0.154P AD=0.28P
+ PS=1.335U PD=2.56U
* device instance $2396 r0 *1 9.725,43.075 sky130_fd_pr__pfet_01v8
M$2396 744 687 37 37 sky130_fd_pr__pfet_01v8 L=0.15U W=0.42U AS=0.1092P
+ AD=0.06405P PS=1.36U PD=0.725U
* device instance $2397 r0 *1 10.18,43.075 sky130_fd_pr__pfet_01v8
M$2397 688 680 744 744 sky130_fd_pr__pfet_01v8 L=0.15U W=0.42U AS=0.06405P
+ AD=0.0567P PS=0.725U PD=0.69U
* device instance $2398 r0 *1 10.6,43.075 sky130_fd_pr__pfet_01v8
M$2398 745 682 688 688 sky130_fd_pr__pfet_01v8 L=0.15U W=0.42U AS=0.0567P
+ AD=0.0882P PS=0.69U PD=0.84U
* device instance $2399 r0 *1 11.17,43.075 sky130_fd_pr__pfet_01v8
M$2399 37 685 745 745 sky130_fd_pr__pfet_01v8 L=0.15U W=0.42U AS=0.0882P
+ AD=0.1113P PS=0.84U PD=1.37U
* device instance $2400 r0 *1 10.57,44.075 sky130_fd_pr__pfet_01v8
M$2400 800 591 757 757 sky130_fd_pr__pfet_01v8 L=0.15U W=0.64U AS=0.1664P
+ AD=0.0672P PS=1.8U PD=0.85U
* device instance $2401 r0 *1 10.93,44.075 sky130_fd_pr__pfet_01v8
M$2401 37 758 800 800 sky130_fd_pr__pfet_01v8 L=0.15U W=0.64U AS=0.0672P
+ AD=0.1664P PS=0.85U PD=1.8U
* device instance $2402 r0 *1 13.595,43.965 sky130_fd_pr__pfet_01v8
M$2402 759 756 757 757 sky130_fd_pr__pfet_01v8 L=0.15U W=0.42U AS=0.15985P
+ AD=0.06405P PS=1.265U PD=0.725U
* device instance $2403 r0 *1 14.05,43.965 sky130_fd_pr__pfet_01v8
M$2403 787 755 759 759 sky130_fd_pr__pfet_01v8 L=0.15U W=0.42U AS=0.06405P
+ AD=0.07665P PS=0.725U PD=0.785U
* device instance $2404 r0 *1 14.565,43.965 sky130_fd_pr__pfet_01v8
M$2404 37 760 787 787 sky130_fd_pr__pfet_01v8 L=0.15U W=0.42U AS=0.07665P
+ AD=0.178875P PS=0.785U PD=1.26U
* device instance $2405 r0 *1 11.87,44.075 sky130_fd_pr__pfet_01v8
M$2405 37 303 758 758 sky130_fd_pr__pfet_01v8 L=0.15U W=0.64U AS=0.1664P
+ AD=0.0928P PS=1.8U PD=0.93U
* device instance $2406 r0 *1 12.31,44.075 sky130_fd_pr__pfet_01v8
M$2406 801 303 37 37 sky130_fd_pr__pfet_01v8 L=0.15U W=0.64U AS=0.0928P
+ AD=0.1152P PS=0.93U PD=1U
* device instance $2407 r0 *1 12.82,44.075 sky130_fd_pr__pfet_01v8
M$2407 757 762 801 801 sky130_fd_pr__pfet_01v8 L=0.15U W=0.64U AS=0.1152P
+ AD=0.15985P PS=1U PD=1.265U
* device instance $2408 r0 *1 15.225,44.13 sky130_fd_pr__pfet_01v8
M$2408 760 759 37 37 sky130_fd_pr__pfet_01v8 L=0.15U W=0.75U AS=0.178875P
+ AD=0.195P PS=1.26U PD=2.02U
* device instance $2409 r0 *1 16.165,43.965 sky130_fd_pr__pfet_01v8
M$2409 789 760 37 37 sky130_fd_pr__pfet_01v8 L=0.15U W=0.42U AS=0.1092P
+ AD=0.06405P PS=1.36U PD=0.725U
* device instance $2410 r0 *1 16.62,43.965 sky130_fd_pr__pfet_01v8
M$2410 761 755 789 789 sky130_fd_pr__pfet_01v8 L=0.15U W=0.42U AS=0.06405P
+ AD=0.0567P PS=0.725U PD=0.69U
* device instance $2411 r0 *1 17.04,43.965 sky130_fd_pr__pfet_01v8
M$2411 790 756 761 761 sky130_fd_pr__pfet_01v8 L=0.15U W=0.42U AS=0.0567P
+ AD=0.0882P PS=0.69U PD=0.84U
* device instance $2412 r0 *1 17.61,43.965 sky130_fd_pr__pfet_01v8
M$2412 37 762 790 790 sky130_fd_pr__pfet_01v8 L=0.15U W=0.42U AS=0.0882P
+ AD=0.1113P PS=0.84U PD=1.37U
* device instance $2413 r0 *1 18.665,44.075 sky130_fd_pr__pfet_01v8
M$2413 37 761 762 762 sky130_fd_pr__pfet_01v8 L=0.15U W=0.64U AS=0.1728P
+ AD=0.154P PS=1.82U PD=1.335U
* device instance $2414 r0 *1 19.15,44.255 sky130_fd_pr__pfet_01v8
M$2414 594 761 37 37 sky130_fd_pr__pfet_01v8 L=0.15U W=1U AS=0.154P AD=0.28P
+ PS=1.335U PD=2.56U
* device instance $2415 r0 *1 23.08,43.075 sky130_fd_pr__pfet_01v8
M$2415 691 726 37 37 sky130_fd_pr__pfet_01v8 L=0.15U W=0.42U AS=0.1113P
+ AD=0.0609P PS=1.37U PD=0.71U
* device instance $2416 r0 *1 23.52,43.075 sky130_fd_pr__pfet_01v8
M$2416 691 115 37 37 sky130_fd_pr__pfet_01v8 L=0.15U W=0.42U AS=0.1841P
+ AD=0.0609P PS=1.26U PD=0.71U
* device instance $2417 r0 *1 24.29,42.965 sky130_fd_pr__pfet_01v8
M$2417 650 691 37 37 sky130_fd_pr__pfet_01v8 L=0.15U W=0.64U AS=0.1841P
+ AD=0.1696P PS=1.26U PD=1.81U
* device instance $2418 r0 *1 26.775,44.16 sky130_fd_pr__pfet_01v8
M$2418 804 64 37 37 sky130_fd_pr__pfet_01v8 L=0.15U W=0.42U AS=0.15835P
+ AD=0.07665P PS=1.395U PD=0.785U
* device instance $2419 r0 *1 27.29,44.16 sky130_fd_pr__pfet_01v8
M$2419 763 597 804 804 sky130_fd_pr__pfet_01v8 L=0.15U W=0.42U AS=0.07665P
+ AD=0.1932P PS=0.785U PD=1.34U
* device instance $2420 r0 *1 28.36,44.16 sky130_fd_pr__pfet_01v8
M$2420 805 794 763 763 sky130_fd_pr__pfet_01v8 L=0.15U W=0.42U AS=0.1932P
+ AD=0.0441P PS=1.34U PD=0.63U
* device instance $2421 r0 *1 28.72,44.16 sky130_fd_pr__pfet_01v8
M$2421 37 812 805 805 sky130_fd_pr__pfet_01v8 L=0.15U W=0.42U AS=0.0441P
+ AD=0.0693P PS=0.63U PD=0.75U
* device instance $2422 r0 *1 29.2,44.16 sky130_fd_pr__pfet_01v8
M$2422 812 64 37 37 sky130_fd_pr__pfet_01v8 L=0.15U W=0.42U AS=0.0693P
+ AD=0.1176P PS=0.75U PD=1.4U
* device instance $2423 r0 *1 26.23,44.255 sky130_fd_pr__pfet_01v8
M$2423 37 763 727 727 sky130_fd_pr__pfet_01v8 L=0.15U W=1U AS=0.26P AD=0.15835P
+ PS=2.52U PD=1.395U
* device instance $2424 r0 *1 33.185,43.075 sky130_fd_pr__pfet_01v8
M$2424 751 698 37 37 sky130_fd_pr__pfet_01v8 L=0.15U W=0.42U AS=0.1092P
+ AD=0.06405P PS=1.36U PD=0.725U
* device instance $2425 r0 *1 33.64,43.075 sky130_fd_pr__pfet_01v8
M$2425 699 692 751 751 sky130_fd_pr__pfet_01v8 L=0.15U W=0.42U AS=0.06405P
+ AD=0.0567P PS=0.725U PD=0.69U
* device instance $2426 r0 *1 34.06,43.075 sky130_fd_pr__pfet_01v8
M$2426 750 693 699 699 sky130_fd_pr__pfet_01v8 L=0.15U W=0.42U AS=0.0567P
+ AD=0.0882P PS=0.69U PD=0.84U
* device instance $2427 r0 *1 34.63,43.075 sky130_fd_pr__pfet_01v8
M$2427 37 696 750 750 sky130_fd_pr__pfet_01v8 L=0.15U W=0.42U AS=0.0882P
+ AD=0.1113P PS=0.84U PD=1.37U
* device instance $2428 r0 *1 34.95,44.075 sky130_fd_pr__pfet_01v8
M$2428 808 795 766 766 sky130_fd_pr__pfet_01v8 L=0.15U W=0.64U AS=0.1664P
+ AD=0.0672P PS=1.8U PD=0.85U
* device instance $2429 r0 *1 35.31,44.075 sky130_fd_pr__pfet_01v8
M$2429 37 767 808 808 sky130_fd_pr__pfet_01v8 L=0.15U W=0.64U AS=0.0672P
+ AD=0.1664P PS=0.85U PD=1.8U
* device instance $2430 r0 *1 37.975,43.965 sky130_fd_pr__pfet_01v8
M$2430 768 765 766 766 sky130_fd_pr__pfet_01v8 L=0.15U W=0.42U AS=0.15985P
+ AD=0.06405P PS=1.265U PD=0.725U
* device instance $2431 r0 *1 38.43,43.965 sky130_fd_pr__pfet_01v8
M$2431 791 764 768 768 sky130_fd_pr__pfet_01v8 L=0.15U W=0.42U AS=0.06405P
+ AD=0.07665P PS=0.725U PD=0.785U
* device instance $2432 r0 *1 38.945,43.965 sky130_fd_pr__pfet_01v8
M$2432 37 769 791 791 sky130_fd_pr__pfet_01v8 L=0.15U W=0.42U AS=0.07665P
+ AD=0.178875P PS=0.785U PD=1.26U
* device instance $2433 r0 *1 36.25,44.075 sky130_fd_pr__pfet_01v8
M$2433 37 94 767 767 sky130_fd_pr__pfet_01v8 L=0.15U W=0.64U AS=0.1664P
+ AD=0.0928P PS=1.8U PD=0.93U
* device instance $2434 r0 *1 36.69,44.075 sky130_fd_pr__pfet_01v8
M$2434 809 94 37 37 sky130_fd_pr__pfet_01v8 L=0.15U W=0.64U AS=0.0928P
+ AD=0.1152P PS=0.93U PD=1U
* device instance $2435 r0 *1 37.2,44.075 sky130_fd_pr__pfet_01v8
M$2435 766 771 809 809 sky130_fd_pr__pfet_01v8 L=0.15U W=0.64U AS=0.1152P
+ AD=0.15985P PS=1U PD=1.265U
* device instance $2436 r0 *1 39.605,44.13 sky130_fd_pr__pfet_01v8
M$2436 769 768 37 37 sky130_fd_pr__pfet_01v8 L=0.15U W=0.75U AS=0.178875P
+ AD=0.195P PS=1.26U PD=2.02U
* device instance $2437 r0 *1 40.545,43.965 sky130_fd_pr__pfet_01v8
M$2437 792 769 37 37 sky130_fd_pr__pfet_01v8 L=0.15U W=0.42U AS=0.1092P
+ AD=0.06405P PS=1.36U PD=0.725U
* device instance $2438 r0 *1 41,43.965 sky130_fd_pr__pfet_01v8
M$2438 770 764 792 792 sky130_fd_pr__pfet_01v8 L=0.15U W=0.42U AS=0.06405P
+ AD=0.0567P PS=0.725U PD=0.69U
* device instance $2439 r0 *1 41.42,43.965 sky130_fd_pr__pfet_01v8
M$2439 793 765 770 770 sky130_fd_pr__pfet_01v8 L=0.15U W=0.42U AS=0.0567P
+ AD=0.0882P PS=0.69U PD=0.84U
* device instance $2440 r0 *1 41.99,43.965 sky130_fd_pr__pfet_01v8
M$2440 37 771 793 793 sky130_fd_pr__pfet_01v8 L=0.15U W=0.42U AS=0.0882P
+ AD=0.1113P PS=0.84U PD=1.37U
* device instance $2441 r0 *1 43.045,44.075 sky130_fd_pr__pfet_01v8
M$2441 37 770 771 771 sky130_fd_pr__pfet_01v8 L=0.15U W=0.64U AS=0.1728P
+ AD=0.154P PS=1.82U PD=1.335U
* device instance $2442 r0 *1 43.53,44.255 sky130_fd_pr__pfet_01v8
M$2442 728 770 37 37 sky130_fd_pr__pfet_01v8 L=0.15U W=1U AS=0.154P AD=0.28P
+ PS=1.335U PD=2.56U
* device instance $2443 r0 *1 44.63,44.255 sky130_fd_pr__pfet_01v8
M$2443 773 796 772 772 sky130_fd_pr__pfet_01v8 L=0.15U W=1U AS=0.26P AD=0.135P
+ PS=2.52U PD=1.27U
* device instance $2444 r0 *1 45.05,44.255 sky130_fd_pr__pfet_01v8
M$2444 775 728 773 773 sky130_fd_pr__pfet_01v8 L=0.15U W=1U AS=0.135P AD=0.135P
+ PS=1.27U PD=1.27U
* device instance $2445 r0 *1 45.47,44.255 sky130_fd_pr__pfet_01v8
M$2445 773 92 775 775 sky130_fd_pr__pfet_01v8 L=0.15U W=1U AS=0.135P AD=0.26P
+ PS=1.27U PD=2.52U
* device instance $2446 r0 *1 46.41,44.255 sky130_fd_pr__pfet_01v8
M$2446 775 134 37 37 sky130_fd_pr__pfet_01v8 L=0.15U W=1U AS=0.26P AD=0.165P
+ PS=2.52U PD=1.33U
* device instance $2447 r0 *1 46.89,44.255 sky130_fd_pr__pfet_01v8
M$2447 37 735 775 775 sky130_fd_pr__pfet_01v8 L=0.15U W=1U AS=0.165P AD=0.1575P
+ PS=1.33U PD=1.315U
* device instance $2448 r0 *1 47.355,44.255 sky130_fd_pr__pfet_01v8
M$2448 774 772 37 37 sky130_fd_pr__pfet_01v8 L=0.15U W=1U AS=0.1575P AD=0.26P
+ PS=1.315U PD=2.52U
* device instance $2449 r0 *1 48.31,44.175 sky130_fd_pr__pfet_01v8
M$2449 776 797 37 37 sky130_fd_pr__pfet_01v8 L=0.15U W=1.68U AS=0.3318P
+ AD=0.3486P PS=3.31U PD=3.35U
* device instance $2451 r0 *1 49.69,44.255 sky130_fd_pr__pfet_01v8
M$2451 811 776 662 662 sky130_fd_pr__pfet_01v8 L=0.15U W=1U AS=0.26P AD=0.105P
+ PS=2.52U PD=1.21U
* device instance $2452 r0 *1 50.05,44.255 sky130_fd_pr__pfet_01v8
M$2452 37 728 811 811 sky130_fd_pr__pfet_01v8 L=0.15U W=1U AS=0.105P AD=0.26P
+ PS=1.21U PD=2.52U
* device instance $2453 r0 *1 51.31,44.545 sky130_fd_pr__pfet_01v8
M$2453 798 728 37 37 sky130_fd_pr__pfet_01v8 L=0.15U W=0.42U AS=0.1573P
+ AD=0.1092P PS=1.39U PD=1.36U
* device instance $2454 r0 *1 51.85,44.255 sky130_fd_pr__pfet_01v8
M$2454 810 797 37 37 sky130_fd_pr__pfet_01v8 L=0.15U W=1U AS=0.1573P AD=0.105P
+ PS=1.39U PD=1.21U
* device instance $2455 r0 *1 52.21,44.255 sky130_fd_pr__pfet_01v8
M$2455 799 798 810 810 sky130_fd_pr__pfet_01v8 L=0.15U W=1U AS=0.105P AD=0.26P
+ PS=1.21U PD=2.52U
* device instance $2456 r0 *1 56.59,44.255 sky130_fd_pr__pfet_01v8
M$2456 807 799 729 729 sky130_fd_pr__pfet_01v8 L=0.15U W=1U AS=0.26P AD=0.105P
+ PS=2.52U PD=1.21U
* device instance $2457 r0 *1 56.95,44.255 sky130_fd_pr__pfet_01v8
M$2457 37 662 807 807 sky130_fd_pr__pfet_01v8 L=0.15U W=1U AS=0.105P AD=0.26P
+ PS=1.21U PD=2.52U
* device instance $2458 r0 *1 61.19,44.255 sky130_fd_pr__pfet_01v8
M$2458 806 569 700 700 sky130_fd_pr__pfet_01v8 L=0.15U W=1U AS=0.26P AD=0.105P
+ PS=2.52U PD=1.21U
* device instance $2459 r0 *1 61.55,44.255 sky130_fd_pr__pfet_01v8
M$2459 37 985 806 806 sky130_fd_pr__pfet_01v8 L=0.15U W=1U AS=0.105P AD=0.26P
+ PS=1.21U PD=2.52U
* device instance $2460 r0 *1 66.23,44.075 sky130_fd_pr__pfet_01v8
M$2460 803 643 779 779 sky130_fd_pr__pfet_01v8 L=0.15U W=0.64U AS=0.1664P
+ AD=0.0672P PS=1.8U PD=0.85U
* device instance $2461 r0 *1 66.59,44.075 sky130_fd_pr__pfet_01v8
M$2461 37 780 803 803 sky130_fd_pr__pfet_01v8 L=0.15U W=0.64U AS=0.0672P
+ AD=0.1664P PS=0.85U PD=1.8U
* device instance $2462 r0 *1 69.255,43.965 sky130_fd_pr__pfet_01v8
M$2462 781 778 779 779 sky130_fd_pr__pfet_01v8 L=0.15U W=0.42U AS=0.15985P
+ AD=0.06405P PS=1.265U PD=0.725U
* device instance $2463 r0 *1 69.71,43.965 sky130_fd_pr__pfet_01v8
M$2463 788 777 781 781 sky130_fd_pr__pfet_01v8 L=0.15U W=0.42U AS=0.06405P
+ AD=0.07665P PS=0.725U PD=0.785U
* device instance $2464 r0 *1 70.225,43.965 sky130_fd_pr__pfet_01v8
M$2464 37 782 788 788 sky130_fd_pr__pfet_01v8 L=0.15U W=0.42U AS=0.07665P
+ AD=0.178875P PS=0.785U PD=1.26U
* device instance $2465 r0 *1 67.53,44.075 sky130_fd_pr__pfet_01v8
M$2465 37 410 780 780 sky130_fd_pr__pfet_01v8 L=0.15U W=0.64U AS=0.1664P
+ AD=0.0928P PS=1.8U PD=0.93U
* device instance $2466 r0 *1 67.97,44.075 sky130_fd_pr__pfet_01v8
M$2466 802 410 37 37 sky130_fd_pr__pfet_01v8 L=0.15U W=0.64U AS=0.0928P
+ AD=0.1152P PS=0.93U PD=1U
* device instance $2467 r0 *1 68.48,44.075 sky130_fd_pr__pfet_01v8
M$2467 779 784 802 802 sky130_fd_pr__pfet_01v8 L=0.15U W=0.64U AS=0.1152P
+ AD=0.15985P PS=1U PD=1.265U
* device instance $2468 r0 *1 70.885,44.13 sky130_fd_pr__pfet_01v8
M$2468 782 781 37 37 sky130_fd_pr__pfet_01v8 L=0.15U W=0.75U AS=0.178875P
+ AD=0.195P PS=1.26U PD=2.02U
* device instance $2469 r0 *1 67.685,43.075 sky130_fd_pr__pfet_01v8
M$2469 738 708 37 37 sky130_fd_pr__pfet_01v8 L=0.15U W=0.42U AS=0.1092P
+ AD=0.06405P PS=1.36U PD=0.725U
* device instance $2470 r0 *1 68.14,43.075 sky130_fd_pr__pfet_01v8
M$2470 709 702 738 738 sky130_fd_pr__pfet_01v8 L=0.15U W=0.42U AS=0.06405P
+ AD=0.0567P PS=0.725U PD=0.69U
* device instance $2471 r0 *1 68.56,43.075 sky130_fd_pr__pfet_01v8
M$2471 736 703 709 709 sky130_fd_pr__pfet_01v8 L=0.15U W=0.42U AS=0.0567P
+ AD=0.0882P PS=0.69U PD=0.84U
* device instance $2472 r0 *1 69.13,43.075 sky130_fd_pr__pfet_01v8
M$2472 37 706 736 736 sky130_fd_pr__pfet_01v8 L=0.15U W=0.42U AS=0.0882P
+ AD=0.1113P PS=0.84U PD=1.37U
* device instance $2473 r0 *1 71.825,43.965 sky130_fd_pr__pfet_01v8
M$2473 786 782 37 37 sky130_fd_pr__pfet_01v8 L=0.15U W=0.42U AS=0.1092P
+ AD=0.06405P PS=1.36U PD=0.725U
* device instance $2474 r0 *1 72.28,43.965 sky130_fd_pr__pfet_01v8
M$2474 783 777 786 786 sky130_fd_pr__pfet_01v8 L=0.15U W=0.42U AS=0.06405P
+ AD=0.0567P PS=0.725U PD=0.69U
* device instance $2475 r0 *1 72.7,43.965 sky130_fd_pr__pfet_01v8
M$2475 785 778 783 783 sky130_fd_pr__pfet_01v8 L=0.15U W=0.42U AS=0.0567P
+ AD=0.0882P PS=0.69U PD=0.84U
* device instance $2476 r0 *1 73.27,43.965 sky130_fd_pr__pfet_01v8
M$2476 37 784 785 785 sky130_fd_pr__pfet_01v8 L=0.15U W=0.42U AS=0.0882P
+ AD=0.1113P PS=0.84U PD=1.37U
* device instance $2477 r0 *1 74.325,44.075 sky130_fd_pr__pfet_01v8
M$2477 37 783 784 784 sky130_fd_pr__pfet_01v8 L=0.15U W=0.64U AS=0.1728P
+ AD=0.154P PS=1.82U PD=1.335U
* device instance $2478 r0 *1 74.81,44.255 sky130_fd_pr__pfet_01v8
M$2478 569 783 37 37 sky130_fd_pr__pfet_01v8 L=0.15U W=1U AS=0.154P AD=0.28P
+ PS=1.335U PD=2.56U
* device instance $2479 r0 *1 7.83,48.225 sky130_fd_pr__pfet_01v8
M$2479 874 867 832 832 sky130_fd_pr__pfet_01v8 L=0.15U W=1U AS=0.26P AD=0.135P
+ PS=2.52U PD=1.27U
* device instance $2480 r0 *1 8.25,48.225 sky130_fd_pr__pfet_01v8
M$2480 872 833 874 874 sky130_fd_pr__pfet_01v8 L=0.15U W=1U AS=0.135P AD=0.135P
+ PS=1.27U PD=1.27U
* device instance $2481 r0 *1 8.67,48.225 sky130_fd_pr__pfet_01v8
M$2481 874 92 872 872 sky130_fd_pr__pfet_01v8 L=0.15U W=1U AS=0.135P AD=0.26P
+ PS=1.27U PD=2.52U
* device instance $2482 r0 *1 9.21,44.105 sky130_fd_pr__pfet_01v8
M$2482 37 681 755 755 sky130_fd_pr__pfet_01v8 L=0.15U W=0.64U AS=0.1664P
+ AD=0.0864P PS=1.8U PD=0.91U
* device instance $2483 r0 *1 9.63,44.105 sky130_fd_pr__pfet_01v8
M$2483 756 755 37 37 sky130_fd_pr__pfet_01v8 L=0.15U W=0.64U AS=0.0864P
+ AD=0.1664P PS=0.91U PD=1.8U
* device instance $2484 r0 *1 9.61,48.225 sky130_fd_pr__pfet_01v8
M$2484 872 157 37 37 sky130_fd_pr__pfet_01v8 L=0.15U W=1U AS=0.26P AD=0.165P
+ PS=2.52U PD=1.33U
* device instance $2485 r0 *1 10.09,48.225 sky130_fd_pr__pfet_01v8
M$2485 37 868 872 872 sky130_fd_pr__pfet_01v8 L=0.15U W=1U AS=0.165P AD=0.1575P
+ PS=1.33U PD=1.315U
* device instance $2486 r0 *1 10.555,48.225 sky130_fd_pr__pfet_01v8
M$2486 873 832 37 37 sky130_fd_pr__pfet_01v8 L=0.15U W=1U AS=0.1575P AD=0.26P
+ PS=1.315U PD=2.52U
* device instance $2487 r0 *1 11.51,48.225 sky130_fd_pr__pfet_01v8
M$2487 37 869 835 835 sky130_fd_pr__pfet_01v8 L=0.15U W=1U AS=0.26P AD=0.26P
+ PS=2.52U PD=2.52U
* device instance $2488 r0 *1 12.45,48.225 sky130_fd_pr__pfet_01v8
M$2488 593 835 37 37 sky130_fd_pr__pfet_01v8 L=0.15U W=4U AS=0.665P AD=0.5475P
+ PS=6.33U PD=5.095U
* device instance $2492 r0 *1 14.145,48.225 sky130_fd_pr__pfet_01v8
M$2492 593 836 37 37 sky130_fd_pr__pfet_01v8 L=0.15U W=4U AS=0.5475P AD=0.795P
+ PS=5.095U PD=6.59U
* device instance $2496 r0 *1 25.77,48.375 sky130_fd_pr__pfet_01v8
M$2496 37 681 837 837 sky130_fd_pr__pfet_01v8 L=0.15U W=0.64U AS=0.1664P
+ AD=0.0864P PS=1.8U PD=0.91U
* device instance $2497 r0 *1 26.19,48.375 sky130_fd_pr__pfet_01v8
M$2497 870 837 37 37 sky130_fd_pr__pfet_01v8 L=0.15U W=0.64U AS=0.0864P
+ AD=0.1664P PS=0.91U PD=1.8U
* device instance $2498 r0 *1 27.13,48.405 sky130_fd_pr__pfet_01v8
M$2498 881 635 838 838 sky130_fd_pr__pfet_01v8 L=0.15U W=0.64U AS=0.1664P
+ AD=0.0672P PS=1.8U PD=0.85U
* device instance $2499 r0 *1 27.49,48.405 sky130_fd_pr__pfet_01v8
M$2499 37 839 881 881 sky130_fd_pr__pfet_01v8 L=0.15U W=0.64U AS=0.0672P
+ AD=0.1664P PS=0.85U PD=1.8U
* device instance $2500 r0 *1 28.43,48.405 sky130_fd_pr__pfet_01v8
M$2500 37 303 839 839 sky130_fd_pr__pfet_01v8 L=0.15U W=0.64U AS=0.1664P
+ AD=0.0928P PS=1.8U PD=0.93U
* device instance $2501 r0 *1 28.87,48.405 sky130_fd_pr__pfet_01v8
M$2501 883 303 37 37 sky130_fd_pr__pfet_01v8 L=0.15U W=0.64U AS=0.0928P
+ AD=0.1152P PS=0.93U PD=1U
* device instance $2502 r0 *1 29.38,48.405 sky130_fd_pr__pfet_01v8
M$2502 838 840 883 883 sky130_fd_pr__pfet_01v8 L=0.15U W=0.64U AS=0.1152P
+ AD=0.15985P PS=1U PD=1.265U
* device instance $2503 r0 *1 30.155,48.515 sky130_fd_pr__pfet_01v8
M$2503 841 870 838 838 sky130_fd_pr__pfet_01v8 L=0.15U W=0.42U AS=0.15985P
+ AD=0.06405P PS=1.265U PD=0.725U
* device instance $2504 r0 *1 30.61,48.515 sky130_fd_pr__pfet_01v8
M$2504 885 837 841 841 sky130_fd_pr__pfet_01v8 L=0.15U W=0.42U AS=0.06405P
+ AD=0.07665P PS=0.725U PD=0.785U
* device instance $2505 r0 *1 31.125,48.515 sky130_fd_pr__pfet_01v8
M$2505 885 842 37 37 sky130_fd_pr__pfet_01v8 L=0.15U W=0.42U AS=0.178875P
+ AD=0.07665P PS=1.26U PD=0.785U
* device instance $2506 r0 *1 31.785,48.35 sky130_fd_pr__pfet_01v8
M$2506 842 841 37 37 sky130_fd_pr__pfet_01v8 L=0.15U W=0.75U AS=0.178875P
+ AD=0.195P PS=1.26U PD=2.02U
* device instance $2507 r0 *1 32.725,48.515 sky130_fd_pr__pfet_01v8
M$2507 884 842 37 37 sky130_fd_pr__pfet_01v8 L=0.15U W=0.42U AS=0.1092P
+ AD=0.06405P PS=1.36U PD=0.725U
* device instance $2508 r0 *1 33.18,48.515 sky130_fd_pr__pfet_01v8
M$2508 843 837 884 884 sky130_fd_pr__pfet_01v8 L=0.15U W=0.42U AS=0.06405P
+ AD=0.0567P PS=0.725U PD=0.69U
* device instance $2509 r0 *1 33.6,48.515 sky130_fd_pr__pfet_01v8
M$2509 882 870 843 843 sky130_fd_pr__pfet_01v8 L=0.15U W=0.42U AS=0.0567P
+ AD=0.0882P PS=0.69U PD=0.84U
* device instance $2510 r0 *1 34.17,48.515 sky130_fd_pr__pfet_01v8
M$2510 37 840 882 882 sky130_fd_pr__pfet_01v8 L=0.15U W=0.42U AS=0.0882P
+ AD=0.1113P PS=0.84U PD=1.37U
* device instance $2511 r0 *1 33.59,44.105 sky130_fd_pr__pfet_01v8
M$2511 37 681 764 764 sky130_fd_pr__pfet_01v8 L=0.15U W=0.64U AS=0.1664P
+ AD=0.0864P PS=1.8U PD=0.91U
* device instance $2512 r0 *1 34.01,44.105 sky130_fd_pr__pfet_01v8
M$2512 765 764 37 37 sky130_fd_pr__pfet_01v8 L=0.15U W=0.64U AS=0.0864P
+ AD=0.1664P PS=0.91U PD=1.8U
* device instance $2513 r0 *1 35.225,48.405 sky130_fd_pr__pfet_01v8
M$2513 840 843 37 37 sky130_fd_pr__pfet_01v8 L=0.15U W=0.64U AS=0.154P
+ AD=0.1728P PS=1.335U PD=1.82U
* device instance $2514 r0 *1 35.71,48.225 sky130_fd_pr__pfet_01v8
M$2514 597 843 37 37 sky130_fd_pr__pfet_01v8 L=0.15U W=1U AS=0.154P AD=0.28P
+ PS=1.335U PD=2.56U
* device instance $2515 r0 *1 41.005,48.405 sky130_fd_pr__pfet_01v8
M$2515 880 776 37 37 sky130_fd_pr__pfet_01v8 L=0.15U W=0.64U AS=0.1696P
+ AD=0.0768P PS=1.81U PD=0.88U
* device instance $2516 r0 *1 41.395,48.405 sky130_fd_pr__pfet_01v8
M$2516 795 64 880 880 sky130_fd_pr__pfet_01v8 L=0.15U W=0.64U AS=0.0768P
+ AD=0.0896P PS=0.88U PD=0.92U
* device instance $2517 r0 *1 41.825,48.405 sky130_fd_pr__pfet_01v8
M$2517 37 845 795 795 sky130_fd_pr__pfet_01v8 L=0.15U W=0.64U AS=0.0896P
+ AD=0.1824P PS=0.92U PD=1.85U
* device instance $2518 r0 *1 44.63,48.375 sky130_fd_pr__pfet_01v8
M$2518 37 979 846 846 sky130_fd_pr__pfet_01v8 L=0.15U W=0.64U AS=0.1664P
+ AD=0.0864P PS=1.8U PD=0.91U
* device instance $2519 r0 *1 45.05,48.375 sky130_fd_pr__pfet_01v8
M$2519 871 846 37 37 sky130_fd_pr__pfet_01v8 L=0.15U W=0.64U AS=0.0864P
+ AD=0.1664P PS=0.91U PD=1.8U
* device instance $2520 r0 *1 45.99,48.405 sky130_fd_pr__pfet_01v8
M$2520 879 774 847 847 sky130_fd_pr__pfet_01v8 L=0.15U W=0.64U AS=0.1664P
+ AD=0.0672P PS=1.8U PD=0.85U
* device instance $2521 r0 *1 46.35,48.405 sky130_fd_pr__pfet_01v8
M$2521 37 848 879 879 sky130_fd_pr__pfet_01v8 L=0.15U W=0.64U AS=0.0672P
+ AD=0.1664P PS=0.85U PD=1.8U
* device instance $2522 r0 *1 47.29,48.405 sky130_fd_pr__pfet_01v8
M$2522 37 303 848 848 sky130_fd_pr__pfet_01v8 L=0.15U W=0.64U AS=0.1664P
+ AD=0.0928P PS=1.8U PD=0.93U
* device instance $2523 r0 *1 47.73,48.405 sky130_fd_pr__pfet_01v8
M$2523 878 303 37 37 sky130_fd_pr__pfet_01v8 L=0.15U W=0.64U AS=0.0928P
+ AD=0.1152P PS=0.93U PD=1U
* device instance $2524 r0 *1 48.24,48.405 sky130_fd_pr__pfet_01v8
M$2524 847 849 878 878 sky130_fd_pr__pfet_01v8 L=0.15U W=0.64U AS=0.1152P
+ AD=0.15985P PS=1U PD=1.265U
* device instance $2525 r0 *1 49.015,48.515 sky130_fd_pr__pfet_01v8
M$2525 850 871 847 847 sky130_fd_pr__pfet_01v8 L=0.15U W=0.42U AS=0.15985P
+ AD=0.06405P PS=1.265U PD=0.725U
* device instance $2526 r0 *1 49.47,48.515 sky130_fd_pr__pfet_01v8
M$2526 877 846 850 850 sky130_fd_pr__pfet_01v8 L=0.15U W=0.42U AS=0.06405P
+ AD=0.07665P PS=0.725U PD=0.785U
* device instance $2527 r0 *1 49.985,48.515 sky130_fd_pr__pfet_01v8
M$2527 877 851 37 37 sky130_fd_pr__pfet_01v8 L=0.15U W=0.42U AS=0.178875P
+ AD=0.07665P PS=1.26U PD=0.785U
* device instance $2528 r0 *1 50.645,48.35 sky130_fd_pr__pfet_01v8
M$2528 851 850 37 37 sky130_fd_pr__pfet_01v8 L=0.15U W=0.75U AS=0.178875P
+ AD=0.195P PS=1.26U PD=2.02U
* device instance $2529 r0 *1 51.585,48.515 sky130_fd_pr__pfet_01v8
M$2529 876 851 37 37 sky130_fd_pr__pfet_01v8 L=0.15U W=0.42U AS=0.1092P
+ AD=0.06405P PS=1.36U PD=0.725U
* device instance $2530 r0 *1 52.04,48.515 sky130_fd_pr__pfet_01v8
M$2530 852 846 876 876 sky130_fd_pr__pfet_01v8 L=0.15U W=0.42U AS=0.06405P
+ AD=0.0567P PS=0.725U PD=0.69U
* device instance $2531 r0 *1 52.46,48.515 sky130_fd_pr__pfet_01v8
M$2531 875 871 852 852 sky130_fd_pr__pfet_01v8 L=0.15U W=0.42U AS=0.0567P
+ AD=0.0882P PS=0.69U PD=0.84U
* device instance $2532 r0 *1 53.03,48.515 sky130_fd_pr__pfet_01v8
M$2532 37 849 875 875 sky130_fd_pr__pfet_01v8 L=0.15U W=0.42U AS=0.0882P
+ AD=0.1113P PS=0.84U PD=1.37U
* device instance $2533 r0 *1 54.085,48.405 sky130_fd_pr__pfet_01v8
M$2533 849 852 37 37 sky130_fd_pr__pfet_01v8 L=0.15U W=0.64U AS=0.154P
+ AD=0.1728P PS=1.335U PD=1.82U
* device instance $2534 r0 *1 54.57,48.225 sky130_fd_pr__pfet_01v8
M$2534 797 852 37 37 sky130_fd_pr__pfet_01v8 L=0.15U W=1U AS=0.154P AD=0.28P
+ PS=1.335U PD=2.56U
* device instance $2535 r0 *1 61.65,48.225 sky130_fd_pr__pfet_01v8
M$2535 37 641 853 853 sky130_fd_pr__pfet_01v8 L=0.15U W=1U AS=0.26P AD=0.135P
+ PS=2.52U PD=1.27U
* device instance $2536 r0 *1 62.07,48.225 sky130_fd_pr__pfet_01v8
M$2536 854 853 37 37 sky130_fd_pr__pfet_01v8 L=0.15U W=3U AS=0.405P AD=0.53P
+ PS=3.81U PD=5.06U
* device instance $2539 r0 *1 64.87,44.105 sky130_fd_pr__pfet_01v8
M$2539 37 979 777 777 sky130_fd_pr__pfet_01v8 L=0.15U W=0.64U AS=0.1664P
+ AD=0.0864P PS=1.8U PD=0.91U
* device instance $2540 r0 *1 65.29,44.105 sky130_fd_pr__pfet_01v8
M$2540 778 777 37 37 sky130_fd_pr__pfet_01v8 L=0.15U W=0.64U AS=0.0864P
+ AD=0.1664P PS=0.91U PD=1.8U
* device instance $2541 r0 *1 4.68,49.405 sky130_fd_pr__pfet_01v8
M$2541 887 886 37 37 sky130_fd_pr__pfet_01v8 L=0.15U W=0.42U AS=0.1113P
+ AD=0.0609P PS=1.37U PD=0.71U
* device instance $2542 r0 *1 5.12,49.405 sky130_fd_pr__pfet_01v8
M$2542 37 115 887 887 sky130_fd_pr__pfet_01v8 L=0.15U W=0.42U AS=0.0609P
+ AD=0.1841P PS=0.71U PD=1.26U
* device instance $2543 r0 *1 5.89,49.515 sky130_fd_pr__pfet_01v8
M$2543 867 887 37 37 sky130_fd_pr__pfet_01v8 L=0.15U W=0.64U AS=0.1841P
+ AD=0.1696P PS=1.26U PD=1.81U
* device instance $2544 r0 *1 7.455,49.6 sky130_fd_pr__pfet_01v8
M$2544 909 64 37 37 sky130_fd_pr__pfet_01v8 L=0.15U W=0.42U AS=0.15835P
+ AD=0.07665P PS=1.395U PD=0.785U
* device instance $2545 r0 *1 7.97,49.6 sky130_fd_pr__pfet_01v8
M$2545 889 916 909 909 sky130_fd_pr__pfet_01v8 L=0.15U W=0.42U AS=0.07665P
+ AD=0.1932P PS=0.785U PD=1.34U
* device instance $2546 r0 *1 9.04,49.6 sky130_fd_pr__pfet_01v8
M$2546 910 915 889 889 sky130_fd_pr__pfet_01v8 L=0.15U W=0.42U AS=0.1932P
+ AD=0.0441P PS=1.34U PD=0.63U
* device instance $2547 r0 *1 9.4,49.6 sky130_fd_pr__pfet_01v8
M$2547 37 917 910 910 sky130_fd_pr__pfet_01v8 L=0.15U W=0.42U AS=0.0441P
+ AD=0.0693P PS=0.63U PD=0.75U
* device instance $2548 r0 *1 9.88,49.6 sky130_fd_pr__pfet_01v8
M$2548 917 64 37 37 sky130_fd_pr__pfet_01v8 L=0.15U W=0.42U AS=0.0693P
+ AD=0.1176P PS=0.75U PD=1.4U
* device instance $2549 r0 *1 6.91,49.695 sky130_fd_pr__pfet_01v8
M$2549 37 889 888 888 sky130_fd_pr__pfet_01v8 L=0.15U W=1U AS=0.26P AD=0.15835P
+ PS=2.52U PD=1.395U
* device instance $2550 r0 *1 11.09,49.695 sky130_fd_pr__pfet_01v8
M$2550 919 833 890 890 sky130_fd_pr__pfet_01v8 L=0.15U W=1U AS=0.26P AD=0.135P
+ PS=2.52U PD=1.27U
* device instance $2551 r0 *1 11.51,49.695 sky130_fd_pr__pfet_01v8
M$2551 37 916 919 919 sky130_fd_pr__pfet_01v8 L=0.15U W=1U AS=0.135P AD=0.135P
+ PS=1.27U PD=1.27U
* device instance $2552 r0 *1 11.93,49.695 sky130_fd_pr__pfet_01v8
M$2552 891 916 37 37 sky130_fd_pr__pfet_01v8 L=0.15U W=1U AS=0.135P AD=0.135P
+ PS=1.27U PD=1.27U
* device instance $2553 r0 *1 12.35,49.695 sky130_fd_pr__pfet_01v8
M$2553 37 833 891 891 sky130_fd_pr__pfet_01v8 L=0.15U W=1U AS=0.135P AD=0.26P
+ PS=1.27U PD=2.52U
* device instance $2554 r0 *1 12.225,53.845 sky130_fd_pr__pfet_01v8
M$2554 934 937 37 37 sky130_fd_pr__pfet_01v8 L=0.15U W=0.64U AS=0.154P
+ AD=0.1728P PS=1.335U PD=1.82U
* device instance $2555 r0 *1 12.71,53.665 sky130_fd_pr__pfet_01v8
M$2555 836 937 37 37 sky130_fd_pr__pfet_01v8 L=0.15U W=1U AS=0.154P AD=0.28P
+ PS=1.335U PD=2.56U
* device instance $2556 r0 *1 13.29,49.695 sky130_fd_pr__pfet_01v8
M$2556 868 890 891 891 sky130_fd_pr__pfet_01v8 L=0.15U W=1U AS=0.26P AD=0.3P
+ PS=2.52U PD=2.6U
* device instance $2557 r0 *1 13.81,53.665 sky130_fd_pr__pfet_01v8
M$2557 37 869 938 938 sky130_fd_pr__pfet_01v8 L=0.15U W=1U AS=0.26P AD=0.135P
+ PS=2.52U PD=1.27U
* device instance $2558 r0 *1 14.23,53.665 sky130_fd_pr__pfet_01v8
M$2558 916 938 37 37 sky130_fd_pr__pfet_01v8 L=0.15U W=4U AS=0.54P AD=0.665P
+ PS=5.08U PD=6.33U
* device instance $2562 r0 *1 17.03,53.665 sky130_fd_pr__pfet_01v8
M$2562 37 836 939 939 sky130_fd_pr__pfet_01v8 L=0.15U W=1U AS=0.26P AD=0.135P
+ PS=2.52U PD=1.27U
* device instance $2563 r0 *1 17.45,53.665 sky130_fd_pr__pfet_01v8
M$2563 833 939 37 37 sky130_fd_pr__pfet_01v8 L=0.15U W=4U AS=0.54P AD=0.665P
+ PS=5.08U PD=6.33U
* device instance $2567 r0 *1 21.19,49.695 sky130_fd_pr__pfet_01v8
M$2567 37 833 892 892 sky130_fd_pr__pfet_01v8 L=0.15U W=4U AS=0.685P AD=0.54P
+ PS=6.37U PD=5.08U
* device instance $2571 r0 *1 22.87,49.695 sky130_fd_pr__pfet_01v8
M$2571 894 893 892 892 sky130_fd_pr__pfet_01v8 L=0.15U W=4U AS=0.54P AD=0.665P
+ PS=5.08U PD=6.33U
* device instance $2575 r0 *1 23.935,53.665 sky130_fd_pr__pfet_01v8
M$2575 940 298 37 37 sky130_fd_pr__pfet_01v8 L=0.15U W=4U AS=0.685P AD=0.56P
+ PS=6.37U PD=5.12U
* device instance $2579 r0 *1 25.655,53.665 sky130_fd_pr__pfet_01v8
M$2579 681 940 37 37 sky130_fd_pr__pfet_01v8 L=0.15U W=16U AS=2.2375P
+ AD=2.3625P PS=20.475U PD=21.725U
* device instance $2595 r0 *1 25.07,49.695 sky130_fd_pr__pfet_01v8
M$2595 894 896 895 895 sky130_fd_pr__pfet_01v8 L=0.15U W=4U AS=0.665P AD=0.54P
+ PS=6.33U PD=5.08U
* device instance $2599 r0 *1 26.75,49.695 sky130_fd_pr__pfet_01v8
M$2599 918 362 895 895 sky130_fd_pr__pfet_01v8 L=0.15U W=4U AS=0.54P AD=0.665P
+ PS=5.08U PD=6.33U
* device instance $2603 r0 *1 43.32,49.405 sky130_fd_pr__pfet_01v8
M$2603 898 897 37 37 sky130_fd_pr__pfet_01v8 L=0.15U W=0.42U AS=0.1113P
+ AD=0.0609P PS=1.37U PD=0.71U
* device instance $2604 r0 *1 43.76,49.405 sky130_fd_pr__pfet_01v8
M$2604 37 115 898 898 sky130_fd_pr__pfet_01v8 L=0.15U W=0.42U AS=0.0609P
+ AD=0.1841P PS=0.71U PD=1.26U
* device instance $2605 r0 *1 44.53,49.515 sky130_fd_pr__pfet_01v8
M$2605 796 898 37 37 sky130_fd_pr__pfet_01v8 L=0.15U W=0.64U AS=0.1841P
+ AD=0.1696P PS=1.26U PD=1.81U
* device instance $2606 r0 *1 56.13,53.665 sky130_fd_pr__pfet_01v8
M$2606 962 941 942 942 sky130_fd_pr__pfet_01v8 L=0.15U W=1U AS=0.26P AD=0.135P
+ PS=2.52U PD=1.27U
* device instance $2607 r0 *1 56.55,53.665 sky130_fd_pr__pfet_01v8
M$2607 960 799 962 962 sky130_fd_pr__pfet_01v8 L=0.15U W=1U AS=0.135P AD=0.135P
+ PS=1.27U PD=1.27U
* device instance $2608 r0 *1 56.97,53.665 sky130_fd_pr__pfet_01v8
M$2608 37 980 960 960 sky130_fd_pr__pfet_01v8 L=0.15U W=1U AS=0.135P AD=0.4P
+ PS=1.27U PD=1.8U
* device instance $2609 r0 *1 57.92,53.665 sky130_fd_pr__pfet_01v8
M$2609 943 942 37 37 sky130_fd_pr__pfet_01v8 L=0.15U W=4U AS=0.805P AD=0.765P
+ PS=5.61U PD=6.53U
* device instance $2613 r0 *1 60.27,53.665 sky130_fd_pr__pfet_01v8
M$2613 37 854 944 944 sky130_fd_pr__pfet_01v8 L=0.15U W=1U AS=0.26P AD=0.135P
+ PS=2.52U PD=1.27U
* device instance $2614 r0 *1 60.69,53.665 sky130_fd_pr__pfet_01v8
M$2614 941 944 37 37 sky130_fd_pr__pfet_01v8 L=0.15U W=4U AS=0.54P AD=0.665P
+ PS=5.08U PD=6.33U
* device instance $2618 r0 *1 64.87,49.545 sky130_fd_pr__pfet_01v8
M$2618 37 979 899 899 sky130_fd_pr__pfet_01v8 L=0.15U W=0.64U AS=0.1664P
+ AD=0.0864P PS=1.8U PD=0.91U
* device instance $2619 r0 *1 65.29,49.545 sky130_fd_pr__pfet_01v8
M$2619 900 899 37 37 sky130_fd_pr__pfet_01v8 L=0.15U W=0.64U AS=0.0864P
+ AD=0.1664P PS=0.91U PD=1.8U
* device instance $2620 r0 *1 66.23,49.515 sky130_fd_pr__pfet_01v8
M$2620 914 902 901 901 sky130_fd_pr__pfet_01v8 L=0.15U W=0.64U AS=0.1664P
+ AD=0.0672P PS=1.8U PD=0.85U
* device instance $2621 r0 *1 66.59,49.515 sky130_fd_pr__pfet_01v8
M$2621 37 903 914 914 sky130_fd_pr__pfet_01v8 L=0.15U W=0.64U AS=0.0672P
+ AD=0.1664P PS=0.85U PD=1.8U
* device instance $2622 r0 *1 69.255,49.405 sky130_fd_pr__pfet_01v8
M$2622 904 900 901 901 sky130_fd_pr__pfet_01v8 L=0.15U W=0.42U AS=0.15985P
+ AD=0.06405P PS=1.265U PD=0.725U
* device instance $2623 r0 *1 69.71,49.405 sky130_fd_pr__pfet_01v8
M$2623 912 899 904 904 sky130_fd_pr__pfet_01v8 L=0.15U W=0.42U AS=0.06405P
+ AD=0.07665P PS=0.725U PD=0.785U
* device instance $2624 r0 *1 70.225,49.405 sky130_fd_pr__pfet_01v8
M$2624 37 905 912 912 sky130_fd_pr__pfet_01v8 L=0.15U W=0.42U AS=0.07665P
+ AD=0.178875P PS=0.785U PD=1.26U
* device instance $2625 r0 *1 67.53,49.515 sky130_fd_pr__pfet_01v8
M$2625 37 410 903 903 sky130_fd_pr__pfet_01v8 L=0.15U W=0.64U AS=0.1664P
+ AD=0.0928P PS=1.8U PD=0.93U
* device instance $2626 r0 *1 67.97,49.515 sky130_fd_pr__pfet_01v8
M$2626 913 410 37 37 sky130_fd_pr__pfet_01v8 L=0.15U W=0.64U AS=0.0928P
+ AD=0.1152P PS=0.93U PD=1U
* device instance $2627 r0 *1 68.48,49.515 sky130_fd_pr__pfet_01v8
M$2627 901 907 913 913 sky130_fd_pr__pfet_01v8 L=0.15U W=0.64U AS=0.1152P
+ AD=0.15985P PS=1U PD=1.265U
* device instance $2628 r0 *1 70.885,49.57 sky130_fd_pr__pfet_01v8
M$2628 905 904 37 37 sky130_fd_pr__pfet_01v8 L=0.15U W=0.75U AS=0.178875P
+ AD=0.195P PS=1.26U PD=2.02U
* device instance $2629 r0 *1 68.175,53.76 sky130_fd_pr__pfet_01v8
M$2629 957 64 37 37 sky130_fd_pr__pfet_01v8 L=0.15U W=0.42U AS=0.15835P
+ AD=0.07665P PS=1.395U PD=0.785U
* device instance $2630 r0 *1 68.69,53.76 sky130_fd_pr__pfet_01v8
M$2630 945 955 957 957 sky130_fd_pr__pfet_01v8 L=0.15U W=0.42U AS=0.07665P
+ AD=0.1932P PS=0.785U PD=1.34U
* device instance $2631 r0 *1 69.76,53.76 sky130_fd_pr__pfet_01v8
M$2631 956 946 945 945 sky130_fd_pr__pfet_01v8 L=0.15U W=0.42U AS=0.1932P
+ AD=0.0441P PS=1.34U PD=0.63U
* device instance $2632 r0 *1 70.12,53.76 sky130_fd_pr__pfet_01v8
M$2632 37 947 956 956 sky130_fd_pr__pfet_01v8 L=0.15U W=0.42U AS=0.0441P
+ AD=0.0693P PS=0.63U PD=0.75U
* device instance $2633 r0 *1 70.6,53.76 sky130_fd_pr__pfet_01v8
M$2633 947 64 37 37 sky130_fd_pr__pfet_01v8 L=0.15U W=0.42U AS=0.0693P
+ AD=0.1176P PS=0.75U PD=1.4U
* device instance $2634 r0 *1 67.63,53.665 sky130_fd_pr__pfet_01v8
M$2634 37 945 902 902 sky130_fd_pr__pfet_01v8 L=0.15U W=1U AS=0.26P AD=0.15835P
+ PS=2.52U PD=1.395U
* device instance $2635 r0 *1 71.825,49.405 sky130_fd_pr__pfet_01v8
M$2635 911 905 37 37 sky130_fd_pr__pfet_01v8 L=0.15U W=0.42U AS=0.1092P
+ AD=0.06405P PS=1.36U PD=0.725U
* device instance $2636 r0 *1 72.28,49.405 sky130_fd_pr__pfet_01v8
M$2636 906 899 911 911 sky130_fd_pr__pfet_01v8 L=0.15U W=0.42U AS=0.06405P
+ AD=0.0567P PS=0.725U PD=0.69U
* device instance $2637 r0 *1 72.7,49.405 sky130_fd_pr__pfet_01v8
M$2637 908 900 906 906 sky130_fd_pr__pfet_01v8 L=0.15U W=0.42U AS=0.0567P
+ AD=0.0882P PS=0.69U PD=0.84U
* device instance $2638 r0 *1 73.27,49.405 sky130_fd_pr__pfet_01v8
M$2638 37 907 908 908 sky130_fd_pr__pfet_01v8 L=0.15U W=0.42U AS=0.0882P
+ AD=0.1113P PS=0.84U PD=1.37U
* device instance $2639 r0 *1 74.325,49.515 sky130_fd_pr__pfet_01v8
M$2639 37 906 907 907 sky130_fd_pr__pfet_01v8 L=0.15U W=0.64U AS=0.1728P
+ AD=0.154P PS=1.82U PD=1.335U
* device instance $2640 r0 *1 74.81,49.695 sky130_fd_pr__pfet_01v8
M$2640 985 906 37 37 sky130_fd_pr__pfet_01v8 L=0.15U W=1U AS=0.154P AD=0.28P
+ PS=1.335U PD=2.56U
* device instance $2641 r0 *1 2.77,53.815 sky130_fd_pr__pfet_01v8
M$2641 37 681 930 930 sky130_fd_pr__pfet_01v8 L=0.15U W=0.64U AS=0.1664P
+ AD=0.0864P PS=1.8U PD=0.91U
* device instance $2642 r0 *1 3.19,53.815 sky130_fd_pr__pfet_01v8
M$2642 931 930 37 37 sky130_fd_pr__pfet_01v8 L=0.15U W=0.64U AS=0.0864P
+ AD=0.1664P PS=0.91U PD=1.8U
* device instance $2643 r0 *1 4.13,53.845 sky130_fd_pr__pfet_01v8
M$2643 958 888 932 932 sky130_fd_pr__pfet_01v8 L=0.15U W=0.64U AS=0.1664P
+ AD=0.0672P PS=1.8U PD=0.85U
* device instance $2644 r0 *1 4.49,53.845 sky130_fd_pr__pfet_01v8
M$2644 37 933 958 958 sky130_fd_pr__pfet_01v8 L=0.15U W=0.64U AS=0.0672P
+ AD=0.1664P PS=0.85U PD=1.8U
* device instance $2645 r0 *1 5.43,53.845 sky130_fd_pr__pfet_01v8
M$2645 37 94 933 933 sky130_fd_pr__pfet_01v8 L=0.15U W=0.64U AS=0.1664P
+ AD=0.0928P PS=1.8U PD=0.93U
* device instance $2646 r0 *1 5.87,53.845 sky130_fd_pr__pfet_01v8
M$2646 959 94 37 37 sky130_fd_pr__pfet_01v8 L=0.15U W=0.64U AS=0.0928P
+ AD=0.1152P PS=0.93U PD=1U
* device instance $2647 r0 *1 6.38,53.845 sky130_fd_pr__pfet_01v8
M$2647 932 934 959 959 sky130_fd_pr__pfet_01v8 L=0.15U W=0.64U AS=0.1152P
+ AD=0.15985P PS=1U PD=1.265U
* device instance $2648 r0 *1 7.155,53.955 sky130_fd_pr__pfet_01v8
M$2648 935 931 932 932 sky130_fd_pr__pfet_01v8 L=0.15U W=0.42U AS=0.15985P
+ AD=0.06405P PS=1.265U PD=0.725U
* device instance $2649 r0 *1 7.61,53.955 sky130_fd_pr__pfet_01v8
M$2649 961 930 935 935 sky130_fd_pr__pfet_01v8 L=0.15U W=0.42U AS=0.06405P
+ AD=0.07665P PS=0.725U PD=0.785U
* device instance $2650 r0 *1 8.125,53.955 sky130_fd_pr__pfet_01v8
M$2650 961 936 37 37 sky130_fd_pr__pfet_01v8 L=0.15U W=0.42U AS=0.178875P
+ AD=0.07665P PS=1.26U PD=0.785U
* device instance $2651 r0 *1 8.785,53.79 sky130_fd_pr__pfet_01v8
M$2651 936 935 37 37 sky130_fd_pr__pfet_01v8 L=0.15U W=0.75U AS=0.178875P
+ AD=0.195P PS=1.26U PD=2.02U
* device instance $2652 r0 *1 9.725,53.955 sky130_fd_pr__pfet_01v8
M$2652 963 936 37 37 sky130_fd_pr__pfet_01v8 L=0.15U W=0.42U AS=0.1092P
+ AD=0.06405P PS=1.36U PD=0.725U
* device instance $2653 r0 *1 10.18,53.955 sky130_fd_pr__pfet_01v8
M$2653 937 930 963 963 sky130_fd_pr__pfet_01v8 L=0.15U W=0.42U AS=0.06405P
+ AD=0.0567P PS=0.725U PD=0.69U
* device instance $2654 r0 *1 10.6,53.955 sky130_fd_pr__pfet_01v8
M$2654 964 931 937 937 sky130_fd_pr__pfet_01v8 L=0.15U W=0.42U AS=0.0567P
+ AD=0.0882P PS=0.69U PD=0.84U
* device instance $2655 r0 *1 11.17,53.955 sky130_fd_pr__pfet_01v8
M$2655 37 934 964 964 sky130_fd_pr__pfet_01v8 L=0.15U W=0.42U AS=0.0882P
+ AD=0.1113P PS=0.84U PD=1.37U
* device instance $2656 r0 *1 10.57,54.955 sky130_fd_pr__pfet_01v8
M$2656 987 873 967 967 sky130_fd_pr__pfet_01v8 L=0.15U W=0.64U AS=0.1664P
+ AD=0.0672P PS=1.8U PD=0.85U
* device instance $2657 r0 *1 10.93,54.955 sky130_fd_pr__pfet_01v8
M$2657 37 968 987 987 sky130_fd_pr__pfet_01v8 L=0.15U W=0.64U AS=0.0672P
+ AD=0.1664P PS=0.85U PD=1.8U
* device instance $2658 r0 *1 13.595,54.845 sky130_fd_pr__pfet_01v8
M$2658 969 966 967 967 sky130_fd_pr__pfet_01v8 L=0.15U W=0.42U AS=0.15985P
+ AD=0.06405P PS=1.265U PD=0.725U
* device instance $2659 r0 *1 14.05,54.845 sky130_fd_pr__pfet_01v8
M$2659 989 965 969 969 sky130_fd_pr__pfet_01v8 L=0.15U W=0.42U AS=0.06405P
+ AD=0.07665P PS=0.725U PD=0.785U
* device instance $2660 r0 *1 14.565,54.845 sky130_fd_pr__pfet_01v8
M$2660 37 970 989 989 sky130_fd_pr__pfet_01v8 L=0.15U W=0.42U AS=0.07665P
+ AD=0.178875P PS=0.785U PD=1.26U
* device instance $2661 r0 *1 11.87,54.955 sky130_fd_pr__pfet_01v8
M$2661 37 303 968 968 sky130_fd_pr__pfet_01v8 L=0.15U W=0.64U AS=0.1664P
+ AD=0.0928P PS=1.8U PD=0.93U
* device instance $2662 r0 *1 12.31,54.955 sky130_fd_pr__pfet_01v8
M$2662 988 303 37 37 sky130_fd_pr__pfet_01v8 L=0.15U W=0.64U AS=0.0928P
+ AD=0.1152P PS=0.93U PD=1U
* device instance $2663 r0 *1 12.82,54.955 sky130_fd_pr__pfet_01v8
M$2663 967 972 988 988 sky130_fd_pr__pfet_01v8 L=0.15U W=0.64U AS=0.1152P
+ AD=0.15985P PS=1U PD=1.265U
* device instance $2664 r0 *1 15.225,55.01 sky130_fd_pr__pfet_01v8
M$2664 970 969 37 37 sky130_fd_pr__pfet_01v8 L=0.15U W=0.75U AS=0.178875P
+ AD=0.195P PS=1.26U PD=2.02U
* device instance $2665 r0 *1 16.165,54.845 sky130_fd_pr__pfet_01v8
M$2665 990 970 37 37 sky130_fd_pr__pfet_01v8 L=0.15U W=0.42U AS=0.1092P
+ AD=0.06405P PS=1.36U PD=0.725U
* device instance $2666 r0 *1 16.62,54.845 sky130_fd_pr__pfet_01v8
M$2666 971 965 990 990 sky130_fd_pr__pfet_01v8 L=0.15U W=0.42U AS=0.06405P
+ AD=0.0567P PS=0.725U PD=0.69U
* device instance $2667 r0 *1 17.04,54.845 sky130_fd_pr__pfet_01v8
M$2667 991 966 971 971 sky130_fd_pr__pfet_01v8 L=0.15U W=0.42U AS=0.0567P
+ AD=0.0882P PS=0.69U PD=0.84U
* device instance $2668 r0 *1 17.61,54.845 sky130_fd_pr__pfet_01v8
M$2668 37 972 991 991 sky130_fd_pr__pfet_01v8 L=0.15U W=0.42U AS=0.0882P
+ AD=0.1113P PS=0.84U PD=1.37U
* device instance $2669 r0 *1 18.665,54.955 sky130_fd_pr__pfet_01v8
M$2669 37 971 972 972 sky130_fd_pr__pfet_01v8 L=0.15U W=0.64U AS=0.1728P
+ AD=0.154P PS=1.82U PD=1.335U
* device instance $2670 r0 *1 19.15,55.135 sky130_fd_pr__pfet_01v8
M$2670 869 971 37 37 sky130_fd_pr__pfet_01v8 L=0.15U W=1U AS=0.154P AD=0.28P
+ PS=1.335U PD=2.56U
* device instance $2671 r0 *1 28.31,55.425 sky130_fd_pr__pfet_01v8
M$2671 973 893 37 37 sky130_fd_pr__pfet_01v8 L=0.15U W=0.42U AS=0.1573P
+ AD=0.1092P PS=1.39U PD=1.36U
* device instance $2672 r0 *1 28.85,55.135 sky130_fd_pr__pfet_01v8
M$2672 998 993 37 37 sky130_fd_pr__pfet_01v8 L=0.15U W=1U AS=0.1573P AD=0.105P
+ PS=1.39U PD=1.21U
* device instance $2673 r0 *1 29.21,55.135 sky130_fd_pr__pfet_01v8
M$2673 976 973 998 998 sky130_fd_pr__pfet_01v8 L=0.15U W=1U AS=0.105P AD=0.26P
+ PS=1.21U PD=2.52U
* device instance $2674 r0 *1 30.85,55.135 sky130_fd_pr__pfet_01v8
M$2674 37 994 974 974 sky130_fd_pr__pfet_01v8 L=0.15U W=4U AS=0.685P AD=0.54P
+ PS=6.37U PD=5.08U
* device instance $2678 r0 *1 32.53,55.135 sky130_fd_pr__pfet_01v8
M$2678 975 115 974 974 sky130_fd_pr__pfet_01v8 L=0.15U W=4U AS=0.54P AD=0.665P
+ PS=5.08U PD=6.33U
* device instance $2681 r0 *1 33.79,55.135 sky130_fd_pr__pfet_01v8
M$2681 999 976 975 975 sky130_fd_pr__pfet_01v8 L=0.15U W=4U AS=0.54P AD=0.54P
+ PS=5.08U PD=5.08U
* device instance $2686 r0 *1 42.815,55.135 sky130_fd_pr__pfet_01v8
M$2686 37 979 977 977 sky130_fd_pr__pfet_01v8 L=0.15U W=3U AS=0.545P AD=0.545P
+ PS=5.09U PD=5.09U
* device instance $2689 r0 *1 44.635,55.135 sky130_fd_pr__pfet_01v8
M$2689 978 298 37 37 sky130_fd_pr__pfet_01v8 L=0.15U W=4U AS=0.685P AD=0.56P
+ PS=6.37U PD=5.12U
* device instance $2693 r0 *1 46.355,55.135 sky130_fd_pr__pfet_01v8
M$2693 979 978 37 37 sky130_fd_pr__pfet_01v8 L=0.15U W=16U AS=2.2375P
+ AD=2.3625P PS=20.475U PD=21.725U
* device instance $2709 r0 *1 59.405,54.955 sky130_fd_pr__pfet_01v8
M$2709 992 799 37 37 sky130_fd_pr__pfet_01v8 L=0.15U W=0.64U AS=0.1696P
+ AD=0.0768P PS=1.81U PD=0.88U
* device instance $2710 r0 *1 59.795,54.955 sky130_fd_pr__pfet_01v8
M$2710 995 941 992 992 sky130_fd_pr__pfet_01v8 L=0.15U W=0.64U AS=0.0768P
+ AD=0.0896P PS=0.88U PD=0.92U
* device instance $2711 r0 *1 60.225,54.955 sky130_fd_pr__pfet_01v8
M$2711 37 980 995 995 sky130_fd_pr__pfet_01v8 L=0.15U W=0.64U AS=0.0896P
+ AD=0.1824P PS=0.92U PD=1.85U
* device instance $2712 r0 *1 62.115,55.135 sky130_fd_pr__pfet_01v8
M$2712 981 943 37 37 sky130_fd_pr__pfet_01v8 L=0.15U W=1U AS=0.265P AD=0.14P
+ PS=2.53U PD=1.28U
* device instance $2713 r0 *1 62.545,55.135 sky130_fd_pr__pfet_01v8
M$2713 37 995 981 981 sky130_fd_pr__pfet_01v8 L=0.15U W=1U AS=0.14P AD=0.1775P
+ PS=1.28U PD=1.355U
* device instance $2714 r0 *1 63.05,55.135 sky130_fd_pr__pfet_01v8
M$2714 996 981 37 37 sky130_fd_pr__pfet_01v8 L=0.15U W=4U AS=0.5975P AD=0.705P
+ PS=5.195U PD=6.41U
* device instance $2718 r0 *1 65.33,55.055 sky130_fd_pr__pfet_01v8
M$2718 980 986 37 37 sky130_fd_pr__pfet_01v8 L=0.15U W=1.68U AS=0.3318P
+ AD=0.3486P PS=3.31U PD=3.35U
* device instance $2720 r0 *1 66.71,55.425 sky130_fd_pr__pfet_01v8
M$2720 982 985 37 37 sky130_fd_pr__pfet_01v8 L=0.15U W=0.42U AS=0.14575P
+ AD=0.1092P PS=1.335U PD=1.36U
* device instance $2721 r0 *1 67.195,55.135 sky130_fd_pr__pfet_01v8
M$2721 983 955 37 37 sky130_fd_pr__pfet_01v8 L=0.15U W=1U AS=0.14575P AD=0.135P
+ PS=1.335U PD=1.27U
* device instance $2722 r0 *1 67.615,55.135 sky130_fd_pr__pfet_01v8
M$2722 37 982 983 983 sky130_fd_pr__pfet_01v8 L=0.15U W=1U AS=0.135P AD=0.265P
+ PS=1.27U PD=2.53U
* device instance $2723 r0 *1 69.05,55.135 sky130_fd_pr__pfet_01v8
M$2723 984 955 37 37 sky130_fd_pr__pfet_01v8 L=0.15U W=1U AS=0.3P AD=0.135P
+ PS=2.6U PD=1.27U
* device instance $2724 r0 *1 69.47,55.135 sky130_fd_pr__pfet_01v8
M$2724 37 985 984 984 sky130_fd_pr__pfet_01v8 L=0.15U W=1U AS=0.135P AD=0.365P
+ PS=1.27U PD=1.73U
* device instance $2725 r0 *1 70.35,55.135 sky130_fd_pr__pfet_01v8
M$2725 997 985 37 37 sky130_fd_pr__pfet_01v8 L=0.15U W=1U AS=0.365P AD=0.105P
+ PS=1.73U PD=1.21U
* device instance $2726 r0 *1 70.71,55.135 sky130_fd_pr__pfet_01v8
M$2726 986 955 997 997 sky130_fd_pr__pfet_01v8 L=0.15U W=1U AS=0.105P AD=0.165P
+ PS=1.21U PD=1.33U
* device instance $2727 r0 *1 71.19,55.135 sky130_fd_pr__pfet_01v8
M$2727 37 984 986 986 sky130_fd_pr__pfet_01v8 L=0.15U W=1U AS=0.165P AD=0.36P
+ PS=1.33U PD=2.72U
* device instance $2728 r0 *1 9.21,54.985 sky130_fd_pr__pfet_01v8
M$2728 37 681 965 965 sky130_fd_pr__pfet_01v8 L=0.15U W=0.64U AS=0.1664P
+ AD=0.0864P PS=1.8U PD=0.91U
* device instance $2729 r0 *1 9.63,54.985 sky130_fd_pr__pfet_01v8
M$2729 966 965 37 37 sky130_fd_pr__pfet_01v8 L=0.15U W=0.64U AS=0.0864P
+ AD=0.1664P PS=0.91U PD=1.8U
* device instance $2730 r0 *1 11.03,60.285 sky130_fd_pr__pfet_01v8
M$2730 1043 1072 37 37 sky130_fd_pr__pfet_01v8 L=0.15U W=0.42U AS=0.1092P
+ AD=0.0672P PS=1.36U PD=0.74U
* device instance $2731 r0 *1 11.5,60.285 sky130_fd_pr__pfet_01v8
M$2731 1044 1042 1043 1043 sky130_fd_pr__pfet_01v8 L=0.15U W=0.42U AS=0.0672P
+ AD=0.06615P PS=0.74U PD=0.735U
* device instance $2732 r0 *1 11.965,60.285 sky130_fd_pr__pfet_01v8
M$2732 1067 1041 1044 1044 sky130_fd_pr__pfet_01v8 L=0.15U W=0.42U AS=0.06615P
+ AD=0.0693P PS=0.735U PD=0.75U
* device instance $2733 r0 *1 12.445,60.285 sky130_fd_pr__pfet_01v8
M$2733 37 1045 1067 1067 sky130_fd_pr__pfet_01v8 L=0.15U W=0.42U AS=0.0693P
+ AD=0.178875P PS=0.75U PD=1.26U
* device instance $2734 r0 *1 13.58,60.285 sky130_fd_pr__pfet_01v8
M$2734 1046 1041 1045 1045 sky130_fd_pr__pfet_01v8 L=0.15U W=0.42U AS=0.1095P
+ AD=0.0567P PS=1.075U PD=0.69U
* device instance $2735 r0 *1 14,60.285 sky130_fd_pr__pfet_01v8
M$2735 1068 1042 1046 1046 sky130_fd_pr__pfet_01v8 L=0.15U W=0.42U AS=0.0567P
+ AD=0.09135P PS=0.69U PD=0.855U
* device instance $2736 r0 *1 14.585,60.285 sky130_fd_pr__pfet_01v8
M$2736 37 1047 1068 1068 sky130_fd_pr__pfet_01v8 L=0.15U W=0.42U AS=0.09135P
+ AD=0.1218P PS=0.855U PD=1.42U
* device instance $2737 r0 *1 13.105,60.45 sky130_fd_pr__pfet_01v8
M$2737 1045 1044 37 37 sky130_fd_pr__pfet_01v8 L=0.15U W=0.75U AS=0.178875P
+ AD=0.1095P PS=1.26U PD=1.075U
* device instance $2738 r0 *1 15.665,60.575 sky130_fd_pr__pfet_01v8
M$2738 37 1046 1047 1047 sky130_fd_pr__pfet_01v8 L=0.15U W=1U AS=0.28P
+ AD=0.1625P PS=2.56U PD=1.325U
* device instance $2739 r0 *1 16.14,60.575 sky130_fd_pr__pfet_01v8
M$2739 64 1047 37 37 sky130_fd_pr__pfet_01v8 L=0.15U W=4U AS=0.575P AD=0.6925P
+ PS=5.15U PD=6.385U
* device instance $2743 r0 *1 20.73,60.575 sky130_fd_pr__pfet_01v8
M$2743 37 1101 1048 1048 sky130_fd_pr__pfet_01v8 L=0.15U W=4U AS=0.685P
+ AD=0.54P PS=6.37U PD=5.08U
* device instance $2747 r0 *1 22.41,60.575 sky130_fd_pr__pfet_01v8
M$2747 1049 1010 1048 1048 sky130_fd_pr__pfet_01v8 L=0.15U W=4U AS=0.54P
+ AD=0.675P PS=5.08U PD=6.35U
* device instance $2751 r0 *1 24.85,60.575 sky130_fd_pr__pfet_01v8
M$2751 37 1049 1050 1050 sky130_fd_pr__pfet_01v8 L=0.15U W=3U AS=0.53P
+ AD=0.405P PS=5.06U PD=3.81U
* device instance $2754 r0 *1 26.11,60.575 sky130_fd_pr__pfet_01v8
M$2754 94 1050 37 37 sky130_fd_pr__pfet_01v8 L=0.15U W=8U AS=1.08P AD=1.205P
+ PS=10.16U PD=11.41U
* device instance $2762 r0 *1 24.87,59.105 sky130_fd_pr__pfet_01v8
M$2762 37 64 1031 1031 sky130_fd_pr__pfet_01v8 L=0.15U W=2U AS=0.415P AD=0.27P
+ PS=3.83U PD=2.54U
* device instance $2764 r0 *1 25.71,59.105 sky130_fd_pr__pfet_01v8
M$2764 1034 976 1031 1031 sky130_fd_pr__pfet_01v8 L=0.15U W=2U AS=0.27P
+ AD=0.415P PS=2.54U PD=3.83U
* device instance $2766 r0 *1 27.09,59.105 sky130_fd_pr__pfet_01v8
M$2766 1010 1015 1034 1034 sky130_fd_pr__pfet_01v8 L=0.15U W=2U AS=0.395P
+ AD=0.395P PS=3.79U PD=3.79U
* device instance $2768 r0 *1 28.65,59.105 sky130_fd_pr__pfet_01v8
M$2768 37 115 1012 1012 sky130_fd_pr__pfet_01v8 L=0.15U W=1U AS=0.38P AD=0.135P
+ PS=2.76U PD=1.27U
* device instance $2769 r0 *1 29.07,59.105 sky130_fd_pr__pfet_01v8
M$2769 92 1011 37 37 sky130_fd_pr__pfet_01v8 L=0.15U W=4U AS=0.54P AD=0.54P
+ PS=5.08U PD=5.08U
* device instance $2773 r0 *1 30.75,59.105 sky130_fd_pr__pfet_01v8
M$2773 1011 1012 37 37 sky130_fd_pr__pfet_01v8 L=0.15U W=2U AS=0.27P AD=0.395P
+ PS=2.54U PD=3.79U
* device instance $2775 r0 *1 32.11,59.105 sky130_fd_pr__pfet_01v8
M$2775 1011 1015 1035 1035 sky130_fd_pr__pfet_01v8 L=0.15U W=2U AS=0.395P
+ AD=0.27P PS=3.79U PD=2.54U
* device instance $2777 r0 *1 32.95,59.105 sky130_fd_pr__pfet_01v8
M$2777 37 976 1035 1035 sky130_fd_pr__pfet_01v8 L=0.15U W=2U AS=0.27P AD=0.415P
+ PS=2.54U PD=3.83U
* device instance $2779 r0 *1 32.21,60.575 sky130_fd_pr__pfet_01v8
M$2779 1081 976 1051 1051 sky130_fd_pr__pfet_01v8 L=0.15U W=1U AS=0.26P
+ AD=0.105P PS=2.52U PD=1.21U
* device instance $2780 r0 *1 32.57,60.575 sky130_fd_pr__pfet_01v8
M$2780 37 1073 1081 1081 sky130_fd_pr__pfet_01v8 L=0.15U W=1U AS=0.105P
+ AD=0.26P PS=1.21U PD=2.52U
* device instance $2781 r0 *1 33.83,60.865 sky130_fd_pr__pfet_01v8
M$2781 1074 993 37 37 sky130_fd_pr__pfet_01v8 L=0.15U W=0.42U AS=0.1573P
+ AD=0.1092P PS=1.39U PD=1.36U
* device instance $2782 r0 *1 34.37,60.575 sky130_fd_pr__pfet_01v8
M$2782 1082 893 37 37 sky130_fd_pr__pfet_01v8 L=0.15U W=1U AS=0.1573P AD=0.105P
+ PS=1.39U PD=1.21U
* device instance $2783 r0 *1 34.73,60.575 sky130_fd_pr__pfet_01v8
M$2783 1073 1074 1082 1082 sky130_fd_pr__pfet_01v8 L=0.15U W=1U AS=0.105P
+ AD=0.26P PS=1.21U PD=2.52U
* device instance $2784 r0 *1 34.97,59.105 sky130_fd_pr__pfet_01v8
M$2784 37 994 1014 1014 sky130_fd_pr__pfet_01v8 L=0.15U W=1U AS=0.26P AD=0.135P
+ PS=2.52U PD=1.27U
* device instance $2785 r0 *1 35.39,59.105 sky130_fd_pr__pfet_01v8
M$2785 1015 1014 37 37 sky130_fd_pr__pfet_01v8 L=0.15U W=4U AS=0.54P AD=0.665P
+ PS=5.08U PD=6.33U
* device instance $2789 r0 *1 37.99,59.105 sky130_fd_pr__pfet_01v8
M$2789 1016 999 37 37 sky130_fd_pr__pfet_01v8 L=0.15U W=2U AS=0.395P AD=0.27P
+ PS=3.79U PD=2.54U
* device instance $2791 r0 *1 38.83,59.105 sky130_fd_pr__pfet_01v8
M$2791 157 1016 37 37 sky130_fd_pr__pfet_01v8 L=0.15U W=6U AS=0.81P AD=0.935P
+ PS=7.62U PD=8.87U
* device instance $2797 r0 *1 40.03,60.575 sky130_fd_pr__pfet_01v8
M$2797 1053 1052 37 37 sky130_fd_pr__pfet_01v8 L=0.15U W=2U AS=0.395P AD=0.27P
+ PS=3.79U PD=2.54U
* device instance $2799 r0 *1 40.87,60.575 sky130_fd_pr__pfet_01v8
M$2799 1053 1033 37 37 sky130_fd_pr__pfet_01v8 L=0.15U W=2U AS=0.275P AD=0.285P
+ PS=2.55U PD=2.57U
* device instance $2801 r0 *1 41.74,60.575 sky130_fd_pr__pfet_01v8
M$2801 1053 1054 37 37 sky130_fd_pr__pfet_01v8 L=0.15U W=2U AS=0.28P AD=0.395P
+ PS=2.56U PD=3.79U
* device instance $2803 r0 *1 42.79,59.105 sky130_fd_pr__pfet_01v8
M$2803 1040 1017 1018 1018 sky130_fd_pr__pfet_01v8 L=0.15U W=1U AS=0.26P
+ AD=0.105P PS=2.52U PD=1.21U
* device instance $2804 r0 *1 43.15,59.105 sky130_fd_pr__pfet_01v8
M$2804 37 1019 1040 1040 sky130_fd_pr__pfet_01v8 L=0.15U W=1U AS=0.105P
+ AD=0.26P PS=1.21U PD=2.52U
* device instance $2805 r0 *1 43.1,60.575 sky130_fd_pr__pfet_01v8
M$2805 1053 1073 1055 1055 sky130_fd_pr__pfet_01v8 L=0.15U W=2U AS=0.395P
+ AD=0.395P PS=3.79U PD=2.79U
* device instance $2807 r0 *1 44.19,60.575 sky130_fd_pr__pfet_01v8
M$2807 1075 1076 1055 1055 sky130_fd_pr__pfet_01v8 L=0.15U W=2U AS=0.395P
+ AD=0.395P PS=2.79U PD=3.79U
* device instance $2809 r0 *1 45.57,60.575 sky130_fd_pr__pfet_01v8
M$2809 1056 1054 1019 1019 sky130_fd_pr__pfet_01v8 L=0.15U W=1U AS=0.265P
+ AD=0.14P PS=2.53U PD=1.28U
* device instance $2810 r0 *1 46,60.575 sky130_fd_pr__pfet_01v8
M$2810 37 1052 1056 1056 sky130_fd_pr__pfet_01v8 L=0.15U W=1U AS=0.14P
+ AD=0.1475P PS=1.28U PD=1.295U
* device instance $2811 r0 *1 46.445,60.575 sky130_fd_pr__pfet_01v8
M$2811 1056 1077 37 37 sky130_fd_pr__pfet_01v8 L=0.15U W=1U AS=0.1475P
+ AD=0.265P PS=1.295U PD=2.53U
* device instance $2812 r0 *1 46.47,59.105 sky130_fd_pr__pfet_01v8
M$2812 37 999 1020 1020 sky130_fd_pr__pfet_01v8 L=0.15U W=1U AS=0.26P AD=0.135P
+ PS=2.52U PD=1.27U
* device instance $2813 r0 *1 46.89,59.105 sky130_fd_pr__pfet_01v8
M$2813 1021 1020 37 37 sky130_fd_pr__pfet_01v8 L=0.15U W=4U AS=0.54P AD=0.665P
+ PS=5.08U PD=6.33U
* device instance $2817 r0 *1 49.69,60.575 sky130_fd_pr__pfet_01v8
M$2817 37 1052 1057 1057 sky130_fd_pr__pfet_01v8 L=0.15U W=2U AS=0.395P
+ AD=0.27P PS=3.79U PD=2.54U
* device instance $2819 r0 *1 50.53,60.575 sky130_fd_pr__pfet_01v8
M$2819 37 1077 1057 1057 sky130_fd_pr__pfet_01v8 L=0.15U W=2U AS=0.27P AD=0.27P
+ PS=2.54U PD=2.54U
* device instance $2821 r0 *1 51.37,60.575 sky130_fd_pr__pfet_01v8
M$2821 37 1054 1057 1057 sky130_fd_pr__pfet_01v8 L=0.15U W=2U AS=0.545P
+ AD=0.59P PS=3.09U PD=3.18U
* device instance $2823 r0 *1 52.85,60.575 sky130_fd_pr__pfet_01v8
M$2823 1058 1076 1057 1057 sky130_fd_pr__pfet_01v8 L=0.15U W=2U AS=0.355P
+ AD=0.435P PS=2.71U PD=3.87U
* device instance $2825 r0 *1 51.15,59.105 sky130_fd_pr__pfet_01v8
M$2825 37 854 1032 1032 sky130_fd_pr__pfet_01v8 L=0.15U W=4U AS=0.685P AD=0.54P
+ PS=6.37U PD=5.08U
* device instance $2829 r0 *1 52.83,59.105 sky130_fd_pr__pfet_01v8
M$2829 1036 799 1032 1032 sky130_fd_pr__pfet_01v8 L=0.15U W=4U AS=0.54P
+ AD=0.665P PS=5.08U PD=6.33U
* device instance $2833 r0 *1 55.03,59.105 sky130_fd_pr__pfet_01v8
M$2833 1036 980 1033 1033 sky130_fd_pr__pfet_01v8 L=0.15U W=4U AS=0.665P
+ AD=0.55P PS=6.33U PD=5.1U
* device instance $2837 r0 *1 56.73,59.105 sky130_fd_pr__pfet_01v8
M$2837 37 983 1033 1033 sky130_fd_pr__pfet_01v8 L=0.15U W=4U AS=0.55P AD=0.54P
+ PS=5.1U PD=5.08U
* device instance $2841 r0 *1 58.41,59.105 sky130_fd_pr__pfet_01v8
M$2841 37 1024 1033 1033 sky130_fd_pr__pfet_01v8 L=0.15U W=4U AS=0.54P
+ AD=0.665P PS=5.08U PD=6.33U
* device instance $2845 r0 *1 60.73,59.105 sky130_fd_pr__pfet_01v8
M$2845 1037 1025 1026 1026 sky130_fd_pr__pfet_01v8 L=0.15U W=1U AS=0.26P
+ AD=0.135P PS=2.52U PD=1.27U
* device instance $2846 r0 *1 61.15,59.105 sky130_fd_pr__pfet_01v8
M$2846 1038 985 1037 1037 sky130_fd_pr__pfet_01v8 L=0.15U W=1U AS=0.135P
+ AD=0.135P PS=1.27U PD=1.27U
* device instance $2847 r0 *1 61.57,59.105 sky130_fd_pr__pfet_01v8
M$2847 1037 92 1038 1038 sky130_fd_pr__pfet_01v8 L=0.15U W=1U AS=0.135P
+ AD=0.26P PS=1.27U PD=2.52U
* device instance $2848 r0 *1 62.51,59.105 sky130_fd_pr__pfet_01v8
M$2848 1038 1021 37 37 sky130_fd_pr__pfet_01v8 L=0.15U W=1U AS=0.26P AD=0.165P
+ PS=2.52U PD=1.33U
* device instance $2849 r0 *1 62.99,59.105 sky130_fd_pr__pfet_01v8
M$2849 37 996 1038 1038 sky130_fd_pr__pfet_01v8 L=0.15U W=1U AS=0.165P
+ AD=0.1575P PS=1.33U PD=1.315U
* device instance $2850 r0 *1 63.455,59.105 sky130_fd_pr__pfet_01v8
M$2850 1027 1026 37 37 sky130_fd_pr__pfet_01v8 L=0.15U W=1U AS=0.1575P AD=0.26P
+ PS=1.315U PD=2.52U
* device instance $2851 r0 *1 64.43,59.105 sky130_fd_pr__pfet_01v8
M$2851 1039 943 37 37 sky130_fd_pr__pfet_01v8 L=0.15U W=1U AS=0.26P AD=0.135P
+ PS=2.52U PD=1.27U
* device instance $2852 r0 *1 64.85,59.105 sky130_fd_pr__pfet_01v8
M$2852 37 983 1039 1039 sky130_fd_pr__pfet_01v8 L=0.15U W=1U AS=0.135P AD=0.26P
+ PS=1.27U PD=2.52U
* device instance $2853 r0 *1 64.85,60.395 sky130_fd_pr__pfet_01v8
M$2853 1080 1027 1061 1061 sky130_fd_pr__pfet_01v8 L=0.15U W=0.64U AS=0.1664P
+ AD=0.0672P PS=1.8U PD=0.85U
* device instance $2854 r0 *1 65.21,60.395 sky130_fd_pr__pfet_01v8
M$2854 37 1062 1080 1080 sky130_fd_pr__pfet_01v8 L=0.15U W=0.64U AS=0.0672P
+ AD=0.1664P PS=0.85U PD=1.8U
* device instance $2855 r0 *1 67.875,60.285 sky130_fd_pr__pfet_01v8
M$2855 1063 1060 1061 1061 sky130_fd_pr__pfet_01v8 L=0.15U W=0.42U AS=0.15985P
+ AD=0.06405P PS=1.265U PD=0.725U
* device instance $2856 r0 *1 68.33,60.285 sky130_fd_pr__pfet_01v8
M$2856 1071 1059 1063 1063 sky130_fd_pr__pfet_01v8 L=0.15U W=0.42U AS=0.06405P
+ AD=0.07665P PS=0.725U PD=0.785U
* device instance $2857 r0 *1 68.845,60.285 sky130_fd_pr__pfet_01v8
M$2857 37 1064 1071 1071 sky130_fd_pr__pfet_01v8 L=0.15U W=0.42U AS=0.07665P
+ AD=0.178875P PS=0.785U PD=1.26U
* device instance $2858 r0 *1 66.15,60.395 sky130_fd_pr__pfet_01v8
M$2858 37 303 1062 1062 sky130_fd_pr__pfet_01v8 L=0.15U W=0.64U AS=0.1664P
+ AD=0.0928P PS=1.8U PD=0.93U
* device instance $2859 r0 *1 66.59,60.395 sky130_fd_pr__pfet_01v8
M$2859 1079 303 37 37 sky130_fd_pr__pfet_01v8 L=0.15U W=0.64U AS=0.0928P
+ AD=0.1152P PS=0.93U PD=1U
* device instance $2860 r0 *1 67.1,60.395 sky130_fd_pr__pfet_01v8
M$2860 1061 1066 1079 1079 sky130_fd_pr__pfet_01v8 L=0.15U W=0.64U AS=0.1152P
+ AD=0.15985P PS=1U PD=1.265U
* device instance $2861 r0 *1 69.505,60.45 sky130_fd_pr__pfet_01v8
M$2861 1064 1063 37 37 sky130_fd_pr__pfet_01v8 L=0.15U W=0.75U AS=0.178875P
+ AD=0.195P PS=1.26U PD=2.02U
* device instance $2862 r0 *1 70.445,60.285 sky130_fd_pr__pfet_01v8
M$2862 1070 1064 37 37 sky130_fd_pr__pfet_01v8 L=0.15U W=0.42U AS=0.1092P
+ AD=0.06405P PS=1.36U PD=0.725U
* device instance $2863 r0 *1 70.9,60.285 sky130_fd_pr__pfet_01v8
M$2863 1065 1059 1070 1070 sky130_fd_pr__pfet_01v8 L=0.15U W=0.42U AS=0.06405P
+ AD=0.0567P PS=0.725U PD=0.69U
* device instance $2864 r0 *1 71.32,60.285 sky130_fd_pr__pfet_01v8
M$2864 1069 1060 1065 1065 sky130_fd_pr__pfet_01v8 L=0.15U W=0.42U AS=0.0567P
+ AD=0.0882P PS=0.69U PD=0.84U
* device instance $2865 r0 *1 71.89,60.285 sky130_fd_pr__pfet_01v8
M$2865 37 1066 1069 1069 sky130_fd_pr__pfet_01v8 L=0.15U W=0.42U AS=0.0882P
+ AD=0.1113P PS=0.84U PD=1.37U
* device instance $2866 r0 *1 72.945,60.395 sky130_fd_pr__pfet_01v8
M$2866 37 1065 1066 1066 sky130_fd_pr__pfet_01v8 L=0.15U W=0.64U AS=0.1728P
+ AD=0.154P PS=1.82U PD=1.335U
* device instance $2867 r0 *1 73.43,60.575 sky130_fd_pr__pfet_01v8
M$2867 955 1065 37 37 sky130_fd_pr__pfet_01v8 L=0.15U W=1U AS=0.154P AD=0.28P
+ PS=1.335U PD=2.56U
* device instance $2868 r0 *1 7.83,64.625 sky130_fd_pr__pfet_01v8
M$2868 1185 1128 37 37 sky130_fd_pr__pfet_01v8 L=0.15U W=1.68U AS=0.3318P
+ AD=0.3486P PS=3.31U PD=3.35U
* device instance $2870 r0 *1 9.21,64.545 sky130_fd_pr__pfet_01v8
M$2870 1135 1129 37 37 sky130_fd_pr__pfet_01v8 L=0.15U W=1U AS=0.26P AD=0.1125P
+ PS=2.52U PD=1.225U
* device instance $2871 r0 *1 9.585,64.545 sky130_fd_pr__pfet_01v8
M$2871 1098 1128 1135 1135 sky130_fd_pr__pfet_01v8 L=0.15U W=1U AS=0.1125P
+ AD=0.2325P PS=1.225U PD=1.465U
* device instance $2872 r0 *1 10.2,64.545 sky130_fd_pr__pfet_01v8
M$2872 1137 1099 1098 1098 sky130_fd_pr__pfet_01v8 L=0.15U W=1U AS=0.2325P
+ AD=0.105P PS=1.465U PD=1.21U
* device instance $2873 r0 *1 10.56,64.545 sky130_fd_pr__pfet_01v8
M$2873 37 918 1137 1137 sky130_fd_pr__pfet_01v8 L=0.15U W=1U AS=0.105P AD=0.27P
+ PS=1.21U PD=2.54U
* device instance $2874 r0 *1 9.67,60.425 sky130_fd_pr__pfet_01v8
M$2874 37 681 1041 1041 sky130_fd_pr__pfet_01v8 L=0.15U W=0.64U AS=0.1664P
+ AD=0.0864P PS=1.8U PD=0.91U
* device instance $2875 r0 *1 10.09,60.425 sky130_fd_pr__pfet_01v8
M$2875 1042 1041 37 37 sky130_fd_pr__pfet_01v8 L=0.15U W=0.64U AS=0.0864P
+ AD=0.1664P PS=0.91U PD=1.8U
* device instance $2876 r0 *1 11.53,64.545 sky130_fd_pr__pfet_01v8
M$2876 115 1130 37 37 sky130_fd_pr__pfet_01v8 L=0.15U W=1U AS=0.26P AD=0.135P
+ PS=2.52U PD=1.27U
* device instance $2877 r0 *1 11.95,64.545 sky130_fd_pr__pfet_01v8
M$2877 37 1100 115 115 sky130_fd_pr__pfet_01v8 L=0.15U W=1U AS=0.135P AD=0.26P
+ PS=1.27U PD=2.52U
* device instance $2878 r0 *1 12.89,64.625 sky130_fd_pr__pfet_01v8
M$2878 1100 64 37 37 sky130_fd_pr__pfet_01v8 L=0.15U W=1.68U AS=0.3318P
+ AD=0.3486P PS=3.31U PD=3.35U
* device instance $2880 r0 *1 17.05,64.545 sky130_fd_pr__pfet_01v8
M$2880 37 1130 1133 1133 sky130_fd_pr__pfet_01v8 L=0.15U W=4U AS=0.685P
+ AD=0.54P PS=6.37U PD=5.08U
* device instance $2884 r0 *1 18.73,64.545 sky130_fd_pr__pfet_01v8
M$2884 1101 64 1133 1133 sky130_fd_pr__pfet_01v8 L=0.15U W=4U AS=0.54P
+ AD=0.675P PS=5.08U PD=6.35U
* device instance $2888 r0 *1 22.255,64.545 sky130_fd_pr__pfet_01v8
M$2888 303 1101 37 37 sky130_fd_pr__pfet_01v8 L=0.15U W=8U AS=1.205P AD=1.205P
+ PS=11.41U PD=11.41U
* device instance $2896 r0 *1 26.49,64.545 sky130_fd_pr__pfet_01v8
M$2896 1102 1049 37 37 sky130_fd_pr__pfet_01v8 L=0.15U W=2U AS=0.395P AD=0.27P
+ PS=3.79U PD=2.54U
* device instance $2898 r0 *1 27.33,64.545 sky130_fd_pr__pfet_01v8
M$2898 410 1102 37 37 sky130_fd_pr__pfet_01v8 L=0.15U W=6U AS=0.81P AD=0.935P
+ PS=7.62U PD=8.87U
* device instance $2904 r0 *1 30.37,64.695 sky130_fd_pr__pfet_01v8
M$2904 37 681 1103 1103 sky130_fd_pr__pfet_01v8 L=0.15U W=0.64U AS=0.1664P
+ AD=0.0864P PS=1.8U PD=0.91U
* device instance $2905 r0 *1 30.79,64.695 sky130_fd_pr__pfet_01v8
M$2905 1105 1103 37 37 sky130_fd_pr__pfet_01v8 L=0.15U W=0.64U AS=0.0864P
+ AD=0.1664P PS=0.91U PD=1.8U
* device instance $2906 r0 *1 39.825,64.725 sky130_fd_pr__pfet_01v8
M$2906 1108 1111 37 37 sky130_fd_pr__pfet_01v8 L=0.15U W=0.64U AS=0.154P
+ AD=0.1728P PS=1.335U PD=1.82U
* device instance $2907 r0 *1 40.31,64.545 sky130_fd_pr__pfet_01v8
M$2907 993 1111 37 37 sky130_fd_pr__pfet_01v8 L=0.15U W=1U AS=0.154P AD=0.28P
+ PS=1.335U PD=2.56U
* device instance $2908 r0 *1 41.41,64.545 sky130_fd_pr__pfet_01v8
M$2908 37 1075 1112 1112 sky130_fd_pr__pfet_01v8 L=0.15U W=1U AS=0.26P
+ AD=0.135P PS=2.52U PD=1.27U
* device instance $2909 r0 *1 41.83,64.545 sky130_fd_pr__pfet_01v8
M$2909 994 1112 37 37 sky130_fd_pr__pfet_01v8 L=0.15U W=4U AS=0.54P AD=0.665P
+ PS=5.08U PD=6.33U
* device instance $2913 r0 *1 45.59,64.545 sky130_fd_pr__pfet_01v8
M$2913 1113 1134 37 37 sky130_fd_pr__pfet_01v8 L=0.15U W=1U AS=0.3P AD=0.135P
+ PS=2.6U PD=1.27U
* device instance $2914 r0 *1 46.01,64.545 sky130_fd_pr__pfet_01v8
M$2914 37 1114 1113 1113 sky130_fd_pr__pfet_01v8 L=0.15U W=1U AS=0.135P
+ AD=0.365P PS=1.27U PD=1.73U
* device instance $2915 r0 *1 46.89,64.545 sky130_fd_pr__pfet_01v8
M$2915 1138 1114 37 37 sky130_fd_pr__pfet_01v8 L=0.15U W=1U AS=0.365P AD=0.105P
+ PS=1.73U PD=1.21U
* device instance $2916 r0 *1 47.25,64.545 sky130_fd_pr__pfet_01v8
M$2916 1054 1134 1138 1138 sky130_fd_pr__pfet_01v8 L=0.15U W=1U AS=0.105P
+ AD=0.165P PS=1.21U PD=1.33U
* device instance $2917 r0 *1 47.73,64.545 sky130_fd_pr__pfet_01v8
M$2917 37 1113 1054 1054 sky130_fd_pr__pfet_01v8 L=0.15U W=1U AS=0.165P
+ AD=0.36P PS=1.33U PD=2.72U
* device instance $2918 r0 *1 47.39,60.85 sky130_fd_pr__pfet_01v8
M$2918 37 1054 1078 1078 sky130_fd_pr__pfet_01v8 L=0.15U W=0.42U AS=0.1092P
+ AD=0.0567P PS=1.36U PD=0.69U
* device instance $2919 r0 *1 47.81,60.85 sky130_fd_pr__pfet_01v8
M$2919 1078 1052 37 37 sky130_fd_pr__pfet_01v8 L=0.15U W=0.42U AS=0.0567P
+ AD=0.06615P PS=0.69U PD=0.735U
* device instance $2920 r0 *1 48.275,60.85 sky130_fd_pr__pfet_01v8
M$2920 1078 1077 37 37 sky130_fd_pr__pfet_01v8 L=0.15U W=0.42U AS=0.142225P
+ AD=0.06615P PS=1.335U PD=0.735U
* device instance $2921 r0 *1 48.75,60.575 sky130_fd_pr__pfet_01v8
M$2921 1017 1078 37 37 sky130_fd_pr__pfet_01v8 L=0.15U W=1U AS=0.142225P
+ AD=0.26P PS=1.335U PD=2.52U
* device instance $2922 r0 *1 48.77,64.545 sky130_fd_pr__pfet_01v8
M$2922 37 1033 1116 1116 sky130_fd_pr__pfet_01v8 L=0.15U W=1U AS=0.26P
+ AD=0.135P PS=2.52U PD=1.27U
* device instance $2923 r0 *1 49.19,64.545 sky130_fd_pr__pfet_01v8
M$2923 1077 1116 37 37 sky130_fd_pr__pfet_01v8 L=0.15U W=4U AS=0.54P AD=0.665P
+ PS=5.08U PD=6.33U
* device instance $2927 r0 *1 51.77,64.255 sky130_fd_pr__pfet_01v8
M$2927 37 1114 1117 1117 sky130_fd_pr__pfet_01v8 L=0.15U W=0.42U AS=0.1092P
+ AD=0.1573P PS=1.36U PD=1.39U
* device instance $2928 r0 *1 52.31,64.545 sky130_fd_pr__pfet_01v8
M$2928 1136 1134 37 37 sky130_fd_pr__pfet_01v8 L=0.15U W=1U AS=0.1573P
+ AD=0.105P PS=1.39U PD=1.21U
* device instance $2929 r0 *1 52.67,64.545 sky130_fd_pr__pfet_01v8
M$2929 1076 1117 1136 1136 sky130_fd_pr__pfet_01v8 L=0.15U W=1U AS=0.105P
+ AD=0.26P PS=1.21U PD=2.52U
* device instance $2930 r0 *1 63.49,60.425 sky130_fd_pr__pfet_01v8
M$2930 37 979 1059 1059 sky130_fd_pr__pfet_01v8 L=0.15U W=0.64U AS=0.1664P
+ AD=0.0864P PS=1.8U PD=0.91U
* device instance $2931 r0 *1 63.91,60.425 sky130_fd_pr__pfet_01v8
M$2931 1060 1059 37 37 sky130_fd_pr__pfet_01v8 L=0.15U W=0.64U AS=0.0864P
+ AD=0.1664P PS=0.91U PD=1.8U
* device instance $2932 r0 *1 64.41,64.255 sky130_fd_pr__pfet_01v8
M$2932 37 1131 1118 1118 sky130_fd_pr__pfet_01v8 L=0.15U W=0.42U AS=0.1092P
+ AD=0.14575P PS=1.36U PD=1.335U
* device instance $2933 r0 *1 64.895,64.545 sky130_fd_pr__pfet_01v8
M$2933 1052 1132 37 37 sky130_fd_pr__pfet_01v8 L=0.15U W=1U AS=0.14575P
+ AD=0.135P PS=1.335U PD=1.27U
* device instance $2934 r0 *1 65.315,64.545 sky130_fd_pr__pfet_01v8
M$2934 37 1118 1052 1052 sky130_fd_pr__pfet_01v8 L=0.15U W=1U AS=0.135P
+ AD=0.265P PS=1.27U PD=2.53U
* device instance $2935 r0 *1 66.71,64.545 sky130_fd_pr__pfet_01v8
M$2935 37 1132 1119 1119 sky130_fd_pr__pfet_01v8 L=0.15U W=1U AS=0.26P
+ AD=0.135P PS=2.52U PD=1.27U
* device instance $2936 r0 *1 67.13,64.545 sky130_fd_pr__pfet_01v8
M$2936 374 1119 37 37 sky130_fd_pr__pfet_01v8 L=0.15U W=4U AS=0.54P AD=0.665P
+ PS=5.08U PD=6.33U
* device instance $2940 r0 *1 5.09,66.015 sky130_fd_pr__pfet_01v8
M$2940 1129 1144 37 37 sky130_fd_pr__pfet_01v8 L=0.15U W=1U AS=0.26P AD=0.135P
+ PS=2.52U PD=1.27U
* device instance $2941 r0 *1 5.51,66.015 sky130_fd_pr__pfet_01v8
M$2941 37 64 1129 1129 sky130_fd_pr__pfet_01v8 L=0.15U W=1U AS=0.135P AD=0.26P
+ PS=1.27U PD=2.52U
* device instance $2942 r0 *1 8.805,65.835 sky130_fd_pr__pfet_01v8
M$2942 1194 1100 37 37 sky130_fd_pr__pfet_01v8 L=0.15U W=0.64U AS=0.1696P
+ AD=0.0768P PS=1.81U PD=0.88U
* device instance $2943 r0 *1 9.195,65.835 sky130_fd_pr__pfet_01v8
M$2943 1072 1144 1194 1194 sky130_fd_pr__pfet_01v8 L=0.15U W=0.64U AS=0.0768P
+ AD=0.0896P PS=0.88U PD=0.92U
* device instance $2944 r0 *1 9.625,65.835 sky130_fd_pr__pfet_01v8
M$2944 37 1145 1072 1072 sky130_fd_pr__pfet_01v8 L=0.15U W=0.64U AS=0.0896P
+ AD=0.1824P PS=0.92U PD=1.85U
* device instance $2945 r0 *1 10.61,66.015 sky130_fd_pr__pfet_01v8
M$2945 1099 1185 37 37 sky130_fd_pr__pfet_01v8 L=0.15U W=1U AS=0.26P AD=0.135P
+ PS=2.52U PD=1.27U
* device instance $2946 r0 *1 11.03,66.015 sky130_fd_pr__pfet_01v8
M$2946 37 1130 1099 1099 sky130_fd_pr__pfet_01v8 L=0.15U W=1U AS=0.135P
+ AD=0.26P PS=1.27U PD=2.52U
* device instance $2947 r0 *1 12.04,66.015 sky130_fd_pr__pfet_01v8
M$2947 37 1186 1146 1146 sky130_fd_pr__pfet_01v8 L=0.15U W=1U AS=0.33P
+ AD=0.2425P PS=2.66U PD=1.485U
* device instance $2948 r0 *1 12.675,66.015 sky130_fd_pr__pfet_01v8
M$2948 1147 918 37 37 sky130_fd_pr__pfet_01v8 L=0.15U W=1U AS=0.2425P AD=0.165P
+ PS=1.485U PD=1.33U
* device instance $2949 r0 *1 13.155,66.015 sky130_fd_pr__pfet_01v8
M$2949 37 1185 1147 1147 sky130_fd_pr__pfet_01v8 L=0.15U W=1U AS=0.165P
+ AD=0.225P PS=1.33U PD=1.45U
* device instance $2950 r0 *1 13.755,66.015 sky130_fd_pr__pfet_01v8
M$2950 1147 1130 37 37 sky130_fd_pr__pfet_01v8 L=0.15U W=1U AS=0.225P AD=0.185P
+ PS=1.45U PD=1.37U
* device instance $2951 r0 *1 14.275,66.015 sky130_fd_pr__pfet_01v8
M$2951 1186 1145 1147 1147 sky130_fd_pr__pfet_01v8 L=0.15U W=1U AS=0.185P
+ AD=0.14P PS=1.37U PD=1.28U
* device instance $2952 r0 *1 14.705,66.015 sky130_fd_pr__pfet_01v8
M$2952 1147 1187 1186 1186 sky130_fd_pr__pfet_01v8 L=0.15U W=1U AS=0.14P
+ AD=0.265P PS=1.28U PD=2.53U
* device instance $2953 r0 *1 24.46,65.725 sky130_fd_pr__pfet_01v8
M$2953 1149 1188 37 37 sky130_fd_pr__pfet_01v8 L=0.15U W=0.42U AS=0.1113P
+ AD=0.0609P PS=1.37U PD=0.71U
* device instance $2954 r0 *1 24.9,65.725 sky130_fd_pr__pfet_01v8
M$2954 37 115 1149 1149 sky130_fd_pr__pfet_01v8 L=0.15U W=0.42U AS=0.0609P
+ AD=0.1841P PS=0.71U PD=1.26U
* device instance $2955 r0 *1 25.67,65.835 sky130_fd_pr__pfet_01v8
M$2955 1150 1149 37 37 sky130_fd_pr__pfet_01v8 L=0.15U W=0.64U AS=0.1841P
+ AD=0.1696P PS=1.26U PD=1.81U
* device instance $2956 r0 *1 26.69,66.015 sky130_fd_pr__pfet_01v8
M$2956 1152 1150 1151 1151 sky130_fd_pr__pfet_01v8 L=0.15U W=1U AS=0.26P
+ AD=0.135P PS=2.52U PD=1.27U
* device instance $2957 r0 *1 27.11,66.015 sky130_fd_pr__pfet_01v8
M$2957 1153 893 1152 1152 sky130_fd_pr__pfet_01v8 L=0.15U W=1U AS=0.135P
+ AD=0.135P PS=1.27U PD=1.27U
* device instance $2958 r0 *1 27.53,66.015 sky130_fd_pr__pfet_01v8
M$2958 1152 92 1153 1153 sky130_fd_pr__pfet_01v8 L=0.15U W=1U AS=0.135P
+ AD=0.26P PS=1.27U PD=2.52U
* device instance $2959 r0 *1 28.47,66.015 sky130_fd_pr__pfet_01v8
M$2959 1153 1154 37 37 sky130_fd_pr__pfet_01v8 L=0.15U W=1U AS=0.26P AD=0.165P
+ PS=2.52U PD=1.33U
* device instance $2960 r0 *1 28.95,66.015 sky130_fd_pr__pfet_01v8
M$2960 37 999 1153 1153 sky130_fd_pr__pfet_01v8 L=0.15U W=1U AS=0.165P
+ AD=0.1575P PS=1.33U PD=1.315U
* device instance $2961 r0 *1 29.415,66.015 sky130_fd_pr__pfet_01v8
M$2961 1104 1151 37 37 sky130_fd_pr__pfet_01v8 L=0.15U W=1U AS=0.1575P AD=0.26P
+ PS=1.315U PD=2.52U
* device instance $2962 r0 *1 31.73,64.725 sky130_fd_pr__pfet_01v8
M$2962 1143 1104 1106 1106 sky130_fd_pr__pfet_01v8 L=0.15U W=0.64U AS=0.1664P
+ AD=0.0672P PS=1.8U PD=0.85U
* device instance $2963 r0 *1 32.09,64.725 sky130_fd_pr__pfet_01v8
M$2963 37 1107 1143 1143 sky130_fd_pr__pfet_01v8 L=0.15U W=0.64U AS=0.0672P
+ AD=0.1664P PS=0.85U PD=1.8U
* device instance $2964 r0 *1 32.25,66.015 sky130_fd_pr__pfet_01v8
M$2964 1155 1058 37 37 sky130_fd_pr__pfet_01v8 L=0.15U W=1U AS=0.3P AD=0.135P
+ PS=2.6U PD=1.27U
* device instance $2965 r0 *1 32.67,66.015 sky130_fd_pr__pfet_01v8
M$2965 37 1051 1155 1155 sky130_fd_pr__pfet_01v8 L=0.15U W=1U AS=0.135P
+ AD=0.365P PS=1.27U PD=1.73U
* device instance $2966 r0 *1 33.55,66.015 sky130_fd_pr__pfet_01v8
M$2966 1198 1051 37 37 sky130_fd_pr__pfet_01v8 L=0.15U W=1U AS=0.365P AD=0.105P
+ PS=1.73U PD=1.21U
* device instance $2967 r0 *1 33.91,66.015 sky130_fd_pr__pfet_01v8
M$2967 1154 1058 1198 1198 sky130_fd_pr__pfet_01v8 L=0.15U W=1U AS=0.105P
+ AD=0.165P PS=1.21U PD=1.33U
* device instance $2968 r0 *1 34.39,66.015 sky130_fd_pr__pfet_01v8
M$2968 37 1155 1154 1154 sky130_fd_pr__pfet_01v8 L=0.15U W=1U AS=0.165P
+ AD=0.36P PS=1.33U PD=2.72U
* device instance $2969 r0 *1 33.03,64.725 sky130_fd_pr__pfet_01v8
M$2969 37 303 1107 1107 sky130_fd_pr__pfet_01v8 L=0.15U W=0.64U AS=0.1664P
+ AD=0.0928P PS=1.8U PD=0.93U
* device instance $2970 r0 *1 33.47,64.725 sky130_fd_pr__pfet_01v8
M$2970 1142 303 37 37 sky130_fd_pr__pfet_01v8 L=0.15U W=0.64U AS=0.0928P
+ AD=0.1152P PS=0.93U PD=1U
* device instance $2971 r0 *1 33.98,64.725 sky130_fd_pr__pfet_01v8
M$2971 1106 1108 1142 1142 sky130_fd_pr__pfet_01v8 L=0.15U W=0.64U AS=0.1152P
+ AD=0.15985P PS=1U PD=1.265U
* device instance $2972 r0 *1 34.755,64.835 sky130_fd_pr__pfet_01v8
M$2972 1109 1105 1106 1106 sky130_fd_pr__pfet_01v8 L=0.15U W=0.42U AS=0.15985P
+ AD=0.06405P PS=1.265U PD=0.725U
* device instance $2973 r0 *1 35.21,64.835 sky130_fd_pr__pfet_01v8
M$2973 1141 1103 1109 1109 sky130_fd_pr__pfet_01v8 L=0.15U W=0.42U AS=0.06405P
+ AD=0.07665P PS=0.725U PD=0.785U
* device instance $2974 r0 *1 35.725,64.835 sky130_fd_pr__pfet_01v8
M$2974 1141 1110 37 37 sky130_fd_pr__pfet_01v8 L=0.15U W=0.42U AS=0.178875P
+ AD=0.07665P PS=1.26U PD=0.785U
* device instance $2975 r0 *1 36.385,64.67 sky130_fd_pr__pfet_01v8
M$2975 1110 1109 37 37 sky130_fd_pr__pfet_01v8 L=0.15U W=0.75U AS=0.178875P
+ AD=0.195P PS=1.26U PD=2.02U
* device instance $2976 r0 *1 36.81,66.015 sky130_fd_pr__pfet_01v8
M$2976 1157 1189 1156 1156 sky130_fd_pr__pfet_01v8 L=0.15U W=1U AS=0.26P
+ AD=0.135P PS=2.52U PD=1.27U
* device instance $2977 r0 *1 37.23,66.015 sky130_fd_pr__pfet_01v8
M$2977 1158 1134 1157 1157 sky130_fd_pr__pfet_01v8 L=0.15U W=1U AS=0.135P
+ AD=0.135P PS=1.27U PD=1.27U
* device instance $2978 r0 *1 37.65,66.015 sky130_fd_pr__pfet_01v8
M$2978 1157 92 1158 1158 sky130_fd_pr__pfet_01v8 L=0.15U W=1U AS=0.135P
+ AD=0.26P PS=1.27U PD=2.52U
* device instance $2979 r0 *1 37.325,64.835 sky130_fd_pr__pfet_01v8
M$2979 1140 1110 37 37 sky130_fd_pr__pfet_01v8 L=0.15U W=0.42U AS=0.1092P
+ AD=0.06405P PS=1.36U PD=0.725U
* device instance $2980 r0 *1 37.78,64.835 sky130_fd_pr__pfet_01v8
M$2980 1111 1103 1140 1140 sky130_fd_pr__pfet_01v8 L=0.15U W=0.42U AS=0.06405P
+ AD=0.0567P PS=0.725U PD=0.69U
* device instance $2981 r0 *1 38.2,64.835 sky130_fd_pr__pfet_01v8
M$2981 1139 1105 1111 1111 sky130_fd_pr__pfet_01v8 L=0.15U W=0.42U AS=0.0567P
+ AD=0.0882P PS=0.69U PD=0.84U
* device instance $2982 r0 *1 38.77,64.835 sky130_fd_pr__pfet_01v8
M$2982 37 1108 1139 1139 sky130_fd_pr__pfet_01v8 L=0.15U W=0.42U AS=0.0882P
+ AD=0.1113P PS=0.84U PD=1.37U
* device instance $2983 r0 *1 38.59,66.015 sky130_fd_pr__pfet_01v8
M$2983 1158 1190 37 37 sky130_fd_pr__pfet_01v8 L=0.15U W=1U AS=0.26P AD=0.165P
+ PS=2.52U PD=1.33U
* device instance $2984 r0 *1 39.07,66.015 sky130_fd_pr__pfet_01v8
M$2984 37 1018 1158 1158 sky130_fd_pr__pfet_01v8 L=0.15U W=1U AS=0.165P
+ AD=0.1575P PS=1.33U PD=1.315U
* device instance $2985 r0 *1 39.535,66.015 sky130_fd_pr__pfet_01v8
M$2985 1204 1156 37 37 sky130_fd_pr__pfet_01v8 L=0.15U W=1U AS=0.1575P AD=0.26P
+ PS=1.315U PD=2.52U
* device instance $2986 r0 *1 41.85,65.835 sky130_fd_pr__pfet_01v8
M$2986 1200 1191 1161 1161 sky130_fd_pr__pfet_01v8 L=0.15U W=0.64U AS=0.1664P
+ AD=0.0672P PS=1.8U PD=0.85U
* device instance $2987 r0 *1 42.21,65.835 sky130_fd_pr__pfet_01v8
M$2987 37 1162 1200 1200 sky130_fd_pr__pfet_01v8 L=0.15U W=0.64U AS=0.0672P
+ AD=0.1664P PS=0.85U PD=1.8U
* device instance $2988 r0 *1 44.875,65.725 sky130_fd_pr__pfet_01v8
M$2988 1163 1160 1161 1161 sky130_fd_pr__pfet_01v8 L=0.15U W=0.42U AS=0.15985P
+ AD=0.06405P PS=1.265U PD=0.725U
* device instance $2989 r0 *1 45.33,65.725 sky130_fd_pr__pfet_01v8
M$2989 1183 1159 1163 1163 sky130_fd_pr__pfet_01v8 L=0.15U W=0.42U AS=0.06405P
+ AD=0.07665P PS=0.725U PD=0.785U
* device instance $2990 r0 *1 45.845,65.725 sky130_fd_pr__pfet_01v8
M$2990 37 1164 1183 1183 sky130_fd_pr__pfet_01v8 L=0.15U W=0.42U AS=0.07665P
+ AD=0.178875P PS=0.785U PD=1.26U
* device instance $2991 r0 *1 43.15,65.835 sky130_fd_pr__pfet_01v8
M$2991 37 410 1162 1162 sky130_fd_pr__pfet_01v8 L=0.15U W=0.64U AS=0.1664P
+ AD=0.0928P PS=1.8U PD=0.93U
* device instance $2992 r0 *1 43.59,65.835 sky130_fd_pr__pfet_01v8
M$2992 1199 410 37 37 sky130_fd_pr__pfet_01v8 L=0.15U W=0.64U AS=0.0928P
+ AD=0.1152P PS=0.93U PD=1U
* device instance $2993 r0 *1 44.1,65.835 sky130_fd_pr__pfet_01v8
M$2993 1161 1166 1199 1199 sky130_fd_pr__pfet_01v8 L=0.15U W=0.64U AS=0.1152P
+ AD=0.15985P PS=1U PD=1.265U
* device instance $2994 r0 *1 46.505,65.89 sky130_fd_pr__pfet_01v8
M$2994 1164 1163 37 37 sky130_fd_pr__pfet_01v8 L=0.15U W=0.75U AS=0.178875P
+ AD=0.195P PS=1.26U PD=2.02U
* device instance $2995 r0 *1 47.445,65.725 sky130_fd_pr__pfet_01v8
M$2995 1184 1164 37 37 sky130_fd_pr__pfet_01v8 L=0.15U W=0.42U AS=0.1092P
+ AD=0.06405P PS=1.36U PD=0.725U
* device instance $2996 r0 *1 47.9,65.725 sky130_fd_pr__pfet_01v8
M$2996 1165 1159 1184 1184 sky130_fd_pr__pfet_01v8 L=0.15U W=0.42U AS=0.06405P
+ AD=0.0567P PS=0.725U PD=0.69U
* device instance $2997 r0 *1 48.32,65.725 sky130_fd_pr__pfet_01v8
M$2997 1182 1160 1165 1165 sky130_fd_pr__pfet_01v8 L=0.15U W=0.42U AS=0.0567P
+ AD=0.0882P PS=0.69U PD=0.84U
* device instance $2998 r0 *1 48.89,65.725 sky130_fd_pr__pfet_01v8
M$2998 37 1166 1182 1182 sky130_fd_pr__pfet_01v8 L=0.15U W=0.42U AS=0.0882P
+ AD=0.1113P PS=0.84U PD=1.37U
* device instance $2999 r0 *1 49.945,65.835 sky130_fd_pr__pfet_01v8
M$2999 37 1165 1166 1166 sky130_fd_pr__pfet_01v8 L=0.15U W=0.64U AS=0.1728P
+ AD=0.154P PS=1.82U PD=1.335U
* device instance $3000 r0 *1 50.43,66.015 sky130_fd_pr__pfet_01v8
M$3000 1134 1165 37 37 sky130_fd_pr__pfet_01v8 L=0.15U W=1U AS=0.154P AD=0.28P
+ PS=1.335U PD=2.56U
* device instance $3001 r0 *1 60.34,65.725 sky130_fd_pr__pfet_01v8
M$3001 1167 1024 37 37 sky130_fd_pr__pfet_01v8 L=0.15U W=0.42U AS=0.1113P
+ AD=0.0609P PS=1.37U PD=0.71U
* device instance $3002 r0 *1 60.78,65.725 sky130_fd_pr__pfet_01v8
M$3002 37 1052 1167 1167 sky130_fd_pr__pfet_01v8 L=0.15U W=0.42U AS=0.0609P
+ AD=0.1841P PS=0.71U PD=1.26U
* device instance $3003 r0 *1 61.55,65.835 sky130_fd_pr__pfet_01v8
M$3003 1168 1167 37 37 sky130_fd_pr__pfet_01v8 L=0.15U W=0.64U AS=0.1841P
+ AD=0.1696P PS=1.26U PD=1.81U
* device instance $3004 r0 *1 62.61,66.015 sky130_fd_pr__pfet_01v8
M$3004 1197 1039 1169 1169 sky130_fd_pr__pfet_01v8 L=0.15U W=1U AS=0.26P
+ AD=0.135P PS=2.52U PD=1.27U
* device instance $3005 r0 *1 63.03,66.015 sky130_fd_pr__pfet_01v8
M$3005 37 1168 1197 1197 sky130_fd_pr__pfet_01v8 L=0.15U W=1U AS=0.135P
+ AD=0.135P PS=1.27U PD=1.27U
* device instance $3006 r0 *1 63.45,66.015 sky130_fd_pr__pfet_01v8
M$3006 1170 1168 37 37 sky130_fd_pr__pfet_01v8 L=0.15U W=1U AS=0.135P AD=0.135P
+ PS=1.27U PD=1.27U
* device instance $3007 r0 *1 63.87,66.015 sky130_fd_pr__pfet_01v8
M$3007 37 1039 1170 1170 sky130_fd_pr__pfet_01v8 L=0.15U W=1U AS=0.135P
+ AD=0.26P PS=1.27U PD=2.52U
* device instance $3008 r0 *1 64.81,66.015 sky130_fd_pr__pfet_01v8
M$3008 1192 1169 1170 1170 sky130_fd_pr__pfet_01v8 L=0.15U W=1U AS=0.26P
+ AD=0.3P PS=2.52U PD=2.6U
* device instance $3009 r0 *1 67.15,65.835 sky130_fd_pr__pfet_01v8
M$3009 1196 1193 1173 1173 sky130_fd_pr__pfet_01v8 L=0.15U W=0.64U AS=0.1664P
+ AD=0.0672P PS=1.8U PD=0.85U
* device instance $3010 r0 *1 67.51,65.835 sky130_fd_pr__pfet_01v8
M$3010 37 1174 1196 1196 sky130_fd_pr__pfet_01v8 L=0.15U W=0.64U AS=0.0672P
+ AD=0.1664P PS=0.85U PD=1.8U
* device instance $3011 r0 *1 70.175,65.725 sky130_fd_pr__pfet_01v8
M$3011 1175 1172 1173 1173 sky130_fd_pr__pfet_01v8 L=0.15U W=0.42U AS=0.15985P
+ AD=0.06405P PS=1.265U PD=0.725U
* device instance $3012 r0 *1 70.63,65.725 sky130_fd_pr__pfet_01v8
M$3012 1181 1171 1175 1175 sky130_fd_pr__pfet_01v8 L=0.15U W=0.42U AS=0.06405P
+ AD=0.07665P PS=0.725U PD=0.785U
* device instance $3013 r0 *1 71.145,65.725 sky130_fd_pr__pfet_01v8
M$3013 37 1176 1181 1181 sky130_fd_pr__pfet_01v8 L=0.15U W=0.42U AS=0.07665P
+ AD=0.178875P PS=0.785U PD=1.26U
* device instance $3014 r0 *1 68.45,65.835 sky130_fd_pr__pfet_01v8
M$3014 37 410 1174 1174 sky130_fd_pr__pfet_01v8 L=0.15U W=0.64U AS=0.1664P
+ AD=0.0928P PS=1.8U PD=0.93U
* device instance $3015 r0 *1 68.89,65.835 sky130_fd_pr__pfet_01v8
M$3015 1195 410 37 37 sky130_fd_pr__pfet_01v8 L=0.15U W=0.64U AS=0.0928P
+ AD=0.1152P PS=0.93U PD=1U
* device instance $3016 r0 *1 69.4,65.835 sky130_fd_pr__pfet_01v8
M$3016 1173 1178 1195 1195 sky130_fd_pr__pfet_01v8 L=0.15U W=0.64U AS=0.1152P
+ AD=0.15985P PS=1U PD=1.265U
* device instance $3017 r0 *1 71.805,65.89 sky130_fd_pr__pfet_01v8
M$3017 1176 1175 37 37 sky130_fd_pr__pfet_01v8 L=0.15U W=0.75U AS=0.178875P
+ AD=0.195P PS=1.26U PD=2.02U
* device instance $3018 r0 *1 72.745,65.725 sky130_fd_pr__pfet_01v8
M$3018 1180 1176 37 37 sky130_fd_pr__pfet_01v8 L=0.15U W=0.42U AS=0.1092P
+ AD=0.06405P PS=1.36U PD=0.725U
* device instance $3019 r0 *1 73.2,65.725 sky130_fd_pr__pfet_01v8
M$3019 1177 1171 1180 1180 sky130_fd_pr__pfet_01v8 L=0.15U W=0.42U AS=0.06405P
+ AD=0.0567P PS=0.725U PD=0.69U
* device instance $3020 r0 *1 73.62,65.725 sky130_fd_pr__pfet_01v8
M$3020 1179 1172 1177 1177 sky130_fd_pr__pfet_01v8 L=0.15U W=0.42U AS=0.0567P
+ AD=0.0882P PS=0.69U PD=0.84U
* device instance $3021 r0 *1 74.19,65.725 sky130_fd_pr__pfet_01v8
M$3021 37 1178 1179 1179 sky130_fd_pr__pfet_01v8 L=0.15U W=0.42U AS=0.0882P
+ AD=0.1113P PS=0.84U PD=1.37U
* device instance $3022 r0 *1 75.245,65.835 sky130_fd_pr__pfet_01v8
M$3022 37 1177 1178 1178 sky130_fd_pr__pfet_01v8 L=0.15U W=0.64U AS=0.1728P
+ AD=0.154P PS=1.82U PD=1.335U
* device instance $3023 r0 *1 75.73,66.015 sky130_fd_pr__pfet_01v8
M$3023 1132 1177 37 37 sky130_fd_pr__pfet_01v8 L=0.15U W=1U AS=0.154P AD=0.28P
+ PS=1.335U PD=2.56U
* device instance $3024 r0 *1 5.55,69.985 sky130_fd_pr__pfet_01v8
M$3024 37 1201 1291 1291 sky130_fd_pr__pfet_01v8 L=0.15U W=2U AS=0.415P
+ AD=0.275P PS=3.83U PD=2.55U
* device instance $3025 r0 *1 5.98,69.985 sky130_fd_pr__pfet_01v8
M$3025 1291 1229 37 37 sky130_fd_pr__pfet_01v8 L=0.15U W=2U AS=0.28P AD=0.275P
+ PS=2.56U PD=2.55U
* device instance $3028 r0 *1 7.25,69.985 sky130_fd_pr__pfet_01v8
M$3028 1145 1128 1291 1291 sky130_fd_pr__pfet_01v8 L=0.15U W=2U AS=0.27P
+ AD=0.495P PS=2.54U PD=3.99U
* device instance $3030 r0 *1 8.75,70.135 sky130_fd_pr__pfet_01v8
M$3030 37 681 1230 1230 sky130_fd_pr__pfet_01v8 L=0.15U W=0.64U AS=0.1664P
+ AD=0.0864P PS=1.8U PD=0.91U
* device instance $3031 r0 *1 9.17,70.135 sky130_fd_pr__pfet_01v8
M$3031 1231 1230 37 37 sky130_fd_pr__pfet_01v8 L=0.15U W=0.64U AS=0.0864P
+ AD=0.1664P PS=0.91U PD=1.8U
* device instance $3032 r0 *1 10.11,70.275 sky130_fd_pr__pfet_01v8
M$3032 1232 1146 37 37 sky130_fd_pr__pfet_01v8 L=0.15U W=0.42U AS=0.1092P
+ AD=0.05775P PS=1.36U PD=0.695U
* device instance $3033 r0 *1 10.535,70.275 sky130_fd_pr__pfet_01v8
M$3033 1233 1231 1232 1232 sky130_fd_pr__pfet_01v8 L=0.15U W=0.42U AS=0.05775P
+ AD=0.06825P PS=0.695U PD=0.745U
* device instance $3034 r0 *1 11.01,70.275 sky130_fd_pr__pfet_01v8
M$3034 1295 1230 1233 1233 sky130_fd_pr__pfet_01v8 L=0.15U W=0.42U AS=0.06825P
+ AD=0.07665P PS=0.745U PD=0.785U
* device instance $3035 r0 *1 11.525,70.275 sky130_fd_pr__pfet_01v8
M$3035 1295 1234 37 37 sky130_fd_pr__pfet_01v8 L=0.15U W=0.42U AS=0.178875P
+ AD=0.07665P PS=1.26U PD=0.785U
* device instance $3036 r0 *1 12.185,70.11 sky130_fd_pr__pfet_01v8
M$3036 1234 1233 37 37 sky130_fd_pr__pfet_01v8 L=0.15U W=0.75U AS=0.178875P
+ AD=0.1095P PS=1.26U PD=1.075U
* device instance $3037 r0 *1 12.66,70.275 sky130_fd_pr__pfet_01v8
M$3037 1235 1230 1234 1234 sky130_fd_pr__pfet_01v8 L=0.15U W=0.42U AS=0.1095P
+ AD=0.0567P PS=1.075U PD=0.69U
* device instance $3038 r0 *1 13.08,70.275 sky130_fd_pr__pfet_01v8
M$3038 1296 1231 1235 1235 sky130_fd_pr__pfet_01v8 L=0.15U W=0.42U AS=0.0567P
+ AD=0.0882P PS=0.69U PD=0.84U
* device instance $3039 r0 *1 13.65,70.275 sky130_fd_pr__pfet_01v8
M$3039 37 1236 1296 1296 sky130_fd_pr__pfet_01v8 L=0.15U W=0.42U AS=0.0882P
+ AD=0.1113P PS=0.84U PD=1.37U
* device instance $3040 r0 *1 14.7,69.985 sky130_fd_pr__pfet_01v8
M$3040 37 1235 1236 1236 sky130_fd_pr__pfet_01v8 L=0.15U W=1U AS=0.27P
+ AD=0.135P PS=2.54U PD=1.27U
* device instance $3041 r0 *1 15.12,69.985 sky130_fd_pr__pfet_01v8
M$3041 1187 1236 37 37 sky130_fd_pr__pfet_01v8 L=0.15U W=1U AS=0.135P AD=0.26P
+ PS=1.27U PD=2.52U
* device instance $3042 r0 *1 15.83,65.935 sky130_fd_pr__pfet_01v8
M$3042 1148 1187 37 37 sky130_fd_pr__pfet_01v8 L=0.15U W=0.42U AS=0.1176P
+ AD=0.0567P PS=1.4U PD=0.69U
* device instance $3043 r0 *1 16.25,65.935 sky130_fd_pr__pfet_01v8
M$3043 1148 1101 37 37 sky130_fd_pr__pfet_01v8 L=0.15U W=0.42U AS=0.16655P
+ AD=0.0567P PS=1.39U PD=0.69U
* device instance $3044 r0 *1 16.79,66.015 sky130_fd_pr__pfet_01v8
M$3044 1229 1148 37 37 sky130_fd_pr__pfet_01v8 L=0.15U W=1U AS=0.16655P
+ AD=0.475P PS=1.39U PD=2.95U
* device instance $3045 r0 *1 22.09,70.135 sky130_fd_pr__pfet_01v8
M$3045 37 681 1237 1237 sky130_fd_pr__pfet_01v8 L=0.15U W=0.64U AS=0.1664P
+ AD=0.0864P PS=1.8U PD=0.91U
* device instance $3046 r0 *1 22.51,70.135 sky130_fd_pr__pfet_01v8
M$3046 1238 1237 37 37 sky130_fd_pr__pfet_01v8 L=0.15U W=0.64U AS=0.0864P
+ AD=0.1664P PS=0.91U PD=1.8U
* device instance $3047 r0 *1 23.45,70.165 sky130_fd_pr__pfet_01v8
M$3047 1297 1274 1239 1239 sky130_fd_pr__pfet_01v8 L=0.15U W=0.64U AS=0.1664P
+ AD=0.0672P PS=1.8U PD=0.85U
* device instance $3048 r0 *1 23.81,70.165 sky130_fd_pr__pfet_01v8
M$3048 37 1240 1297 1297 sky130_fd_pr__pfet_01v8 L=0.15U W=0.64U AS=0.0672P
+ AD=0.1664P PS=0.85U PD=1.8U
* device instance $3049 r0 *1 24.75,70.165 sky130_fd_pr__pfet_01v8
M$3049 37 410 1240 1240 sky130_fd_pr__pfet_01v8 L=0.15U W=0.64U AS=0.1664P
+ AD=0.0928P PS=1.8U PD=0.93U
* device instance $3050 r0 *1 25.19,70.165 sky130_fd_pr__pfet_01v8
M$3050 1298 410 37 37 sky130_fd_pr__pfet_01v8 L=0.15U W=0.64U AS=0.0928P
+ AD=0.1152P PS=0.93U PD=1U
* device instance $3051 r0 *1 25.7,70.165 sky130_fd_pr__pfet_01v8
M$3051 1239 1275 1298 1298 sky130_fd_pr__pfet_01v8 L=0.15U W=0.64U AS=0.1152P
+ AD=0.15985P PS=1U PD=1.265U
* device instance $3052 r0 *1 26.475,70.275 sky130_fd_pr__pfet_01v8
M$3052 1241 1238 1239 1239 sky130_fd_pr__pfet_01v8 L=0.15U W=0.42U AS=0.15985P
+ AD=0.06405P PS=1.265U PD=0.725U
* device instance $3053 r0 *1 26.93,70.275 sky130_fd_pr__pfet_01v8
M$3053 1299 1237 1241 1241 sky130_fd_pr__pfet_01v8 L=0.15U W=0.42U AS=0.06405P
+ AD=0.07665P PS=0.725U PD=0.785U
* device instance $3054 r0 *1 27.445,70.275 sky130_fd_pr__pfet_01v8
M$3054 1299 1242 37 37 sky130_fd_pr__pfet_01v8 L=0.15U W=0.42U AS=0.178875P
+ AD=0.07665P PS=1.26U PD=0.785U
* device instance $3055 r0 *1 28.105,70.11 sky130_fd_pr__pfet_01v8
M$3055 1242 1241 37 37 sky130_fd_pr__pfet_01v8 L=0.15U W=0.75U AS=0.178875P
+ AD=0.195P PS=1.26U PD=2.02U
* device instance $3056 r0 *1 29.045,70.275 sky130_fd_pr__pfet_01v8
M$3056 1301 1242 37 37 sky130_fd_pr__pfet_01v8 L=0.15U W=0.42U AS=0.1092P
+ AD=0.06405P PS=1.36U PD=0.725U
* device instance $3057 r0 *1 29.5,70.275 sky130_fd_pr__pfet_01v8
M$3057 1243 1237 1301 1301 sky130_fd_pr__pfet_01v8 L=0.15U W=0.42U AS=0.06405P
+ AD=0.0567P PS=0.725U PD=0.69U
* device instance $3058 r0 *1 29.92,70.275 sky130_fd_pr__pfet_01v8
M$3058 1302 1238 1243 1243 sky130_fd_pr__pfet_01v8 L=0.15U W=0.42U AS=0.0567P
+ AD=0.0882P PS=0.69U PD=0.84U
* device instance $3059 r0 *1 30.49,70.275 sky130_fd_pr__pfet_01v8
M$3059 37 1275 1302 1302 sky130_fd_pr__pfet_01v8 L=0.15U W=0.42U AS=0.0882P
+ AD=0.1113P PS=0.84U PD=1.37U
* device instance $3060 r0 *1 31.545,70.165 sky130_fd_pr__pfet_01v8
M$3060 1275 1243 37 37 sky130_fd_pr__pfet_01v8 L=0.15U W=0.64U AS=0.154P
+ AD=0.1728P PS=1.335U PD=1.82U
* device instance $3061 r0 *1 32.03,69.985 sky130_fd_pr__pfet_01v8
M$3061 893 1243 37 37 sky130_fd_pr__pfet_01v8 L=0.15U W=1U AS=0.154P AD=0.28P
+ PS=1.335U PD=2.56U
* device instance $3062 r0 *1 33.13,69.985 sky130_fd_pr__pfet_01v8
M$3062 37 999 1244 1244 sky130_fd_pr__pfet_01v8 L=0.15U W=1U AS=0.26P AD=0.135P
+ PS=2.52U PD=1.27U
* device instance $3063 r0 *1 33.55,69.985 sky130_fd_pr__pfet_01v8
M$3063 1190 1244 37 37 sky130_fd_pr__pfet_01v8 L=0.15U W=4U AS=0.54P AD=0.665P
+ PS=5.08U PD=6.33U
* device instance $3067 r0 *1 40.49,65.865 sky130_fd_pr__pfet_01v8
M$3067 37 979 1159 1159 sky130_fd_pr__pfet_01v8 L=0.15U W=0.64U AS=0.1664P
+ AD=0.0864P PS=1.8U PD=0.91U
* device instance $3068 r0 *1 40.91,65.865 sky130_fd_pr__pfet_01v8
M$3068 1160 1159 37 37 sky130_fd_pr__pfet_01v8 L=0.15U W=0.64U AS=0.0864P
+ AD=0.1664P PS=0.91U PD=1.8U
* device instance $3069 r0 *1 40.51,69.985 sky130_fd_pr__pfet_01v8
M$3069 845 1276 37 37 sky130_fd_pr__pfet_01v8 L=0.15U W=1U AS=0.26P AD=0.135P
+ PS=2.52U PD=1.27U
* device instance $3070 r0 *1 40.93,69.985 sky130_fd_pr__pfet_01v8
M$3070 37 64 845 845 sky130_fd_pr__pfet_01v8 L=0.15U W=1U AS=0.135P AD=0.26P
+ PS=1.27U PD=2.52U
* device instance $3071 r0 *1 41.94,70.275 sky130_fd_pr__pfet_01v8
M$3071 1245 1286 37 37 sky130_fd_pr__pfet_01v8 L=0.15U W=0.42U AS=0.1113P
+ AD=0.0609P PS=1.37U PD=0.71U
* device instance $3072 r0 *1 42.38,70.275 sky130_fd_pr__pfet_01v8
M$3072 1245 115 37 37 sky130_fd_pr__pfet_01v8 L=0.15U W=0.42U AS=0.1841P
+ AD=0.0609P PS=1.26U PD=0.71U
* device instance $3073 r0 *1 43.15,70.165 sky130_fd_pr__pfet_01v8
M$3073 1189 1245 37 37 sky130_fd_pr__pfet_01v8 L=0.15U W=0.64U AS=0.1841P
+ AD=0.1696P PS=1.26U PD=1.81U
* device instance $3074 r0 *1 44.63,70.135 sky130_fd_pr__pfet_01v8
M$3074 37 979 1246 1246 sky130_fd_pr__pfet_01v8 L=0.15U W=0.64U AS=0.1664P
+ AD=0.0864P PS=1.8U PD=0.91U
* device instance $3075 r0 *1 45.05,70.135 sky130_fd_pr__pfet_01v8
M$3075 1247 1246 37 37 sky130_fd_pr__pfet_01v8 L=0.15U W=0.64U AS=0.0864P
+ AD=0.1664P PS=0.91U PD=1.8U
* device instance $3076 r0 *1 45.99,70.165 sky130_fd_pr__pfet_01v8
M$3076 1306 1204 1248 1248 sky130_fd_pr__pfet_01v8 L=0.15U W=0.64U AS=0.1664P
+ AD=0.0672P PS=1.8U PD=0.85U
* device instance $3077 r0 *1 46.35,70.165 sky130_fd_pr__pfet_01v8
M$3077 37 1249 1306 1306 sky130_fd_pr__pfet_01v8 L=0.15U W=0.64U AS=0.0672P
+ AD=0.1664P PS=0.85U PD=1.8U
* device instance $3078 r0 *1 47.29,70.165 sky130_fd_pr__pfet_01v8
M$3078 37 303 1249 1249 sky130_fd_pr__pfet_01v8 L=0.15U W=0.64U AS=0.1664P
+ AD=0.0928P PS=1.8U PD=0.93U
* device instance $3079 r0 *1 47.73,70.165 sky130_fd_pr__pfet_01v8
M$3079 1305 303 37 37 sky130_fd_pr__pfet_01v8 L=0.15U W=0.64U AS=0.0928P
+ AD=0.1152P PS=0.93U PD=1U
* device instance $3080 r0 *1 48.24,70.165 sky130_fd_pr__pfet_01v8
M$3080 1248 1277 1305 1305 sky130_fd_pr__pfet_01v8 L=0.15U W=0.64U AS=0.1152P
+ AD=0.15985P PS=1U PD=1.265U
* device instance $3081 r0 *1 49.015,70.275 sky130_fd_pr__pfet_01v8
M$3081 1250 1247 1248 1248 sky130_fd_pr__pfet_01v8 L=0.15U W=0.42U AS=0.15985P
+ AD=0.06405P PS=1.265U PD=0.725U
* device instance $3082 r0 *1 49.47,70.275 sky130_fd_pr__pfet_01v8
M$3082 1304 1246 1250 1250 sky130_fd_pr__pfet_01v8 L=0.15U W=0.42U AS=0.06405P
+ AD=0.07665P PS=0.725U PD=0.785U
* device instance $3083 r0 *1 49.985,70.275 sky130_fd_pr__pfet_01v8
M$3083 1304 1251 37 37 sky130_fd_pr__pfet_01v8 L=0.15U W=0.42U AS=0.178875P
+ AD=0.07665P PS=1.26U PD=0.785U
* device instance $3084 r0 *1 50.645,70.11 sky130_fd_pr__pfet_01v8
M$3084 1251 1250 37 37 sky130_fd_pr__pfet_01v8 L=0.15U W=0.75U AS=0.178875P
+ AD=0.195P PS=1.26U PD=2.02U
* device instance $3085 r0 *1 51.585,70.275 sky130_fd_pr__pfet_01v8
M$3085 1303 1251 37 37 sky130_fd_pr__pfet_01v8 L=0.15U W=0.42U AS=0.1092P
+ AD=0.06405P PS=1.36U PD=0.725U
* device instance $3086 r0 *1 52.04,70.275 sky130_fd_pr__pfet_01v8
M$3086 1252 1246 1303 1303 sky130_fd_pr__pfet_01v8 L=0.15U W=0.42U AS=0.06405P
+ AD=0.0567P PS=0.725U PD=0.69U
* device instance $3087 r0 *1 52.46,70.275 sky130_fd_pr__pfet_01v8
M$3087 1300 1247 1252 1252 sky130_fd_pr__pfet_01v8 L=0.15U W=0.42U AS=0.0567P
+ AD=0.0882P PS=0.69U PD=0.84U
* device instance $3088 r0 *1 53.03,70.275 sky130_fd_pr__pfet_01v8
M$3088 37 1277 1300 1300 sky130_fd_pr__pfet_01v8 L=0.15U W=0.42U AS=0.0882P
+ AD=0.1113P PS=0.84U PD=1.37U
* device instance $3089 r0 *1 54.085,70.165 sky130_fd_pr__pfet_01v8
M$3089 1277 1252 37 37 sky130_fd_pr__pfet_01v8 L=0.15U W=0.64U AS=0.154P
+ AD=0.1728P PS=1.335U PD=1.82U
* device instance $3090 r0 *1 54.57,69.985 sky130_fd_pr__pfet_01v8
M$3090 1114 1252 37 37 sky130_fd_pr__pfet_01v8 L=0.15U W=1U AS=0.154P AD=0.28P
+ PS=1.335U PD=2.56U
* device instance $3091 r0 *1 57.12,70.275 sky130_fd_pr__pfet_01v8
M$3091 1253 1287 37 37 sky130_fd_pr__pfet_01v8 L=0.15U W=0.42U AS=0.1113P
+ AD=0.0609P PS=1.37U PD=0.71U
* device instance $3092 r0 *1 57.56,70.275 sky130_fd_pr__pfet_01v8
M$3092 1253 115 37 37 sky130_fd_pr__pfet_01v8 L=0.15U W=0.42U AS=0.1841P
+ AD=0.0609P PS=1.26U PD=0.71U
* device instance $3093 r0 *1 58.33,70.165 sky130_fd_pr__pfet_01v8
M$3093 1025 1253 37 37 sky130_fd_pr__pfet_01v8 L=0.15U W=0.64U AS=0.1841P
+ AD=0.1696P PS=1.26U PD=1.81U
* device instance $3094 r0 *1 60.27,69.985 sky130_fd_pr__pfet_01v8
M$3094 1292 1278 1254 1254 sky130_fd_pr__pfet_01v8 L=0.15U W=1U AS=0.26P
+ AD=0.135P PS=2.52U PD=1.27U
* device instance $3095 r0 *1 60.69,69.985 sky130_fd_pr__pfet_01v8
M$3095 1288 1279 1292 1292 sky130_fd_pr__pfet_01v8 L=0.15U W=1U AS=0.135P
+ AD=0.135P PS=1.27U PD=1.27U
* device instance $3096 r0 *1 61.11,69.985 sky130_fd_pr__pfet_01v8
M$3096 1292 92 1288 1288 sky130_fd_pr__pfet_01v8 L=0.15U W=1U AS=0.135P
+ AD=0.26P PS=1.27U PD=2.52U
* device instance $3097 r0 *1 62.05,69.985 sky130_fd_pr__pfet_01v8
M$3097 1288 1021 37 37 sky130_fd_pr__pfet_01v8 L=0.15U W=1U AS=0.26P AD=0.165P
+ PS=2.52U PD=1.33U
* device instance $3098 r0 *1 62.53,69.985 sky130_fd_pr__pfet_01v8
M$3098 37 1192 1288 1288 sky130_fd_pr__pfet_01v8 L=0.15U W=1U AS=0.165P
+ AD=0.1575P PS=1.33U PD=1.315U
* device instance $3099 r0 *1 62.995,69.985 sky130_fd_pr__pfet_01v8
M$3099 1289 1254 37 37 sky130_fd_pr__pfet_01v8 L=0.15U W=1U AS=0.1575P AD=0.26P
+ PS=1.315U PD=2.52U
* device instance $3100 r0 *1 63.95,69.695 sky130_fd_pr__pfet_01v8
M$3100 37 1132 1255 1255 sky130_fd_pr__pfet_01v8 L=0.15U W=0.42U AS=0.1092P
+ AD=0.14575P PS=1.36U PD=1.335U
* device instance $3101 r0 *1 64.435,69.985 sky130_fd_pr__pfet_01v8
M$3101 1024 1131 37 37 sky130_fd_pr__pfet_01v8 L=0.15U W=1U AS=0.14575P
+ AD=0.135P PS=1.335U PD=1.27U
* device instance $3102 r0 *1 64.855,69.985 sky130_fd_pr__pfet_01v8
M$3102 37 1255 1024 1024 sky130_fd_pr__pfet_01v8 L=0.15U W=1U AS=0.135P
+ AD=0.265P PS=1.27U PD=2.53U
* device instance $3103 r0 *1 65.79,65.865 sky130_fd_pr__pfet_01v8
M$3103 37 979 1171 1171 sky130_fd_pr__pfet_01v8 L=0.15U W=0.64U AS=0.1664P
+ AD=0.0864P PS=1.8U PD=0.91U
* device instance $3104 r0 *1 66.21,65.865 sky130_fd_pr__pfet_01v8
M$3104 1172 1171 37 37 sky130_fd_pr__pfet_01v8 L=0.15U W=0.64U AS=0.0864P
+ AD=0.1664P PS=0.91U PD=1.8U
* device instance $3105 r0 *1 68.175,70.08 sky130_fd_pr__pfet_01v8
M$3105 1294 64 37 37 sky130_fd_pr__pfet_01v8 L=0.15U W=0.42U AS=0.15835P
+ AD=0.07665P PS=1.395U PD=0.785U
* device instance $3106 r0 *1 68.69,70.08 sky130_fd_pr__pfet_01v8
M$3106 1256 1131 1294 1294 sky130_fd_pr__pfet_01v8 L=0.15U W=0.42U AS=0.07665P
+ AD=0.1932P PS=0.785U PD=1.34U
* device instance $3107 r0 *1 69.76,70.08 sky130_fd_pr__pfet_01v8
M$3107 1293 1290 1256 1256 sky130_fd_pr__pfet_01v8 L=0.15U W=0.42U AS=0.1932P
+ AD=0.0441P PS=1.34U PD=0.63U
* device instance $3108 r0 *1 70.12,70.08 sky130_fd_pr__pfet_01v8
M$3108 37 1257 1293 1293 sky130_fd_pr__pfet_01v8 L=0.15U W=0.42U AS=0.0441P
+ AD=0.0693P PS=0.63U PD=0.75U
* device instance $3109 r0 *1 70.6,70.08 sky130_fd_pr__pfet_01v8
M$3109 1257 64 37 37 sky130_fd_pr__pfet_01v8 L=0.15U W=0.42U AS=0.0693P
+ AD=0.1176P PS=0.75U PD=1.4U
* device instance $3110 r0 *1 67.63,69.985 sky130_fd_pr__pfet_01v8
M$3110 37 1256 1193 1193 sky130_fd_pr__pfet_01v8 L=0.15U W=1U AS=0.26P
+ AD=0.15835P PS=2.52U PD=1.395U
* device instance $3111 r0 *1 8.29,71.305 sky130_fd_pr__pfet_01v8
M$3111 37 681 1307 1307 sky130_fd_pr__pfet_01v8 L=0.15U W=0.64U AS=0.1664P
+ AD=0.0864P PS=1.8U PD=0.91U
* device instance $3112 r0 *1 8.71,71.305 sky130_fd_pr__pfet_01v8
M$3112 1308 1307 37 37 sky130_fd_pr__pfet_01v8 L=0.15U W=0.64U AS=0.0864P
+ AD=0.1664P PS=0.91U PD=1.8U
* device instance $3113 r0 *1 9.65,71.165 sky130_fd_pr__pfet_01v8
M$3113 1309 1098 37 37 sky130_fd_pr__pfet_01v8 L=0.15U W=0.42U AS=0.1092P
+ AD=0.05775P PS=1.36U PD=0.695U
* device instance $3114 r0 *1 10.075,71.165 sky130_fd_pr__pfet_01v8
M$3114 1310 1308 1309 1309 sky130_fd_pr__pfet_01v8 L=0.15U W=0.42U AS=0.05775P
+ AD=0.06825P PS=0.695U PD=0.745U
* device instance $3115 r0 *1 10.55,71.165 sky130_fd_pr__pfet_01v8
M$3115 1328 1307 1310 1310 sky130_fd_pr__pfet_01v8 L=0.15U W=0.42U AS=0.06825P
+ AD=0.07665P PS=0.745U PD=0.785U
* device instance $3116 r0 *1 11.065,71.165 sky130_fd_pr__pfet_01v8
M$3116 37 1311 1328 1328 sky130_fd_pr__pfet_01v8 L=0.15U W=0.42U AS=0.07665P
+ AD=0.178875P PS=0.785U PD=1.26U
* device instance $3117 r0 *1 12.2,71.165 sky130_fd_pr__pfet_01v8
M$3117 1312 1307 1311 1311 sky130_fd_pr__pfet_01v8 L=0.15U W=0.42U AS=0.1095P
+ AD=0.0567P PS=1.075U PD=0.69U
* device instance $3118 r0 *1 12.62,71.165 sky130_fd_pr__pfet_01v8
M$3118 1329 1308 1312 1312 sky130_fd_pr__pfet_01v8 L=0.15U W=0.42U AS=0.0567P
+ AD=0.0882P PS=0.69U PD=0.84U
* device instance $3119 r0 *1 13.19,71.165 sky130_fd_pr__pfet_01v8
M$3119 37 1313 1329 1329 sky130_fd_pr__pfet_01v8 L=0.15U W=0.42U AS=0.0882P
+ AD=0.1113P PS=0.84U PD=1.37U
* device instance $3120 r0 *1 11.725,71.33 sky130_fd_pr__pfet_01v8
M$3120 1311 1310 37 37 sky130_fd_pr__pfet_01v8 L=0.15U W=0.75U AS=0.178875P
+ AD=0.1095P PS=1.26U PD=1.075U
* device instance $3121 r0 *1 14.24,71.455 sky130_fd_pr__pfet_01v8
M$3121 37 1312 1313 1313 sky130_fd_pr__pfet_01v8 L=0.15U W=1U AS=0.27P
+ AD=0.135P PS=2.54U PD=1.27U
* device instance $3122 r0 *1 14.66,71.455 sky130_fd_pr__pfet_01v8
M$3122 1130 1313 37 37 sky130_fd_pr__pfet_01v8 L=0.15U W=1U AS=0.135P AD=0.26P
+ PS=1.27U PD=2.52U
* device instance $3123 r0 *1 26.775,71.36 sky130_fd_pr__pfet_01v8
M$3123 1330 64 37 37 sky130_fd_pr__pfet_01v8 L=0.15U W=0.42U AS=0.15835P
+ AD=0.07665P PS=1.395U PD=0.785U
* device instance $3124 r0 *1 27.29,71.36 sky130_fd_pr__pfet_01v8
M$3124 1314 993 1330 1330 sky130_fd_pr__pfet_01v8 L=0.15U W=0.42U AS=0.07665P
+ AD=0.1932P PS=0.785U PD=1.34U
* device instance $3125 r0 *1 28.36,71.36 sky130_fd_pr__pfet_01v8
M$3125 1331 1315 1314 1314 sky130_fd_pr__pfet_01v8 L=0.15U W=0.42U AS=0.1932P
+ AD=0.0441P PS=1.34U PD=0.63U
* device instance $3126 r0 *1 28.72,71.36 sky130_fd_pr__pfet_01v8
M$3126 37 1339 1331 1331 sky130_fd_pr__pfet_01v8 L=0.15U W=0.42U AS=0.0441P
+ AD=0.0693P PS=0.63U PD=0.75U
* device instance $3127 r0 *1 29.2,71.36 sky130_fd_pr__pfet_01v8
M$3127 1339 64 37 37 sky130_fd_pr__pfet_01v8 L=0.15U W=0.42U AS=0.0693P
+ AD=0.1176P PS=0.75U PD=1.4U
* device instance $3128 r0 *1 26.23,71.455 sky130_fd_pr__pfet_01v8
M$3128 37 1314 1274 1274 sky130_fd_pr__pfet_01v8 L=0.15U W=1U AS=0.26P
+ AD=0.15835P PS=2.52U PD=1.395U
* device instance $3129 r0 *1 45.175,71.36 sky130_fd_pr__pfet_01v8
M$3129 1332 64 37 37 sky130_fd_pr__pfet_01v8 L=0.15U W=0.42U AS=0.15835P
+ AD=0.07665P PS=1.395U PD=0.785U
* device instance $3130 r0 *1 45.69,71.36 sky130_fd_pr__pfet_01v8
M$3130 1316 1114 1332 1332 sky130_fd_pr__pfet_01v8 L=0.15U W=0.42U AS=0.07665P
+ AD=0.1932P PS=0.785U PD=1.34U
* device instance $3131 r0 *1 46.76,71.36 sky130_fd_pr__pfet_01v8
M$3131 1333 1317 1316 1316 sky130_fd_pr__pfet_01v8 L=0.15U W=0.42U AS=0.1932P
+ AD=0.0441P PS=1.34U PD=0.63U
* device instance $3132 r0 *1 47.12,71.36 sky130_fd_pr__pfet_01v8
M$3132 37 1340 1333 1333 sky130_fd_pr__pfet_01v8 L=0.15U W=0.42U AS=0.0441P
+ AD=0.0693P PS=0.63U PD=0.75U
* device instance $3133 r0 *1 47.6,71.36 sky130_fd_pr__pfet_01v8
M$3133 1340 64 37 37 sky130_fd_pr__pfet_01v8 L=0.15U W=0.42U AS=0.0693P
+ AD=0.1176P PS=0.75U PD=1.4U
* device instance $3134 r0 *1 44.63,71.455 sky130_fd_pr__pfet_01v8
M$3134 37 1316 1191 1191 sky130_fd_pr__pfet_01v8 L=0.15U W=1U AS=0.26P
+ AD=0.15835P PS=2.52U PD=1.395U
* device instance $3135 r0 *1 58.5,71.165 sky130_fd_pr__pfet_01v8
M$3135 1319 1318 37 37 sky130_fd_pr__pfet_01v8 L=0.15U W=0.42U AS=0.1113P
+ AD=0.0609P PS=1.37U PD=0.71U
* device instance $3136 r0 *1 58.94,71.165 sky130_fd_pr__pfet_01v8
M$3136 37 115 1319 1319 sky130_fd_pr__pfet_01v8 L=0.15U W=0.42U AS=0.0609P
+ AD=0.1841P PS=0.71U PD=1.26U
* device instance $3137 r0 *1 59.71,71.275 sky130_fd_pr__pfet_01v8
M$3137 1278 1319 37 37 sky130_fd_pr__pfet_01v8 L=0.15U W=0.64U AS=0.1841P
+ AD=0.1696P PS=1.26U PD=1.81U
* device instance $3138 r0 *1 60.73,71.305 sky130_fd_pr__pfet_01v8
M$3138 37 979 1320 1320 sky130_fd_pr__pfet_01v8 L=0.15U W=0.64U AS=0.1664P
+ AD=0.0864P PS=1.8U PD=0.91U
* device instance $3139 r0 *1 61.15,71.305 sky130_fd_pr__pfet_01v8
M$3139 1321 1320 37 37 sky130_fd_pr__pfet_01v8 L=0.15U W=0.64U AS=0.0864P
+ AD=0.1664P PS=0.91U PD=1.8U
* device instance $3140 r0 *1 62.09,71.275 sky130_fd_pr__pfet_01v8
M$3140 1336 1289 1322 1322 sky130_fd_pr__pfet_01v8 L=0.15U W=0.64U AS=0.1664P
+ AD=0.0672P PS=1.8U PD=0.85U
* device instance $3141 r0 *1 62.45,71.275 sky130_fd_pr__pfet_01v8
M$3141 37 1323 1336 1336 sky130_fd_pr__pfet_01v8 L=0.15U W=0.64U AS=0.0672P
+ AD=0.1664P PS=0.85U PD=1.8U
* device instance $3142 r0 *1 65.115,71.165 sky130_fd_pr__pfet_01v8
M$3142 1324 1321 1322 1322 sky130_fd_pr__pfet_01v8 L=0.15U W=0.42U AS=0.15985P
+ AD=0.06405P PS=1.265U PD=0.725U
* device instance $3143 r0 *1 65.57,71.165 sky130_fd_pr__pfet_01v8
M$3143 1338 1320 1324 1324 sky130_fd_pr__pfet_01v8 L=0.15U W=0.42U AS=0.06405P
+ AD=0.07665P PS=0.725U PD=0.785U
* device instance $3144 r0 *1 66.085,71.165 sky130_fd_pr__pfet_01v8
M$3144 37 1325 1338 1338 sky130_fd_pr__pfet_01v8 L=0.15U W=0.42U AS=0.07665P
+ AD=0.178875P PS=0.785U PD=1.26U
* device instance $3145 r0 *1 63.39,71.275 sky130_fd_pr__pfet_01v8
M$3145 37 303 1323 1323 sky130_fd_pr__pfet_01v8 L=0.15U W=0.64U AS=0.1664P
+ AD=0.0928P PS=1.8U PD=0.93U
* device instance $3146 r0 *1 63.83,71.275 sky130_fd_pr__pfet_01v8
M$3146 1337 303 37 37 sky130_fd_pr__pfet_01v8 L=0.15U W=0.64U AS=0.0928P
+ AD=0.1152P PS=0.93U PD=1U
* device instance $3147 r0 *1 64.34,71.275 sky130_fd_pr__pfet_01v8
M$3147 1322 1327 1337 1337 sky130_fd_pr__pfet_01v8 L=0.15U W=0.64U AS=0.1152P
+ AD=0.15985P PS=1U PD=1.265U
* device instance $3148 r0 *1 66.745,71.33 sky130_fd_pr__pfet_01v8
M$3148 1325 1324 37 37 sky130_fd_pr__pfet_01v8 L=0.15U W=0.75U AS=0.178875P
+ AD=0.195P PS=1.26U PD=2.02U
* device instance $3149 r0 *1 65.79,75.425 sky130_fd_pr__pfet_01v8
M$3149 37 1132 1353 1353 sky130_fd_pr__pfet_01v8 L=0.15U W=1U AS=0.26P
+ AD=0.135P PS=2.52U PD=1.27U
* device instance $3150 r0 *1 66.21,75.425 sky130_fd_pr__pfet_01v8
M$3150 1279 1353 37 37 sky130_fd_pr__pfet_01v8 L=0.15U W=4U AS=0.54P AD=0.665P
+ PS=5.08U PD=6.33U
* device instance $3154 r0 *1 67.685,71.165 sky130_fd_pr__pfet_01v8
M$3154 1335 1325 37 37 sky130_fd_pr__pfet_01v8 L=0.15U W=0.42U AS=0.1092P
+ AD=0.06405P PS=1.36U PD=0.725U
* device instance $3155 r0 *1 68.14,71.165 sky130_fd_pr__pfet_01v8
M$3155 1326 1320 1335 1335 sky130_fd_pr__pfet_01v8 L=0.15U W=0.42U AS=0.06405P
+ AD=0.0567P PS=0.725U PD=0.69U
* device instance $3156 r0 *1 68.56,71.165 sky130_fd_pr__pfet_01v8
M$3156 1334 1321 1326 1326 sky130_fd_pr__pfet_01v8 L=0.15U W=0.42U AS=0.0567P
+ AD=0.0882P PS=0.69U PD=0.84U
* device instance $3157 r0 *1 69.13,71.165 sky130_fd_pr__pfet_01v8
M$3157 37 1327 1334 1334 sky130_fd_pr__pfet_01v8 L=0.15U W=0.42U AS=0.0882P
+ AD=0.1113P PS=0.84U PD=1.37U
* device instance $3158 r0 *1 70.185,71.275 sky130_fd_pr__pfet_01v8
M$3158 37 1326 1327 1327 sky130_fd_pr__pfet_01v8 L=0.15U W=0.64U AS=0.1728P
+ AD=0.154P PS=1.82U PD=1.335U
* device instance $3159 r0 *1 70.67,71.455 sky130_fd_pr__pfet_01v8
M$3159 1131 1326 37 37 sky130_fd_pr__pfet_01v8 L=0.15U W=1U AS=0.154P AD=0.28P
+ PS=1.335U PD=2.56U
.ENDS gcd
