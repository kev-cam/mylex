* cell t
.SUBCKT t
* net 1 VGND
* net 34 VPWR
* device instance $1 r0 *1 0.49,6 sky130_fd_pr__nfet_01v8
M$1 71 63 46 46 sky130_fd_pr__nfet_01v8 L=0.15U W=0.65U AS=0.169P AD=0.08775P
+ PS=1.82U PD=0.92U
* device instance $2 r0 *1 0.91,6 sky130_fd_pr__nfet_01v8
M$2 47 48 71 71 sky130_fd_pr__nfet_01v8 L=0.15U W=0.65U AS=0.08775P AD=0.169P
+ PS=0.92U PD=1.82U
* device instance $3 r0 *1 7.39,0.56 sky130_fd_pr__nfet_01v8
M$3 33 12 1 1 sky130_fd_pr__nfet_01v8 L=0.15U W=0.65U AS=0.169P AD=0.08775P
+ PS=1.82U PD=0.92U
* device instance $4 r0 *1 7.81,0.56 sky130_fd_pr__nfet_01v8
M$4 23 13 33 33 sky130_fd_pr__nfet_01v8 L=0.15U W=0.65U AS=0.08775P AD=0.169P
+ PS=0.92U PD=1.82U
* device instance $5 r0 *1 4.63,0.56 sky130_fd_pr__nfet_01v8
M$5 30 8 1 1 sky130_fd_pr__nfet_01v8 L=0.15U W=0.65U AS=0.169P AD=0.08775P
+ PS=1.82U PD=0.92U
* device instance $6 r0 *1 5.05,0.56 sky130_fd_pr__nfet_01v8
M$6 21 9 30 30 sky130_fd_pr__nfet_01v8 L=0.15U W=0.65U AS=0.08775P AD=0.169P
+ PS=0.92U PD=1.82U
* device instance $7 r0 *1 1.87,6 sky130_fd_pr__nfet_01v8
M$7 73 64 46 46 sky130_fd_pr__nfet_01v8 L=0.15U W=0.65U AS=0.169P AD=0.08775P
+ PS=1.82U PD=0.92U
* device instance $8 r0 *1 2.29,6 sky130_fd_pr__nfet_01v8
M$8 49 50 73 73 sky130_fd_pr__nfet_01v8 L=0.15U W=0.65U AS=0.08775P AD=0.169P
+ PS=0.92U PD=1.82U
* device instance $9 r0 *1 6.01,0.56 sky130_fd_pr__nfet_01v8
M$9 32 10 1 1 sky130_fd_pr__nfet_01v8 L=0.15U W=0.65U AS=0.169P AD=0.08775P
+ PS=1.82U PD=0.92U
* device instance $10 r0 *1 6.43,0.56 sky130_fd_pr__nfet_01v8
M$10 22 11 32 32 sky130_fd_pr__nfet_01v8 L=0.15U W=0.65U AS=0.08775P AD=0.169P
+ PS=0.92U PD=1.82U
* device instance $11 r0 *1 2.31,4.88 sky130_fd_pr__nfet_01v8
M$11 38 45 46 46 sky130_fd_pr__nfet_01v8 L=0.15U W=0.65U AS=0.169P AD=0.118625P
+ PS=1.82U PD=1.015U
* device instance $12 r0 *1 2.825,4.88 sky130_fd_pr__nfet_01v8
M$12 46 35 38 38 sky130_fd_pr__nfet_01v8 L=0.15U W=0.65U AS=0.118625P
+ AD=0.089375P PS=1.015U PD=0.925U
* device instance $13 r0 *1 3.25,4.88 sky130_fd_pr__nfet_01v8
M$13 38 36 46 46 sky130_fd_pr__nfet_01v8 L=0.15U W=0.65U AS=0.089375P
+ AD=0.08775P PS=0.925U PD=0.92U
* device instance $14 r0 *1 3.67,4.88 sky130_fd_pr__nfet_01v8
M$14 46 37 38 38 sky130_fd_pr__nfet_01v8 L=0.15U W=0.65U AS=0.08775P AD=0.169P
+ PS=0.92U PD=1.82U
* device instance $15 r0 *1 1.87,0.56 sky130_fd_pr__nfet_01v8
M$15 28 4 1 1 sky130_fd_pr__nfet_01v8 L=0.15U W=0.65U AS=0.169P AD=0.08775P
+ PS=1.82U PD=0.92U
* device instance $16 r0 *1 2.29,0.56 sky130_fd_pr__nfet_01v8
M$16 19 5 28 28 sky130_fd_pr__nfet_01v8 L=0.15U W=0.65U AS=0.08775P AD=0.169P
+ PS=0.92U PD=1.82U
* device instance $17 r0 *1 0.49,0.56 sky130_fd_pr__nfet_01v8
M$17 26 2 1 1 sky130_fd_pr__nfet_01v8 L=0.15U W=0.65U AS=0.169P AD=0.08775P
+ PS=1.82U PD=0.92U
* device instance $18 r0 *1 0.91,0.56 sky130_fd_pr__nfet_01v8
M$18 18 3 26 26 sky130_fd_pr__nfet_01v8 L=0.15U W=0.65U AS=0.08775P AD=0.169P
+ PS=0.92U PD=1.82U
* device instance $19 r0 *1 3.25,6 sky130_fd_pr__nfet_01v8
M$19 74 65 46 46 sky130_fd_pr__nfet_01v8 L=0.15U W=0.65U AS=0.169P AD=0.08775P
+ PS=1.82U PD=0.92U
* device instance $20 r0 *1 3.67,6 sky130_fd_pr__nfet_01v8
M$20 51 52 74 74 sky130_fd_pr__nfet_01v8 L=0.15U W=0.65U AS=0.08775P AD=0.169P
+ PS=0.92U PD=1.82U
* device instance $21 r0 *1 7.39,6 sky130_fd_pr__nfet_01v8
M$21 78 68 46 46 sky130_fd_pr__nfet_01v8 L=0.15U W=0.65U AS=0.169P AD=0.08775P
+ PS=1.82U PD=0.92U
* device instance $22 r0 *1 7.81,6 sky130_fd_pr__nfet_01v8
M$22 57 58 78 78 sky130_fd_pr__nfet_01v8 L=0.15U W=0.65U AS=0.08775P AD=0.169P
+ PS=0.92U PD=1.82U
* device instance $23 r0 *1 6.01,6 sky130_fd_pr__nfet_01v8
M$23 77 67 46 46 sky130_fd_pr__nfet_01v8 L=0.15U W=0.65U AS=0.169P AD=0.08775P
+ PS=1.82U PD=0.92U
* device instance $24 r0 *1 6.43,6 sky130_fd_pr__nfet_01v8
M$24 55 56 77 77 sky130_fd_pr__nfet_01v8 L=0.15U W=0.65U AS=0.08775P AD=0.169P
+ PS=0.92U PD=1.82U
* device instance $25 r0 *1 4.63,6 sky130_fd_pr__nfet_01v8
M$25 76 66 46 46 sky130_fd_pr__nfet_01v8 L=0.15U W=0.65U AS=0.169P AD=0.08775P
+ PS=1.82U PD=0.92U
* device instance $26 r0 *1 5.05,6 sky130_fd_pr__nfet_01v8
M$26 53 54 76 76 sky130_fd_pr__nfet_01v8 L=0.15U W=0.65U AS=0.08775P AD=0.169P
+ PS=0.92U PD=1.82U
* device instance $27 r0 *1 8.77,0.56 sky130_fd_pr__nfet_01v8
M$27 31 14 1 1 sky130_fd_pr__nfet_01v8 L=0.15U W=0.65U AS=0.169P AD=0.08775P
+ PS=1.82U PD=0.92U
* device instance $28 r0 *1 9.19,0.56 sky130_fd_pr__nfet_01v8
M$28 24 15 31 31 sky130_fd_pr__nfet_01v8 L=0.15U W=0.65U AS=0.08775P AD=0.169P
+ PS=0.92U PD=1.82U
* device instance $29 r0 *1 8.77,6 sky130_fd_pr__nfet_01v8
M$29 75 69 46 46 sky130_fd_pr__nfet_01v8 L=0.15U W=0.65U AS=0.169P AD=0.08775P
+ PS=1.82U PD=0.92U
* device instance $30 r0 *1 9.19,6 sky130_fd_pr__nfet_01v8
M$30 59 60 75 75 sky130_fd_pr__nfet_01v8 L=0.15U W=0.65U AS=0.08775P AD=0.169P
+ PS=0.92U PD=1.82U
* device instance $31 r0 *1 10.15,0.56 sky130_fd_pr__nfet_01v8
M$31 27 16 1 1 sky130_fd_pr__nfet_01v8 L=0.15U W=0.65U AS=0.169P AD=0.08775P
+ PS=1.82U PD=0.92U
* device instance $32 r0 *1 10.57,0.56 sky130_fd_pr__nfet_01v8
M$32 25 17 27 27 sky130_fd_pr__nfet_01v8 L=0.15U W=0.65U AS=0.08775P AD=0.169P
+ PS=0.92U PD=1.82U
* device instance $33 r0 *1 10.15,6 sky130_fd_pr__nfet_01v8
M$33 72 70 46 46 sky130_fd_pr__nfet_01v8 L=0.15U W=0.65U AS=0.169P AD=0.08775P
+ PS=1.82U PD=0.92U
* device instance $34 r0 *1 10.57,6 sky130_fd_pr__nfet_01v8
M$34 61 62 72 72 sky130_fd_pr__nfet_01v8 L=0.15U W=0.65U AS=0.08775P AD=0.169P
+ PS=0.92U PD=1.82U
* device instance $35 r0 *1 3.25,0.56 sky130_fd_pr__nfet_01v8
M$35 29 6 1 1 sky130_fd_pr__nfet_01v8 L=0.15U W=0.65U AS=0.169P AD=0.08775P
+ PS=1.82U PD=0.92U
* device instance $36 r0 *1 3.67,0.56 sky130_fd_pr__nfet_01v8
M$36 20 7 29 29 sky130_fd_pr__nfet_01v8 L=0.15U W=0.65U AS=0.08775P AD=0.169P
+ PS=0.92U PD=1.82U
* device instance $37 r0 *1 8.77,7.425 sky130_fd_pr__pfet_01v8
M$37 59 69 79 79 sky130_fd_pr__pfet_01v8 L=0.15U W=1U AS=0.26P AD=0.135P
+ PS=2.52U PD=1.27U
* device instance $38 r0 *1 9.19,7.425 sky130_fd_pr__pfet_01v8
M$38 79 60 59 59 sky130_fd_pr__pfet_01v8 L=0.15U W=1U AS=0.135P AD=0.26P
+ PS=1.27U PD=2.52U
* device instance $39 r0 *1 6.01,7.425 sky130_fd_pr__pfet_01v8
M$39 55 67 79 79 sky130_fd_pr__pfet_01v8 L=0.15U W=1U AS=0.26P AD=0.135P
+ PS=2.52U PD=1.27U
* device instance $40 r0 *1 6.43,7.425 sky130_fd_pr__pfet_01v8
M$40 79 56 55 55 sky130_fd_pr__pfet_01v8 L=0.15U W=1U AS=0.135P AD=0.26P
+ PS=1.27U PD=2.52U
* device instance $41 r0 *1 3.25,7.425 sky130_fd_pr__pfet_01v8
M$41 51 65 79 79 sky130_fd_pr__pfet_01v8 L=0.15U W=1U AS=0.26P AD=0.135P
+ PS=2.52U PD=1.27U
* device instance $42 r0 *1 3.67,7.425 sky130_fd_pr__pfet_01v8
M$42 79 52 51 51 sky130_fd_pr__pfet_01v8 L=0.15U W=1U AS=0.135P AD=0.26P
+ PS=1.27U PD=2.52U
* device instance $43 r0 *1 1.87,7.425 sky130_fd_pr__pfet_01v8
M$43 49 64 79 79 sky130_fd_pr__pfet_01v8 L=0.15U W=1U AS=0.26P AD=0.135P
+ PS=2.52U PD=1.27U
* device instance $44 r0 *1 2.29,7.425 sky130_fd_pr__pfet_01v8
M$44 79 50 49 49 sky130_fd_pr__pfet_01v8 L=0.15U W=1U AS=0.135P AD=0.26P
+ PS=1.27U PD=2.52U
* device instance $45 r0 *1 0.49,7.425 sky130_fd_pr__pfet_01v8
M$45 47 63 79 79 sky130_fd_pr__pfet_01v8 L=0.15U W=1U AS=0.26P AD=0.135P
+ PS=2.52U PD=1.27U
* device instance $46 r0 *1 0.91,7.425 sky130_fd_pr__pfet_01v8
M$46 79 48 47 47 sky130_fd_pr__pfet_01v8 L=0.15U W=1U AS=0.135P AD=0.26P
+ PS=1.27U PD=2.52U
* device instance $47 r0 *1 2.31,3.455 sky130_fd_pr__pfet_01v8
M$47 39 45 38 38 sky130_fd_pr__pfet_01v8 L=0.15U W=1U AS=0.26P AD=0.13P
+ PS=2.52U PD=1.26U
* device instance $48 r0 *1 2.72,3.455 sky130_fd_pr__pfet_01v8
M$48 41 35 39 39 sky130_fd_pr__pfet_01v8 L=0.15U W=1U AS=0.13P AD=0.19P
+ PS=1.26U PD=1.38U
* device instance $49 r0 *1 3.25,3.455 sky130_fd_pr__pfet_01v8
M$49 44 36 41 41 sky130_fd_pr__pfet_01v8 L=0.15U W=1U AS=0.19P AD=0.135P
+ PS=1.38U PD=1.27U
* device instance $50 r0 *1 3.67,3.455 sky130_fd_pr__pfet_01v8
M$50 34 37 44 44 sky130_fd_pr__pfet_01v8 L=0.15U W=1U AS=0.135P AD=0.13P
+ PS=1.27U PD=1.26U
* device instance $51 r0 *1 4.08,3.455 sky130_fd_pr__pfet_01v8
M$51 43 37 34 34 sky130_fd_pr__pfet_01v8 L=0.15U W=1U AS=0.13P AD=0.345P
+ PS=1.26U PD=1.69U
* device instance $52 r0 *1 4.92,3.455 sky130_fd_pr__pfet_01v8
M$52 42 36 43 43 sky130_fd_pr__pfet_01v8 L=0.15U W=1U AS=0.345P AD=0.4P
+ PS=1.69U PD=1.8U
* device instance $53 r0 *1 5.87,3.455 sky130_fd_pr__pfet_01v8
M$53 40 35 42 42 sky130_fd_pr__pfet_01v8 L=0.15U W=1U AS=0.4P AD=0.34P PS=1.8U
+ PD=1.68U
* device instance $54 r0 *1 6.7,3.455 sky130_fd_pr__pfet_01v8
M$54 38 45 40 40 sky130_fd_pr__pfet_01v8 L=0.15U W=1U AS=0.34P AD=0.68P
+ PS=1.68U PD=3.36U
* device instance $55 r0 *1 7.39,7.425 sky130_fd_pr__pfet_01v8
M$55 57 68 79 79 sky130_fd_pr__pfet_01v8 L=0.15U W=1U AS=0.26P AD=0.135P
+ PS=2.52U PD=1.27U
* device instance $56 r0 *1 7.81,7.425 sky130_fd_pr__pfet_01v8
M$56 79 58 57 57 sky130_fd_pr__pfet_01v8 L=0.15U W=1U AS=0.135P AD=0.26P
+ PS=1.27U PD=2.52U
* device instance $57 r0 *1 4.63,1.985 sky130_fd_pr__pfet_01v8
M$57 21 8 34 34 sky130_fd_pr__pfet_01v8 L=0.15U W=1U AS=0.26P AD=0.135P
+ PS=2.52U PD=1.27U
* device instance $58 r0 *1 5.05,1.985 sky130_fd_pr__pfet_01v8
M$58 34 9 21 21 sky130_fd_pr__pfet_01v8 L=0.15U W=1U AS=0.135P AD=0.26P
+ PS=1.27U PD=2.52U
* device instance $59 r0 *1 6.01,1.985 sky130_fd_pr__pfet_01v8
M$59 22 10 34 34 sky130_fd_pr__pfet_01v8 L=0.15U W=1U AS=0.26P AD=0.135P
+ PS=2.52U PD=1.27U
* device instance $60 r0 *1 6.43,1.985 sky130_fd_pr__pfet_01v8
M$60 34 11 22 22 sky130_fd_pr__pfet_01v8 L=0.15U W=1U AS=0.135P AD=0.26P
+ PS=1.27U PD=2.52U
* device instance $61 r0 *1 4.63,7.425 sky130_fd_pr__pfet_01v8
M$61 53 66 79 79 sky130_fd_pr__pfet_01v8 L=0.15U W=1U AS=0.26P AD=0.135P
+ PS=2.52U PD=1.27U
* device instance $62 r0 *1 5.05,7.425 sky130_fd_pr__pfet_01v8
M$62 79 54 53 53 sky130_fd_pr__pfet_01v8 L=0.15U W=1U AS=0.135P AD=0.26P
+ PS=1.27U PD=2.52U
* device instance $63 r0 *1 3.25,1.985 sky130_fd_pr__pfet_01v8
M$63 20 6 34 34 sky130_fd_pr__pfet_01v8 L=0.15U W=1U AS=0.26P AD=0.135P
+ PS=2.52U PD=1.27U
* device instance $64 r0 *1 3.67,1.985 sky130_fd_pr__pfet_01v8
M$64 34 7 20 20 sky130_fd_pr__pfet_01v8 L=0.15U W=1U AS=0.135P AD=0.26P
+ PS=1.27U PD=2.52U
* device instance $65 r0 *1 0.49,1.985 sky130_fd_pr__pfet_01v8
M$65 18 2 34 34 sky130_fd_pr__pfet_01v8 L=0.15U W=1U AS=0.26P AD=0.135P
+ PS=2.52U PD=1.27U
* device instance $66 r0 *1 0.91,1.985 sky130_fd_pr__pfet_01v8
M$66 34 3 18 18 sky130_fd_pr__pfet_01v8 L=0.15U W=1U AS=0.135P AD=0.26P
+ PS=1.27U PD=2.52U
* device instance $67 r0 *1 10.15,7.425 sky130_fd_pr__pfet_01v8
M$67 61 70 79 79 sky130_fd_pr__pfet_01v8 L=0.15U W=1U AS=0.26P AD=0.135P
+ PS=2.52U PD=1.27U
* device instance $68 r0 *1 10.57,7.425 sky130_fd_pr__pfet_01v8
M$68 79 62 61 61 sky130_fd_pr__pfet_01v8 L=0.15U W=1U AS=0.135P AD=0.26P
+ PS=1.27U PD=2.52U
* device instance $69 r0 *1 1.87,1.985 sky130_fd_pr__pfet_01v8
M$69 19 4 34 34 sky130_fd_pr__pfet_01v8 L=0.15U W=1U AS=0.26P AD=0.135P
+ PS=2.52U PD=1.27U
* device instance $70 r0 *1 2.29,1.985 sky130_fd_pr__pfet_01v8
M$70 34 5 19 19 sky130_fd_pr__pfet_01v8 L=0.15U W=1U AS=0.135P AD=0.26P
+ PS=1.27U PD=2.52U
* device instance $71 r0 *1 10.15,1.985 sky130_fd_pr__pfet_01v8
M$71 25 16 34 34 sky130_fd_pr__pfet_01v8 L=0.15U W=1U AS=0.26P AD=0.135P
+ PS=2.52U PD=1.27U
* device instance $72 r0 *1 10.57,1.985 sky130_fd_pr__pfet_01v8
M$72 34 17 25 25 sky130_fd_pr__pfet_01v8 L=0.15U W=1U AS=0.135P AD=0.26P
+ PS=1.27U PD=2.52U
* device instance $73 r0 *1 7.39,1.985 sky130_fd_pr__pfet_01v8
M$73 23 12 34 34 sky130_fd_pr__pfet_01v8 L=0.15U W=1U AS=0.26P AD=0.135P
+ PS=2.52U PD=1.27U
* device instance $74 r0 *1 7.81,1.985 sky130_fd_pr__pfet_01v8
M$74 34 13 23 23 sky130_fd_pr__pfet_01v8 L=0.15U W=1U AS=0.135P AD=0.26P
+ PS=1.27U PD=2.52U
* device instance $75 r0 *1 8.77,1.985 sky130_fd_pr__pfet_01v8
M$75 24 14 34 34 sky130_fd_pr__pfet_01v8 L=0.15U W=1U AS=0.26P AD=0.135P
+ PS=2.52U PD=1.27U
* device instance $76 r0 *1 9.19,1.985 sky130_fd_pr__pfet_01v8
M$76 34 15 24 24 sky130_fd_pr__pfet_01v8 L=0.15U W=1U AS=0.135P AD=0.26P
+ PS=1.27U PD=2.52U
.ENDS t
