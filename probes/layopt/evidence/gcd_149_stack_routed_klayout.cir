* cell gcd
.SUBCKT gcd
* net 1 req_msg[2]
* net 2 req_msg[6]
* net 3 resp_msg[5]
* net 4 resp_msg[8]
* net 12 dpath.a_lt_b$in1\[2\]
* net 20 dpath.a_lt_b$in0\[8\]
* net 31 clknet_2_0__leaf_clk
* net 32 dpath.b_mux$out\[2\]
* net 34 dpath.a_mux$out\[8\]
* net 36 VDD
* net 50 dpath.a_mux$out\[2\]
* net 56 dpath.a_lt_b$in0\[2\]
* net 60 dpath.b_mux$out\[6\]
* net 61 dpath.a_mux$out\[6\]
* net 62 _004_
* net 63 req_rdy
* net 64 _075_
* net 66 _048_
* net 67 _069_
* net 69 resp_msg[7]
* net 73 dpath.b_mux$out\[8\]
* net 90 _089_
* net 91 _080_
* net 92 resp_msg[6]
* net 93 net1
* net 96 VSS
* net 111 _093_
* net 114 _076_
* net 124 _090_
* net 126 dpath.b_mux$out\[7\]
* net 128 dpath.a_lt_b$in0\[7\]
* net 129 req_msg[7]
* net 132 _087_
* net 134 net6
* net 136 req_msg[8]
* net 156 req_msg[18]
* net 157 net2
* net 158 resp_msg[2]
* net 159 req_msg[22]
* net 160 req_msg[23]
* net 161 dpath.a_lt_b$in1\[8\]
* net 163 req_msg[21]
* net 164 req_msg[24]
* net 167 _088_
* net 180 net9
* net 191 dpath.a_lt_b$in0\[6\]
* net 195 dpath.a_lt_b$in1\[7\]
* net 197 dpath.a_mux$out\[7\]
* net 210 _022_
* net 217 _040_
* net 218 dpath.a_lt_b$in1\[6\]
* net 219 net32
* net 220 _023_
* net 256 _041_
* net 259 _047_
* net 260 _070_
* net 262 _027_
* net 264 _030_
* net 266 net11
* net 268 _046_
* net 270 _049_
* net 271 _026_
* net 272 _024_
* net 274 _025_
* net 277 _050_
* net 279 _051_
* net 282 _036_
* net 293 _042_
* net 297 clknet_0_clk
* net 302 ctrl$a_reg_en\[0\]
* net 307 _052_
* net 310 _020_
* net 328 _043_
* net 329 _034_
* net 333 clknet_2_1__leaf_clk
* net 334 _068_
* net 338 _019_
* net 341 _039_
* net 342 _021_
* net 343 dpath.a_lt_b$in0\[9\]
* net 344 dpath.a_lt_b$in1\[9\]
* net 347 resp_msg[9]
* net 352 req_msg[19]
* net 354 _092_
* net 360 resp_msg[3]
* net 362 _103_
* net 373 net52
* net 379 dpath.a_mux$out\[9\]
* net 398 dpath.a_lt_b$in1\[3\]
* net 399 _073_
* net 400 dpath.b_mux$out\[5\]
* net 401 _086_
* net 402 dpath.b_mux$out\[9\]
* net 407 net16
* net 408 _100_
* net 409 net5
* net 410 dpath.a_mux$out\[3\]
* net 411 dpath.a_lt_b$in1\[5\]
* net 436 _035_
* net 440 _071_
* net 441 _045_
* net 449 req_msg[9]
* net 459 dpath.b_mux$out\[3\]
* net 461 dpath.a_lt_b$in0\[3\]
* net 462 req_msg[25]
* net 464 req_msg[3]
* net 487 _029_
* net 490 req_msg[5]
* net 513 _031_
* net 514 dpath.a_lt_b$in0\[5\]
* net 535 _033_
* net 537 _044_
* net 539 _028_
* net 547 _072_
* net 550 dpath.a_mux$out\[5\]
* net 555 dpath.a_lt_b$in1\[1\]
* net 556 _005_
* net 558 resp_msg[4]
* net 568 _085_
* net 571 dpath.a_lt_b$in1\[10\]
* net 573 dpath.a_mux$out\[10\]
* net 574 resp_msg[10]
* net 580 net8
* net 589 _094_
* net 591 resp_msg[1]
* net 592 dpath.a_mux$out\[1\]
* net 594 _037_
* net 595 dpath.a_lt_b$in0\[1\]
* net 596 _032_
* net 598 dpath.a_lt_b$in0\[4\]
* net 600 req_msg[26]
* net 601 _053_
* net 603 _018_
* net 606 _017_
* net 623 req_msg[17]
* net 625 dpath.b_mux$out\[1\]
* net 627 req_msg[1]
* net 629 net12
* net 632 _038_
* net 636 dpath.a_mux$out\[4\]
* net 640 _054_
* net 642 _055_
* net 644 dpath.b_mux$out\[10\]
* net 646 req_msg[10]
* net 651 _091_
* net 652 dpath.a_lt_b$in1\[4\]
* net 653 dpath.a_lt_b$in0\[10\]
* net 662 clk
* net 663 _015_
* net 682 clknet_2_2__leaf_clk
* net 701 _099_
* net 727 req_msg[20]
* net 728 dpath.b_mux$out\[4\]
* net 729 dpath.a_lt_b$in1\[11\]
* net 730 _067_
* net 735 _101_
* net 736 resp_msg[11]
* net 775 dpath.a_mux$out\[11\]
* net 777 _003_
* net 795 req_msg[4]
* net 796 dpath.b_mux$out\[11\]
* net 797 _084_
* net 798 dpath.a_lt_b$in0\[11\]
* net 800 _016_
* net 834 net13
* net 837 dpath.a_lt_b$in1\[0\]
* net 846 _074_
* net 855 net3
* net 868 _095_
* net 869 resp_msg[0]
* net 870 dpath.a_lt_b$in0\[0\]
* net 874 dpath.a_mux$out\[0\]
* net 887 req_msg[16]
* net 889 dpath.b_mux$out\[0\]
* net 894 dpath.a_lt_b$in1\[15\]
* net 897 _102_
* net 898 req_msg[27]
* net 903 dpath.b_mux$out\[12\]
* net 916 req_msg[0]
* net 917 net7
* net 919 _104_
* net 942 net30
* net 944 _056_
* net 947 req_msg[12]
* net 956 dpath.a_lt_b$in0\[12\]
* net 977 _062_
* net 980 clknet_2_3__leaf_clk
* net 981 _014_
* net 984 _012_
* net 986 dpath.a_lt_b$in1\[12\]
* net 987 _013_
* net 994 dpath.a_lt_b$in0\[15\]
* net 995 net4
* net 996 _066_
* net 997 resp_msg[12]
* net 1000 _079_
* net 1011 _078_
* net 1016 net10
* net 1018 _059_
* net 1019 resp_msg[14]
* net 1020 _064_
* net 1022 net15
* net 1025 _010_
* net 1026 _083_
* net 1028 dpath.a_mux$out\[12\]
* net 1029 _057_
* net 1035 _058_
* net 1050 ctrl$b_reg_en\[0\]
* net 1052 _063_
* net 1054 _011_
* net 1056 _009_
* net 1060 _060_
* net 1074 _000_
* net 1075 _061_
* net 1076 _077_
* net 1077 _008_
* net 1078 net28
* net 1099 _002_
* net 1100 _105_
* net 1101 _006_
* net 1102 _096_
* net 1105 dpath.a_mux$out\[15\]
* net 1115 dpath.a_lt_b$in0\[14\]
* net 1129 reset
* net 1130 _106_
* net 1131 ctrl.state.out\[2\]
* net 1132 dpath.a_lt_b$in0\[13\]
* net 1133 dpath.a_lt_b$in1\[13\]
* net 1135 dpath.a_lt_b$in1\[14\]
* net 1145 req_val
* net 1146 _097_
* net 1147 _001_
* net 1151 _098_
* net 1155 resp_msg[15]
* net 1169 _065_
* net 1186 _007_
* net 1188 ctrl.state.out\[1\]
* net 1189 req_msg[31]
* net 1190 _081_
* net 1191 net14
* net 1192 dpath.b_mux$out\[14\]
* net 1193 resp_msg[13]
* net 1194 dpath.b_mux$out\[13\]
* net 1202 resp_rdy
* net 1205 dpath.a_mux$out\[14\]
* net 1230 resp_val
* net 1275 dpath.b_mux$out\[15\]
* net 1277 req_msg[11]
* net 1279 _082_
* net 1280 net53
* net 1287 req_msg[30]
* net 1288 req_msg[28]
* net 1290 dpath.a_mux$out\[13\]
* net 1291 req_msg[13]
* net 1316 req_msg[15]
* net 1318 req_msg[14]
* net 1319 req_msg[29]
* device instance $1 r0 *1 5.07,3.165 sky130_fd_pr__nfet_01v8
M$1 96 31 5 5 sky130_fd_pr__nfet_01v8 L=0.15U W=0.42U AS=0.1092P AD=0.0567P
+ PS=1.36U PD=0.69U
* device instance $2 r0 *1 5.49,3.165 sky130_fd_pr__nfet_01v8
M$2 6 5 96 96 sky130_fd_pr__nfet_01v8 L=0.15U W=0.42U AS=0.0567P AD=0.1092P
+ PS=0.69U PD=1.36U
* device instance $3 r0 *1 6.43,3.165 sky130_fd_pr__nfet_01v8
M$3 21 32 7 7 sky130_fd_pr__nfet_01v8 L=0.15U W=0.42U AS=0.1092P AD=0.0441P
+ PS=1.36U PD=0.63U
* device instance $4 r0 *1 6.79,3.165 sky130_fd_pr__nfet_01v8
M$4 96 93 21 21 sky130_fd_pr__nfet_01v8 L=0.15U W=0.42U AS=0.0441P AD=0.1092P
+ PS=0.63U PD=1.36U
* device instance $5 r0 *1 9.59,3.135 sky130_fd_pr__nfet_01v8
M$5 9 5 7 7 sky130_fd_pr__nfet_01v8 L=0.15U W=0.36U AS=0.1446P AD=0.0522P
+ PS=1.18U PD=0.65U
* device instance $6 r0 *1 10.03,3.135 sky130_fd_pr__nfet_01v8
M$6 23 6 9 9 sky130_fd_pr__nfet_01v8 L=0.15U W=0.36U AS=0.0522P AD=0.0759P
+ PS=0.65U PD=0.8U
* device instance $7 r0 *1 7.73,3.165 sky130_fd_pr__nfet_01v8
M$7 96 93 33 33 sky130_fd_pr__nfet_01v8 L=0.15U W=0.42U AS=0.1092P AD=0.0609P
+ PS=1.36U PD=0.71U
* device instance $8 r0 *1 8.17,3.165 sky130_fd_pr__nfet_01v8
M$8 22 33 96 96 sky130_fd_pr__nfet_01v8 L=0.15U W=0.42U AS=0.0609P AD=0.0756P
+ PS=0.71U PD=0.78U
* device instance $9 r0 *1 8.68,3.165 sky130_fd_pr__nfet_01v8
M$9 7 8 22 22 sky130_fd_pr__nfet_01v8 L=0.15U W=0.42U AS=0.0756P AD=0.1446P
+ PS=0.78U PD=1.18U
* device instance $10 r0 *1 10.56,3.165 sky130_fd_pr__nfet_01v8
M$10 96 10 23 23 sky130_fd_pr__nfet_01v8 L=0.15U W=0.42U AS=0.0759P AD=0.12095P
+ PS=0.8U PD=1.085U
* device instance $11 r0 *1 11.155,3.275 sky130_fd_pr__nfet_01v8
M$11 10 9 96 96 sky130_fd_pr__nfet_01v8 L=0.15U W=0.64U AS=0.12095P AD=0.1664P
+ PS=1.085U PD=1.8U
* device instance $12 r0 *1 12.58,3.135 sky130_fd_pr__nfet_01v8
M$12 11 6 24 24 sky130_fd_pr__nfet_01v8 L=0.15U W=0.36U AS=0.0678P AD=0.0684P
+ PS=0.755U PD=0.74U
* device instance $13 r0 *1 13.11,3.135 sky130_fd_pr__nfet_01v8
M$13 26 5 11 11 sky130_fd_pr__nfet_01v8 L=0.15U W=0.36U AS=0.0684P AD=0.066P
+ PS=0.74U PD=0.745U
* device instance $14 r0 *1 12.095,3.165 sky130_fd_pr__nfet_01v8
M$14 24 10 96 96 sky130_fd_pr__nfet_01v8 L=0.15U W=0.42U AS=0.1092P AD=0.0678P
+ PS=1.36U PD=0.755U
* device instance $15 r0 *1 13.585,3.165 sky130_fd_pr__nfet_01v8
M$15 96 8 26 26 sky130_fd_pr__nfet_01v8 L=0.15U W=0.42U AS=0.066P AD=0.1092P
+ PS=0.745U PD=1.36U
* device instance $16 r0 *1 14.525,3.165 sky130_fd_pr__nfet_01v8
M$16 96 11 8 8 sky130_fd_pr__nfet_01v8 L=0.15U W=0.42U AS=0.1092P AD=0.10025P
+ PS=1.36U PD=0.985U
* device instance $17 r0 *1 15.01,3.28 sky130_fd_pr__nfet_01v8
M$17 12 11 96 96 sky130_fd_pr__nfet_01v8 L=0.15U W=0.65U AS=0.10025P AD=0.182P
+ PS=0.985U PD=1.86U
* device instance $18 r0 *1 60.73,3.165 sky130_fd_pr__nfet_01v8
M$18 96 333 13 13 sky130_fd_pr__nfet_01v8 L=0.15U W=0.42U AS=0.1092P AD=0.0567P
+ PS=1.36U PD=0.69U
* device instance $19 r0 *1 61.15,3.165 sky130_fd_pr__nfet_01v8
M$19 14 13 96 96 sky130_fd_pr__nfet_01v8 L=0.15U W=0.42U AS=0.0567P AD=0.1092P
+ PS=0.69U PD=1.36U
* device instance $20 r0 *1 62.09,3.165 sky130_fd_pr__nfet_01v8
M$20 30 34 15 15 sky130_fd_pr__nfet_01v8 L=0.15U W=0.42U AS=0.1092P AD=0.0441P
+ PS=1.36U PD=0.63U
* device instance $21 r0 *1 62.45,3.165 sky130_fd_pr__nfet_01v8
M$21 96 302 30 30 sky130_fd_pr__nfet_01v8 L=0.15U W=0.42U AS=0.0441P AD=0.1092P
+ PS=0.63U PD=1.36U
* device instance $22 r0 *1 65.25,3.135 sky130_fd_pr__nfet_01v8
M$22 17 13 15 15 sky130_fd_pr__nfet_01v8 L=0.15U W=0.36U AS=0.1446P AD=0.0522P
+ PS=1.18U PD=0.65U
* device instance $23 r0 *1 65.69,3.135 sky130_fd_pr__nfet_01v8
M$23 28 14 17 17 sky130_fd_pr__nfet_01v8 L=0.15U W=0.36U AS=0.0522P AD=0.0759P
+ PS=0.65U PD=0.8U
* device instance $24 r0 *1 63.39,3.165 sky130_fd_pr__nfet_01v8
M$24 96 302 35 35 sky130_fd_pr__nfet_01v8 L=0.15U W=0.42U AS=0.1092P AD=0.0609P
+ PS=1.36U PD=0.71U
* device instance $25 r0 *1 63.83,3.165 sky130_fd_pr__nfet_01v8
M$25 29 35 96 96 sky130_fd_pr__nfet_01v8 L=0.15U W=0.42U AS=0.0609P AD=0.0756P
+ PS=0.71U PD=0.78U
* device instance $26 r0 *1 64.34,3.165 sky130_fd_pr__nfet_01v8
M$26 15 16 29 29 sky130_fd_pr__nfet_01v8 L=0.15U W=0.42U AS=0.0756P AD=0.1446P
+ PS=0.78U PD=1.18U
* device instance $27 r0 *1 66.22,3.165 sky130_fd_pr__nfet_01v8
M$27 96 18 28 28 sky130_fd_pr__nfet_01v8 L=0.15U W=0.42U AS=0.0759P AD=0.12095P
+ PS=0.8U PD=1.085U
* device instance $28 r0 *1 66.815,3.275 sky130_fd_pr__nfet_01v8
M$28 18 17 96 96 sky130_fd_pr__nfet_01v8 L=0.15U W=0.64U AS=0.12095P AD=0.1664P
+ PS=1.085U PD=1.8U
* device instance $29 r0 *1 68.24,3.135 sky130_fd_pr__nfet_01v8
M$29 19 14 27 27 sky130_fd_pr__nfet_01v8 L=0.15U W=0.36U AS=0.0678P AD=0.0684P
+ PS=0.755U PD=0.74U
* device instance $30 r0 *1 68.77,3.135 sky130_fd_pr__nfet_01v8
M$30 25 13 19 19 sky130_fd_pr__nfet_01v8 L=0.15U W=0.36U AS=0.0684P AD=0.066P
+ PS=0.74U PD=0.745U
* device instance $31 r0 *1 67.755,3.165 sky130_fd_pr__nfet_01v8
M$31 27 18 96 96 sky130_fd_pr__nfet_01v8 L=0.15U W=0.42U AS=0.1092P AD=0.0678P
+ PS=1.36U PD=0.755U
* device instance $32 r0 *1 69.245,3.165 sky130_fd_pr__nfet_01v8
M$32 96 16 25 25 sky130_fd_pr__nfet_01v8 L=0.15U W=0.42U AS=0.066P AD=0.1092P
+ PS=0.745U PD=1.36U
* device instance $33 r0 *1 70.185,3.165 sky130_fd_pr__nfet_01v8
M$33 96 19 16 16 sky130_fd_pr__nfet_01v8 L=0.15U W=0.42U AS=0.1092P AD=0.10025P
+ PS=1.36U PD=0.985U
* device instance $34 r0 *1 70.67,3.28 sky130_fd_pr__nfet_01v8
M$34 20 19 96 96 sky130_fd_pr__nfet_01v8 L=0.15U W=0.65U AS=0.10025P AD=0.182P
+ PS=0.985U PD=1.86U
* device instance $35 r0 *1 5.53,7.715 sky130_fd_pr__nfet_01v8
M$35 96 31 47 47 sky130_fd_pr__nfet_01v8 L=0.15U W=0.42U AS=0.1092P AD=0.0567P
+ PS=1.36U PD=0.69U
* device instance $36 r0 *1 5.95,7.715 sky130_fd_pr__nfet_01v8
M$36 48 47 96 96 sky130_fd_pr__nfet_01v8 L=0.15U W=0.42U AS=0.0567P AD=0.1092P
+ PS=0.69U PD=1.36U
* device instance $37 r0 *1 6.89,7.715 sky130_fd_pr__nfet_01v8
M$37 98 50 49 49 sky130_fd_pr__nfet_01v8 L=0.15U W=0.42U AS=0.1092P AD=0.0441P
+ PS=1.36U PD=0.63U
* device instance $38 r0 *1 7.25,7.715 sky130_fd_pr__nfet_01v8
M$38 96 302 98 98 sky130_fd_pr__nfet_01v8 L=0.15U W=0.42U AS=0.0441P AD=0.1092P
+ PS=0.63U PD=1.36U
* device instance $39 r0 *1 8.19,7.715 sky130_fd_pr__nfet_01v8
M$39 96 302 51 51 sky130_fd_pr__nfet_01v8 L=0.15U W=0.42U AS=0.1092P AD=0.0609P
+ PS=1.36U PD=0.71U
* device instance $40 r0 *1 8.63,7.715 sky130_fd_pr__nfet_01v8
M$40 100 51 96 96 sky130_fd_pr__nfet_01v8 L=0.15U W=0.42U AS=0.0609P AD=0.0756P
+ PS=0.71U PD=0.78U
* device instance $41 r0 *1 9.14,7.715 sky130_fd_pr__nfet_01v8
M$41 49 55 100 100 sky130_fd_pr__nfet_01v8 L=0.15U W=0.42U AS=0.0756P
+ AD=0.1446P PS=0.78U PD=1.18U
* device instance $42 r0 *1 10.05,7.745 sky130_fd_pr__nfet_01v8
M$42 52 47 49 49 sky130_fd_pr__nfet_01v8 L=0.15U W=0.36U AS=0.1446P AD=0.0522P
+ PS=1.18U PD=0.65U
* device instance $43 r0 *1 10.49,7.745 sky130_fd_pr__nfet_01v8
M$43 52 48 102 102 sky130_fd_pr__nfet_01v8 L=0.15U W=0.36U AS=0.0759P
+ AD=0.0522P PS=0.8U PD=0.65U
* device instance $44 r0 *1 11.02,7.715 sky130_fd_pr__nfet_01v8
M$44 102 53 96 96 sky130_fd_pr__nfet_01v8 L=0.15U W=0.42U AS=0.12095P
+ AD=0.0759P PS=1.085U PD=0.8U
* device instance $45 r0 *1 11.615,7.605 sky130_fd_pr__nfet_01v8
M$45 53 52 96 96 sky130_fd_pr__nfet_01v8 L=0.15U W=0.64U AS=0.12095P AD=0.1664P
+ PS=1.085U PD=1.8U
* device instance $46 r0 *1 12.555,7.715 sky130_fd_pr__nfet_01v8
M$46 104 53 96 96 sky130_fd_pr__nfet_01v8 L=0.15U W=0.42U AS=0.1092P AD=0.0678P
+ PS=1.36U PD=0.755U
* device instance $47 r0 *1 13.04,7.745 sky130_fd_pr__nfet_01v8
M$47 54 48 104 104 sky130_fd_pr__nfet_01v8 L=0.15U W=0.36U AS=0.0678P
+ AD=0.0684P PS=0.755U PD=0.74U
* device instance $48 r0 *1 13.57,7.745 sky130_fd_pr__nfet_01v8
M$48 54 47 105 105 sky130_fd_pr__nfet_01v8 L=0.15U W=0.36U AS=0.066P AD=0.0684P
+ PS=0.745U PD=0.74U
* device instance $49 r0 *1 14.045,7.715 sky130_fd_pr__nfet_01v8
M$49 96 55 105 105 sky130_fd_pr__nfet_01v8 L=0.15U W=0.42U AS=0.066P AD=0.1092P
+ PS=0.745U PD=1.36U
* device instance $50 r0 *1 14.985,7.715 sky130_fd_pr__nfet_01v8
M$50 55 54 96 96 sky130_fd_pr__nfet_01v8 L=0.15U W=0.42U AS=0.10025P AD=0.1092P
+ PS=0.985U PD=1.36U
* device instance $51 r0 *1 15.47,7.6 sky130_fd_pr__nfet_01v8
M$51 56 54 96 96 sky130_fd_pr__nfet_01v8 L=0.15U W=0.65U AS=0.10025P AD=0.182P
+ PS=0.985U PD=1.86U
* device instance $52 r0 *1 23.47,7.6 sky130_fd_pr__nfet_01v8
M$52 96 90 57 57 sky130_fd_pr__nfet_01v8 L=0.15U W=0.65U AS=0.169P AD=0.10725P
+ PS=1.82U PD=0.98U
* device instance $53 r0 *1 23.95,7.6 sky130_fd_pr__nfet_01v8
M$53 109 218 96 96 sky130_fd_pr__nfet_01v8 L=0.15U W=0.65U AS=0.10725P
+ AD=0.06825P PS=0.98U PD=0.86U
* device instance $54 r0 *1 24.31,7.6 sky130_fd_pr__nfet_01v8
M$54 57 91 109 109 sky130_fd_pr__nfet_01v8 L=0.15U W=0.65U AS=0.06825P
+ AD=0.169P PS=0.86U PD=1.82U
* device instance $55 r0 *1 25.25,7.6 sky130_fd_pr__nfet_01v8
M$55 108 157 57 57 sky130_fd_pr__nfet_01v8 L=0.15U W=0.65U AS=0.169P
+ AD=0.10725P PS=1.82U PD=0.98U
* device instance $56 r0 *1 25.73,7.6 sky130_fd_pr__nfet_01v8
M$56 96 92 108 108 sky130_fd_pr__nfet_01v8 L=0.15U W=0.65U AS=0.10725P
+ AD=0.102375P PS=0.98U PD=0.965U
* device instance $57 r0 *1 26.195,7.6 sky130_fd_pr__nfet_01v8
M$57 61 57 96 96 sky130_fd_pr__nfet_01v8 L=0.15U W=0.65U AS=0.102375P AD=0.169P
+ PS=0.965U PD=1.82U
* device instance $58 r0 *1 27.64,7.715 sky130_fd_pr__nfet_01v8
M$58 96 62 95 95 sky130_fd_pr__nfet_01v8 L=0.15U W=0.42U AS=0.1113P AD=0.0588P
+ PS=1.37U PD=0.7U
* device instance $59 r0 *1 28.07,7.715 sky130_fd_pr__nfet_01v8
M$59 95 63 96 96 sky130_fd_pr__nfet_01v8 L=0.15U W=0.42U AS=0.0588P AD=0.0588P
+ PS=0.7U PD=0.7U
* device instance $60 r0 *1 28.5,7.715 sky130_fd_pr__nfet_01v8
M$60 60 64 95 95 sky130_fd_pr__nfet_01v8 L=0.15U W=0.42U AS=0.0588P AD=0.1113P
+ PS=0.7U PD=1.37U
* device instance $61 r0 *1 44.67,7.6 sky130_fd_pr__nfet_01v8
M$61 65 66 96 96 sky130_fd_pr__nfet_01v8 L=0.15U W=0.65U AS=0.169P AD=0.08775P
+ PS=1.82U PD=0.92U
* device instance $62 r0 *1 45.09,7.6 sky130_fd_pr__nfet_01v8
M$62 96 67 65 65 sky130_fd_pr__nfet_01v8 L=0.15U W=0.65U AS=0.08775P
+ AD=0.08775P PS=0.92U PD=0.92U
* device instance $63 r0 *1 45.51,7.6 sky130_fd_pr__nfet_01v8
M$63 107 67 96 96 sky130_fd_pr__nfet_01v8 L=0.15U W=0.65U AS=0.08775P
+ AD=0.08775P PS=0.92U PD=0.92U
* device instance $64 r0 *1 45.93,7.6 sky130_fd_pr__nfet_01v8
M$64 69 66 107 107 sky130_fd_pr__nfet_01v8 L=0.15U W=0.65U AS=0.08775P
+ AD=0.25025P PS=0.92U PD=1.42U
* device instance $65 r0 *1 46.85,7.6 sky130_fd_pr__nfet_01v8
M$65 96 65 69 69 sky130_fd_pr__nfet_01v8 L=0.15U W=0.65U AS=0.25025P AD=0.208P
+ PS=1.42U PD=1.94U
* device instance $66 r0 *1 64.87,7.715 sky130_fd_pr__nfet_01v8
M$66 96 333 70 70 sky130_fd_pr__nfet_01v8 L=0.15U W=0.42U AS=0.1092P AD=0.0567P
+ PS=1.36U PD=0.69U
* device instance $67 r0 *1 65.29,7.715 sky130_fd_pr__nfet_01v8
M$67 71 70 96 96 sky130_fd_pr__nfet_01v8 L=0.15U W=0.42U AS=0.0567P AD=0.1092P
+ PS=0.69U PD=1.36U
* device instance $68 r0 *1 66.23,7.715 sky130_fd_pr__nfet_01v8
M$68 106 73 72 72 sky130_fd_pr__nfet_01v8 L=0.15U W=0.42U AS=0.1092P AD=0.0441P
+ PS=1.36U PD=0.63U
* device instance $69 r0 *1 66.59,7.715 sky130_fd_pr__nfet_01v8
M$69 96 93 106 106 sky130_fd_pr__nfet_01v8 L=0.15U W=0.42U AS=0.0441P
+ AD=0.1092P PS=0.63U PD=1.36U
* device instance $70 r0 *1 67.53,7.715 sky130_fd_pr__nfet_01v8
M$70 96 93 74 74 sky130_fd_pr__nfet_01v8 L=0.15U W=0.42U AS=0.1092P AD=0.0609P
+ PS=1.36U PD=0.71U
* device instance $71 r0 *1 67.97,7.715 sky130_fd_pr__nfet_01v8
M$71 103 74 96 96 sky130_fd_pr__nfet_01v8 L=0.15U W=0.42U AS=0.0609P AD=0.0756P
+ PS=0.71U PD=0.78U
* device instance $72 r0 *1 68.48,7.715 sky130_fd_pr__nfet_01v8
M$72 72 78 103 103 sky130_fd_pr__nfet_01v8 L=0.15U W=0.42U AS=0.0756P
+ AD=0.1446P PS=0.78U PD=1.18U
* device instance $73 r0 *1 69.39,7.745 sky130_fd_pr__nfet_01v8
M$73 75 70 72 72 sky130_fd_pr__nfet_01v8 L=0.15U W=0.36U AS=0.1446P AD=0.0522P
+ PS=1.18U PD=0.65U
* device instance $74 r0 *1 69.83,7.745 sky130_fd_pr__nfet_01v8
M$74 75 71 101 101 sky130_fd_pr__nfet_01v8 L=0.15U W=0.36U AS=0.0759P
+ AD=0.0522P PS=0.8U PD=0.65U
* device instance $75 r0 *1 70.36,7.715 sky130_fd_pr__nfet_01v8
M$75 101 76 96 96 sky130_fd_pr__nfet_01v8 L=0.15U W=0.42U AS=0.12095P
+ AD=0.0759P PS=1.085U PD=0.8U
* device instance $76 r0 *1 70.955,7.605 sky130_fd_pr__nfet_01v8
M$76 76 75 96 96 sky130_fd_pr__nfet_01v8 L=0.15U W=0.64U AS=0.12095P AD=0.1664P
+ PS=1.085U PD=1.8U
* device instance $77 r0 *1 71.895,7.715 sky130_fd_pr__nfet_01v8
M$77 99 76 96 96 sky130_fd_pr__nfet_01v8 L=0.15U W=0.42U AS=0.1092P AD=0.0678P
+ PS=1.36U PD=0.755U
* device instance $78 r0 *1 72.38,7.745 sky130_fd_pr__nfet_01v8
M$78 77 71 99 99 sky130_fd_pr__nfet_01v8 L=0.15U W=0.36U AS=0.0678P AD=0.0684P
+ PS=0.755U PD=0.74U
* device instance $79 r0 *1 72.91,7.745 sky130_fd_pr__nfet_01v8
M$79 77 70 97 97 sky130_fd_pr__nfet_01v8 L=0.15U W=0.36U AS=0.066P AD=0.0684P
+ PS=0.745U PD=0.74U
* device instance $80 r0 *1 73.385,7.715 sky130_fd_pr__nfet_01v8
M$80 96 78 97 97 sky130_fd_pr__nfet_01v8 L=0.15U W=0.42U AS=0.066P AD=0.1092P
+ PS=0.745U PD=1.36U
* device instance $81 r0 *1 74.325,7.715 sky130_fd_pr__nfet_01v8
M$81 78 77 96 96 sky130_fd_pr__nfet_01v8 L=0.15U W=0.42U AS=0.10025P AD=0.1092P
+ PS=0.985U PD=1.36U
* device instance $82 r0 *1 74.81,7.6 sky130_fd_pr__nfet_01v8
M$82 161 77 96 96 sky130_fd_pr__nfet_01v8 L=0.15U W=0.65U AS=0.10025P AD=0.182P
+ PS=0.985U PD=1.86U
* device instance $83 r0 *1 6.98,8.605 sky130_fd_pr__nfet_01v8
M$83 138 156 110 110 sky130_fd_pr__nfet_01v8 L=0.15U W=0.42U AS=0.1113P
+ AD=0.0441P PS=1.37U PD=0.63U
* device instance $84 r0 *1 7.34,8.605 sky130_fd_pr__nfet_01v8
M$84 96 114 138 138 sky130_fd_pr__nfet_01v8 L=0.15U W=0.42U AS=0.0441P
+ AD=0.0966P PS=0.63U PD=0.88U
* device instance $85 r0 *1 7.95,8.605 sky130_fd_pr__nfet_01v8
M$85 111 110 96 96 sky130_fd_pr__nfet_01v8 L=0.15U W=0.42U AS=0.0966P
+ AD=0.1113P PS=0.88U PD=1.37U
* device instance $86 r0 *1 9.21,8.72 sky130_fd_pr__nfet_01v8
M$86 96 111 112 112 sky130_fd_pr__nfet_01v8 L=0.15U W=0.65U AS=0.169P
+ AD=0.10725P PS=1.82U PD=0.98U
* device instance $87 r0 *1 9.69,8.72 sky130_fd_pr__nfet_01v8
M$87 139 12 96 96 sky130_fd_pr__nfet_01v8 L=0.15U W=0.65U AS=0.10725P
+ AD=0.06825P PS=0.98U PD=0.86U
* device instance $88 r0 *1 10.05,8.72 sky130_fd_pr__nfet_01v8
M$88 112 91 139 139 sky130_fd_pr__nfet_01v8 L=0.15U W=0.65U AS=0.06825P
+ AD=0.169P PS=0.86U PD=1.82U
* device instance $89 r0 *1 10.99,8.72 sky130_fd_pr__nfet_01v8
M$89 140 157 112 112 sky130_fd_pr__nfet_01v8 L=0.15U W=0.65U AS=0.169P
+ AD=0.10725P PS=1.82U PD=0.98U
* device instance $90 r0 *1 11.47,8.72 sky130_fd_pr__nfet_01v8
M$90 96 158 140 140 sky130_fd_pr__nfet_01v8 L=0.15U W=0.65U AS=0.10725P
+ AD=0.102375P PS=0.98U PD=0.965U
* device instance $91 r0 *1 11.935,8.72 sky130_fd_pr__nfet_01v8
M$91 50 112 96 96 sky130_fd_pr__nfet_01v8 L=0.15U W=0.65U AS=0.102375P
+ AD=0.169P PS=0.965U PD=1.82U
* device instance $92 r0 *1 23.08,8.605 sky130_fd_pr__nfet_01v8
M$92 141 159 113 113 sky130_fd_pr__nfet_01v8 L=0.15U W=0.42U AS=0.1113P
+ AD=0.0441P PS=1.37U PD=0.63U
* device instance $93 r0 *1 23.44,8.605 sky130_fd_pr__nfet_01v8
M$93 96 114 141 141 sky130_fd_pr__nfet_01v8 L=0.15U W=0.42U AS=0.0441P
+ AD=0.0966P PS=0.63U PD=0.88U
* device instance $94 r0 *1 24.05,8.605 sky130_fd_pr__nfet_01v8
M$94 90 113 96 96 sky130_fd_pr__nfet_01v8 L=0.15U W=0.42U AS=0.0966P AD=0.1113P
+ PS=0.88U PD=1.37U
* device instance $95 r0 *1 25.31,8.605 sky130_fd_pr__nfet_01v8
M$95 96 31 115 115 sky130_fd_pr__nfet_01v8 L=0.15U W=0.42U AS=0.1092P
+ AD=0.0567P PS=1.36U PD=0.69U
* device instance $96 r0 *1 25.73,8.605 sky130_fd_pr__nfet_01v8
M$96 116 115 96 96 sky130_fd_pr__nfet_01v8 L=0.15U W=0.42U AS=0.0567P
+ AD=0.1092P PS=0.69U PD=1.36U
* device instance $97 r0 *1 26.67,8.605 sky130_fd_pr__nfet_01v8
M$97 142 60 117 117 sky130_fd_pr__nfet_01v8 L=0.15U W=0.42U AS=0.1092P
+ AD=0.0441P PS=1.36U PD=0.63U
* device instance $98 r0 *1 27.03,8.605 sky130_fd_pr__nfet_01v8
M$98 96 93 142 142 sky130_fd_pr__nfet_01v8 L=0.15U W=0.42U AS=0.0441P
+ AD=0.1092P PS=0.63U PD=1.36U
* device instance $99 r0 *1 29.83,8.575 sky130_fd_pr__nfet_01v8
M$99 120 115 117 117 sky130_fd_pr__nfet_01v8 L=0.15U W=0.36U AS=0.1446P
+ AD=0.0522P PS=1.18U PD=0.65U
* device instance $100 r0 *1 30.27,8.575 sky130_fd_pr__nfet_01v8
M$100 145 116 120 120 sky130_fd_pr__nfet_01v8 L=0.15U W=0.36U AS=0.0522P
+ AD=0.0759P PS=0.65U PD=0.8U
* device instance $101 r0 *1 27.97,8.605 sky130_fd_pr__nfet_01v8
M$101 96 93 118 118 sky130_fd_pr__nfet_01v8 L=0.15U W=0.42U AS=0.1092P
+ AD=0.0609P PS=1.36U PD=0.71U
* device instance $102 r0 *1 28.41,8.605 sky130_fd_pr__nfet_01v8
M$102 143 118 96 96 sky130_fd_pr__nfet_01v8 L=0.15U W=0.42U AS=0.0609P
+ AD=0.0756P PS=0.71U PD=0.78U
* device instance $103 r0 *1 28.92,8.605 sky130_fd_pr__nfet_01v8
M$103 117 119 143 143 sky130_fd_pr__nfet_01v8 L=0.15U W=0.42U AS=0.0756P
+ AD=0.1446P PS=0.78U PD=1.18U
* device instance $104 r0 *1 30.8,8.605 sky130_fd_pr__nfet_01v8
M$104 96 121 145 145 sky130_fd_pr__nfet_01v8 L=0.15U W=0.42U AS=0.0759P
+ AD=0.12095P PS=0.8U PD=1.085U
* device instance $105 r0 *1 31.395,8.715 sky130_fd_pr__nfet_01v8
M$105 121 120 96 96 sky130_fd_pr__nfet_01v8 L=0.15U W=0.64U AS=0.12095P
+ AD=0.1664P PS=1.085U PD=1.8U
* device instance $106 r0 *1 32.82,8.575 sky130_fd_pr__nfet_01v8
M$106 122 116 147 147 sky130_fd_pr__nfet_01v8 L=0.15U W=0.36U AS=0.0678P
+ AD=0.0684P PS=0.755U PD=0.74U
* device instance $107 r0 *1 33.35,8.575 sky130_fd_pr__nfet_01v8
M$107 148 115 122 122 sky130_fd_pr__nfet_01v8 L=0.15U W=0.36U AS=0.0684P
+ AD=0.066P PS=0.74U PD=0.745U
* device instance $108 r0 *1 32.335,8.605 sky130_fd_pr__nfet_01v8
M$108 147 121 96 96 sky130_fd_pr__nfet_01v8 L=0.15U W=0.42U AS=0.1092P
+ AD=0.0678P PS=1.36U PD=0.755U
* device instance $109 r0 *1 33.825,8.605 sky130_fd_pr__nfet_01v8
M$109 96 119 148 148 sky130_fd_pr__nfet_01v8 L=0.15U W=0.42U AS=0.066P
+ AD=0.1092P PS=0.745U PD=1.36U
* device instance $110 r0 *1 34.765,8.605 sky130_fd_pr__nfet_01v8
M$110 96 122 119 119 sky130_fd_pr__nfet_01v8 L=0.15U W=0.42U AS=0.1092P
+ AD=0.10025P PS=1.36U PD=0.985U
* device instance $111 r0 *1 35.25,8.72 sky130_fd_pr__nfet_01v8
M$111 218 122 96 96 sky130_fd_pr__nfet_01v8 L=0.15U W=0.65U AS=0.10025P
+ AD=0.182P PS=0.985U PD=1.86U
* device instance $112 r0 *1 37.34,8.605 sky130_fd_pr__nfet_01v8
M$112 149 163 123 123 sky130_fd_pr__nfet_01v8 L=0.15U W=0.42U AS=0.1113P
+ AD=0.0441P PS=1.37U PD=0.63U
* device instance $113 r0 *1 37.7,8.605 sky130_fd_pr__nfet_01v8
M$113 96 114 149 149 sky130_fd_pr__nfet_01v8 L=0.15U W=0.42U AS=0.0441P
+ AD=0.0966P PS=0.63U PD=0.88U
* device instance $114 r0 *1 38.31,8.605 sky130_fd_pr__nfet_01v8
M$114 124 123 96 96 sky130_fd_pr__nfet_01v8 L=0.15U W=0.42U AS=0.0966P
+ AD=0.1113P PS=0.88U PD=1.37U
* device instance $115 r0 *1 44.7,8.605 sky130_fd_pr__nfet_01v8
M$115 150 160 125 125 sky130_fd_pr__nfet_01v8 L=0.15U W=0.42U AS=0.1113P
+ AD=0.0441P PS=1.37U PD=0.63U
* device instance $116 r0 *1 45.06,8.605 sky130_fd_pr__nfet_01v8
M$116 96 114 150 150 sky130_fd_pr__nfet_01v8 L=0.15U W=0.42U AS=0.0441P
+ AD=0.0966P PS=0.63U PD=0.88U
* device instance $117 r0 *1 45.67,8.605 sky130_fd_pr__nfet_01v8
M$117 167 125 96 96 sky130_fd_pr__nfet_01v8 L=0.15U W=0.42U AS=0.0966P
+ AD=0.1113P PS=0.88U PD=1.37U
* device instance $118 r0 *1 47.475,8.605 sky130_fd_pr__nfet_01v8
M$118 151 63 96 96 sky130_fd_pr__nfet_01v8 L=0.15U W=0.42U AS=0.11285P
+ AD=0.0693P PS=1.045U PD=0.75U
* device instance $119 r0 *1 47.955,8.605 sky130_fd_pr__nfet_01v8
M$119 127 129 151 151 sky130_fd_pr__nfet_01v8 L=0.15U W=0.42U AS=0.0693P
+ AD=0.09975P PS=0.75U PD=0.895U
* device instance $120 r0 *1 48.58,8.605 sky130_fd_pr__nfet_01v8
M$120 152 128 127 127 sky130_fd_pr__nfet_01v8 L=0.15U W=0.42U AS=0.09975P
+ AD=0.0693P PS=0.895U PD=0.75U
* device instance $121 r0 *1 49.06,8.605 sky130_fd_pr__nfet_01v8
M$121 96 130 152 152 sky130_fd_pr__nfet_01v8 L=0.15U W=0.42U AS=0.0693P
+ AD=0.1449P PS=0.75U PD=1.11U
* device instance $122 r0 *1 49.9,8.605 sky130_fd_pr__nfet_01v8
M$122 130 63 96 96 sky130_fd_pr__nfet_01v8 L=0.15U W=0.42U AS=0.1449P
+ AD=0.1092P PS=1.11U PD=1.36U
* device instance $123 r0 *1 46.93,8.72 sky130_fd_pr__nfet_01v8
M$123 96 127 126 126 sky130_fd_pr__nfet_01v8 L=0.15U W=0.65U AS=0.169P
+ AD=0.11285P PS=1.82U PD=1.045U
* device instance $124 r0 *1 57.58,8.605 sky130_fd_pr__nfet_01v8
M$124 153 164 131 131 sky130_fd_pr__nfet_01v8 L=0.15U W=0.42U AS=0.1113P
+ AD=0.0441P PS=1.37U PD=0.63U
* device instance $125 r0 *1 57.94,8.605 sky130_fd_pr__nfet_01v8
M$125 96 114 153 153 sky130_fd_pr__nfet_01v8 L=0.15U W=0.42U AS=0.0441P
+ AD=0.0966P PS=0.63U PD=0.88U
* device instance $126 r0 *1 58.55,8.605 sky130_fd_pr__nfet_01v8
M$126 132 131 96 96 sky130_fd_pr__nfet_01v8 L=0.15U W=0.42U AS=0.0966P
+ AD=0.1113P PS=0.88U PD=1.37U
* device instance $127 r0 *1 59.81,8.72 sky130_fd_pr__nfet_01v8
M$127 96 132 133 133 sky130_fd_pr__nfet_01v8 L=0.15U W=0.65U AS=0.169P
+ AD=0.10725P PS=1.82U PD=0.98U
* device instance $128 r0 *1 60.29,8.72 sky130_fd_pr__nfet_01v8
M$128 155 161 96 96 sky130_fd_pr__nfet_01v8 L=0.15U W=0.65U AS=0.10725P
+ AD=0.06825P PS=0.98U PD=0.86U
* device instance $129 r0 *1 60.65,8.72 sky130_fd_pr__nfet_01v8
M$129 133 91 155 155 sky130_fd_pr__nfet_01v8 L=0.15U W=0.65U AS=0.06825P
+ AD=0.169P PS=0.86U PD=1.82U
* device instance $130 r0 *1 61.59,8.72 sky130_fd_pr__nfet_01v8
M$130 154 134 133 133 sky130_fd_pr__nfet_01v8 L=0.15U W=0.65U AS=0.169P
+ AD=0.10725P PS=1.82U PD=0.98U
* device instance $131 r0 *1 62.07,8.72 sky130_fd_pr__nfet_01v8
M$131 96 4 154 154 sky130_fd_pr__nfet_01v8 L=0.15U W=0.65U AS=0.10725P
+ AD=0.102375P PS=0.98U PD=0.965U
* device instance $132 r0 *1 62.535,8.72 sky130_fd_pr__nfet_01v8
M$132 34 133 96 96 sky130_fd_pr__nfet_01v8 L=0.15U W=0.65U AS=0.102375P
+ AD=0.169P PS=0.965U PD=1.82U
* device instance $133 r0 *1 68.175,8.605 sky130_fd_pr__nfet_01v8
M$133 146 63 96 96 sky130_fd_pr__nfet_01v8 L=0.15U W=0.42U AS=0.11285P
+ AD=0.0693P PS=1.045U PD=0.75U
* device instance $134 r0 *1 68.655,8.605 sky130_fd_pr__nfet_01v8
M$134 135 136 146 146 sky130_fd_pr__nfet_01v8 L=0.15U W=0.42U AS=0.0693P
+ AD=0.09975P PS=0.75U PD=0.895U
* device instance $135 r0 *1 69.28,8.605 sky130_fd_pr__nfet_01v8
M$135 144 20 135 135 sky130_fd_pr__nfet_01v8 L=0.15U W=0.42U AS=0.09975P
+ AD=0.0693P PS=0.895U PD=0.75U
* device instance $136 r0 *1 69.76,8.605 sky130_fd_pr__nfet_01v8
M$136 96 137 144 144 sky130_fd_pr__nfet_01v8 L=0.15U W=0.42U AS=0.0693P
+ AD=0.1449P PS=0.75U PD=1.11U
* device instance $137 r0 *1 70.6,8.605 sky130_fd_pr__nfet_01v8
M$137 137 63 96 96 sky130_fd_pr__nfet_01v8 L=0.15U W=0.42U AS=0.1449P
+ AD=0.1092P PS=1.11U PD=1.36U
* device instance $138 r0 *1 67.63,8.72 sky130_fd_pr__nfet_01v8
M$138 96 135 73 73 sky130_fd_pr__nfet_01v8 L=0.15U W=0.65U AS=0.169P
+ AD=0.11285P PS=1.82U PD=1.045U
* device instance $139 r0 *1 7.83,13.04 sky130_fd_pr__nfet_01v8
M$139 96 178 32 32 sky130_fd_pr__nfet_01v8 L=0.15U W=0.65U AS=0.169P
+ AD=0.11285P PS=1.82U PD=1.045U
* device instance $140 r0 *1 8.375,13.155 sky130_fd_pr__nfet_01v8
M$140 235 63 96 96 sky130_fd_pr__nfet_01v8 L=0.15U W=0.42U AS=0.11285P
+ AD=0.0693P PS=1.045U PD=0.75U
* device instance $141 r0 *1 8.855,13.155 sky130_fd_pr__nfet_01v8
M$141 178 1 235 235 sky130_fd_pr__nfet_01v8 L=0.15U W=0.42U AS=0.0693P
+ AD=0.09975P PS=0.75U PD=0.895U
* device instance $142 r0 *1 9.48,13.155 sky130_fd_pr__nfet_01v8
M$142 236 56 178 178 sky130_fd_pr__nfet_01v8 L=0.15U W=0.42U AS=0.09975P
+ AD=0.0693P PS=0.895U PD=0.75U
* device instance $143 r0 *1 9.96,13.155 sky130_fd_pr__nfet_01v8
M$143 96 232 236 236 sky130_fd_pr__nfet_01v8 L=0.15U W=0.42U AS=0.0693P
+ AD=0.1449P PS=0.75U PD=1.11U
* device instance $144 r0 *1 10.8,13.155 sky130_fd_pr__nfet_01v8
M$144 232 63 96 96 sky130_fd_pr__nfet_01v8 L=0.15U W=0.42U AS=0.1449P
+ AD=0.1092P PS=1.11U PD=1.36U
* device instance $145 r0 *1 12.53,13.04 sky130_fd_pr__nfet_01v8
M$145 238 217 179 179 sky130_fd_pr__nfet_01v8 L=0.15U W=0.65U AS=0.169P
+ AD=0.06825P PS=1.82U PD=0.86U
* device instance $146 r0 *1 12.89,13.04 sky130_fd_pr__nfet_01v8
M$146 96 180 238 238 sky130_fd_pr__nfet_01v8 L=0.15U W=0.65U AS=0.06825P
+ AD=0.08775P PS=0.86U PD=0.92U
* device instance $147 r0 *1 13.31,13.04 sky130_fd_pr__nfet_01v8
M$147 233 180 96 96 sky130_fd_pr__nfet_01v8 L=0.15U W=0.65U AS=0.08775P
+ AD=0.169P PS=0.92U PD=1.82U
* device instance $148 r0 *1 14.25,13.04 sky130_fd_pr__nfet_01v8
M$148 233 217 96 96 sky130_fd_pr__nfet_01v8 L=0.15U W=0.65U AS=0.169P
+ AD=0.08775P PS=1.82U PD=0.92U
* device instance $149 r0 *1 14.67,13.04 sky130_fd_pr__nfet_01v8
M$149 158 179 233 233 sky130_fd_pr__nfet_01v8 L=0.15U W=0.65U AS=0.08775P
+ AD=0.195P PS=0.92U PD=1.9U
* device instance $150 r0 *1 15.69,13.04 sky130_fd_pr__nfet_01v8
M$150 181 56 96 96 sky130_fd_pr__nfet_01v8 L=0.15U W=0.65U AS=0.169P
+ AD=0.08775P PS=1.82U PD=0.92U
* device instance $151 r0 *1 16.11,13.04 sky130_fd_pr__nfet_01v8
M$151 96 12 181 181 sky130_fd_pr__nfet_01v8 L=0.15U W=0.65U AS=0.08775P
+ AD=0.08775P PS=0.92U PD=0.92U
* device instance $152 r0 *1 16.53,13.04 sky130_fd_pr__nfet_01v8
M$152 240 12 96 96 sky130_fd_pr__nfet_01v8 L=0.15U W=0.65U AS=0.08775P
+ AD=0.08775P PS=0.92U PD=0.92U
* device instance $153 r0 *1 16.95,13.04 sky130_fd_pr__nfet_01v8
M$153 217 56 240 240 sky130_fd_pr__nfet_01v8 L=0.15U W=0.65U AS=0.08775P
+ AD=0.25025P PS=0.92U PD=1.42U
* device instance $154 r0 *1 17.87,13.04 sky130_fd_pr__nfet_01v8
M$154 96 181 217 217 sky130_fd_pr__nfet_01v8 L=0.15U W=0.65U AS=0.25025P
+ AD=0.208P PS=1.42U PD=1.94U
* device instance $155 r0 *1 19.33,13.155 sky130_fd_pr__nfet_01v8
M$155 96 31 183 183 sky130_fd_pr__nfet_01v8 L=0.15U W=0.42U AS=0.1092P
+ AD=0.0567P PS=1.36U PD=0.69U
* device instance $156 r0 *1 19.75,13.155 sky130_fd_pr__nfet_01v8
M$156 184 183 96 96 sky130_fd_pr__nfet_01v8 L=0.15U W=0.42U AS=0.0567P
+ AD=0.1092P PS=0.69U PD=1.36U
* device instance $157 r0 *1 20.69,13.155 sky130_fd_pr__nfet_01v8
M$157 241 61 185 185 sky130_fd_pr__nfet_01v8 L=0.15U W=0.42U AS=0.1092P
+ AD=0.0441P PS=1.36U PD=0.63U
* device instance $158 r0 *1 21.05,13.155 sky130_fd_pr__nfet_01v8
M$158 96 302 241 241 sky130_fd_pr__nfet_01v8 L=0.15U W=0.42U AS=0.0441P
+ AD=0.1092P PS=0.63U PD=1.36U
* device instance $159 r0 *1 21.99,13.155 sky130_fd_pr__nfet_01v8
M$159 96 302 186 186 sky130_fd_pr__nfet_01v8 L=0.15U W=0.42U AS=0.1092P
+ AD=0.0609P PS=1.36U PD=0.71U
* device instance $160 r0 *1 22.43,13.155 sky130_fd_pr__nfet_01v8
M$160 242 186 96 96 sky130_fd_pr__nfet_01v8 L=0.15U W=0.42U AS=0.0609P
+ AD=0.0756P PS=0.71U PD=0.78U
* device instance $161 r0 *1 22.94,13.155 sky130_fd_pr__nfet_01v8
M$161 185 190 242 242 sky130_fd_pr__nfet_01v8 L=0.15U W=0.42U AS=0.0756P
+ AD=0.1446P PS=0.78U PD=1.18U
* device instance $162 r0 *1 23.85,13.185 sky130_fd_pr__nfet_01v8
M$162 187 183 185 185 sky130_fd_pr__nfet_01v8 L=0.15U W=0.36U AS=0.1446P
+ AD=0.0522P PS=1.18U PD=0.65U
* device instance $163 r0 *1 24.29,13.185 sky130_fd_pr__nfet_01v8
M$163 187 184 244 244 sky130_fd_pr__nfet_01v8 L=0.15U W=0.36U AS=0.0759P
+ AD=0.0522P PS=0.8U PD=0.65U
* device instance $164 r0 *1 24.82,13.155 sky130_fd_pr__nfet_01v8
M$164 244 188 96 96 sky130_fd_pr__nfet_01v8 L=0.15U W=0.42U AS=0.12095P
+ AD=0.0759P PS=1.085U PD=0.8U
* device instance $165 r0 *1 25.415,13.045 sky130_fd_pr__nfet_01v8
M$165 188 187 96 96 sky130_fd_pr__nfet_01v8 L=0.15U W=0.64U AS=0.12095P
+ AD=0.1664P PS=1.085U PD=1.8U
* device instance $166 r0 *1 26.355,13.155 sky130_fd_pr__nfet_01v8
M$166 245 188 96 96 sky130_fd_pr__nfet_01v8 L=0.15U W=0.42U AS=0.1092P
+ AD=0.0678P PS=1.36U PD=0.755U
* device instance $167 r0 *1 26.84,13.185 sky130_fd_pr__nfet_01v8
M$167 189 184 245 245 sky130_fd_pr__nfet_01v8 L=0.15U W=0.36U AS=0.0678P
+ AD=0.0684P PS=0.755U PD=0.74U
* device instance $168 r0 *1 27.37,13.185 sky130_fd_pr__nfet_01v8
M$168 189 183 246 246 sky130_fd_pr__nfet_01v8 L=0.15U W=0.36U AS=0.066P
+ AD=0.0684P PS=0.745U PD=0.74U
* device instance $169 r0 *1 27.845,13.155 sky130_fd_pr__nfet_01v8
M$169 96 190 246 246 sky130_fd_pr__nfet_01v8 L=0.15U W=0.42U AS=0.066P
+ AD=0.1092P PS=0.745U PD=1.36U
* device instance $170 r0 *1 28.785,13.155 sky130_fd_pr__nfet_01v8
M$170 190 189 96 96 sky130_fd_pr__nfet_01v8 L=0.15U W=0.42U AS=0.10025P
+ AD=0.1092P PS=0.985U PD=1.36U
* device instance $171 r0 *1 29.27,13.04 sky130_fd_pr__nfet_01v8
M$171 191 189 96 96 sky130_fd_pr__nfet_01v8 L=0.15U W=0.65U AS=0.10025P
+ AD=0.182P PS=0.985U PD=1.86U
* device instance $172 r0 *1 30.85,13.04 sky130_fd_pr__nfet_01v8
M$172 247 2 96 96 sky130_fd_pr__nfet_01v8 L=0.15U W=0.65U AS=0.169P AD=0.08775P
+ PS=1.82U PD=0.92U
* device instance $173 r0 *1 31.27,13.04 sky130_fd_pr__nfet_01v8
M$173 64 63 247 247 sky130_fd_pr__nfet_01v8 L=0.15U W=0.65U AS=0.08775P
+ AD=0.169P PS=0.92U PD=1.82U
* device instance $174 r0 *1 32.625,13.155 sky130_fd_pr__nfet_01v8
M$174 96 191 62 62 sky130_fd_pr__nfet_01v8 L=0.15U W=0.42U AS=0.1092P
+ AD=0.1197P PS=1.36U PD=1.41U
* device instance $175 r0 *1 33.605,13.04 sky130_fd_pr__nfet_01v8
M$175 96 218 234 234 sky130_fd_pr__nfet_01v8 L=0.15U W=1.3U AS=0.299P AD=0.182P
+ PS=2.87U PD=1.86U
* device instance $176 r0 *1 34.035,13.04 sky130_fd_pr__nfet_01v8
M$176 234 62 96 96 sky130_fd_pr__nfet_01v8 L=0.15U W=1.3U AS=0.182P AD=0.21775P
+ PS=1.86U PD=1.97U
* device instance $179 r0 *1 35.435,13.04 sky130_fd_pr__nfet_01v8
M$179 66 259 234 234 sky130_fd_pr__nfet_01v8 L=0.15U W=1.3U AS=0.182P
+ AD=0.26325P PS=1.86U PD=2.76U
* device instance $181 r0 *1 40.95,13.04 sky130_fd_pr__nfet_01v8
M$181 96 167 193 193 sky130_fd_pr__nfet_01v8 L=0.15U W=0.65U AS=0.169P
+ AD=0.10725P PS=1.82U PD=0.98U
* device instance $182 r0 *1 41.43,13.04 sky130_fd_pr__nfet_01v8
M$182 248 195 96 96 sky130_fd_pr__nfet_01v8 L=0.15U W=0.65U AS=0.10725P
+ AD=0.06825P PS=0.98U PD=0.86U
* device instance $183 r0 *1 41.79,13.04 sky130_fd_pr__nfet_01v8
M$183 193 91 248 248 sky130_fd_pr__nfet_01v8 L=0.15U W=0.65U AS=0.06825P
+ AD=0.169P PS=0.86U PD=1.82U
* device instance $184 r0 *1 42.73,13.04 sky130_fd_pr__nfet_01v8
M$184 251 134 193 193 sky130_fd_pr__nfet_01v8 L=0.15U W=0.65U AS=0.169P
+ AD=0.10725P PS=1.82U PD=0.98U
* device instance $185 r0 *1 43.21,13.04 sky130_fd_pr__nfet_01v8
M$185 96 69 251 251 sky130_fd_pr__nfet_01v8 L=0.15U W=0.65U AS=0.10725P
+ AD=0.102375P PS=0.98U PD=0.965U
* device instance $186 r0 *1 43.675,13.04 sky130_fd_pr__nfet_01v8
M$186 197 193 96 96 sky130_fd_pr__nfet_01v8 L=0.15U W=0.65U AS=0.102375P
+ AD=0.169P PS=0.965U PD=1.82U
* device instance $187 r0 *1 46.93,13.155 sky130_fd_pr__nfet_01v8
M$187 96 333 198 198 sky130_fd_pr__nfet_01v8 L=0.15U W=0.42U AS=0.1092P
+ AD=0.0567P PS=1.36U PD=0.69U
* device instance $188 r0 *1 47.35,13.155 sky130_fd_pr__nfet_01v8
M$188 199 198 96 96 sky130_fd_pr__nfet_01v8 L=0.15U W=0.42U AS=0.0567P
+ AD=0.1092P PS=0.69U PD=1.36U
* device instance $189 r0 *1 48.29,13.155 sky130_fd_pr__nfet_01v8
M$189 253 126 200 200 sky130_fd_pr__nfet_01v8 L=0.15U W=0.42U AS=0.1092P
+ AD=0.0441P PS=1.36U PD=0.63U
* device instance $190 r0 *1 48.65,13.155 sky130_fd_pr__nfet_01v8
M$190 96 93 253 253 sky130_fd_pr__nfet_01v8 L=0.15U W=0.42U AS=0.0441P
+ AD=0.1092P PS=0.63U PD=1.36U
* device instance $191 r0 *1 49.59,13.155 sky130_fd_pr__nfet_01v8
M$191 96 93 201 201 sky130_fd_pr__nfet_01v8 L=0.15U W=0.42U AS=0.1092P
+ AD=0.0609P PS=1.36U PD=0.71U
* device instance $192 r0 *1 50.03,13.155 sky130_fd_pr__nfet_01v8
M$192 254 201 96 96 sky130_fd_pr__nfet_01v8 L=0.15U W=0.42U AS=0.0609P
+ AD=0.0756P PS=0.71U PD=0.78U
* device instance $193 r0 *1 50.54,13.155 sky130_fd_pr__nfet_01v8
M$193 200 205 254 254 sky130_fd_pr__nfet_01v8 L=0.15U W=0.42U AS=0.0756P
+ AD=0.1446P PS=0.78U PD=1.18U
* device instance $194 r0 *1 51.45,13.185 sky130_fd_pr__nfet_01v8
M$194 202 198 200 200 sky130_fd_pr__nfet_01v8 L=0.15U W=0.36U AS=0.1446P
+ AD=0.0522P PS=1.18U PD=0.65U
* device instance $195 r0 *1 51.89,13.185 sky130_fd_pr__nfet_01v8
M$195 202 199 252 252 sky130_fd_pr__nfet_01v8 L=0.15U W=0.36U AS=0.0759P
+ AD=0.0522P PS=0.8U PD=0.65U
* device instance $196 r0 *1 52.42,13.155 sky130_fd_pr__nfet_01v8
M$196 252 203 96 96 sky130_fd_pr__nfet_01v8 L=0.15U W=0.42U AS=0.12095P
+ AD=0.0759P PS=1.085U PD=0.8U
* device instance $197 r0 *1 53.015,13.045 sky130_fd_pr__nfet_01v8
M$197 203 202 96 96 sky130_fd_pr__nfet_01v8 L=0.15U W=0.64U AS=0.12095P
+ AD=0.1664P PS=1.085U PD=1.8U
* device instance $198 r0 *1 53.955,13.155 sky130_fd_pr__nfet_01v8
M$198 250 203 96 96 sky130_fd_pr__nfet_01v8 L=0.15U W=0.42U AS=0.1092P
+ AD=0.0678P PS=1.36U PD=0.755U
* device instance $199 r0 *1 54.44,13.185 sky130_fd_pr__nfet_01v8
M$199 204 199 250 250 sky130_fd_pr__nfet_01v8 L=0.15U W=0.36U AS=0.0678P
+ AD=0.0684P PS=0.755U PD=0.74U
* device instance $200 r0 *1 54.97,13.185 sky130_fd_pr__nfet_01v8
M$200 204 198 249 249 sky130_fd_pr__nfet_01v8 L=0.15U W=0.36U AS=0.066P
+ AD=0.0684P PS=0.745U PD=0.74U
* device instance $201 r0 *1 55.445,13.155 sky130_fd_pr__nfet_01v8
M$201 96 205 249 249 sky130_fd_pr__nfet_01v8 L=0.15U W=0.42U AS=0.066P
+ AD=0.1092P PS=0.745U PD=1.36U
* device instance $202 r0 *1 56.385,13.155 sky130_fd_pr__nfet_01v8
M$202 205 204 96 96 sky130_fd_pr__nfet_01v8 L=0.15U W=0.42U AS=0.10025P
+ AD=0.1092P PS=0.985U PD=1.36U
* device instance $203 r0 *1 56.87,13.04 sky130_fd_pr__nfet_01v8
M$203 195 204 96 96 sky130_fd_pr__nfet_01v8 L=0.15U W=0.65U AS=0.10025P
+ AD=0.182P PS=0.985U PD=1.86U
* device instance $204 r0 *1 61.69,13.04 sky130_fd_pr__nfet_01v8
M$204 206 219 96 96 sky130_fd_pr__nfet_01v8 L=0.15U W=0.65U AS=0.169P
+ AD=0.08775P PS=1.82U PD=0.92U
* device instance $205 r0 *1 62.11,13.04 sky130_fd_pr__nfet_01v8
M$205 96 220 206 206 sky130_fd_pr__nfet_01v8 L=0.15U W=0.65U AS=0.08775P
+ AD=0.08775P PS=0.92U PD=0.92U
* device instance $206 r0 *1 62.53,13.04 sky130_fd_pr__nfet_01v8
M$206 243 220 96 96 sky130_fd_pr__nfet_01v8 L=0.15U W=0.65U AS=0.08775P
+ AD=0.08775P PS=0.92U PD=0.92U
* device instance $207 r0 *1 62.95,13.04 sky130_fd_pr__nfet_01v8
M$207 4 219 243 243 sky130_fd_pr__nfet_01v8 L=0.15U W=0.65U AS=0.08775P
+ AD=0.25025P PS=0.92U PD=1.42U
* device instance $208 r0 *1 63.87,13.04 sky130_fd_pr__nfet_01v8
M$208 96 206 4 4 sky130_fd_pr__nfet_01v8 L=0.15U W=0.65U AS=0.25025P AD=0.208P
+ PS=1.42U PD=1.94U
* device instance $209 r0 *1 66.29,13.04 sky130_fd_pr__nfet_01v8
M$209 208 20 96 96 sky130_fd_pr__nfet_01v8 L=0.15U W=0.65U AS=0.169P
+ AD=0.08775P PS=1.82U PD=0.92U
* device instance $210 r0 *1 66.71,13.04 sky130_fd_pr__nfet_01v8
M$210 96 161 208 208 sky130_fd_pr__nfet_01v8 L=0.15U W=0.65U AS=0.08775P
+ AD=0.08775P PS=0.92U PD=0.92U
* device instance $211 r0 *1 67.13,13.04 sky130_fd_pr__nfet_01v8
M$211 239 161 96 96 sky130_fd_pr__nfet_01v8 L=0.15U W=0.65U AS=0.08775P
+ AD=0.08775P PS=0.92U PD=0.92U
* device instance $212 r0 *1 67.55,13.04 sky130_fd_pr__nfet_01v8
M$212 220 20 239 239 sky130_fd_pr__nfet_01v8 L=0.15U W=0.65U AS=0.08775P
+ AD=0.25025P PS=0.92U PD=1.42U
* device instance $213 r0 *1 68.47,13.04 sky130_fd_pr__nfet_01v8
M$213 96 208 220 220 sky130_fd_pr__nfet_01v8 L=0.15U W=0.65U AS=0.25025P
+ AD=0.208P PS=1.42U PD=1.94U
* device instance $214 r0 *1 69.47,12.925 sky130_fd_pr__nfet_01v8
M$214 96 161 221 221 sky130_fd_pr__nfet_01v8 L=0.15U W=0.42U AS=0.1092P
+ AD=0.10025P PS=1.36U PD=0.985U
* device instance $215 r0 *1 69.955,13.04 sky130_fd_pr__nfet_01v8
M$215 237 20 96 96 sky130_fd_pr__nfet_01v8 L=0.15U W=0.65U AS=0.10025P
+ AD=0.08775P PS=0.985U PD=0.92U
* device instance $216 r0 *1 70.375,13.04 sky130_fd_pr__nfet_01v8
M$216 210 221 237 237 sky130_fd_pr__nfet_01v8 L=0.15U W=0.65U AS=0.08775P
+ AD=0.169P PS=0.92U PD=1.82U
* device instance $217 r0 *1 12.665,14.045 sky130_fd_pr__nfet_01v8
M$217 96 56 255 255 sky130_fd_pr__nfet_01v8 L=0.15U W=0.42U AS=0.1092P
+ AD=0.10025P PS=1.36U PD=0.985U
* device instance $218 r0 *1 13.15,14.16 sky130_fd_pr__nfet_01v8
M$218 282 12 96 96 sky130_fd_pr__nfet_01v8 L=0.15U W=0.65U AS=0.10025P
+ AD=0.08775P PS=0.985U PD=0.92U
* device instance $219 r0 *1 13.57,14.16 sky130_fd_pr__nfet_01v8
M$219 96 255 282 282 sky130_fd_pr__nfet_01v8 L=0.15U W=0.65U AS=0.08775P
+ AD=0.169P PS=0.92U PD=1.82U
* device instance $220 r0 *1 13.82,18.48 sky130_fd_pr__nfet_01v8
M$220 96 294 293 293 sky130_fd_pr__nfet_01v8 L=0.15U W=0.65U AS=0.169P
+ AD=0.25675P PS=1.82U PD=1.44U
* device instance $221 r0 *1 14.76,18.48 sky130_fd_pr__nfet_01v8
M$221 294 282 96 96 sky130_fd_pr__nfet_01v8 L=0.15U W=0.65U AS=0.25675P
+ AD=0.089375P PS=1.44U PD=0.925U
* device instance $222 r0 *1 15.185,18.48 sky130_fd_pr__nfet_01v8
M$222 323 180 294 294 sky130_fd_pr__nfet_01v8 L=0.15U W=0.65U AS=0.089375P
+ AD=0.091P PS=0.925U PD=0.93U
* device instance $223 r0 *1 15.615,18.48 sky130_fd_pr__nfet_01v8
M$223 96 256 323 323 sky130_fd_pr__nfet_01v8 L=0.15U W=0.65U AS=0.091P
+ AD=0.17225P PS=0.93U PD=1.83U
* device instance $224 r0 *1 15.145,14.045 sky130_fd_pr__nfet_01v8
M$224 96 217 256 256 sky130_fd_pr__nfet_01v8 L=0.15U W=0.42U AS=0.1092P
+ AD=0.1197P PS=1.36U PD=1.41U
* device instance $225 r0 *1 28.63,14.16 sky130_fd_pr__nfet_01v8
M$225 281 191 257 257 sky130_fd_pr__nfet_01v8 L=0.15U W=0.65U AS=0.169P
+ AD=0.06825P PS=1.82U PD=0.86U
* device instance $226 r0 *1 28.99,14.16 sky130_fd_pr__nfet_01v8
M$226 96 218 281 281 sky130_fd_pr__nfet_01v8 L=0.15U W=0.65U AS=0.06825P
+ AD=0.08775P PS=0.86U PD=0.92U
* device instance $227 r0 *1 29.41,14.16 sky130_fd_pr__nfet_01v8
M$227 258 218 96 96 sky130_fd_pr__nfet_01v8 L=0.15U W=0.65U AS=0.08775P
+ AD=0.169P PS=0.92U PD=1.82U
* device instance $228 r0 *1 30.35,14.16 sky130_fd_pr__nfet_01v8
M$228 258 191 96 96 sky130_fd_pr__nfet_01v8 L=0.15U W=0.65U AS=0.169P
+ AD=0.08775P PS=1.82U PD=0.92U
* device instance $229 r0 *1 30.77,14.16 sky130_fd_pr__nfet_01v8
M$229 262 257 258 258 sky130_fd_pr__nfet_01v8 L=0.15U W=0.65U AS=0.08775P
+ AD=0.195P PS=0.92U PD=1.9U
* device instance $230 r0 *1 31.985,14.045 sky130_fd_pr__nfet_01v8
M$230 96 259 261 261 sky130_fd_pr__nfet_01v8 L=0.15U W=0.42U AS=0.1092P
+ AD=0.10025P PS=1.36U PD=0.985U
* device instance $231 r0 *1 32.47,14.16 sky130_fd_pr__nfet_01v8
M$231 92 260 96 96 sky130_fd_pr__nfet_01v8 L=0.15U W=0.65U AS=0.10025P
+ AD=0.08775P PS=0.985U PD=0.92U
* device instance $232 r0 *1 32.89,14.16 sky130_fd_pr__nfet_01v8
M$232 96 261 92 92 sky130_fd_pr__nfet_01v8 L=0.15U W=0.65U AS=0.08775P
+ AD=0.169P PS=0.92U PD=1.82U
* device instance $233 r0 *1 34.05,14.16 sky130_fd_pr__nfet_01v8
M$233 259 262 263 263 sky130_fd_pr__nfet_01v8 L=0.15U W=1.3U AS=0.25675P
+ AD=0.1755P PS=2.74U PD=1.84U
* device instance $235 r0 *1 34.89,14.16 sky130_fd_pr__nfet_01v8
M$235 265 264 263 263 sky130_fd_pr__nfet_01v8 L=0.15U W=1.3U AS=0.1755P
+ AD=0.25675P PS=1.84U PD=2.74U
* device instance $237 r0 *1 34.07,18.48 sky130_fd_pr__nfet_01v8
M$237 260 262 96 96 sky130_fd_pr__nfet_01v8 L=0.15U W=0.65U AS=0.17225P
+ AD=0.091P PS=1.83U PD=0.93U
* device instance $238 r0 *1 34.5,18.48 sky130_fd_pr__nfet_01v8
M$238 325 264 260 260 sky130_fd_pr__nfet_01v8 L=0.15U W=0.65U AS=0.091P
+ AD=0.095875P PS=0.93U PD=0.945U
* device instance $239 r0 *1 34.945,18.48 sky130_fd_pr__nfet_01v8
M$239 96 266 325 325 sky130_fd_pr__nfet_01v8 L=0.15U W=0.65U AS=0.095875P
+ AD=0.17225P PS=0.945U PD=1.83U
* device instance $240 r0 *1 35.89,18.48 sky130_fd_pr__nfet_01v8
M$240 271 62 96 96 sky130_fd_pr__nfet_01v8 L=0.15U W=0.65U AS=0.169P
+ AD=0.08775P PS=1.82U PD=0.92U
* device instance $241 r0 *1 36.31,18.48 sky130_fd_pr__nfet_01v8
M$241 96 218 271 271 sky130_fd_pr__nfet_01v8 L=0.15U W=0.65U AS=0.08775P
+ AD=0.169P PS=0.92U PD=1.82U
* device instance $242 r0 *1 36.25,14.16 sky130_fd_pr__nfet_01v8
M$242 265 266 96 96 sky130_fd_pr__nfet_01v8 L=0.15U W=1.3U AS=0.25675P
+ AD=0.28925P PS=2.74U PD=2.84U
* device instance $244 r0 *1 37.73,14.16 sky130_fd_pr__nfet_01v8
M$244 96 264 267 267 sky130_fd_pr__nfet_01v8 L=0.15U W=1.3U AS=0.25675P
+ AD=0.1755P PS=2.74U PD=1.84U
* device instance $246 r0 *1 38.57,14.16 sky130_fd_pr__nfet_01v8
M$246 269 268 267 267 sky130_fd_pr__nfet_01v8 L=0.15U W=1.3U AS=0.1755P
+ AD=0.25675P PS=1.84U PD=2.74U
* device instance $248 r0 *1 39.93,14.16 sky130_fd_pr__nfet_01v8
M$248 269 262 270 270 sky130_fd_pr__nfet_01v8 L=0.15U W=1.3U AS=0.25675P
+ AD=0.18525P PS=2.74U PD=1.87U
* device instance $250 r0 *1 40.8,14.16 sky130_fd_pr__nfet_01v8
M$250 96 271 270 270 sky130_fd_pr__nfet_01v8 L=0.15U W=1.3U AS=0.18525P
+ AD=0.25675P PS=1.87U PD=2.09U
* device instance $252 r0 *1 41.89,14.16 sky130_fd_pr__nfet_01v8
M$252 96 272 270 270 sky130_fd_pr__nfet_01v8 L=0.15U W=1.3U AS=0.25675P
+ AD=0.25675P PS=2.09U PD=2.74U
* device instance $254 r0 *1 45.325,14.045 sky130_fd_pr__nfet_01v8
M$254 96 128 273 273 sky130_fd_pr__nfet_01v8 L=0.15U W=0.42U AS=0.1092P
+ AD=0.10025P PS=1.36U PD=0.985U
* device instance $255 r0 *1 45.81,14.16 sky130_fd_pr__nfet_01v8
M$255 272 195 96 96 sky130_fd_pr__nfet_01v8 L=0.15U W=0.65U AS=0.10025P
+ AD=0.08775P PS=0.985U PD=0.92U
* device instance $256 r0 *1 46.23,14.16 sky130_fd_pr__nfet_01v8
M$256 96 273 272 272 sky130_fd_pr__nfet_01v8 L=0.15U W=0.65U AS=0.08775P
+ AD=0.169P PS=0.92U PD=1.82U
* device instance $257 r0 *1 47.39,14.16 sky130_fd_pr__nfet_01v8
M$257 67 274 96 96 sky130_fd_pr__nfet_01v8 L=0.15U W=0.65U AS=0.169P
+ AD=0.08775P PS=1.82U PD=0.92U
* device instance $258 r0 *1 47.81,14.16 sky130_fd_pr__nfet_01v8
M$258 96 272 67 67 sky130_fd_pr__nfet_01v8 L=0.15U W=0.65U AS=0.08775P
+ AD=0.169P PS=0.92U PD=1.82U
* device instance $259 r0 *1 50.385,14.045 sky130_fd_pr__nfet_01v8
M$259 96 195 275 275 sky130_fd_pr__nfet_01v8 L=0.15U W=0.42U AS=0.1092P
+ AD=0.10025P PS=1.36U PD=0.985U
* device instance $260 r0 *1 50.87,14.16 sky130_fd_pr__nfet_01v8
M$260 274 128 96 96 sky130_fd_pr__nfet_01v8 L=0.15U W=0.65U AS=0.10025P
+ AD=0.08775P PS=0.985U PD=0.92U
* device instance $261 r0 *1 51.29,14.16 sky130_fd_pr__nfet_01v8
M$261 96 275 274 274 sky130_fd_pr__nfet_01v8 L=0.15U W=0.65U AS=0.08775P
+ AD=0.169P PS=0.92U PD=1.82U
* device instance $262 r0 *1 53.625,18.595 sky130_fd_pr__nfet_01v8
M$262 306 305 96 96 sky130_fd_pr__nfet_01v8 L=0.15U W=0.42U AS=0.10025P
+ AD=0.1092P PS=0.985U PD=1.36U
* device instance $263 r0 *1 54.11,18.48 sky130_fd_pr__nfet_01v8
M$263 128 305 96 96 sky130_fd_pr__nfet_01v8 L=0.15U W=0.65U AS=0.10025P
+ AD=0.182P PS=0.985U PD=1.86U
* device instance $264 r0 *1 57.655,14.045 sky130_fd_pr__nfet_01v8
M$264 276 274 96 96 sky130_fd_pr__nfet_01v8 L=0.15U W=0.42U AS=0.1092P
+ AD=0.0567P PS=1.36U PD=0.69U
* device instance $265 r0 *1 58.075,14.045 sky130_fd_pr__nfet_01v8
M$265 96 270 276 276 sky130_fd_pr__nfet_01v8 L=0.15U W=0.42U AS=0.0567P
+ AD=0.10025P PS=0.69U PD=0.985U
* device instance $266 r0 *1 58.56,14.16 sky130_fd_pr__nfet_01v8
M$266 277 276 96 96 sky130_fd_pr__nfet_01v8 L=0.15U W=0.65U AS=0.10025P
+ AD=0.169P PS=0.985U PD=1.82U
* device instance $267 r0 *1 59.95,18.48 sky130_fd_pr__nfet_01v8
M$267 96 220 317 317 sky130_fd_pr__nfet_01v8 L=0.15U W=1.3U AS=0.25675P
+ AD=0.1755P PS=2.74U PD=1.84U
* device instance $269 r0 *1 60.79,18.48 sky130_fd_pr__nfet_01v8
M$269 96 270 317 317 sky130_fd_pr__nfet_01v8 L=0.15U W=1.3U AS=0.1755P
+ AD=0.1755P PS=1.84U PD=1.84U
* device instance $271 r0 *1 61.63,18.48 sky130_fd_pr__nfet_01v8
M$271 96 274 317 317 sky130_fd_pr__nfet_01v8 L=0.15U W=1.3U AS=0.3185P
+ AD=0.3185P PS=2.28U PD=2.28U
* device instance $273 r0 *1 62.91,18.48 sky130_fd_pr__nfet_01v8
M$273 318 210 317 317 sky130_fd_pr__nfet_01v8 L=0.15U W=1.3U AS=0.1755P
+ AD=0.26975P PS=1.84U PD=2.78U
* device instance $275 r0 *1 63.52,14.045 sky130_fd_pr__nfet_01v8
M$275 96 220 278 278 sky130_fd_pr__nfet_01v8 L=0.15U W=0.42U AS=0.1113P
+ AD=0.0588P PS=1.37U PD=0.7U
* device instance $276 r0 *1 63.95,14.045 sky130_fd_pr__nfet_01v8
M$276 278 277 96 96 sky130_fd_pr__nfet_01v8 L=0.15U W=0.42U AS=0.0588P
+ AD=0.0588P PS=0.7U PD=0.7U
* device instance $277 r0 *1 64.38,14.045 sky130_fd_pr__nfet_01v8
M$277 279 210 278 278 sky130_fd_pr__nfet_01v8 L=0.15U W=0.42U AS=0.0588P
+ AD=0.1113P PS=0.7U PD=1.37U
* device instance $278 r0 *1 64.31,18.48 sky130_fd_pr__nfet_01v8
M$278 318 310 307 307 sky130_fd_pr__nfet_01v8 L=0.15U W=1.3U AS=0.26975P
+ AD=0.25675P PS=2.78U PD=2.74U
* device instance $280 r0 *1 65.33,14.16 sky130_fd_pr__nfet_01v8
M$280 96 277 280 280 sky130_fd_pr__nfet_01v8 L=0.15U W=0.65U AS=0.169P
+ AD=0.08775P PS=1.82U PD=0.92U
* device instance $281 r0 *1 65.75,14.16 sky130_fd_pr__nfet_01v8
M$281 219 280 96 96 sky130_fd_pr__nfet_01v8 L=0.15U W=2.6U AS=0.351P
+ AD=0.43225P PS=3.68U PD=4.58U
* device instance $285 r0 *1 17.03,19.6 sky130_fd_pr__nfet_01v8
M$285 96 341 326 326 sky130_fd_pr__nfet_01v8 L=0.15U W=0.65U AS=0.169P
+ AD=0.08775P PS=1.82U PD=0.92U
* device instance $286 r0 *1 17.45,19.6 sky130_fd_pr__nfet_01v8
M$286 180 326 96 96 sky130_fd_pr__nfet_01v8 L=0.15U W=2.6U AS=0.351P
+ AD=0.43225P PS=3.68U PD=4.58U
* device instance $290 r0 *1 19.79,19.6 sky130_fd_pr__nfet_01v8
M$290 327 341 96 96 sky130_fd_pr__nfet_01v8 L=0.15U W=2.6U AS=0.43225P
+ AD=0.351P PS=4.58U PD=3.68U
* device instance $293 r0 *1 21.05,19.6 sky130_fd_pr__nfet_01v8
M$293 328 256 327 327 sky130_fd_pr__nfet_01v8 L=0.15U W=2.6U AS=0.351P
+ AD=0.351P PS=3.68U PD=3.68U
* device instance $298 r0 *1 23.15,19.6 sky130_fd_pr__nfet_01v8
M$298 328 329 96 96 sky130_fd_pr__nfet_01v8 L=0.15U W=2.6U AS=0.378625P
+ AD=0.47775P PS=3.765U PD=4.72U
* device instance $301 r0 *1 24.49,19.6 sky130_fd_pr__nfet_01v8
M$301 96 282 328 328 sky130_fd_pr__nfet_01v8 L=0.15U W=2.6U AS=0.352625P
+ AD=0.35425P PS=3.685U PD=3.69U
* device instance $306 r0 *1 27.155,19.485 sky130_fd_pr__nfet_01v8
M$306 330 297 96 96 sky130_fd_pr__nfet_01v8 L=0.15U W=1.68U AS=0.2877P
+ AD=0.2352P PS=3.47U PD=2.8U
* device instance $310 r0 *1 28.875,19.485 sky130_fd_pr__nfet_01v8
M$310 31 330 96 96 sky130_fd_pr__nfet_01v8 L=0.15U W=6.72U AS=0.93975P
+ AD=0.99225P PS=11.195U PD=11.865U
* device instance $326 r0 *1 36.35,19.6 sky130_fd_pr__nfet_01v8
M$326 96 268 331 331 sky130_fd_pr__nfet_01v8 L=0.15U W=0.65U AS=0.169P
+ AD=0.08775P PS=1.82U PD=0.92U
* device instance $327 r0 *1 36.77,19.6 sky130_fd_pr__nfet_01v8
M$327 266 331 96 96 sky130_fd_pr__nfet_01v8 L=0.15U W=2.6U AS=0.351P
+ AD=0.43225P PS=3.68U PD=4.58U
* device instance $331 r0 *1 44.17,18.595 sky130_fd_pr__nfet_01v8
M$331 96 333 298 298 sky130_fd_pr__nfet_01v8 L=0.15U W=0.42U AS=0.1092P
+ AD=0.0567P PS=1.36U PD=0.69U
* device instance $332 r0 *1 44.59,18.595 sky130_fd_pr__nfet_01v8
M$332 299 298 96 96 sky130_fd_pr__nfet_01v8 L=0.15U W=0.42U AS=0.0567P
+ AD=0.1092P PS=0.69U PD=1.36U
* device instance $333 r0 *1 45.53,18.595 sky130_fd_pr__nfet_01v8
M$333 324 197 300 300 sky130_fd_pr__nfet_01v8 L=0.15U W=0.42U AS=0.1092P
+ AD=0.0441P PS=1.36U PD=0.63U
* device instance $334 r0 *1 45.89,18.595 sky130_fd_pr__nfet_01v8
M$334 96 302 324 324 sky130_fd_pr__nfet_01v8 L=0.15U W=0.42U AS=0.0441P
+ AD=0.1092P PS=0.63U PD=1.36U
* device instance $335 r0 *1 46.475,19.485 sky130_fd_pr__nfet_01v8
M$335 332 297 96 96 sky130_fd_pr__nfet_01v8 L=0.15U W=1.68U AS=0.2877P
+ AD=0.2352P PS=3.47U PD=2.8U
* device instance $339 r0 *1 48.195,19.485 sky130_fd_pr__nfet_01v8
M$339 333 332 96 96 sky130_fd_pr__nfet_01v8 L=0.15U W=6.72U AS=0.93975P
+ AD=0.99225P PS=11.195U PD=11.865U
* device instance $355 r0 *1 46.83,18.595 sky130_fd_pr__nfet_01v8
M$355 96 302 301 301 sky130_fd_pr__nfet_01v8 L=0.15U W=0.42U AS=0.1092P
+ AD=0.0609P PS=1.36U PD=0.71U
* device instance $356 r0 *1 47.27,18.595 sky130_fd_pr__nfet_01v8
M$356 322 301 96 96 sky130_fd_pr__nfet_01v8 L=0.15U W=0.42U AS=0.0609P
+ AD=0.0756P PS=0.71U PD=0.78U
* device instance $357 r0 *1 47.78,18.595 sky130_fd_pr__nfet_01v8
M$357 300 306 322 322 sky130_fd_pr__nfet_01v8 L=0.15U W=0.42U AS=0.0756P
+ AD=0.1446P PS=0.78U PD=1.18U
* device instance $358 r0 *1 48.69,18.625 sky130_fd_pr__nfet_01v8
M$358 303 298 300 300 sky130_fd_pr__nfet_01v8 L=0.15U W=0.36U AS=0.1446P
+ AD=0.0522P PS=1.18U PD=0.65U
* device instance $359 r0 *1 49.13,18.625 sky130_fd_pr__nfet_01v8
M$359 303 299 321 321 sky130_fd_pr__nfet_01v8 L=0.15U W=0.36U AS=0.0759P
+ AD=0.0522P PS=0.8U PD=0.65U
* device instance $360 r0 *1 49.66,18.595 sky130_fd_pr__nfet_01v8
M$360 321 304 96 96 sky130_fd_pr__nfet_01v8 L=0.15U W=0.42U AS=0.12095P
+ AD=0.0759P PS=1.085U PD=0.8U
* device instance $361 r0 *1 50.255,18.485 sky130_fd_pr__nfet_01v8
M$361 304 303 96 96 sky130_fd_pr__nfet_01v8 L=0.15U W=0.64U AS=0.12095P
+ AD=0.1664P PS=1.085U PD=1.8U
* device instance $362 r0 *1 51.195,18.595 sky130_fd_pr__nfet_01v8
M$362 320 304 96 96 sky130_fd_pr__nfet_01v8 L=0.15U W=0.42U AS=0.1092P
+ AD=0.0678P PS=1.36U PD=0.755U
* device instance $363 r0 *1 51.68,18.625 sky130_fd_pr__nfet_01v8
M$363 305 299 320 320 sky130_fd_pr__nfet_01v8 L=0.15U W=0.36U AS=0.0678P
+ AD=0.0684P PS=0.755U PD=0.74U
* device instance $364 r0 *1 52.21,18.625 sky130_fd_pr__nfet_01v8
M$364 305 298 319 319 sky130_fd_pr__nfet_01v8 L=0.15U W=0.36U AS=0.066P
+ AD=0.0684P PS=0.745U PD=0.74U
* device instance $365 r0 *1 52.685,18.595 sky130_fd_pr__nfet_01v8
M$365 96 306 319 319 sky130_fd_pr__nfet_01v8 L=0.15U W=0.42U AS=0.066P
+ AD=0.1092P PS=0.745U PD=1.36U
* device instance $366 r0 *1 63.51,19.6 sky130_fd_pr__nfet_01v8
M$366 340 342 96 96 sky130_fd_pr__nfet_01v8 L=0.15U W=0.65U AS=0.169P
+ AD=0.08775P PS=1.82U PD=0.92U
* device instance $367 r0 *1 63.93,19.6 sky130_fd_pr__nfet_01v8
M$367 334 310 340 340 sky130_fd_pr__nfet_01v8 L=0.15U W=0.65U AS=0.08775P
+ AD=0.169P PS=0.92U PD=1.82U
* device instance $368 r0 *1 64.97,19.6 sky130_fd_pr__nfet_01v8
M$368 339 279 335 335 sky130_fd_pr__nfet_01v8 L=0.15U W=0.65U AS=0.169P
+ AD=0.06825P PS=1.82U PD=0.86U
* device instance $369 r0 *1 65.33,19.6 sky130_fd_pr__nfet_01v8
M$369 96 334 339 339 sky130_fd_pr__nfet_01v8 L=0.15U W=0.65U AS=0.06825P
+ AD=0.08775P PS=0.86U PD=0.92U
* device instance $370 r0 *1 65.75,19.6 sky130_fd_pr__nfet_01v8
M$370 336 334 96 96 sky130_fd_pr__nfet_01v8 L=0.15U W=0.65U AS=0.08775P
+ AD=0.169P PS=0.92U PD=1.82U
* device instance $371 r0 *1 66.69,19.6 sky130_fd_pr__nfet_01v8
M$371 336 279 96 96 sky130_fd_pr__nfet_01v8 L=0.15U W=0.65U AS=0.169P
+ AD=0.08775P PS=1.82U PD=0.92U
* device instance $372 r0 *1 67.11,19.6 sky130_fd_pr__nfet_01v8
M$372 347 335 336 336 sky130_fd_pr__nfet_01v8 L=0.15U W=0.65U AS=0.08775P
+ AD=0.195P PS=0.92U PD=1.9U
* device instance $373 r0 *1 68.325,19.485 sky130_fd_pr__nfet_01v8
M$373 96 343 337 337 sky130_fd_pr__nfet_01v8 L=0.15U W=0.42U AS=0.1092P
+ AD=0.10025P PS=1.36U PD=0.985U
* device instance $374 r0 *1 68.81,19.6 sky130_fd_pr__nfet_01v8
M$374 338 344 96 96 sky130_fd_pr__nfet_01v8 L=0.15U W=0.65U AS=0.10025P
+ AD=0.08775P PS=0.985U PD=0.92U
* device instance $375 r0 *1 69.23,19.6 sky130_fd_pr__nfet_01v8
M$375 96 337 338 338 sky130_fd_pr__nfet_01v8 L=0.15U W=0.65U AS=0.08775P
+ AD=0.169P PS=0.92U PD=1.82U
* device instance $376 r0 *1 6.98,24.035 sky130_fd_pr__nfet_01v8
M$376 414 352 353 353 sky130_fd_pr__nfet_01v8 L=0.15U W=0.42U AS=0.1113P
+ AD=0.0441P PS=1.37U PD=0.63U
* device instance $377 r0 *1 7.34,24.035 sky130_fd_pr__nfet_01v8
M$377 96 114 414 414 sky130_fd_pr__nfet_01v8 L=0.15U W=0.42U AS=0.0441P
+ AD=0.0966P PS=0.63U PD=0.88U
* device instance $378 r0 *1 7.95,24.035 sky130_fd_pr__nfet_01v8
M$378 354 353 96 96 sky130_fd_pr__nfet_01v8 L=0.15U W=0.42U AS=0.0966P
+ AD=0.1113P PS=0.88U PD=1.37U
* device instance $379 r0 *1 9.21,23.92 sky130_fd_pr__nfet_01v8
M$379 96 354 355 355 sky130_fd_pr__nfet_01v8 L=0.15U W=0.65U AS=0.169P
+ AD=0.10725P PS=1.82U PD=0.98U
* device instance $380 r0 *1 9.69,23.92 sky130_fd_pr__nfet_01v8
M$380 416 398 96 96 sky130_fd_pr__nfet_01v8 L=0.15U W=0.65U AS=0.10725P
+ AD=0.06825P PS=0.98U PD=0.86U
* device instance $381 r0 *1 10.05,23.92 sky130_fd_pr__nfet_01v8
M$381 355 91 416 416 sky130_fd_pr__nfet_01v8 L=0.15U W=0.65U AS=0.06825P
+ AD=0.169P PS=0.86U PD=1.82U
* device instance $382 r0 *1 10.99,23.92 sky130_fd_pr__nfet_01v8
M$382 417 157 355 355 sky130_fd_pr__nfet_01v8 L=0.15U W=0.65U AS=0.169P
+ AD=0.10725P PS=1.82U PD=0.98U
* device instance $383 r0 *1 11.47,23.92 sky130_fd_pr__nfet_01v8
M$383 96 360 417 417 sky130_fd_pr__nfet_01v8 L=0.15U W=0.65U AS=0.10725P
+ AD=0.102375P PS=0.98U PD=0.965U
* device instance $384 r0 *1 11.935,23.92 sky130_fd_pr__nfet_01v8
M$384 410 355 96 96 sky130_fd_pr__nfet_01v8 L=0.15U W=0.65U AS=0.102375P
+ AD=0.169P PS=0.965U PD=1.82U
* device instance $385 r0 *1 12.93,23.92 sky130_fd_pr__nfet_01v8
M$385 358 399 96 96 sky130_fd_pr__nfet_01v8 L=0.15U W=0.65U AS=0.169P
+ AD=0.08775P PS=1.82U PD=0.92U
* device instance $386 r0 *1 13.35,23.92 sky130_fd_pr__nfet_01v8
M$386 96 293 358 358 sky130_fd_pr__nfet_01v8 L=0.15U W=0.65U AS=0.08775P
+ AD=0.08775P PS=0.92U PD=0.92U
* device instance $387 r0 *1 13.77,23.92 sky130_fd_pr__nfet_01v8
M$387 420 293 96 96 sky130_fd_pr__nfet_01v8 L=0.15U W=0.65U AS=0.08775P
+ AD=0.08775P PS=0.92U PD=0.92U
* device instance $388 r0 *1 14.19,23.92 sky130_fd_pr__nfet_01v8
M$388 360 399 420 420 sky130_fd_pr__nfet_01v8 L=0.15U W=0.65U AS=0.08775P
+ AD=0.25025P PS=0.92U PD=1.42U
* device instance $389 r0 *1 15.11,23.92 sky130_fd_pr__nfet_01v8
M$389 96 358 360 360 sky130_fd_pr__nfet_01v8 L=0.15U W=0.65U AS=0.25025P
+ AD=0.208P PS=1.42U PD=1.94U
* device instance $390 r0 *1 17.49,24.005 sky130_fd_pr__nfet_01v8
M$390 361 407 96 96 sky130_fd_pr__nfet_01v8 L=0.15U W=0.42U AS=0.1092P
+ AD=0.0693P PS=1.36U PD=0.75U
* device instance $391 r0 *1 17.97,24.005 sky130_fd_pr__nfet_01v8
M$391 96 12 361 361 sky130_fd_pr__nfet_01v8 L=0.15U W=0.42U AS=0.0693P
+ AD=0.0567P PS=0.75U PD=0.69U
* device instance $392 r0 *1 18.39,24.005 sky130_fd_pr__nfet_01v8
M$392 361 398 96 96 sky130_fd_pr__nfet_01v8 L=0.15U W=0.42U AS=0.0567P
+ AD=0.0567P PS=0.69U PD=0.69U
* device instance $393 r0 *1 18.81,24.005 sky130_fd_pr__nfet_01v8
M$393 361 218 96 96 sky130_fd_pr__nfet_01v8 L=0.15U W=0.42U AS=0.101875P
+ AD=0.0567P PS=0.99U PD=0.69U
* device instance $394 r0 *1 19.3,23.92 sky130_fd_pr__nfet_01v8
M$394 362 361 96 96 sky130_fd_pr__nfet_01v8 L=0.15U W=0.65U AS=0.101875P
+ AD=0.1755P PS=0.99U PD=1.84U
* device instance $395 r0 *1 27.625,24.035 sky130_fd_pr__nfet_01v8
M$395 363 31 96 96 sky130_fd_pr__nfet_01v8 L=0.15U W=1.68U AS=0.315P AD=0.3423P
+ PS=3.6U PD=3.73U
* device instance $399 r0 *1 41.41,24.035 sky130_fd_pr__nfet_01v8
M$399 96 333 364 364 sky130_fd_pr__nfet_01v8 L=0.15U W=0.42U AS=0.1092P
+ AD=0.0567P PS=1.36U PD=0.69U
* device instance $400 r0 *1 41.83,24.035 sky130_fd_pr__nfet_01v8
M$400 365 364 96 96 sky130_fd_pr__nfet_01v8 L=0.15U W=0.42U AS=0.0567P
+ AD=0.1092P PS=0.69U PD=1.36U
* device instance $401 r0 *1 42.77,24.035 sky130_fd_pr__nfet_01v8
M$401 427 400 366 366 sky130_fd_pr__nfet_01v8 L=0.15U W=0.42U AS=0.1092P
+ AD=0.0441P PS=1.36U PD=0.63U
* device instance $402 r0 *1 43.13,24.035 sky130_fd_pr__nfet_01v8
M$402 96 93 427 427 sky130_fd_pr__nfet_01v8 L=0.15U W=0.42U AS=0.0441P
+ AD=0.1092P PS=0.63U PD=1.36U
* device instance $403 r0 *1 44.07,24.035 sky130_fd_pr__nfet_01v8
M$403 96 93 367 367 sky130_fd_pr__nfet_01v8 L=0.15U W=0.42U AS=0.1092P
+ AD=0.0609P PS=1.36U PD=0.71U
* device instance $404 r0 *1 44.51,24.035 sky130_fd_pr__nfet_01v8
M$404 426 367 96 96 sky130_fd_pr__nfet_01v8 L=0.15U W=0.42U AS=0.0609P
+ AD=0.0756P PS=0.71U PD=0.78U
* device instance $405 r0 *1 45.02,24.035 sky130_fd_pr__nfet_01v8
M$405 366 371 426 426 sky130_fd_pr__nfet_01v8 L=0.15U W=0.42U AS=0.0756P
+ AD=0.1446P PS=0.78U PD=1.18U
* device instance $406 r0 *1 45.93,24.065 sky130_fd_pr__nfet_01v8
M$406 368 364 366 366 sky130_fd_pr__nfet_01v8 L=0.15U W=0.36U AS=0.1446P
+ AD=0.0522P PS=1.18U PD=0.65U
* device instance $407 r0 *1 46.37,24.065 sky130_fd_pr__nfet_01v8
M$407 368 365 425 425 sky130_fd_pr__nfet_01v8 L=0.15U W=0.36U AS=0.0759P
+ AD=0.0522P PS=0.8U PD=0.65U
* device instance $408 r0 *1 46.9,24.035 sky130_fd_pr__nfet_01v8
M$408 425 369 96 96 sky130_fd_pr__nfet_01v8 L=0.15U W=0.42U AS=0.12095P
+ AD=0.0759P PS=1.085U PD=0.8U
* device instance $409 r0 *1 47.495,23.925 sky130_fd_pr__nfet_01v8
M$409 369 368 96 96 sky130_fd_pr__nfet_01v8 L=0.15U W=0.64U AS=0.12095P
+ AD=0.1664P PS=1.085U PD=1.8U
* device instance $410 r0 *1 48.435,24.035 sky130_fd_pr__nfet_01v8
M$410 424 369 96 96 sky130_fd_pr__nfet_01v8 L=0.15U W=0.42U AS=0.1092P
+ AD=0.0678P PS=1.36U PD=0.755U
* device instance $411 r0 *1 48.92,24.065 sky130_fd_pr__nfet_01v8
M$411 370 365 424 424 sky130_fd_pr__nfet_01v8 L=0.15U W=0.36U AS=0.0678P
+ AD=0.0684P PS=0.755U PD=0.74U
* device instance $412 r0 *1 49.45,24.065 sky130_fd_pr__nfet_01v8
M$412 370 364 423 423 sky130_fd_pr__nfet_01v8 L=0.15U W=0.36U AS=0.066P
+ AD=0.0684P PS=0.745U PD=0.74U
* device instance $413 r0 *1 49.925,24.035 sky130_fd_pr__nfet_01v8
M$413 96 371 423 423 sky130_fd_pr__nfet_01v8 L=0.15U W=0.42U AS=0.066P
+ AD=0.1092P PS=0.745U PD=1.36U
* device instance $414 r0 *1 50.865,24.035 sky130_fd_pr__nfet_01v8
M$414 371 370 96 96 sky130_fd_pr__nfet_01v8 L=0.15U W=0.42U AS=0.10025P
+ AD=0.1092P PS=0.985U PD=1.36U
* device instance $415 r0 *1 51.35,23.92 sky130_fd_pr__nfet_01v8
M$415 411 370 96 96 sky130_fd_pr__nfet_01v8 L=0.15U W=0.65U AS=0.10025P
+ AD=0.182P PS=0.985U PD=1.86U
* device instance $416 r0 *1 53.39,23.92 sky130_fd_pr__nfet_01v8
M$416 408 373 96 96 sky130_fd_pr__nfet_01v8 L=0.15U W=1.3U AS=0.26975P
+ AD=0.1755P PS=2.78U PD=1.84U
* device instance $418 r0 *1 54.23,23.92 sky130_fd_pr__nfet_01v8
M$418 408 344 96 96 sky130_fd_pr__nfet_01v8 L=0.15U W=1.3U AS=0.1755P
+ AD=0.26975P PS=1.84U PD=2.78U
* device instance $420 r0 *1 55.63,23.92 sky130_fd_pr__nfet_01v8
M$420 408 161 96 96 sky130_fd_pr__nfet_01v8 L=0.15U W=1.3U AS=0.26975P
+ AD=0.1755P PS=2.78U PD=1.84U
* device instance $422 r0 *1 56.47,23.92 sky130_fd_pr__nfet_01v8
M$422 408 195 96 96 sky130_fd_pr__nfet_01v8 L=0.15U W=1.3U AS=0.1755P
+ AD=0.25675P PS=1.84U PD=2.74U
* device instance $424 r0 *1 60.73,23.92 sky130_fd_pr__nfet_01v8
M$424 96 401 376 376 sky130_fd_pr__nfet_01v8 L=0.15U W=0.65U AS=0.169P
+ AD=0.10725P PS=1.82U PD=0.98U
* device instance $425 r0 *1 61.21,23.92 sky130_fd_pr__nfet_01v8
M$425 422 344 96 96 sky130_fd_pr__nfet_01v8 L=0.15U W=0.65U AS=0.10725P
+ AD=0.06825P PS=0.98U PD=0.86U
* device instance $426 r0 *1 61.57,23.92 sky130_fd_pr__nfet_01v8
M$426 376 91 422 422 sky130_fd_pr__nfet_01v8 L=0.15U W=0.65U AS=0.06825P
+ AD=0.169P PS=0.86U PD=1.82U
* device instance $427 r0 *1 62.51,23.92 sky130_fd_pr__nfet_01v8
M$427 421 134 376 376 sky130_fd_pr__nfet_01v8 L=0.15U W=0.65U AS=0.169P
+ AD=0.10725P PS=1.82U PD=0.98U
* device instance $428 r0 *1 62.99,23.92 sky130_fd_pr__nfet_01v8
M$428 96 347 421 421 sky130_fd_pr__nfet_01v8 L=0.15U W=0.65U AS=0.10725P
+ AD=0.102375P PS=0.98U PD=0.965U
* device instance $429 r0 *1 63.455,23.92 sky130_fd_pr__nfet_01v8
M$429 379 376 96 96 sky130_fd_pr__nfet_01v8 L=0.15U W=0.65U AS=0.102375P
+ AD=0.169P PS=0.965U PD=1.82U
* device instance $430 r0 *1 64.41,24.035 sky130_fd_pr__nfet_01v8
M$430 96 333 380 380 sky130_fd_pr__nfet_01v8 L=0.15U W=0.42U AS=0.1092P
+ AD=0.0567P PS=1.36U PD=0.69U
* device instance $431 r0 *1 64.83,24.035 sky130_fd_pr__nfet_01v8
M$431 381 380 96 96 sky130_fd_pr__nfet_01v8 L=0.15U W=0.42U AS=0.0567P
+ AD=0.1092P PS=0.69U PD=1.36U
* device instance $432 r0 *1 65.77,24.035 sky130_fd_pr__nfet_01v8
M$432 419 402 382 382 sky130_fd_pr__nfet_01v8 L=0.15U W=0.42U AS=0.1092P
+ AD=0.0441P PS=1.36U PD=0.63U
* device instance $433 r0 *1 66.13,24.035 sky130_fd_pr__nfet_01v8
M$433 96 409 419 419 sky130_fd_pr__nfet_01v8 L=0.15U W=0.42U AS=0.0441P
+ AD=0.1092P PS=0.63U PD=1.36U
* device instance $434 r0 *1 67.07,24.035 sky130_fd_pr__nfet_01v8
M$434 96 409 383 383 sky130_fd_pr__nfet_01v8 L=0.15U W=0.42U AS=0.1092P
+ AD=0.0609P PS=1.36U PD=0.71U
* device instance $435 r0 *1 67.51,24.035 sky130_fd_pr__nfet_01v8
M$435 418 383 96 96 sky130_fd_pr__nfet_01v8 L=0.15U W=0.42U AS=0.0609P
+ AD=0.0756P PS=0.71U PD=0.78U
* device instance $436 r0 *1 68.02,24.035 sky130_fd_pr__nfet_01v8
M$436 382 387 418 418 sky130_fd_pr__nfet_01v8 L=0.15U W=0.42U AS=0.0756P
+ AD=0.1446P PS=0.78U PD=1.18U
* device instance $437 r0 *1 68.93,24.065 sky130_fd_pr__nfet_01v8
M$437 384 380 382 382 sky130_fd_pr__nfet_01v8 L=0.15U W=0.36U AS=0.1446P
+ AD=0.0522P PS=1.18U PD=0.65U
* device instance $438 r0 *1 69.37,24.065 sky130_fd_pr__nfet_01v8
M$438 384 381 415 415 sky130_fd_pr__nfet_01v8 L=0.15U W=0.36U AS=0.0759P
+ AD=0.0522P PS=0.8U PD=0.65U
* device instance $439 r0 *1 69.9,24.035 sky130_fd_pr__nfet_01v8
M$439 415 385 96 96 sky130_fd_pr__nfet_01v8 L=0.15U W=0.42U AS=0.12095P
+ AD=0.0759P PS=1.085U PD=0.8U
* device instance $440 r0 *1 70.495,23.925 sky130_fd_pr__nfet_01v8
M$440 385 384 96 96 sky130_fd_pr__nfet_01v8 L=0.15U W=0.64U AS=0.12095P
+ AD=0.1664P PS=1.085U PD=1.8U
* device instance $441 r0 *1 71.435,24.035 sky130_fd_pr__nfet_01v8
M$441 413 385 96 96 sky130_fd_pr__nfet_01v8 L=0.15U W=0.42U AS=0.1092P
+ AD=0.0678P PS=1.36U PD=0.755U
* device instance $442 r0 *1 71.92,24.065 sky130_fd_pr__nfet_01v8
M$442 386 381 413 413 sky130_fd_pr__nfet_01v8 L=0.15U W=0.36U AS=0.0678P
+ AD=0.0684P PS=0.755U PD=0.74U
* device instance $443 r0 *1 72.45,24.065 sky130_fd_pr__nfet_01v8
M$443 386 380 412 412 sky130_fd_pr__nfet_01v8 L=0.15U W=0.36U AS=0.066P
+ AD=0.0684P PS=0.745U PD=0.74U
* device instance $444 r0 *1 72.925,24.035 sky130_fd_pr__nfet_01v8
M$444 96 387 412 412 sky130_fd_pr__nfet_01v8 L=0.15U W=0.42U AS=0.066P
+ AD=0.1092P PS=0.745U PD=1.36U
* device instance $445 r0 *1 73.865,24.035 sky130_fd_pr__nfet_01v8
M$445 387 386 96 96 sky130_fd_pr__nfet_01v8 L=0.15U W=0.42U AS=0.10025P
+ AD=0.1092P PS=0.985U PD=1.36U
* device instance $446 r0 *1 74.35,23.92 sky130_fd_pr__nfet_01v8
M$446 344 386 96 96 sky130_fd_pr__nfet_01v8 L=0.15U W=0.65U AS=0.10025P
+ AD=0.182P PS=0.985U PD=1.86U
* device instance $447 r0 *1 4.61,24.925 sky130_fd_pr__nfet_01v8
M$447 96 31 428 428 sky130_fd_pr__nfet_01v8 L=0.15U W=0.42U AS=0.1092P
+ AD=0.0567P PS=1.36U PD=0.69U
* device instance $448 r0 *1 5.03,24.925 sky130_fd_pr__nfet_01v8
M$448 429 428 96 96 sky130_fd_pr__nfet_01v8 L=0.15U W=0.42U AS=0.0567P
+ AD=0.1092P PS=0.69U PD=1.36U
* device instance $449 r0 *1 5.97,24.925 sky130_fd_pr__nfet_01v8
M$449 451 459 430 430 sky130_fd_pr__nfet_01v8 L=0.15U W=0.42U AS=0.1092P
+ AD=0.0441P PS=1.36U PD=0.63U
* device instance $450 r0 *1 6.33,24.925 sky130_fd_pr__nfet_01v8
M$450 96 93 451 451 sky130_fd_pr__nfet_01v8 L=0.15U W=0.42U AS=0.0441P
+ AD=0.1092P PS=0.63U PD=1.36U
* device instance $451 r0 *1 9.13,24.895 sky130_fd_pr__nfet_01v8
M$451 432 428 430 430 sky130_fd_pr__nfet_01v8 L=0.15U W=0.36U AS=0.1446P
+ AD=0.0522P PS=1.18U PD=0.65U
* device instance $452 r0 *1 9.57,24.895 sky130_fd_pr__nfet_01v8
M$452 453 429 432 432 sky130_fd_pr__nfet_01v8 L=0.15U W=0.36U AS=0.0522P
+ AD=0.0759P PS=0.65U PD=0.8U
* device instance $453 r0 *1 7.27,24.925 sky130_fd_pr__nfet_01v8
M$453 96 93 460 460 sky130_fd_pr__nfet_01v8 L=0.15U W=0.42U AS=0.1092P
+ AD=0.0609P PS=1.36U PD=0.71U
* device instance $454 r0 *1 7.71,24.925 sky130_fd_pr__nfet_01v8
M$454 452 460 96 96 sky130_fd_pr__nfet_01v8 L=0.15U W=0.42U AS=0.0609P
+ AD=0.0756P PS=0.71U PD=0.78U
* device instance $455 r0 *1 8.22,24.925 sky130_fd_pr__nfet_01v8
M$455 430 431 452 452 sky130_fd_pr__nfet_01v8 L=0.15U W=0.42U AS=0.0756P
+ AD=0.1446P PS=0.78U PD=1.18U
* device instance $456 r0 *1 10.1,24.925 sky130_fd_pr__nfet_01v8
M$456 96 433 453 453 sky130_fd_pr__nfet_01v8 L=0.15U W=0.42U AS=0.0759P
+ AD=0.12095P PS=0.8U PD=1.085U
* device instance $457 r0 *1 10.695,25.035 sky130_fd_pr__nfet_01v8
M$457 433 432 96 96 sky130_fd_pr__nfet_01v8 L=0.15U W=0.64U AS=0.12095P
+ AD=0.1664P PS=1.085U PD=1.8U
* device instance $458 r0 *1 12.12,24.895 sky130_fd_pr__nfet_01v8
M$458 434 429 454 454 sky130_fd_pr__nfet_01v8 L=0.15U W=0.36U AS=0.0678P
+ AD=0.0684P PS=0.755U PD=0.74U
* device instance $459 r0 *1 12.65,24.895 sky130_fd_pr__nfet_01v8
M$459 455 428 434 434 sky130_fd_pr__nfet_01v8 L=0.15U W=0.36U AS=0.0684P
+ AD=0.066P PS=0.74U PD=0.745U
* device instance $460 r0 *1 11.635,24.925 sky130_fd_pr__nfet_01v8
M$460 454 433 96 96 sky130_fd_pr__nfet_01v8 L=0.15U W=0.42U AS=0.1092P
+ AD=0.0678P PS=1.36U PD=0.755U
* device instance $461 r0 *1 13.125,24.925 sky130_fd_pr__nfet_01v8
M$461 96 431 455 455 sky130_fd_pr__nfet_01v8 L=0.15U W=0.42U AS=0.066P
+ AD=0.1092P PS=0.745U PD=1.36U
* device instance $462 r0 *1 14.065,24.925 sky130_fd_pr__nfet_01v8
M$462 96 434 431 431 sky130_fd_pr__nfet_01v8 L=0.15U W=0.42U AS=0.1092P
+ AD=0.10025P PS=1.36U PD=0.985U
* device instance $463 r0 *1 14.55,25.04 sky130_fd_pr__nfet_01v8
M$463 398 434 96 96 sky130_fd_pr__nfet_01v8 L=0.15U W=0.65U AS=0.10025P
+ AD=0.182P PS=0.985U PD=1.86U
* device instance $464 r0 *1 18.185,24.925 sky130_fd_pr__nfet_01v8
M$464 96 398 435 435 sky130_fd_pr__nfet_01v8 L=0.15U W=0.42U AS=0.1092P
+ AD=0.10025P PS=1.36U PD=0.985U
* device instance $465 r0 *1 18.67,25.04 sky130_fd_pr__nfet_01v8
M$465 436 461 96 96 sky130_fd_pr__nfet_01v8 L=0.15U W=0.65U AS=0.10025P
+ AD=0.08775P PS=0.985U PD=0.92U
* device instance $466 r0 *1 19.09,25.04 sky130_fd_pr__nfet_01v8
M$466 96 435 436 436 sky130_fd_pr__nfet_01v8 L=0.15U W=0.65U AS=0.08775P
+ AD=0.169P PS=0.92U PD=1.82U
* device instance $467 r0 *1 20.25,25.04 sky130_fd_pr__nfet_01v8
M$467 399 436 96 96 sky130_fd_pr__nfet_01v8 L=0.15U W=0.65U AS=0.169P
+ AD=0.08775P PS=1.82U PD=0.92U
* device instance $468 r0 *1 20.67,25.04 sky130_fd_pr__nfet_01v8
M$468 96 329 399 399 sky130_fd_pr__nfet_01v8 L=0.15U W=0.65U AS=0.08775P
+ AD=0.169P PS=0.92U PD=1.82U
* device instance $469 r0 *1 21.865,24.925 sky130_fd_pr__nfet_01v8
M$469 96 461 437 437 sky130_fd_pr__nfet_01v8 L=0.15U W=0.42U AS=0.1092P
+ AD=0.10025P PS=1.36U PD=0.985U
* device instance $470 r0 *1 22.35,25.04 sky130_fd_pr__nfet_01v8
M$470 329 398 96 96 sky130_fd_pr__nfet_01v8 L=0.15U W=0.65U AS=0.10025P
+ AD=0.08775P PS=0.985U PD=0.92U
* device instance $471 r0 *1 22.77,25.04 sky130_fd_pr__nfet_01v8
M$471 96 437 329 329 sky130_fd_pr__nfet_01v8 L=0.15U W=0.65U AS=0.08775P
+ AD=0.169P PS=0.92U PD=1.82U
* device instance $472 r0 *1 34.985,25.04 sky130_fd_pr__nfet_01v8
M$472 439 440 438 438 sky130_fd_pr__nfet_01v8 L=0.15U W=1.3U AS=0.2665P
+ AD=0.1755P PS=2.77U PD=1.84U
* device instance $474 r0 *1 35.825,25.04 sky130_fd_pr__nfet_01v8
M$474 96 441 438 438 sky130_fd_pr__nfet_01v8 L=0.15U W=1.3U AS=0.1755P
+ AD=0.26975P PS=1.84U PD=2.78U
* device instance $476 r0 *1 37.225,25.04 sky130_fd_pr__nfet_01v8
M$476 442 441 96 96 sky130_fd_pr__nfet_01v8 L=0.15U W=1.3U AS=0.26975P
+ AD=0.1755P PS=2.78U PD=1.84U
* device instance $478 r0 *1 38.065,25.04 sky130_fd_pr__nfet_01v8
M$478 442 440 96 96 sky130_fd_pr__nfet_01v8 L=0.15U W=1.3U AS=0.186875P
+ AD=0.268125P PS=1.875U PD=2.775U
* device instance $480 r0 *1 39.46,25.04 sky130_fd_pr__nfet_01v8
M$480 442 439 3 3 sky130_fd_pr__nfet_01v8 L=0.15U W=1.3U AS=0.25675P
+ AD=0.25675P PS=2.74U PD=2.74U
* device instance $482 r0 *1 46.47,25.04 sky130_fd_pr__nfet_01v8
M$482 96 333 443 443 sky130_fd_pr__nfet_01v8 L=0.15U W=1.95U AS=0.3445P
+ AD=0.26325P PS=3.66U PD=2.76U
* device instance $485 r0 *1 47.73,25.04 sky130_fd_pr__nfet_01v8
M$485 444 443 96 96 sky130_fd_pr__nfet_01v8 L=0.15U W=3.9U AS=0.5265P
+ AD=0.5265P PS=5.52U PD=5.52U
* device instance $491 r0 *1 50.25,25.04 sky130_fd_pr__nfet_01v8
M$491 445 444 96 96 sky130_fd_pr__nfet_01v8 L=0.15U W=10.4U AS=1.404P
+ AD=1.48525P PS=14.72U PD=15.62U
* device instance $507 r0 *1 61.26,24.925 sky130_fd_pr__nfet_01v8
M$507 458 462 446 446 sky130_fd_pr__nfet_01v8 L=0.15U W=0.42U AS=0.1113P
+ AD=0.0441P PS=1.37U PD=0.63U
* device instance $508 r0 *1 61.62,24.925 sky130_fd_pr__nfet_01v8
M$508 96 114 458 458 sky130_fd_pr__nfet_01v8 L=0.15U W=0.42U AS=0.0441P
+ AD=0.0966P PS=0.63U PD=0.88U
* device instance $509 r0 *1 62.23,24.925 sky130_fd_pr__nfet_01v8
M$509 401 446 96 96 sky130_fd_pr__nfet_01v8 L=0.15U W=0.42U AS=0.0966P
+ AD=0.1113P PS=0.88U PD=1.37U
* device instance $510 r0 *1 64.365,24.925 sky130_fd_pr__nfet_01v8
M$510 96 338 310 310 sky130_fd_pr__nfet_01v8 L=0.15U W=0.42U AS=0.1092P
+ AD=0.1197P PS=1.36U PD=1.41U
* device instance $511 r0 *1 65.33,25.155 sky130_fd_pr__nfet_01v8
M$511 447 343 96 96 sky130_fd_pr__nfet_01v8 L=0.15U W=0.42U AS=0.10025P
+ AD=0.1092P PS=0.985U PD=1.36U
* device instance $512 r0 *1 65.815,25.04 sky130_fd_pr__nfet_01v8
M$512 463 344 96 96 sky130_fd_pr__nfet_01v8 L=0.15U W=0.65U AS=0.10025P
+ AD=0.08775P PS=0.985U PD=0.92U
* device instance $513 r0 *1 66.235,25.04 sky130_fd_pr__nfet_01v8
M$513 342 447 463 463 sky130_fd_pr__nfet_01v8 L=0.15U W=0.65U AS=0.08775P
+ AD=0.169P PS=0.92U PD=1.82U
* device instance $514 r0 *1 68.175,24.925 sky130_fd_pr__nfet_01v8
M$514 457 63 96 96 sky130_fd_pr__nfet_01v8 L=0.15U W=0.42U AS=0.11285P
+ AD=0.0693P PS=1.045U PD=0.75U
* device instance $515 r0 *1 68.655,24.925 sky130_fd_pr__nfet_01v8
M$515 448 449 457 457 sky130_fd_pr__nfet_01v8 L=0.15U W=0.42U AS=0.0693P
+ AD=0.09975P PS=0.75U PD=0.895U
* device instance $516 r0 *1 69.28,24.925 sky130_fd_pr__nfet_01v8
M$516 456 343 448 448 sky130_fd_pr__nfet_01v8 L=0.15U W=0.42U AS=0.09975P
+ AD=0.0693P PS=0.895U PD=0.75U
* device instance $517 r0 *1 69.76,24.925 sky130_fd_pr__nfet_01v8
M$517 96 450 456 456 sky130_fd_pr__nfet_01v8 L=0.15U W=0.42U AS=0.0693P
+ AD=0.1449P PS=0.75U PD=1.11U
* device instance $518 r0 *1 70.6,24.925 sky130_fd_pr__nfet_01v8
M$518 450 63 96 96 sky130_fd_pr__nfet_01v8 L=0.15U W=0.42U AS=0.1449P
+ AD=0.1092P PS=1.11U PD=1.36U
* device instance $519 r0 *1 67.63,25.04 sky130_fd_pr__nfet_01v8
M$519 96 448 402 402 sky130_fd_pr__nfet_01v8 L=0.15U W=0.65U AS=0.169P
+ AD=0.11285P PS=1.82U PD=1.045U
* device instance $520 r0 *1 5.07,29.36 sky130_fd_pr__nfet_01v8
M$520 96 476 459 459 sky130_fd_pr__nfet_01v8 L=0.15U W=0.65U AS=0.169P
+ AD=0.11285P PS=1.82U PD=1.045U
* device instance $521 r0 *1 5.615,29.475 sky130_fd_pr__nfet_01v8
M$521 520 63 96 96 sky130_fd_pr__nfet_01v8 L=0.15U W=0.42U AS=0.11285P
+ AD=0.0693P PS=1.045U PD=0.75U
* device instance $522 r0 *1 6.095,29.475 sky130_fd_pr__nfet_01v8
M$522 476 464 520 520 sky130_fd_pr__nfet_01v8 L=0.15U W=0.42U AS=0.0693P
+ AD=0.09975P PS=0.75U PD=0.895U
* device instance $523 r0 *1 6.72,29.475 sky130_fd_pr__nfet_01v8
M$523 522 461 476 476 sky130_fd_pr__nfet_01v8 L=0.15U W=0.42U AS=0.09975P
+ AD=0.0693P PS=0.895U PD=0.75U
* device instance $524 r0 *1 7.2,29.475 sky130_fd_pr__nfet_01v8
M$524 96 515 522 522 sky130_fd_pr__nfet_01v8 L=0.15U W=0.42U AS=0.0693P
+ AD=0.1449P PS=0.75U PD=1.11U
* device instance $525 r0 *1 8.04,29.475 sky130_fd_pr__nfet_01v8
M$525 515 63 96 96 sky130_fd_pr__nfet_01v8 L=0.15U W=0.42U AS=0.1449P
+ AD=0.1092P PS=1.11U PD=1.36U
* device instance $526 r0 *1 9.21,29.475 sky130_fd_pr__nfet_01v8
M$526 96 31 477 477 sky130_fd_pr__nfet_01v8 L=0.15U W=0.42U AS=0.1092P
+ AD=0.0567P PS=1.36U PD=0.69U
* device instance $527 r0 *1 9.63,29.475 sky130_fd_pr__nfet_01v8
M$527 478 477 96 96 sky130_fd_pr__nfet_01v8 L=0.15U W=0.42U AS=0.0567P
+ AD=0.1092P PS=0.69U PD=1.36U
* device instance $528 r0 *1 10.57,29.475 sky130_fd_pr__nfet_01v8
M$528 524 410 479 479 sky130_fd_pr__nfet_01v8 L=0.15U W=0.42U AS=0.1092P
+ AD=0.0441P PS=1.36U PD=0.63U
* device instance $529 r0 *1 10.93,29.475 sky130_fd_pr__nfet_01v8
M$529 96 302 524 524 sky130_fd_pr__nfet_01v8 L=0.15U W=0.42U AS=0.0441P
+ AD=0.1092P PS=0.63U PD=1.36U
* device instance $530 r0 *1 11.87,29.475 sky130_fd_pr__nfet_01v8
M$530 96 302 480 480 sky130_fd_pr__nfet_01v8 L=0.15U W=0.42U AS=0.1092P
+ AD=0.0609P PS=1.36U PD=0.71U
* device instance $531 r0 *1 12.31,29.475 sky130_fd_pr__nfet_01v8
M$531 527 480 96 96 sky130_fd_pr__nfet_01v8 L=0.15U W=0.42U AS=0.0609P
+ AD=0.0756P PS=0.71U PD=0.78U
* device instance $532 r0 *1 12.82,29.475 sky130_fd_pr__nfet_01v8
M$532 479 484 527 527 sky130_fd_pr__nfet_01v8 L=0.15U W=0.42U AS=0.0756P
+ AD=0.1446P PS=0.78U PD=1.18U
* device instance $533 r0 *1 13.73,29.505 sky130_fd_pr__nfet_01v8
M$533 481 477 479 479 sky130_fd_pr__nfet_01v8 L=0.15U W=0.36U AS=0.1446P
+ AD=0.0522P PS=1.18U PD=0.65U
* device instance $534 r0 *1 14.17,29.505 sky130_fd_pr__nfet_01v8
M$534 481 478 528 528 sky130_fd_pr__nfet_01v8 L=0.15U W=0.36U AS=0.0759P
+ AD=0.0522P PS=0.8U PD=0.65U
* device instance $535 r0 *1 14.7,29.475 sky130_fd_pr__nfet_01v8
M$535 528 482 96 96 sky130_fd_pr__nfet_01v8 L=0.15U W=0.42U AS=0.12095P
+ AD=0.0759P PS=1.085U PD=0.8U
* device instance $536 r0 *1 15.295,29.365 sky130_fd_pr__nfet_01v8
M$536 482 481 96 96 sky130_fd_pr__nfet_01v8 L=0.15U W=0.64U AS=0.12095P
+ AD=0.1664P PS=1.085U PD=1.8U
* device instance $537 r0 *1 16.235,29.475 sky130_fd_pr__nfet_01v8
M$537 529 482 96 96 sky130_fd_pr__nfet_01v8 L=0.15U W=0.42U AS=0.1092P
+ AD=0.0678P PS=1.36U PD=0.755U
* device instance $538 r0 *1 16.72,29.505 sky130_fd_pr__nfet_01v8
M$538 483 478 529 529 sky130_fd_pr__nfet_01v8 L=0.15U W=0.36U AS=0.0678P
+ AD=0.0684P PS=0.755U PD=0.74U
* device instance $539 r0 *1 17.25,29.505 sky130_fd_pr__nfet_01v8
M$539 483 477 531 531 sky130_fd_pr__nfet_01v8 L=0.15U W=0.36U AS=0.066P
+ AD=0.0684P PS=0.745U PD=0.74U
* device instance $540 r0 *1 17.725,29.475 sky130_fd_pr__nfet_01v8
M$540 96 484 531 531 sky130_fd_pr__nfet_01v8 L=0.15U W=0.42U AS=0.066P
+ AD=0.1092P PS=0.745U PD=1.36U
* device instance $541 r0 *1 18.665,29.475 sky130_fd_pr__nfet_01v8
M$541 484 483 96 96 sky130_fd_pr__nfet_01v8 L=0.15U W=0.42U AS=0.10025P
+ AD=0.1092P PS=0.985U PD=1.36U
* device instance $542 r0 *1 19.15,29.36 sky130_fd_pr__nfet_01v8
M$542 461 483 96 96 sky130_fd_pr__nfet_01v8 L=0.15U W=0.65U AS=0.10025P
+ AD=0.182P PS=0.985U PD=1.86U
* device instance $543 r0 *1 26.26,30.365 sky130_fd_pr__nfet_01v8
M$543 96 436 534 534 sky130_fd_pr__nfet_01v8 L=0.15U W=0.42U AS=0.1113P
+ AD=0.0588P PS=1.37U PD=0.7U
* device instance $544 r0 *1 26.69,30.365 sky130_fd_pr__nfet_01v8
M$544 534 328 96 96 sky130_fd_pr__nfet_01v8 L=0.15U W=0.42U AS=0.0588P
+ AD=0.0588P PS=0.7U PD=0.7U
* device instance $545 r0 *1 27.12,30.365 sky130_fd_pr__nfet_01v8
M$545 547 535 534 534 sky130_fd_pr__nfet_01v8 L=0.15U W=0.42U AS=0.0588P
+ AD=0.1113P PS=0.7U PD=1.37U
* device instance $546 r0 *1 30.91,29.36 sky130_fd_pr__nfet_01v8
M$546 516 328 96 96 sky130_fd_pr__nfet_01v8 L=0.15U W=2.6U AS=0.44525P
+ AD=0.351P PS=4.62U PD=3.68U
* device instance $550 r0 *1 32.59,29.36 sky130_fd_pr__nfet_01v8
M$550 516 436 96 96 sky130_fd_pr__nfet_01v8 L=0.15U W=2.6U AS=0.351P AD=0.3575P
+ PS=3.68U PD=3.7U
* device instance $554 r0 *1 34.29,29.36 sky130_fd_pr__nfet_01v8
M$554 516 535 96 96 sky130_fd_pr__nfet_01v8 L=0.15U W=2.6U AS=0.3575P
+ AD=0.44525P PS=3.7U PD=4.62U
* device instance $558 r0 *1 31.77,30.48 sky130_fd_pr__nfet_01v8
M$558 542 537 96 96 sky130_fd_pr__nfet_01v8 L=0.15U W=0.65U AS=0.169P
+ AD=0.08775P PS=1.82U PD=0.92U
* device instance $559 r0 *1 32.19,30.48 sky130_fd_pr__nfet_01v8
M$559 441 513 542 542 sky130_fd_pr__nfet_01v8 L=0.15U W=0.65U AS=0.08775P
+ AD=0.12025P PS=0.92U PD=1.02U
* device instance $560 r0 *1 32.71,30.48 sky130_fd_pr__nfet_01v8
M$560 543 513 441 441 sky130_fd_pr__nfet_01v8 L=0.15U W=0.65U AS=0.12025P
+ AD=0.08775P PS=1.02U PD=0.92U
* device instance $561 r0 *1 33.13,30.48 sky130_fd_pr__nfet_01v8
M$561 96 537 543 543 sky130_fd_pr__nfet_01v8 L=0.15U W=0.65U AS=0.08775P
+ AD=0.169P PS=0.92U PD=1.82U
* device instance $562 r0 *1 35.91,30.48 sky130_fd_pr__nfet_01v8
M$562 544 264 96 96 sky130_fd_pr__nfet_01v8 L=0.15U W=0.65U AS=0.169P
+ AD=0.08775P PS=1.82U PD=0.92U
* device instance $563 r0 *1 36.33,30.48 sky130_fd_pr__nfet_01v8
M$563 440 487 544 544 sky130_fd_pr__nfet_01v8 L=0.15U W=0.65U AS=0.08775P
+ AD=0.169P PS=0.92U PD=1.82U
* device instance $564 r0 *1 36.53,29.36 sky130_fd_pr__nfet_01v8
M$564 516 513 518 518 sky130_fd_pr__nfet_01v8 L=0.15U W=2.6U AS=0.44525P
+ AD=0.351P PS=4.62U PD=3.68U
* device instance $568 r0 *1 38.21,29.36 sky130_fd_pr__nfet_01v8
M$568 268 487 518 518 sky130_fd_pr__nfet_01v8 L=0.15U W=2.6U AS=0.351P
+ AD=0.44525P PS=3.68U PD=4.62U
* device instance $572 r0 *1 38.19,30.48 sky130_fd_pr__nfet_01v8
M$572 96 124 538 538 sky130_fd_pr__nfet_01v8 L=0.15U W=0.65U AS=0.169P
+ AD=0.10725P PS=1.82U PD=0.98U
* device instance $573 r0 *1 38.67,30.48 sky130_fd_pr__nfet_01v8
M$573 545 411 96 96 sky130_fd_pr__nfet_01v8 L=0.15U W=0.65U AS=0.10725P
+ AD=0.06825P PS=0.98U PD=0.86U
* device instance $574 r0 *1 39.03,30.48 sky130_fd_pr__nfet_01v8
M$574 538 91 545 545 sky130_fd_pr__nfet_01v8 L=0.15U W=0.65U AS=0.06825P
+ AD=0.169P PS=0.86U PD=1.82U
* device instance $575 r0 *1 39.97,30.48 sky130_fd_pr__nfet_01v8
M$575 546 134 538 538 sky130_fd_pr__nfet_01v8 L=0.15U W=0.65U AS=0.169P
+ AD=0.10725P PS=1.82U PD=0.98U
* device instance $576 r0 *1 40.45,30.48 sky130_fd_pr__nfet_01v8
M$576 96 3 546 546 sky130_fd_pr__nfet_01v8 L=0.15U W=0.65U AS=0.10725P
+ AD=0.102375P PS=0.98U PD=0.965U
* device instance $577 r0 *1 40.915,30.48 sky130_fd_pr__nfet_01v8
M$577 550 538 96 96 sky130_fd_pr__nfet_01v8 L=0.15U W=0.65U AS=0.102375P
+ AD=0.169P PS=0.965U PD=1.82U
* device instance $578 r0 *1 41.87,29.245 sky130_fd_pr__nfet_01v8
M$578 96 514 488 488 sky130_fd_pr__nfet_01v8 L=0.15U W=0.42U AS=0.1092P
+ AD=0.10025P PS=1.36U PD=0.985U
* device instance $579 r0 *1 42.355,29.36 sky130_fd_pr__nfet_01v8
M$579 533 411 96 96 sky130_fd_pr__nfet_01v8 L=0.15U W=0.65U AS=0.10025P
+ AD=0.08775P PS=0.985U PD=0.92U
* device instance $580 r0 *1 42.775,29.36 sky130_fd_pr__nfet_01v8
M$580 264 488 533 533 sky130_fd_pr__nfet_01v8 L=0.15U W=0.65U AS=0.08775P
+ AD=0.169P PS=0.92U PD=1.82U
* device instance $581 r0 *1 42.285,30.365 sky130_fd_pr__nfet_01v8
M$581 96 539 487 487 sky130_fd_pr__nfet_01v8 L=0.15U W=0.42U AS=0.1092P
+ AD=0.1197P PS=1.36U PD=1.41U
* device instance $582 r0 *1 44.17,29.36 sky130_fd_pr__nfet_01v8
M$582 96 489 400 400 sky130_fd_pr__nfet_01v8 L=0.15U W=0.65U AS=0.169P
+ AD=0.11285P PS=1.82U PD=1.045U
* device instance $583 r0 *1 44.715,29.475 sky130_fd_pr__nfet_01v8
M$583 532 63 96 96 sky130_fd_pr__nfet_01v8 L=0.15U W=0.42U AS=0.11285P
+ AD=0.0693P PS=1.045U PD=0.75U
* device instance $584 r0 *1 45.195,29.475 sky130_fd_pr__nfet_01v8
M$584 489 490 532 532 sky130_fd_pr__nfet_01v8 L=0.15U W=0.42U AS=0.0693P
+ AD=0.09975P PS=0.75U PD=0.895U
* device instance $585 r0 *1 45.82,29.475 sky130_fd_pr__nfet_01v8
M$585 530 514 489 489 sky130_fd_pr__nfet_01v8 L=0.15U W=0.42U AS=0.09975P
+ AD=0.0693P PS=0.895U PD=0.75U
* device instance $586 r0 *1 46.3,29.475 sky130_fd_pr__nfet_01v8
M$586 96 517 530 530 sky130_fd_pr__nfet_01v8 L=0.15U W=0.42U AS=0.0693P
+ AD=0.1449P PS=0.75U PD=1.11U
* device instance $587 r0 *1 47.14,29.475 sky130_fd_pr__nfet_01v8
M$587 517 63 96 96 sky130_fd_pr__nfet_01v8 L=0.15U W=0.42U AS=0.1449P
+ AD=0.1092P PS=1.11U PD=1.36U
* device instance $588 r0 *1 44.865,30.365 sky130_fd_pr__nfet_01v8
M$588 96 514 540 540 sky130_fd_pr__nfet_01v8 L=0.15U W=0.42U AS=0.1092P
+ AD=0.10025P PS=1.36U PD=0.985U
* device instance $589 r0 *1 45.35,30.48 sky130_fd_pr__nfet_01v8
M$589 539 411 96 96 sky130_fd_pr__nfet_01v8 L=0.15U W=0.65U AS=0.10025P
+ AD=0.08775P PS=0.985U PD=0.92U
* device instance $590 r0 *1 45.77,30.48 sky130_fd_pr__nfet_01v8
M$590 96 540 539 539 sky130_fd_pr__nfet_01v8 L=0.15U W=0.65U AS=0.08775P
+ AD=0.169P PS=0.92U PD=1.82U
* device instance $591 r0 *1 47.19,30.48 sky130_fd_pr__nfet_01v8
M$591 541 1000 96 96 sky130_fd_pr__nfet_01v8 L=0.15U W=1.3U AS=0.25675P
+ AD=0.1755P PS=2.74U PD=1.84U
* device instance $593 r0 *1 48.03,30.48 sky130_fd_pr__nfet_01v8
M$593 134 541 96 96 sky130_fd_pr__nfet_01v8 L=0.15U W=3.9U AS=0.5265P
+ AD=0.60775P PS=5.52U PD=6.42U
* device instance $599 r0 *1 60.73,29.475 sky130_fd_pr__nfet_01v8
M$599 96 333 491 491 sky130_fd_pr__nfet_01v8 L=0.15U W=0.42U AS=0.1092P
+ AD=0.0567P PS=1.36U PD=0.69U
* device instance $600 r0 *1 61.15,29.475 sky130_fd_pr__nfet_01v8
M$600 492 491 96 96 sky130_fd_pr__nfet_01v8 L=0.15U W=0.42U AS=0.0567P
+ AD=0.1092P PS=0.69U PD=1.36U
* device instance $601 r0 *1 62.09,29.475 sky130_fd_pr__nfet_01v8
M$601 526 379 493 493 sky130_fd_pr__nfet_01v8 L=0.15U W=0.42U AS=0.1092P
+ AD=0.0441P PS=1.36U PD=0.63U
* device instance $602 r0 *1 62.45,29.475 sky130_fd_pr__nfet_01v8
M$602 96 302 526 526 sky130_fd_pr__nfet_01v8 L=0.15U W=0.42U AS=0.0441P
+ AD=0.1092P PS=0.63U PD=1.36U
* device instance $603 r0 *1 63.39,29.475 sky130_fd_pr__nfet_01v8
M$603 96 302 494 494 sky130_fd_pr__nfet_01v8 L=0.15U W=0.42U AS=0.1092P
+ AD=0.0609P PS=1.36U PD=0.71U
* device instance $604 r0 *1 63.83,29.475 sky130_fd_pr__nfet_01v8
M$604 525 494 96 96 sky130_fd_pr__nfet_01v8 L=0.15U W=0.42U AS=0.0609P
+ AD=0.0756P PS=0.71U PD=0.78U
* device instance $605 r0 *1 64.34,29.475 sky130_fd_pr__nfet_01v8
M$605 493 498 525 525 sky130_fd_pr__nfet_01v8 L=0.15U W=0.42U AS=0.0756P
+ AD=0.1446P PS=0.78U PD=1.18U
* device instance $606 r0 *1 65.25,29.505 sky130_fd_pr__nfet_01v8
M$606 495 491 493 493 sky130_fd_pr__nfet_01v8 L=0.15U W=0.36U AS=0.1446P
+ AD=0.0522P PS=1.18U PD=0.65U
* device instance $607 r0 *1 65.69,29.505 sky130_fd_pr__nfet_01v8
M$607 495 492 523 523 sky130_fd_pr__nfet_01v8 L=0.15U W=0.36U AS=0.0759P
+ AD=0.0522P PS=0.8U PD=0.65U
* device instance $608 r0 *1 66.22,29.475 sky130_fd_pr__nfet_01v8
M$608 523 496 96 96 sky130_fd_pr__nfet_01v8 L=0.15U W=0.42U AS=0.12095P
+ AD=0.0759P PS=1.085U PD=0.8U
* device instance $609 r0 *1 66.815,29.365 sky130_fd_pr__nfet_01v8
M$609 496 495 96 96 sky130_fd_pr__nfet_01v8 L=0.15U W=0.64U AS=0.12095P
+ AD=0.1664P PS=1.085U PD=1.8U
* device instance $610 r0 *1 67.755,29.475 sky130_fd_pr__nfet_01v8
M$610 521 496 96 96 sky130_fd_pr__nfet_01v8 L=0.15U W=0.42U AS=0.1092P
+ AD=0.0678P PS=1.36U PD=0.755U
* device instance $611 r0 *1 68.24,29.505 sky130_fd_pr__nfet_01v8
M$611 497 492 521 521 sky130_fd_pr__nfet_01v8 L=0.15U W=0.36U AS=0.0678P
+ AD=0.0684P PS=0.755U PD=0.74U
* device instance $612 r0 *1 68.77,29.505 sky130_fd_pr__nfet_01v8
M$612 497 491 519 519 sky130_fd_pr__nfet_01v8 L=0.15U W=0.36U AS=0.066P
+ AD=0.0684P PS=0.745U PD=0.74U
* device instance $613 r0 *1 69.245,29.475 sky130_fd_pr__nfet_01v8
M$613 96 498 519 519 sky130_fd_pr__nfet_01v8 L=0.15U W=0.42U AS=0.066P
+ AD=0.1092P PS=0.745U PD=1.36U
* device instance $614 r0 *1 70.185,29.475 sky130_fd_pr__nfet_01v8
M$614 498 497 96 96 sky130_fd_pr__nfet_01v8 L=0.15U W=0.42U AS=0.10025P
+ AD=0.1092P PS=0.985U PD=1.36U
* device instance $615 r0 *1 70.67,29.36 sky130_fd_pr__nfet_01v8
M$615 343 497 96 96 sky130_fd_pr__nfet_01v8 L=0.15U W=0.65U AS=0.10025P
+ AD=0.182P PS=0.985U PD=1.86U
* device instance $616 r0 *1 13.765,34.915 sky130_fd_pr__nfet_01v8
M$616 96 555 556 556 sky130_fd_pr__nfet_01v8 L=0.15U W=0.42U AS=0.1092P
+ AD=0.1197P PS=1.36U PD=1.41U
* device instance $617 r0 *1 27.155,34.8 sky130_fd_pr__nfet_01v8
M$617 588 537 557 557 sky130_fd_pr__nfet_01v8 L=0.15U W=0.65U AS=0.17225P
+ AD=0.06825P PS=1.83U PD=0.86U
* device instance $618 r0 *1 27.515,34.8 sky130_fd_pr__nfet_01v8
M$618 96 547 588 588 sky130_fd_pr__nfet_01v8 L=0.15U W=0.65U AS=0.06825P
+ AD=0.138125P PS=0.86U PD=1.075U
* device instance $619 r0 *1 28.09,34.8 sky130_fd_pr__nfet_01v8
M$619 558 557 96 96 sky130_fd_pr__nfet_01v8 L=0.15U W=2.6U AS=0.411125P
+ AD=0.45825P PS=3.865U PD=4.66U
* device instance $623 r0 *1 28.08,30.395 sky130_fd_pr__nfet_01v8
M$623 96 328 536 536 sky130_fd_pr__nfet_01v8 L=0.15U W=0.42U AS=0.1092P
+ AD=0.0567P PS=1.36U PD=0.69U
* device instance $624 r0 *1 28.5,30.395 sky130_fd_pr__nfet_01v8
M$624 536 436 96 96 sky130_fd_pr__nfet_01v8 L=0.15U W=0.42U AS=0.0567P
+ AD=0.0567P PS=0.69U PD=0.69U
* device instance $625 r0 *1 28.92,30.395 sky130_fd_pr__nfet_01v8
M$625 536 535 96 96 sky130_fd_pr__nfet_01v8 L=0.15U W=0.42U AS=0.101875P
+ AD=0.0567P PS=0.99U PD=0.69U
* device instance $626 r0 *1 29.41,30.48 sky130_fd_pr__nfet_01v8
M$626 537 536 96 96 sky130_fd_pr__nfet_01v8 L=0.15U W=0.65U AS=0.101875P
+ AD=0.182P PS=0.99U PD=1.86U
* device instance $627 r0 *1 40.49,34.915 sky130_fd_pr__nfet_01v8
M$627 96 333 559 559 sky130_fd_pr__nfet_01v8 L=0.15U W=0.42U AS=0.1092P
+ AD=0.0567P PS=1.36U PD=0.69U
* device instance $628 r0 *1 40.91,34.915 sky130_fd_pr__nfet_01v8
M$628 560 559 96 96 sky130_fd_pr__nfet_01v8 L=0.15U W=0.42U AS=0.0567P
+ AD=0.1092P PS=0.69U PD=1.36U
* device instance $629 r0 *1 41.85,34.915 sky130_fd_pr__nfet_01v8
M$629 587 550 562 562 sky130_fd_pr__nfet_01v8 L=0.15U W=0.42U AS=0.1092P
+ AD=0.0441P PS=1.36U PD=0.63U
* device instance $630 r0 *1 42.21,34.915 sky130_fd_pr__nfet_01v8
M$630 96 302 587 587 sky130_fd_pr__nfet_01v8 L=0.15U W=0.42U AS=0.0441P
+ AD=0.1092P PS=0.63U PD=1.36U
* device instance $631 r0 *1 43.15,34.915 sky130_fd_pr__nfet_01v8
M$631 96 302 561 561 sky130_fd_pr__nfet_01v8 L=0.15U W=0.42U AS=0.1092P
+ AD=0.0609P PS=1.36U PD=0.71U
* device instance $632 r0 *1 43.59,34.915 sky130_fd_pr__nfet_01v8
M$632 586 561 96 96 sky130_fd_pr__nfet_01v8 L=0.15U W=0.42U AS=0.0609P
+ AD=0.0756P PS=0.71U PD=0.78U
* device instance $633 r0 *1 44.1,34.915 sky130_fd_pr__nfet_01v8
M$633 562 566 586 586 sky130_fd_pr__nfet_01v8 L=0.15U W=0.42U AS=0.0756P
+ AD=0.1446P PS=0.78U PD=1.18U
* device instance $634 r0 *1 45.01,34.945 sky130_fd_pr__nfet_01v8
M$634 563 559 562 562 sky130_fd_pr__nfet_01v8 L=0.15U W=0.36U AS=0.1446P
+ AD=0.0522P PS=1.18U PD=0.65U
* device instance $635 r0 *1 45.45,34.945 sky130_fd_pr__nfet_01v8
M$635 563 560 585 585 sky130_fd_pr__nfet_01v8 L=0.15U W=0.36U AS=0.0759P
+ AD=0.0522P PS=0.8U PD=0.65U
* device instance $636 r0 *1 45.98,34.915 sky130_fd_pr__nfet_01v8
M$636 585 564 96 96 sky130_fd_pr__nfet_01v8 L=0.15U W=0.42U AS=0.12095P
+ AD=0.0759P PS=1.085U PD=0.8U
* device instance $637 r0 *1 46.575,34.805 sky130_fd_pr__nfet_01v8
M$637 564 563 96 96 sky130_fd_pr__nfet_01v8 L=0.15U W=0.64U AS=0.12095P
+ AD=0.1664P PS=1.085U PD=1.8U
* device instance $638 r0 *1 47.515,34.915 sky130_fd_pr__nfet_01v8
M$638 584 564 96 96 sky130_fd_pr__nfet_01v8 L=0.15U W=0.42U AS=0.1092P
+ AD=0.0678P PS=1.36U PD=0.755U
* device instance $639 r0 *1 48,34.945 sky130_fd_pr__nfet_01v8
M$639 565 560 584 584 sky130_fd_pr__nfet_01v8 L=0.15U W=0.36U AS=0.0678P
+ AD=0.0684P PS=0.755U PD=0.74U
* device instance $640 r0 *1 48.53,34.945 sky130_fd_pr__nfet_01v8
M$640 565 559 583 583 sky130_fd_pr__nfet_01v8 L=0.15U W=0.36U AS=0.066P
+ AD=0.0684P PS=0.745U PD=0.74U
* device instance $641 r0 *1 49.005,34.915 sky130_fd_pr__nfet_01v8
M$641 96 566 583 583 sky130_fd_pr__nfet_01v8 L=0.15U W=0.42U AS=0.066P
+ AD=0.1092P PS=0.745U PD=1.36U
* device instance $642 r0 *1 49.945,34.915 sky130_fd_pr__nfet_01v8
M$642 566 565 96 96 sky130_fd_pr__nfet_01v8 L=0.15U W=0.42U AS=0.10025P
+ AD=0.1092P PS=0.985U PD=1.36U
* device instance $643 r0 *1 50.43,34.8 sky130_fd_pr__nfet_01v8
M$643 514 565 96 96 sky130_fd_pr__nfet_01v8 L=0.15U W=0.65U AS=0.10025P
+ AD=0.182P PS=0.985U PD=1.86U
* device instance $644 r0 *1 59.81,34.8 sky130_fd_pr__nfet_01v8
M$644 96 307 567 567 sky130_fd_pr__nfet_01v8 L=0.15U W=0.65U AS=0.169P
+ AD=0.08775P PS=1.82U PD=0.92U
* device instance $645 r0 *1 60.23,34.8 sky130_fd_pr__nfet_01v8
M$645 580 567 96 96 sky130_fd_pr__nfet_01v8 L=0.15U W=2.6U AS=0.351P
+ AD=0.43225P PS=3.68U PD=4.58U
* device instance $649 r0 *1 62.57,34.8 sky130_fd_pr__nfet_01v8
M$649 96 568 569 569 sky130_fd_pr__nfet_01v8 L=0.15U W=0.65U AS=0.169P
+ AD=0.10725P PS=1.82U PD=0.98U
* device instance $650 r0 *1 63.05,34.8 sky130_fd_pr__nfet_01v8
M$650 582 571 96 96 sky130_fd_pr__nfet_01v8 L=0.15U W=0.65U AS=0.10725P
+ AD=0.06825P PS=0.98U PD=0.86U
* device instance $651 r0 *1 63.41,34.8 sky130_fd_pr__nfet_01v8
M$651 569 91 582 582 sky130_fd_pr__nfet_01v8 L=0.15U W=0.65U AS=0.06825P
+ AD=0.169P PS=0.86U PD=1.82U
* device instance $652 r0 *1 64.35,34.8 sky130_fd_pr__nfet_01v8
M$652 581 157 569 569 sky130_fd_pr__nfet_01v8 L=0.15U W=0.65U AS=0.169P
+ AD=0.10725P PS=1.82U PD=0.98U
* device instance $653 r0 *1 64.83,34.8 sky130_fd_pr__nfet_01v8
M$653 96 574 581 581 sky130_fd_pr__nfet_01v8 L=0.15U W=0.65U AS=0.10725P
+ AD=0.102375P PS=0.98U PD=0.965U
* device instance $654 r0 *1 65.295,34.8 sky130_fd_pr__nfet_01v8
M$654 573 569 96 96 sky130_fd_pr__nfet_01v8 L=0.15U W=0.65U AS=0.102375P
+ AD=0.169P PS=0.965U PD=1.82U
* device instance $655 r0 *1 8.75,35.92 sky130_fd_pr__nfet_01v8
M$655 96 589 590 590 sky130_fd_pr__nfet_01v8 L=0.15U W=0.65U AS=0.169P
+ AD=0.10725P PS=1.82U PD=0.98U
* device instance $656 r0 *1 9.23,35.92 sky130_fd_pr__nfet_01v8
M$656 607 407 96 96 sky130_fd_pr__nfet_01v8 L=0.15U W=0.65U AS=0.10725P
+ AD=0.06825P PS=0.98U PD=0.86U
* device instance $657 r0 *1 9.59,35.92 sky130_fd_pr__nfet_01v8
M$657 590 91 607 607 sky130_fd_pr__nfet_01v8 L=0.15U W=0.65U AS=0.06825P
+ AD=0.169P PS=0.86U PD=1.82U
* device instance $658 r0 *1 10.53,35.92 sky130_fd_pr__nfet_01v8
M$658 608 157 590 590 sky130_fd_pr__nfet_01v8 L=0.15U W=0.65U AS=0.169P
+ AD=0.10725P PS=1.82U PD=0.98U
* device instance $659 r0 *1 11.01,35.92 sky130_fd_pr__nfet_01v8
M$659 96 591 608 608 sky130_fd_pr__nfet_01v8 L=0.15U W=0.65U AS=0.10725P
+ AD=0.102375P PS=0.98U PD=0.965U
* device instance $660 r0 *1 11.475,35.92 sky130_fd_pr__nfet_01v8
M$660 592 590 96 96 sky130_fd_pr__nfet_01v8 L=0.15U W=0.65U AS=0.102375P
+ AD=0.169P PS=0.965U PD=1.82U
* device instance $661 r0 *1 12.53,35.805 sky130_fd_pr__nfet_01v8
M$661 609 556 593 593 sky130_fd_pr__nfet_01v8 L=0.15U W=0.42U AS=0.1092P
+ AD=0.0441P PS=1.36U PD=0.63U
* device instance $662 r0 *1 12.89,35.805 sky130_fd_pr__nfet_01v8
M$662 96 594 609 609 sky130_fd_pr__nfet_01v8 L=0.15U W=0.42U AS=0.0441P
+ AD=0.0567P PS=0.63U PD=0.69U
* device instance $663 r0 *1 13.31,35.805 sky130_fd_pr__nfet_01v8
M$663 610 594 96 96 sky130_fd_pr__nfet_01v8 L=0.15U W=0.42U AS=0.0567P
+ AD=0.0441P PS=0.69U PD=0.63U
* device instance $664 r0 *1 13.67,35.805 sky130_fd_pr__nfet_01v8
M$664 593 595 610 610 sky130_fd_pr__nfet_01v8 L=0.15U W=0.42U AS=0.0441P
+ AD=0.0567P PS=0.63U PD=0.69U
* device instance $665 r0 *1 14.09,35.805 sky130_fd_pr__nfet_01v8
M$665 611 595 593 593 sky130_fd_pr__nfet_01v8 L=0.15U W=0.42U AS=0.0567P
+ AD=0.0441P PS=0.69U PD=0.63U
* device instance $666 r0 *1 14.45,35.805 sky130_fd_pr__nfet_01v8
M$666 96 556 611 611 sky130_fd_pr__nfet_01v8 L=0.15U W=0.42U AS=0.0441P
+ AD=0.162225P PS=0.63U PD=1.25U
* device instance $667 r0 *1 15.2,35.92 sky130_fd_pr__nfet_01v8
M$667 341 593 96 96 sky130_fd_pr__nfet_01v8 L=0.15U W=1.3U AS=0.249975P
+ AD=0.26325P PS=2.17U PD=2.76U
* device instance $669 r0 *1 31.705,35.805 sky130_fd_pr__nfet_01v8
M$669 96 596 535 535 sky130_fd_pr__nfet_01v8 L=0.15U W=0.42U AS=0.1092P
+ AD=0.1197P PS=1.36U PD=1.41U
* device instance $670 r0 *1 34.05,36.035 sky130_fd_pr__nfet_01v8
M$670 597 652 96 96 sky130_fd_pr__nfet_01v8 L=0.15U W=0.42U AS=0.10025P
+ AD=0.1092P PS=0.985U PD=1.36U
* device instance $671 r0 *1 34.535,35.92 sky130_fd_pr__nfet_01v8
M$671 612 598 96 96 sky130_fd_pr__nfet_01v8 L=0.15U W=0.65U AS=0.10025P
+ AD=0.08775P PS=0.985U PD=0.92U
* device instance $672 r0 *1 34.955,35.92 sky130_fd_pr__nfet_01v8
M$672 513 597 612 612 sky130_fd_pr__nfet_01v8 L=0.15U W=0.65U AS=0.08775P
+ AD=0.169P PS=0.92U PD=1.82U
* device instance $673 r0 *1 59.42,35.805 sky130_fd_pr__nfet_01v8
M$673 613 600 599 599 sky130_fd_pr__nfet_01v8 L=0.15U W=0.42U AS=0.1113P
+ AD=0.0441P PS=1.37U PD=0.63U
* device instance $674 r0 *1 59.78,35.805 sky130_fd_pr__nfet_01v8
M$674 96 114 613 613 sky130_fd_pr__nfet_01v8 L=0.15U W=0.42U AS=0.0441P
+ AD=0.0966P PS=0.63U PD=0.88U
* device instance $675 r0 *1 60.39,35.805 sky130_fd_pr__nfet_01v8
M$675 568 599 96 96 sky130_fd_pr__nfet_01v8 L=0.15U W=0.42U AS=0.0966P
+ AD=0.1113P PS=0.88U PD=1.37U
* device instance $676 r0 *1 61.67,35.92 sky130_fd_pr__nfet_01v8
M$676 614 580 96 96 sky130_fd_pr__nfet_01v8 L=0.15U W=0.65U AS=0.169P
+ AD=0.08775P PS=1.82U PD=0.92U
* device instance $677 r0 *1 62.09,35.92 sky130_fd_pr__nfet_01v8
M$677 601 342 614 614 sky130_fd_pr__nfet_01v8 L=0.15U W=0.65U AS=0.08775P
+ AD=0.169P PS=0.92U PD=1.82U
* device instance $678 r0 *1 63.13,35.92 sky130_fd_pr__nfet_01v8
M$678 615 601 602 602 sky130_fd_pr__nfet_01v8 L=0.15U W=0.65U AS=0.169P
+ AD=0.06825P PS=1.82U PD=0.86U
* device instance $679 r0 *1 63.49,35.92 sky130_fd_pr__nfet_01v8
M$679 96 603 615 615 sky130_fd_pr__nfet_01v8 L=0.15U W=0.65U AS=0.06825P
+ AD=0.08775P PS=0.86U PD=0.92U
* device instance $680 r0 *1 63.91,35.92 sky130_fd_pr__nfet_01v8
M$680 604 603 96 96 sky130_fd_pr__nfet_01v8 L=0.15U W=0.65U AS=0.08775P
+ AD=0.169P PS=0.92U PD=1.82U
* device instance $681 r0 *1 64.85,35.92 sky130_fd_pr__nfet_01v8
M$681 604 601 96 96 sky130_fd_pr__nfet_01v8 L=0.15U W=0.65U AS=0.169P
+ AD=0.08775P PS=1.82U PD=0.92U
* device instance $682 r0 *1 65.27,35.92 sky130_fd_pr__nfet_01v8
M$682 574 602 604 604 sky130_fd_pr__nfet_01v8 L=0.15U W=0.65U AS=0.08775P
+ AD=0.195P PS=0.92U PD=1.9U
* device instance $683 r0 *1 66.485,35.805 sky130_fd_pr__nfet_01v8
M$683 96 653 605 605 sky130_fd_pr__nfet_01v8 L=0.15U W=0.42U AS=0.1092P
+ AD=0.10025P PS=1.36U PD=0.985U
* device instance $684 r0 *1 66.97,35.92 sky130_fd_pr__nfet_01v8
M$684 606 571 96 96 sky130_fd_pr__nfet_01v8 L=0.15U W=0.65U AS=0.10025P
+ AD=0.08775P PS=0.985U PD=0.92U
* device instance $685 r0 *1 67.39,35.92 sky130_fd_pr__nfet_01v8
M$685 96 605 606 606 sky130_fd_pr__nfet_01v8 L=0.15U W=0.65U AS=0.08775P
+ AD=0.169P PS=0.92U PD=1.82U
* device instance $686 r0 *1 6.91,40.24 sky130_fd_pr__nfet_01v8
M$686 96 626 625 625 sky130_fd_pr__nfet_01v8 L=0.15U W=0.65U AS=0.169P
+ AD=0.11285P PS=1.82U PD=1.045U
* device instance $687 r0 *1 7.455,40.355 sky130_fd_pr__nfet_01v8
M$687 669 63 96 96 sky130_fd_pr__nfet_01v8 L=0.15U W=0.42U AS=0.11285P
+ AD=0.0693P PS=1.045U PD=0.75U
* device instance $688 r0 *1 7.935,40.355 sky130_fd_pr__nfet_01v8
M$688 626 627 669 669 sky130_fd_pr__nfet_01v8 L=0.15U W=0.42U AS=0.0693P
+ AD=0.09975P PS=0.75U PD=0.895U
* device instance $689 r0 *1 8.56,40.355 sky130_fd_pr__nfet_01v8
M$689 670 595 626 626 sky130_fd_pr__nfet_01v8 L=0.15U W=0.42U AS=0.09975P
+ AD=0.0693P PS=0.895U PD=0.75U
* device instance $690 r0 *1 9.04,40.355 sky130_fd_pr__nfet_01v8
M$690 96 659 670 670 sky130_fd_pr__nfet_01v8 L=0.15U W=0.42U AS=0.0693P
+ AD=0.1449P PS=0.75U PD=1.11U
* device instance $691 r0 *1 9.88,40.355 sky130_fd_pr__nfet_01v8
M$691 659 63 96 96 sky130_fd_pr__nfet_01v8 L=0.15U W=0.42U AS=0.1449P
+ AD=0.1092P PS=1.11U PD=1.36U
* device instance $692 r0 *1 11.15,40.24 sky130_fd_pr__nfet_01v8
M$692 671 632 628 628 sky130_fd_pr__nfet_01v8 L=0.15U W=0.65U AS=0.169P
+ AD=0.06825P PS=1.82U PD=0.86U
* device instance $693 r0 *1 11.51,40.24 sky130_fd_pr__nfet_01v8
M$693 96 629 671 671 sky130_fd_pr__nfet_01v8 L=0.15U W=0.65U AS=0.06825P
+ AD=0.08775P PS=0.86U PD=0.92U
* device instance $694 r0 *1 11.93,40.24 sky130_fd_pr__nfet_01v8
M$694 660 629 96 96 sky130_fd_pr__nfet_01v8 L=0.15U W=0.65U AS=0.08775P
+ AD=0.169P PS=0.92U PD=1.82U
* device instance $695 r0 *1 12.87,40.24 sky130_fd_pr__nfet_01v8
M$695 660 632 96 96 sky130_fd_pr__nfet_01v8 L=0.15U W=0.65U AS=0.169P
+ AD=0.08775P PS=1.82U PD=0.92U
* device instance $696 r0 *1 13.29,40.24 sky130_fd_pr__nfet_01v8
M$696 591 628 660 660 sky130_fd_pr__nfet_01v8 L=0.15U W=0.65U AS=0.08775P
+ AD=0.195P PS=0.92U PD=1.9U
* device instance $697 r0 *1 14.31,40.24 sky130_fd_pr__nfet_01v8
M$697 630 595 96 96 sky130_fd_pr__nfet_01v8 L=0.15U W=0.65U AS=0.169P
+ AD=0.08775P PS=1.82U PD=0.92U
* device instance $698 r0 *1 14.73,40.24 sky130_fd_pr__nfet_01v8
M$698 96 407 630 630 sky130_fd_pr__nfet_01v8 L=0.15U W=0.65U AS=0.08775P
+ AD=0.08775P PS=0.92U PD=0.92U
* device instance $699 r0 *1 15.15,40.24 sky130_fd_pr__nfet_01v8
M$699 673 407 96 96 sky130_fd_pr__nfet_01v8 L=0.15U W=0.65U AS=0.08775P
+ AD=0.08775P PS=0.92U PD=0.92U
* device instance $700 r0 *1 15.57,40.24 sky130_fd_pr__nfet_01v8
M$700 632 595 673 673 sky130_fd_pr__nfet_01v8 L=0.15U W=0.65U AS=0.08775P
+ AD=0.25025P PS=0.92U PD=1.42U
* device instance $701 r0 *1 16.49,40.24 sky130_fd_pr__nfet_01v8
M$701 96 630 632 632 sky130_fd_pr__nfet_01v8 L=0.15U W=0.65U AS=0.25025P
+ AD=0.208P PS=1.42U PD=1.94U
* device instance $702 r0 *1 25.77,40.24 sky130_fd_pr__nfet_01v8
M$702 96 651 633 633 sky130_fd_pr__nfet_01v8 L=0.15U W=0.65U AS=0.169P
+ AD=0.10725P PS=1.82U PD=0.98U
* device instance $703 r0 *1 26.25,40.24 sky130_fd_pr__nfet_01v8
M$703 678 652 96 96 sky130_fd_pr__nfet_01v8 L=0.15U W=0.65U AS=0.10725P
+ AD=0.06825P PS=0.98U PD=0.86U
* device instance $704 r0 *1 26.61,40.24 sky130_fd_pr__nfet_01v8
M$704 633 91 678 678 sky130_fd_pr__nfet_01v8 L=0.15U W=0.65U AS=0.06825P
+ AD=0.169P PS=0.86U PD=1.82U
* device instance $705 r0 *1 27.55,40.24 sky130_fd_pr__nfet_01v8
M$705 679 134 633 633 sky130_fd_pr__nfet_01v8 L=0.15U W=0.65U AS=0.169P
+ AD=0.10725P PS=1.82U PD=0.98U
* device instance $706 r0 *1 28.03,40.24 sky130_fd_pr__nfet_01v8
M$706 96 558 679 679 sky130_fd_pr__nfet_01v8 L=0.15U W=0.65U AS=0.10725P
+ AD=0.102375P PS=0.98U PD=0.965U
* device instance $707 r0 *1 28.495,40.24 sky130_fd_pr__nfet_01v8
M$707 636 633 96 96 sky130_fd_pr__nfet_01v8 L=0.15U W=0.65U AS=0.102375P
+ AD=0.169P PS=0.965U PD=1.82U
* device instance $708 r0 *1 30.93,40.24 sky130_fd_pr__nfet_01v8
M$708 680 598 637 637 sky130_fd_pr__nfet_01v8 L=0.15U W=0.65U AS=0.169P
+ AD=0.06825P PS=1.82U PD=0.86U
* device instance $709 r0 *1 31.29,40.24 sky130_fd_pr__nfet_01v8
M$709 96 652 680 680 sky130_fd_pr__nfet_01v8 L=0.15U W=0.65U AS=0.06825P
+ AD=0.08775P PS=0.86U PD=0.92U
* device instance $710 r0 *1 31.71,40.24 sky130_fd_pr__nfet_01v8
M$710 661 652 96 96 sky130_fd_pr__nfet_01v8 L=0.15U W=0.65U AS=0.08775P
+ AD=0.169P PS=0.92U PD=1.82U
* device instance $711 r0 *1 32.65,40.24 sky130_fd_pr__nfet_01v8
M$711 661 598 96 96 sky130_fd_pr__nfet_01v8 L=0.15U W=0.65U AS=0.169P
+ AD=0.08775P PS=1.82U PD=0.92U
* device instance $712 r0 *1 33.07,40.24 sky130_fd_pr__nfet_01v8
M$712 596 637 661 661 sky130_fd_pr__nfet_01v8 L=0.15U W=0.65U AS=0.08775P
+ AD=0.195P PS=0.92U PD=1.9U
* device instance $713 r0 *1 55.67,40.24 sky130_fd_pr__nfet_01v8
M$713 677 580 96 96 sky130_fd_pr__nfet_01v8 L=0.15U W=0.65U AS=0.169P
+ AD=0.06825P PS=1.82U PD=0.86U
* device instance $714 r0 *1 56.03,40.24 sky130_fd_pr__nfet_01v8
M$714 676 342 677 677 sky130_fd_pr__nfet_01v8 L=0.15U W=0.65U AS=0.06825P
+ AD=0.118625P PS=0.86U PD=1.015U
* device instance $715 r0 *1 56.545,40.24 sky130_fd_pr__nfet_01v8
M$715 640 603 676 676 sky130_fd_pr__nfet_01v8 L=0.15U W=0.65U AS=0.118625P
+ AD=0.105625P PS=1.015U PD=0.975U
* device instance $716 r0 *1 57.02,40.24 sky130_fd_pr__nfet_01v8
M$716 96 606 640 640 sky130_fd_pr__nfet_01v8 L=0.15U W=0.65U AS=0.105625P
+ AD=0.1755P PS=0.975U PD=1.84U
* device instance $717 r0 *1 59.35,40.24 sky130_fd_pr__nfet_01v8
M$717 675 342 96 96 sky130_fd_pr__nfet_01v8 L=0.15U W=0.65U AS=0.169P
+ AD=0.089375P PS=1.82U PD=0.925U
* device instance $718 r0 *1 59.775,40.24 sky130_fd_pr__nfet_01v8
M$718 674 307 675 675 sky130_fd_pr__nfet_01v8 L=0.15U W=0.65U AS=0.089375P
+ AD=0.091P PS=0.925U PD=0.93U
* device instance $719 r0 *1 60.205,40.24 sky130_fd_pr__nfet_01v8
M$719 642 603 674 674 sky130_fd_pr__nfet_01v8 L=0.15U W=0.65U AS=0.091P
+ AD=0.115375P PS=0.93U PD=1.005U
* device instance $720 r0 *1 60.71,40.24 sky130_fd_pr__nfet_01v8
M$720 96 606 642 642 sky130_fd_pr__nfet_01v8 L=0.15U W=0.65U AS=0.115375P
+ AD=0.112125P PS=1.005U PD=0.995U
* device instance $721 r0 *1 61.205,40.24 sky130_fd_pr__nfet_01v8
M$721 642 663 96 96 sky130_fd_pr__nfet_01v8 L=0.15U W=0.65U AS=0.112125P
+ AD=0.169P PS=0.995U PD=1.82U
* device instance $722 r0 *1 64.51,40.24 sky130_fd_pr__nfet_01v8
M$722 672 653 643 643 sky130_fd_pr__nfet_01v8 L=0.15U W=0.65U AS=0.169P
+ AD=0.06825P PS=1.82U PD=0.86U
* device instance $723 r0 *1 64.87,40.24 sky130_fd_pr__nfet_01v8
M$723 96 571 672 672 sky130_fd_pr__nfet_01v8 L=0.15U W=0.65U AS=0.06825P
+ AD=0.08775P PS=0.86U PD=0.92U
* device instance $724 r0 *1 65.29,40.24 sky130_fd_pr__nfet_01v8
M$724 664 571 96 96 sky130_fd_pr__nfet_01v8 L=0.15U W=0.65U AS=0.08775P
+ AD=0.169P PS=0.92U PD=1.82U
* device instance $725 r0 *1 66.23,40.24 sky130_fd_pr__nfet_01v8
M$725 664 653 96 96 sky130_fd_pr__nfet_01v8 L=0.15U W=0.65U AS=0.169P
+ AD=0.08775P PS=1.82U PD=0.92U
* device instance $726 r0 *1 66.65,40.24 sky130_fd_pr__nfet_01v8
M$726 603 643 664 664 sky130_fd_pr__nfet_01v8 L=0.15U W=0.65U AS=0.08775P
+ AD=0.195P PS=0.92U PD=1.9U
* device instance $727 r0 *1 68.09,40.24 sky130_fd_pr__nfet_01v8
M$727 96 645 644 644 sky130_fd_pr__nfet_01v8 L=0.15U W=0.65U AS=0.169P
+ AD=0.11285P PS=1.82U PD=1.045U
* device instance $728 r0 *1 68.635,40.355 sky130_fd_pr__nfet_01v8
M$728 668 63 96 96 sky130_fd_pr__nfet_01v8 L=0.15U W=0.42U AS=0.11285P
+ AD=0.0693P PS=1.045U PD=0.75U
* device instance $729 r0 *1 69.115,40.355 sky130_fd_pr__nfet_01v8
M$729 645 646 668 668 sky130_fd_pr__nfet_01v8 L=0.15U W=0.42U AS=0.0693P
+ AD=0.09975P PS=0.75U PD=0.895U
* device instance $730 r0 *1 69.74,40.355 sky130_fd_pr__nfet_01v8
M$730 667 653 645 645 sky130_fd_pr__nfet_01v8 L=0.15U W=0.42U AS=0.09975P
+ AD=0.0693P PS=0.895U PD=0.75U
* device instance $731 r0 *1 70.22,40.355 sky130_fd_pr__nfet_01v8
M$731 96 665 667 667 sky130_fd_pr__nfet_01v8 L=0.15U W=0.42U AS=0.0693P
+ AD=0.1449P PS=0.75U PD=1.11U
* device instance $732 r0 *1 71.06,40.355 sky130_fd_pr__nfet_01v8
M$732 665 63 96 96 sky130_fd_pr__nfet_01v8 L=0.15U W=0.42U AS=0.1449P
+ AD=0.1092P PS=1.11U PD=1.36U
* device instance $733 r0 *1 2.77,41.245 sky130_fd_pr__nfet_01v8
M$733 96 682 681 681 sky130_fd_pr__nfet_01v8 L=0.15U W=0.42U AS=0.1092P
+ AD=0.0567P PS=1.36U PD=0.69U
* device instance $734 r0 *1 3.19,41.245 sky130_fd_pr__nfet_01v8
M$734 683 681 96 96 sky130_fd_pr__nfet_01v8 L=0.15U W=0.42U AS=0.0567P
+ AD=0.1092P PS=0.69U PD=1.36U
* device instance $735 r0 *1 4.13,41.245 sky130_fd_pr__nfet_01v8
M$735 711 625 684 684 sky130_fd_pr__nfet_01v8 L=0.15U W=0.42U AS=0.1092P
+ AD=0.0441P PS=1.36U PD=0.63U
* device instance $736 r0 *1 4.49,41.245 sky130_fd_pr__nfet_01v8
M$736 96 93 711 711 sky130_fd_pr__nfet_01v8 L=0.15U W=0.42U AS=0.0441P
+ AD=0.1092P PS=0.63U PD=1.36U
* device instance $737 r0 *1 4.68,40.355 sky130_fd_pr__nfet_01v8
M$737 666 623 624 624 sky130_fd_pr__nfet_01v8 L=0.15U W=0.42U AS=0.1113P
+ AD=0.0441P PS=1.37U PD=0.63U
* device instance $738 r0 *1 5.04,40.355 sky130_fd_pr__nfet_01v8
M$738 96 114 666 666 sky130_fd_pr__nfet_01v8 L=0.15U W=0.42U AS=0.0441P
+ AD=0.0966P PS=0.63U PD=0.88U
* device instance $739 r0 *1 5.65,40.355 sky130_fd_pr__nfet_01v8
M$739 589 624 96 96 sky130_fd_pr__nfet_01v8 L=0.15U W=0.42U AS=0.0966P
+ AD=0.1113P PS=0.88U PD=1.37U
* device instance $740 r0 *1 7.29,41.215 sky130_fd_pr__nfet_01v8
M$740 687 681 684 684 sky130_fd_pr__nfet_01v8 L=0.15U W=0.36U AS=0.1446P
+ AD=0.0522P PS=1.18U PD=0.65U
* device instance $741 r0 *1 7.73,41.215 sky130_fd_pr__nfet_01v8
M$741 713 683 687 687 sky130_fd_pr__nfet_01v8 L=0.15U W=0.36U AS=0.0522P
+ AD=0.0759P PS=0.65U PD=0.8U
* device instance $742 r0 *1 5.43,41.245 sky130_fd_pr__nfet_01v8
M$742 96 93 685 685 sky130_fd_pr__nfet_01v8 L=0.15U W=0.42U AS=0.1092P
+ AD=0.0609P PS=1.36U PD=0.71U
* device instance $743 r0 *1 5.87,41.245 sky130_fd_pr__nfet_01v8
M$743 712 685 96 96 sky130_fd_pr__nfet_01v8 L=0.15U W=0.42U AS=0.0609P
+ AD=0.0756P PS=0.71U PD=0.78U
* device instance $744 r0 *1 6.38,41.245 sky130_fd_pr__nfet_01v8
M$744 684 686 712 712 sky130_fd_pr__nfet_01v8 L=0.15U W=0.42U AS=0.0756P
+ AD=0.1446P PS=0.78U PD=1.18U
* device instance $745 r0 *1 8.26,41.245 sky130_fd_pr__nfet_01v8
M$745 96 688 713 713 sky130_fd_pr__nfet_01v8 L=0.15U W=0.42U AS=0.0759P
+ AD=0.12095P PS=0.8U PD=1.085U
* device instance $746 r0 *1 8.855,41.355 sky130_fd_pr__nfet_01v8
M$746 688 687 96 96 sky130_fd_pr__nfet_01v8 L=0.15U W=0.64U AS=0.12095P
+ AD=0.1664P PS=1.085U PD=1.8U
* device instance $747 r0 *1 10.28,41.215 sky130_fd_pr__nfet_01v8
M$747 689 683 714 714 sky130_fd_pr__nfet_01v8 L=0.15U W=0.36U AS=0.0678P
+ AD=0.0684P PS=0.755U PD=0.74U
* device instance $748 r0 *1 10.81,41.215 sky130_fd_pr__nfet_01v8
M$748 715 681 689 689 sky130_fd_pr__nfet_01v8 L=0.15U W=0.36U AS=0.0684P
+ AD=0.066P PS=0.74U PD=0.745U
* device instance $749 r0 *1 9.795,41.245 sky130_fd_pr__nfet_01v8
M$749 714 688 96 96 sky130_fd_pr__nfet_01v8 L=0.15U W=0.42U AS=0.1092P
+ AD=0.0678P PS=1.36U PD=0.755U
* device instance $750 r0 *1 11.285,41.245 sky130_fd_pr__nfet_01v8
M$750 96 686 715 715 sky130_fd_pr__nfet_01v8 L=0.15U W=0.42U AS=0.066P
+ AD=0.1092P PS=0.745U PD=1.36U
* device instance $751 r0 *1 12.225,41.245 sky130_fd_pr__nfet_01v8
M$751 96 689 686 686 sky130_fd_pr__nfet_01v8 L=0.15U W=0.42U AS=0.1092P
+ AD=0.10025P PS=1.36U PD=0.985U
* device instance $752 r0 *1 12.71,41.36 sky130_fd_pr__nfet_01v8
M$752 555 689 96 96 sky130_fd_pr__nfet_01v8 L=0.15U W=0.65U AS=0.10025P
+ AD=0.182P PS=0.985U PD=1.86U
* device instance $753 r0 *1 13.81,41.36 sky130_fd_pr__nfet_01v8
M$753 96 555 690 690 sky130_fd_pr__nfet_01v8 L=0.15U W=0.65U AS=0.169P
+ AD=0.08775P PS=1.82U PD=0.92U
* device instance $754 r0 *1 14.23,41.36 sky130_fd_pr__nfet_01v8
M$754 407 690 96 96 sky130_fd_pr__nfet_01v8 L=0.15U W=2.6U AS=0.351P
+ AD=0.43225P PS=3.68U PD=4.58U
* device instance $758 r0 *1 17.03,41.36 sky130_fd_pr__nfet_01v8
M$758 96 594 691 691 sky130_fd_pr__nfet_01v8 L=0.15U W=0.65U AS=0.169P
+ AD=0.08775P PS=1.82U PD=0.92U
* device instance $759 r0 *1 17.45,41.36 sky130_fd_pr__nfet_01v8
M$759 629 691 96 96 sky130_fd_pr__nfet_01v8 L=0.15U W=2.6U AS=0.351P
+ AD=0.43225P PS=3.68U PD=4.58U
* device instance $763 r0 *1 23.08,41.245 sky130_fd_pr__nfet_01v8
M$763 719 727 692 692 sky130_fd_pr__nfet_01v8 L=0.15U W=0.42U AS=0.1113P
+ AD=0.0441P PS=1.37U PD=0.63U
* device instance $764 r0 *1 23.44,41.245 sky130_fd_pr__nfet_01v8
M$764 96 114 719 719 sky130_fd_pr__nfet_01v8 L=0.15U W=0.42U AS=0.0441P
+ AD=0.0966P PS=0.63U PD=0.88U
* device instance $765 r0 *1 24.05,41.245 sky130_fd_pr__nfet_01v8
M$765 651 692 96 96 sky130_fd_pr__nfet_01v8 L=0.15U W=0.42U AS=0.0966P
+ AD=0.1113P PS=0.88U PD=1.37U
* device instance $766 r0 *1 26.23,41.245 sky130_fd_pr__nfet_01v8
M$766 96 682 693 693 sky130_fd_pr__nfet_01v8 L=0.15U W=0.42U AS=0.1092P
+ AD=0.0567P PS=1.36U PD=0.69U
* device instance $767 r0 *1 26.65,41.245 sky130_fd_pr__nfet_01v8
M$767 694 693 96 96 sky130_fd_pr__nfet_01v8 L=0.15U W=0.42U AS=0.0567P
+ AD=0.1092P PS=0.69U PD=1.36U
* device instance $768 r0 *1 27.59,41.245 sky130_fd_pr__nfet_01v8
M$768 721 728 695 695 sky130_fd_pr__nfet_01v8 L=0.15U W=0.42U AS=0.1092P
+ AD=0.0441P PS=1.36U PD=0.63U
* device instance $769 r0 *1 27.95,41.245 sky130_fd_pr__nfet_01v8
M$769 96 93 721 721 sky130_fd_pr__nfet_01v8 L=0.15U W=0.42U AS=0.0441P
+ AD=0.1092P PS=0.63U PD=1.36U
* device instance $770 r0 *1 30.75,41.215 sky130_fd_pr__nfet_01v8
M$770 698 693 695 695 sky130_fd_pr__nfet_01v8 L=0.15U W=0.36U AS=0.1446P
+ AD=0.0522P PS=1.18U PD=0.65U
* device instance $771 r0 *1 31.19,41.215 sky130_fd_pr__nfet_01v8
M$771 724 694 698 698 sky130_fd_pr__nfet_01v8 L=0.15U W=0.36U AS=0.0522P
+ AD=0.0759P PS=0.65U PD=0.8U
* device instance $772 r0 *1 28.89,41.245 sky130_fd_pr__nfet_01v8
M$772 96 93 696 696 sky130_fd_pr__nfet_01v8 L=0.15U W=0.42U AS=0.1092P
+ AD=0.0609P PS=1.36U PD=0.71U
* device instance $773 r0 *1 29.33,41.245 sky130_fd_pr__nfet_01v8
M$773 723 696 96 96 sky130_fd_pr__nfet_01v8 L=0.15U W=0.42U AS=0.0609P
+ AD=0.0756P PS=0.71U PD=0.78U
* device instance $774 r0 *1 29.84,41.245 sky130_fd_pr__nfet_01v8
M$774 695 697 723 723 sky130_fd_pr__nfet_01v8 L=0.15U W=0.42U AS=0.0756P
+ AD=0.1446P PS=0.78U PD=1.18U
* device instance $775 r0 *1 31.72,41.245 sky130_fd_pr__nfet_01v8
M$775 96 699 724 724 sky130_fd_pr__nfet_01v8 L=0.15U W=0.42U AS=0.0759P
+ AD=0.12095P PS=0.8U PD=1.085U
* device instance $776 r0 *1 32.315,41.355 sky130_fd_pr__nfet_01v8
M$776 699 698 96 96 sky130_fd_pr__nfet_01v8 L=0.15U W=0.64U AS=0.12095P
+ AD=0.1664P PS=1.085U PD=1.8U
* device instance $777 r0 *1 33.74,41.215 sky130_fd_pr__nfet_01v8
M$777 700 694 725 725 sky130_fd_pr__nfet_01v8 L=0.15U W=0.36U AS=0.0678P
+ AD=0.0684P PS=0.755U PD=0.74U
* device instance $778 r0 *1 34.27,41.215 sky130_fd_pr__nfet_01v8
M$778 726 693 700 700 sky130_fd_pr__nfet_01v8 L=0.15U W=0.36U AS=0.0684P
+ AD=0.066P PS=0.74U PD=0.745U
* device instance $779 r0 *1 33.255,41.245 sky130_fd_pr__nfet_01v8
M$779 725 699 96 96 sky130_fd_pr__nfet_01v8 L=0.15U W=0.42U AS=0.1092P
+ AD=0.0678P PS=1.36U PD=0.755U
* device instance $780 r0 *1 34.745,41.245 sky130_fd_pr__nfet_01v8
M$780 96 697 726 726 sky130_fd_pr__nfet_01v8 L=0.15U W=0.42U AS=0.066P
+ AD=0.1092P PS=0.745U PD=1.36U
* device instance $781 r0 *1 35.435,40.355 sky130_fd_pr__nfet_01v8
M$781 638 662 96 96 sky130_fd_pr__nfet_01v8 L=0.15U W=1.68U AS=0.2877P
+ AD=0.2352P PS=3.47U PD=2.8U
* device instance $785 r0 *1 37.155,40.355 sky130_fd_pr__nfet_01v8
M$785 297 638 96 96 sky130_fd_pr__nfet_01v8 L=0.15U W=6.72U AS=0.93975P
+ AD=0.99225P PS=11.195U PD=11.865U
* device instance $801 r0 *1 35.685,41.245 sky130_fd_pr__nfet_01v8
M$801 96 700 697 697 sky130_fd_pr__nfet_01v8 L=0.15U W=0.42U AS=0.1092P
+ AD=0.10025P PS=1.36U PD=0.985U
* device instance $802 r0 *1 36.17,41.36 sky130_fd_pr__nfet_01v8
M$802 652 700 96 96 sky130_fd_pr__nfet_01v8 L=0.15U W=0.65U AS=0.10025P
+ AD=0.182P PS=0.985U PD=1.86U
* device instance $803 r0 *1 44.63,41.36 sky130_fd_pr__nfet_01v8
M$803 735 652 96 96 sky130_fd_pr__nfet_01v8 L=0.15U W=0.65U AS=0.169P
+ AD=0.118625P PS=1.82U PD=1.015U
* device instance $804 r0 *1 45.145,41.36 sky130_fd_pr__nfet_01v8
M$804 96 411 735 735 sky130_fd_pr__nfet_01v8 L=0.15U W=0.65U AS=0.118625P
+ AD=0.089375P PS=1.015U PD=0.925U
* device instance $805 r0 *1 45.57,41.36 sky130_fd_pr__nfet_01v8
M$805 735 729 96 96 sky130_fd_pr__nfet_01v8 L=0.15U W=0.65U AS=0.089375P
+ AD=0.08775P PS=0.925U PD=0.92U
* device instance $806 r0 *1 45.99,41.36 sky130_fd_pr__nfet_01v8
M$806 96 1135 735 735 sky130_fd_pr__nfet_01v8 L=0.15U W=0.65U AS=0.08775P
+ AD=0.169P PS=0.92U PD=1.82U
* device instance $807 r0 *1 49.23,41.36 sky130_fd_pr__nfet_01v8
M$807 734 735 96 96 sky130_fd_pr__nfet_01v8 L=0.15U W=0.65U AS=0.169P
+ AD=0.08775P PS=1.82U PD=0.92U
* device instance $808 r0 *1 49.65,41.36 sky130_fd_pr__nfet_01v8
M$808 733 701 734 734 sky130_fd_pr__nfet_01v8 L=0.15U W=0.65U AS=0.08775P
+ AD=0.10725P PS=0.92U PD=0.98U
* device instance $809 r0 *1 50.13,41.36 sky130_fd_pr__nfet_01v8
M$809 897 408 733 733 sky130_fd_pr__nfet_01v8 L=0.15U W=0.65U AS=0.10725P
+ AD=0.169P PS=0.98U PD=1.82U
* device instance $810 r0 *1 57.61,41.36 sky130_fd_pr__nfet_01v8
M$810 732 730 731 731 sky130_fd_pr__nfet_01v8 L=0.15U W=0.65U AS=0.169P
+ AD=0.06825P PS=1.82U PD=0.86U
* device instance $811 r0 *1 57.97,41.36 sky130_fd_pr__nfet_01v8
M$811 96 640 732 732 sky130_fd_pr__nfet_01v8 L=0.15U W=0.65U AS=0.06825P
+ AD=0.08775P PS=0.86U PD=0.92U
* device instance $812 r0 *1 58.39,41.36 sky130_fd_pr__nfet_01v8
M$812 702 640 96 96 sky130_fd_pr__nfet_01v8 L=0.15U W=0.65U AS=0.08775P
+ AD=0.169P PS=0.92U PD=1.82U
* device instance $813 r0 *1 59.33,41.36 sky130_fd_pr__nfet_01v8
M$813 702 730 96 96 sky130_fd_pr__nfet_01v8 L=0.15U W=0.65U AS=0.169P
+ AD=0.08775P PS=1.82U PD=0.92U
* device instance $814 r0 *1 59.75,41.36 sky130_fd_pr__nfet_01v8
M$814 736 731 702 702 sky130_fd_pr__nfet_01v8 L=0.15U W=0.65U AS=0.08775P
+ AD=0.195P PS=0.92U PD=1.9U
* device instance $815 r0 *1 60.73,41.245 sky130_fd_pr__nfet_01v8
M$815 96 980 703 703 sky130_fd_pr__nfet_01v8 L=0.15U W=0.42U AS=0.1092P
+ AD=0.0567P PS=1.36U PD=0.69U
* device instance $816 r0 *1 61.15,41.245 sky130_fd_pr__nfet_01v8
M$816 704 703 96 96 sky130_fd_pr__nfet_01v8 L=0.15U W=0.42U AS=0.0567P
+ AD=0.1092P PS=0.69U PD=1.36U
* device instance $817 r0 *1 62.09,41.245 sky130_fd_pr__nfet_01v8
M$817 722 573 705 705 sky130_fd_pr__nfet_01v8 L=0.15U W=0.42U AS=0.1092P
+ AD=0.0441P PS=1.36U PD=0.63U
* device instance $818 r0 *1 62.45,41.245 sky130_fd_pr__nfet_01v8
M$818 96 302 722 722 sky130_fd_pr__nfet_01v8 L=0.15U W=0.42U AS=0.0441P
+ AD=0.1092P PS=0.63U PD=1.36U
* device instance $819 r0 *1 65.25,41.215 sky130_fd_pr__nfet_01v8
M$819 708 703 705 705 sky130_fd_pr__nfet_01v8 L=0.15U W=0.36U AS=0.1446P
+ AD=0.0522P PS=1.18U PD=0.65U
* device instance $820 r0 *1 65.69,41.215 sky130_fd_pr__nfet_01v8
M$820 718 704 708 708 sky130_fd_pr__nfet_01v8 L=0.15U W=0.36U AS=0.0522P
+ AD=0.0759P PS=0.65U PD=0.8U
* device instance $821 r0 *1 63.39,41.245 sky130_fd_pr__nfet_01v8
M$821 96 302 706 706 sky130_fd_pr__nfet_01v8 L=0.15U W=0.42U AS=0.1092P
+ AD=0.0609P PS=1.36U PD=0.71U
* device instance $822 r0 *1 63.83,41.245 sky130_fd_pr__nfet_01v8
M$822 720 706 96 96 sky130_fd_pr__nfet_01v8 L=0.15U W=0.42U AS=0.0609P
+ AD=0.0756P PS=0.71U PD=0.78U
* device instance $823 r0 *1 64.34,41.245 sky130_fd_pr__nfet_01v8
M$823 705 707 720 720 sky130_fd_pr__nfet_01v8 L=0.15U W=0.42U AS=0.0756P
+ AD=0.1446P PS=0.78U PD=1.18U
* device instance $824 r0 *1 66.22,41.245 sky130_fd_pr__nfet_01v8
M$824 96 709 718 718 sky130_fd_pr__nfet_01v8 L=0.15U W=0.42U AS=0.0759P
+ AD=0.12095P PS=0.8U PD=1.085U
* device instance $825 r0 *1 66.815,41.355 sky130_fd_pr__nfet_01v8
M$825 709 708 96 96 sky130_fd_pr__nfet_01v8 L=0.15U W=0.64U AS=0.12095P
+ AD=0.1664P PS=1.085U PD=1.8U
* device instance $826 r0 *1 68.24,41.215 sky130_fd_pr__nfet_01v8
M$826 710 704 717 717 sky130_fd_pr__nfet_01v8 L=0.15U W=0.36U AS=0.0678P
+ AD=0.0684P PS=0.755U PD=0.74U
* device instance $827 r0 *1 68.77,41.215 sky130_fd_pr__nfet_01v8
M$827 716 703 710 710 sky130_fd_pr__nfet_01v8 L=0.15U W=0.36U AS=0.0684P
+ AD=0.066P PS=0.74U PD=0.745U
* device instance $828 r0 *1 67.755,41.245 sky130_fd_pr__nfet_01v8
M$828 717 709 96 96 sky130_fd_pr__nfet_01v8 L=0.15U W=0.42U AS=0.1092P
+ AD=0.0678P PS=1.36U PD=0.755U
* device instance $829 r0 *1 69.245,41.245 sky130_fd_pr__nfet_01v8
M$829 96 707 716 716 sky130_fd_pr__nfet_01v8 L=0.15U W=0.42U AS=0.066P
+ AD=0.1092P PS=0.745U PD=1.36U
* device instance $830 r0 *1 70.185,41.245 sky130_fd_pr__nfet_01v8
M$830 96 710 707 707 sky130_fd_pr__nfet_01v8 L=0.15U W=0.42U AS=0.1092P
+ AD=0.10025P PS=1.36U PD=0.985U
* device instance $831 r0 *1 70.67,41.36 sky130_fd_pr__nfet_01v8
M$831 653 710 96 96 sky130_fd_pr__nfet_01v8 L=0.15U W=0.65U AS=0.10025P
+ AD=0.182P PS=0.985U PD=1.86U
* device instance $832 r0 *1 7.83,46.8 sky130_fd_pr__nfet_01v8
M$832 96 868 833 833 sky130_fd_pr__nfet_01v8 L=0.15U W=0.65U AS=0.169P
+ AD=0.10725P PS=1.82U PD=0.98U
* device instance $833 r0 *1 8.31,46.8 sky130_fd_pr__nfet_01v8
M$833 856 834 96 96 sky130_fd_pr__nfet_01v8 L=0.15U W=0.65U AS=0.10725P
+ AD=0.06825P PS=0.98U PD=0.86U
* device instance $834 r0 *1 8.67,46.8 sky130_fd_pr__nfet_01v8
M$834 833 91 856 856 sky130_fd_pr__nfet_01v8 L=0.15U W=0.65U AS=0.06825P
+ AD=0.169P PS=0.86U PD=1.82U
* device instance $835 r0 *1 9.21,45.795 sky130_fd_pr__nfet_01v8
M$835 96 682 756 756 sky130_fd_pr__nfet_01v8 L=0.15U W=0.42U AS=0.1092P
+ AD=0.0567P PS=1.36U PD=0.69U
* device instance $836 r0 *1 9.63,45.795 sky130_fd_pr__nfet_01v8
M$836 757 756 96 96 sky130_fd_pr__nfet_01v8 L=0.15U W=0.42U AS=0.0567P
+ AD=0.1092P PS=0.69U PD=1.36U
* device instance $837 r0 *1 9.61,46.8 sky130_fd_pr__nfet_01v8
M$837 857 157 833 833 sky130_fd_pr__nfet_01v8 L=0.15U W=0.65U AS=0.169P
+ AD=0.10725P PS=1.82U PD=0.98U
* device instance $838 r0 *1 10.09,46.8 sky130_fd_pr__nfet_01v8
M$838 96 869 857 857 sky130_fd_pr__nfet_01v8 L=0.15U W=0.65U AS=0.10725P
+ AD=0.102375P PS=0.98U PD=0.965U
* device instance $839 r0 *1 10.555,46.8 sky130_fd_pr__nfet_01v8
M$839 874 833 96 96 sky130_fd_pr__nfet_01v8 L=0.15U W=0.65U AS=0.102375P
+ AD=0.169P PS=0.965U PD=1.82U
* device instance $840 r0 *1 10.57,45.795 sky130_fd_pr__nfet_01v8
M$840 817 592 758 758 sky130_fd_pr__nfet_01v8 L=0.15U W=0.42U AS=0.1092P
+ AD=0.0441P PS=1.36U PD=0.63U
* device instance $841 r0 *1 10.93,45.795 sky130_fd_pr__nfet_01v8
M$841 96 302 817 817 sky130_fd_pr__nfet_01v8 L=0.15U W=0.42U AS=0.0441P
+ AD=0.1092P PS=0.63U PD=1.36U
* device instance $842 r0 *1 11.51,46.8 sky130_fd_pr__nfet_01v8
M$842 96 870 836 836 sky130_fd_pr__nfet_01v8 L=0.15U W=0.65U AS=0.169P
+ AD=0.169P PS=1.82U PD=1.82U
* device instance $843 r0 *1 11.87,45.795 sky130_fd_pr__nfet_01v8
M$843 96 302 759 759 sky130_fd_pr__nfet_01v8 L=0.15U W=0.42U AS=0.1092P
+ AD=0.0609P PS=1.36U PD=0.71U
* device instance $844 r0 *1 12.31,45.795 sky130_fd_pr__nfet_01v8
M$844 819 759 96 96 sky130_fd_pr__nfet_01v8 L=0.15U W=0.42U AS=0.0609P
+ AD=0.0756P PS=0.71U PD=0.78U
* device instance $845 r0 *1 12.82,45.795 sky130_fd_pr__nfet_01v8
M$845 758 763 819 819 sky130_fd_pr__nfet_01v8 L=0.15U W=0.42U AS=0.0756P
+ AD=0.1446P PS=0.78U PD=1.18U
* device instance $846 r0 *1 13.73,45.825 sky130_fd_pr__nfet_01v8
M$846 760 756 758 758 sky130_fd_pr__nfet_01v8 L=0.15U W=0.36U AS=0.1446P
+ AD=0.0522P PS=1.18U PD=0.65U
* device instance $847 r0 *1 14.17,45.825 sky130_fd_pr__nfet_01v8
M$847 760 757 821 821 sky130_fd_pr__nfet_01v8 L=0.15U W=0.36U AS=0.0759P
+ AD=0.0522P PS=0.8U PD=0.65U
* device instance $848 r0 *1 14.7,45.795 sky130_fd_pr__nfet_01v8
M$848 821 761 96 96 sky130_fd_pr__nfet_01v8 L=0.15U W=0.42U AS=0.12095P
+ AD=0.0759P PS=1.085U PD=0.8U
* device instance $849 r0 *1 15.295,45.685 sky130_fd_pr__nfet_01v8
M$849 761 760 96 96 sky130_fd_pr__nfet_01v8 L=0.15U W=0.64U AS=0.12095P
+ AD=0.1664P PS=1.085U PD=1.8U
* device instance $850 r0 *1 12.45,46.8 sky130_fd_pr__nfet_01v8
M$850 594 836 835 835 sky130_fd_pr__nfet_01v8 L=0.15U W=2.6U AS=0.43225P
+ AD=0.355875P PS=4.58U PD=3.695U
* device instance $854 r0 *1 14.145,46.8 sky130_fd_pr__nfet_01v8
M$854 96 837 835 835 sky130_fd_pr__nfet_01v8 L=0.15U W=2.6U AS=0.355875P
+ AD=0.51675P PS=3.695U PD=4.84U
* device instance $858 r0 *1 16.235,45.795 sky130_fd_pr__nfet_01v8
M$858 822 761 96 96 sky130_fd_pr__nfet_01v8 L=0.15U W=0.42U AS=0.1092P
+ AD=0.0678P PS=1.36U PD=0.755U
* device instance $859 r0 *1 16.72,45.825 sky130_fd_pr__nfet_01v8
M$859 762 757 822 822 sky130_fd_pr__nfet_01v8 L=0.15U W=0.36U AS=0.0678P
+ AD=0.0684P PS=0.755U PD=0.74U
* device instance $860 r0 *1 17.25,45.825 sky130_fd_pr__nfet_01v8
M$860 762 756 823 823 sky130_fd_pr__nfet_01v8 L=0.15U W=0.36U AS=0.066P
+ AD=0.0684P PS=0.745U PD=0.74U
* device instance $861 r0 *1 17.725,45.795 sky130_fd_pr__nfet_01v8
M$861 96 763 823 823 sky130_fd_pr__nfet_01v8 L=0.15U W=0.42U AS=0.066P
+ AD=0.1092P PS=0.745U PD=1.36U
* device instance $862 r0 *1 18.665,45.795 sky130_fd_pr__nfet_01v8
M$862 763 762 96 96 sky130_fd_pr__nfet_01v8 L=0.15U W=0.42U AS=0.10025P
+ AD=0.1092P PS=0.985U PD=1.36U
* device instance $863 r0 *1 19.15,45.68 sky130_fd_pr__nfet_01v8
M$863 595 762 96 96 sky130_fd_pr__nfet_01v8 L=0.15U W=0.65U AS=0.10025P
+ AD=0.182P PS=0.985U PD=1.86U
* device instance $864 r0 *1 25.77,46.685 sky130_fd_pr__nfet_01v8
M$864 96 682 838 838 sky130_fd_pr__nfet_01v8 L=0.15U W=0.42U AS=0.1092P
+ AD=0.0567P PS=1.36U PD=0.69U
* device instance $865 r0 *1 26.19,46.685 sky130_fd_pr__nfet_01v8
M$865 871 838 96 96 sky130_fd_pr__nfet_01v8 L=0.15U W=0.42U AS=0.0567P
+ AD=0.1092P PS=0.69U PD=1.36U
* device instance $866 r0 *1 26.23,45.68 sky130_fd_pr__nfet_01v8
M$866 96 764 728 728 sky130_fd_pr__nfet_01v8 L=0.15U W=0.65U AS=0.169P
+ AD=0.11285P PS=1.82U PD=1.045U
* device instance $867 r0 *1 26.775,45.795 sky130_fd_pr__nfet_01v8
M$867 824 63 96 96 sky130_fd_pr__nfet_01v8 L=0.15U W=0.42U AS=0.11285P
+ AD=0.0693P PS=1.045U PD=0.75U
* device instance $868 r0 *1 27.255,45.795 sky130_fd_pr__nfet_01v8
M$868 764 795 824 824 sky130_fd_pr__nfet_01v8 L=0.15U W=0.42U AS=0.0693P
+ AD=0.09975P PS=0.75U PD=0.895U
* device instance $869 r0 *1 27.88,45.795 sky130_fd_pr__nfet_01v8
M$869 825 598 764 764 sky130_fd_pr__nfet_01v8 L=0.15U W=0.42U AS=0.09975P
+ AD=0.0693P PS=0.895U PD=0.75U
* device instance $870 r0 *1 28.36,45.795 sky130_fd_pr__nfet_01v8
M$870 96 813 825 825 sky130_fd_pr__nfet_01v8 L=0.15U W=0.42U AS=0.0693P
+ AD=0.1449P PS=0.75U PD=1.11U
* device instance $871 r0 *1 29.2,45.795 sky130_fd_pr__nfet_01v8
M$871 813 63 96 96 sky130_fd_pr__nfet_01v8 L=0.15U W=0.42U AS=0.1449P
+ AD=0.1092P PS=1.11U PD=1.36U
* device instance $872 r0 *1 27.13,46.685 sky130_fd_pr__nfet_01v8
M$872 858 636 839 839 sky130_fd_pr__nfet_01v8 L=0.15U W=0.42U AS=0.1092P
+ AD=0.0441P PS=1.36U PD=0.63U
* device instance $873 r0 *1 27.49,46.685 sky130_fd_pr__nfet_01v8
M$873 96 302 858 858 sky130_fd_pr__nfet_01v8 L=0.15U W=0.42U AS=0.0441P
+ AD=0.1092P PS=0.63U PD=1.36U
* device instance $874 r0 *1 30.29,46.655 sky130_fd_pr__nfet_01v8
M$874 842 838 839 839 sky130_fd_pr__nfet_01v8 L=0.15U W=0.36U AS=0.1446P
+ AD=0.0522P PS=1.18U PD=0.65U
* device instance $875 r0 *1 30.73,46.655 sky130_fd_pr__nfet_01v8
M$875 860 871 842 842 sky130_fd_pr__nfet_01v8 L=0.15U W=0.36U AS=0.0522P
+ AD=0.0759P PS=0.65U PD=0.8U
* device instance $876 r0 *1 28.43,46.685 sky130_fd_pr__nfet_01v8
M$876 96 302 840 840 sky130_fd_pr__nfet_01v8 L=0.15U W=0.42U AS=0.1092P
+ AD=0.0609P PS=1.36U PD=0.71U
* device instance $877 r0 *1 28.87,46.685 sky130_fd_pr__nfet_01v8
M$877 859 840 96 96 sky130_fd_pr__nfet_01v8 L=0.15U W=0.42U AS=0.0609P
+ AD=0.0756P PS=0.71U PD=0.78U
* device instance $878 r0 *1 29.38,46.685 sky130_fd_pr__nfet_01v8
M$878 839 841 859 859 sky130_fd_pr__nfet_01v8 L=0.15U W=0.42U AS=0.0756P
+ AD=0.1446P PS=0.78U PD=1.18U
* device instance $879 r0 *1 31.26,46.685 sky130_fd_pr__nfet_01v8
M$879 96 843 860 860 sky130_fd_pr__nfet_01v8 L=0.15U W=0.42U AS=0.0759P
+ AD=0.12095P PS=0.8U PD=1.085U
* device instance $880 r0 *1 31.855,46.795 sky130_fd_pr__nfet_01v8
M$880 843 842 96 96 sky130_fd_pr__nfet_01v8 L=0.15U W=0.64U AS=0.12095P
+ AD=0.1664P PS=1.085U PD=1.8U
* device instance $881 r0 *1 33.28,46.655 sky130_fd_pr__nfet_01v8
M$881 844 871 861 861 sky130_fd_pr__nfet_01v8 L=0.15U W=0.36U AS=0.0678P
+ AD=0.0684P PS=0.755U PD=0.74U
* device instance $882 r0 *1 33.81,46.655 sky130_fd_pr__nfet_01v8
M$882 862 838 844 844 sky130_fd_pr__nfet_01v8 L=0.15U W=0.36U AS=0.0684P
+ AD=0.066P PS=0.74U PD=0.745U
* device instance $883 r0 *1 32.795,46.685 sky130_fd_pr__nfet_01v8
M$883 861 843 96 96 sky130_fd_pr__nfet_01v8 L=0.15U W=0.42U AS=0.1092P
+ AD=0.0678P PS=1.36U PD=0.755U
* device instance $884 r0 *1 34.285,46.685 sky130_fd_pr__nfet_01v8
M$884 96 841 862 862 sky130_fd_pr__nfet_01v8 L=0.15U W=0.42U AS=0.066P
+ AD=0.1092P PS=0.745U PD=1.36U
* device instance $885 r0 *1 33.59,45.795 sky130_fd_pr__nfet_01v8
M$885 96 682 765 765 sky130_fd_pr__nfet_01v8 L=0.15U W=0.42U AS=0.1092P
+ AD=0.0567P PS=1.36U PD=0.69U
* device instance $886 r0 *1 34.01,45.795 sky130_fd_pr__nfet_01v8
M$886 766 765 96 96 sky130_fd_pr__nfet_01v8 L=0.15U W=0.42U AS=0.0567P
+ AD=0.1092P PS=0.69U PD=1.36U
* device instance $887 r0 *1 34.95,45.795 sky130_fd_pr__nfet_01v8
M$887 829 796 767 767 sky130_fd_pr__nfet_01v8 L=0.15U W=0.42U AS=0.1092P
+ AD=0.0441P PS=1.36U PD=0.63U
* device instance $888 r0 *1 35.31,45.795 sky130_fd_pr__nfet_01v8
M$888 96 93 829 829 sky130_fd_pr__nfet_01v8 L=0.15U W=0.42U AS=0.0441P
+ AD=0.1092P PS=0.63U PD=1.36U
* device instance $889 r0 *1 35.225,46.685 sky130_fd_pr__nfet_01v8
M$889 96 844 841 841 sky130_fd_pr__nfet_01v8 L=0.15U W=0.42U AS=0.1092P
+ AD=0.10025P PS=1.36U PD=0.985U
* device instance $890 r0 *1 35.71,46.8 sky130_fd_pr__nfet_01v8
M$890 598 844 96 96 sky130_fd_pr__nfet_01v8 L=0.15U W=0.65U AS=0.10025P
+ AD=0.182P PS=0.985U PD=1.86U
* device instance $891 r0 *1 36.25,45.795 sky130_fd_pr__nfet_01v8
M$891 96 93 768 768 sky130_fd_pr__nfet_01v8 L=0.15U W=0.42U AS=0.1092P
+ AD=0.0609P PS=1.36U PD=0.71U
* device instance $892 r0 *1 36.69,45.795 sky130_fd_pr__nfet_01v8
M$892 831 768 96 96 sky130_fd_pr__nfet_01v8 L=0.15U W=0.42U AS=0.0609P
+ AD=0.0756P PS=0.71U PD=0.78U
* device instance $893 r0 *1 37.2,45.795 sky130_fd_pr__nfet_01v8
M$893 767 772 831 831 sky130_fd_pr__nfet_01v8 L=0.15U W=0.42U AS=0.0756P
+ AD=0.1446P PS=0.78U PD=1.18U
* device instance $894 r0 *1 38.11,45.825 sky130_fd_pr__nfet_01v8
M$894 769 765 767 767 sky130_fd_pr__nfet_01v8 L=0.15U W=0.36U AS=0.1446P
+ AD=0.0522P PS=1.18U PD=0.65U
* device instance $895 r0 *1 38.55,45.825 sky130_fd_pr__nfet_01v8
M$895 769 766 832 832 sky130_fd_pr__nfet_01v8 L=0.15U W=0.36U AS=0.0759P
+ AD=0.0522P PS=0.8U PD=0.65U
* device instance $896 r0 *1 39.08,45.795 sky130_fd_pr__nfet_01v8
M$896 832 770 96 96 sky130_fd_pr__nfet_01v8 L=0.15U W=0.42U AS=0.12095P
+ AD=0.0759P PS=1.085U PD=0.8U
* device instance $897 r0 *1 39.675,45.685 sky130_fd_pr__nfet_01v8
M$897 770 769 96 96 sky130_fd_pr__nfet_01v8 L=0.15U W=0.64U AS=0.12095P
+ AD=0.1664P PS=1.085U PD=1.8U
* device instance $898 r0 *1 40.615,45.795 sky130_fd_pr__nfet_01v8
M$898 830 770 96 96 sky130_fd_pr__nfet_01v8 L=0.15U W=0.42U AS=0.1092P
+ AD=0.0678P PS=1.36U PD=0.755U
* device instance $899 r0 *1 41.1,45.825 sky130_fd_pr__nfet_01v8
M$899 771 766 830 830 sky130_fd_pr__nfet_01v8 L=0.15U W=0.36U AS=0.0678P
+ AD=0.0684P PS=0.755U PD=0.74U
* device instance $900 r0 *1 41.63,45.825 sky130_fd_pr__nfet_01v8
M$900 771 765 828 828 sky130_fd_pr__nfet_01v8 L=0.15U W=0.36U AS=0.066P
+ AD=0.0684P PS=0.745U PD=0.74U
* device instance $901 r0 *1 42.105,45.795 sky130_fd_pr__nfet_01v8
M$901 96 772 828 828 sky130_fd_pr__nfet_01v8 L=0.15U W=0.42U AS=0.066P
+ AD=0.1092P PS=0.745U PD=1.36U
* device instance $902 r0 *1 40.98,46.685 sky130_fd_pr__nfet_01v8
M$902 96 777 845 845 sky130_fd_pr__nfet_01v8 L=0.15U W=0.42U AS=0.1113P
+ AD=0.0588P PS=1.37U PD=0.7U
* device instance $903 r0 *1 41.41,46.685 sky130_fd_pr__nfet_01v8
M$903 845 63 96 96 sky130_fd_pr__nfet_01v8 L=0.15U W=0.42U AS=0.0588P
+ AD=0.0588P PS=0.7U PD=0.7U
* device instance $904 r0 *1 41.84,46.685 sky130_fd_pr__nfet_01v8
M$904 796 846 845 845 sky130_fd_pr__nfet_01v8 L=0.15U W=0.42U AS=0.0588P
+ AD=0.1113P PS=0.7U PD=1.37U
* device instance $905 r0 *1 43.045,45.795 sky130_fd_pr__nfet_01v8
M$905 772 771 96 96 sky130_fd_pr__nfet_01v8 L=0.15U W=0.42U AS=0.10025P
+ AD=0.1092P PS=0.985U PD=1.36U
* device instance $906 r0 *1 43.53,45.68 sky130_fd_pr__nfet_01v8
M$906 729 771 96 96 sky130_fd_pr__nfet_01v8 L=0.15U W=0.65U AS=0.10025P
+ AD=0.182P PS=0.985U PD=1.86U
* device instance $907 r0 *1 44.63,45.68 sky130_fd_pr__nfet_01v8
M$907 96 797 773 773 sky130_fd_pr__nfet_01v8 L=0.15U W=0.65U AS=0.169P
+ AD=0.10725P PS=1.82U PD=0.98U
* device instance $908 r0 *1 45.11,45.68 sky130_fd_pr__nfet_01v8
M$908 827 729 96 96 sky130_fd_pr__nfet_01v8 L=0.15U W=0.65U AS=0.10725P
+ AD=0.06825P PS=0.98U PD=0.86U
* device instance $909 r0 *1 45.47,45.68 sky130_fd_pr__nfet_01v8
M$909 773 91 827 827 sky130_fd_pr__nfet_01v8 L=0.15U W=0.65U AS=0.06825P
+ AD=0.169P PS=0.86U PD=1.82U
* device instance $910 r0 *1 44.63,46.685 sky130_fd_pr__nfet_01v8
M$910 96 980 847 847 sky130_fd_pr__nfet_01v8 L=0.15U W=0.42U AS=0.1092P
+ AD=0.0567P PS=1.36U PD=0.69U
* device instance $911 r0 *1 45.05,46.685 sky130_fd_pr__nfet_01v8
M$911 872 847 96 96 sky130_fd_pr__nfet_01v8 L=0.15U W=0.42U AS=0.0567P
+ AD=0.1092P PS=0.69U PD=1.36U
* device instance $912 r0 *1 45.99,46.685 sky130_fd_pr__nfet_01v8
M$912 863 775 848 848 sky130_fd_pr__nfet_01v8 L=0.15U W=0.42U AS=0.1092P
+ AD=0.0441P PS=1.36U PD=0.63U
* device instance $913 r0 *1 46.35,46.685 sky130_fd_pr__nfet_01v8
M$913 96 302 863 863 sky130_fd_pr__nfet_01v8 L=0.15U W=0.42U AS=0.0441P
+ AD=0.1092P PS=0.63U PD=1.36U
* device instance $914 r0 *1 46.41,45.68 sky130_fd_pr__nfet_01v8
M$914 826 134 773 773 sky130_fd_pr__nfet_01v8 L=0.15U W=0.65U AS=0.169P
+ AD=0.10725P PS=1.82U PD=0.98U
* device instance $915 r0 *1 46.89,45.68 sky130_fd_pr__nfet_01v8
M$915 96 736 826 826 sky130_fd_pr__nfet_01v8 L=0.15U W=0.65U AS=0.10725P
+ AD=0.102375P PS=0.98U PD=0.965U
* device instance $916 r0 *1 47.355,45.68 sky130_fd_pr__nfet_01v8
M$916 775 773 96 96 sky130_fd_pr__nfet_01v8 L=0.15U W=0.65U AS=0.102375P
+ AD=0.169P PS=0.965U PD=1.82U
* device instance $917 r0 *1 49.15,46.655 sky130_fd_pr__nfet_01v8
M$917 851 847 848 848 sky130_fd_pr__nfet_01v8 L=0.15U W=0.36U AS=0.1446P
+ AD=0.0522P PS=1.18U PD=0.65U
* device instance $918 r0 *1 49.59,46.655 sky130_fd_pr__nfet_01v8
M$918 865 872 851 851 sky130_fd_pr__nfet_01v8 L=0.15U W=0.36U AS=0.0522P
+ AD=0.0759P PS=0.65U PD=0.8U
* device instance $919 r0 *1 47.29,46.685 sky130_fd_pr__nfet_01v8
M$919 96 302 849 849 sky130_fd_pr__nfet_01v8 L=0.15U W=0.42U AS=0.1092P
+ AD=0.0609P PS=1.36U PD=0.71U
* device instance $920 r0 *1 47.73,46.685 sky130_fd_pr__nfet_01v8
M$920 864 849 96 96 sky130_fd_pr__nfet_01v8 L=0.15U W=0.42U AS=0.0609P
+ AD=0.0756P PS=0.71U PD=0.78U
* device instance $921 r0 *1 48.24,46.685 sky130_fd_pr__nfet_01v8
M$921 848 850 864 864 sky130_fd_pr__nfet_01v8 L=0.15U W=0.42U AS=0.0756P
+ AD=0.1446P PS=0.78U PD=1.18U
* device instance $922 r0 *1 50.12,46.685 sky130_fd_pr__nfet_01v8
M$922 96 852 865 865 sky130_fd_pr__nfet_01v8 L=0.15U W=0.42U AS=0.0759P
+ AD=0.12095P PS=0.8U PD=1.085U
* device instance $923 r0 *1 50.715,46.795 sky130_fd_pr__nfet_01v8
M$923 852 851 96 96 sky130_fd_pr__nfet_01v8 L=0.15U W=0.64U AS=0.12095P
+ AD=0.1664P PS=1.085U PD=1.8U
* device instance $924 r0 *1 48.725,45.795 sky130_fd_pr__nfet_01v8
M$924 96 798 777 777 sky130_fd_pr__nfet_01v8 L=0.15U W=0.42U AS=0.1092P
+ AD=0.1197P PS=1.36U PD=1.41U
* device instance $925 r0 *1 49.69,45.68 sky130_fd_pr__nfet_01v8
M$925 663 777 96 96 sky130_fd_pr__nfet_01v8 L=0.15U W=0.65U AS=0.169P
+ AD=0.08775P PS=1.82U PD=0.92U
* device instance $926 r0 *1 50.11,45.68 sky130_fd_pr__nfet_01v8
M$926 96 729 663 663 sky130_fd_pr__nfet_01v8 L=0.15U W=0.65U AS=0.08775P
+ AD=0.169P PS=0.92U PD=1.82U
* device instance $927 r0 *1 51.305,45.795 sky130_fd_pr__nfet_01v8
M$927 799 729 96 96 sky130_fd_pr__nfet_01v8 L=0.15U W=0.42U AS=0.10025P
+ AD=0.1092P PS=0.985U PD=1.36U
* device instance $928 r0 *1 51.79,45.68 sky130_fd_pr__nfet_01v8
M$928 800 798 96 96 sky130_fd_pr__nfet_01v8 L=0.15U W=0.65U AS=0.10025P
+ AD=0.08775P PS=0.985U PD=0.92U
* device instance $929 r0 *1 52.21,45.68 sky130_fd_pr__nfet_01v8
M$929 96 799 800 800 sky130_fd_pr__nfet_01v8 L=0.15U W=0.65U AS=0.08775P
+ AD=0.169P PS=0.92U PD=1.82U
* device instance $930 r0 *1 52.14,46.655 sky130_fd_pr__nfet_01v8
M$930 853 872 866 866 sky130_fd_pr__nfet_01v8 L=0.15U W=0.36U AS=0.0678P
+ AD=0.0684P PS=0.755U PD=0.74U
* device instance $931 r0 *1 52.67,46.655 sky130_fd_pr__nfet_01v8
M$931 867 847 853 853 sky130_fd_pr__nfet_01v8 L=0.15U W=0.36U AS=0.0684P
+ AD=0.066P PS=0.74U PD=0.745U
* device instance $932 r0 *1 51.655,46.685 sky130_fd_pr__nfet_01v8
M$932 866 852 96 96 sky130_fd_pr__nfet_01v8 L=0.15U W=0.42U AS=0.1092P
+ AD=0.0678P PS=1.36U PD=0.755U
* device instance $933 r0 *1 53.145,46.685 sky130_fd_pr__nfet_01v8
M$933 96 850 867 867 sky130_fd_pr__nfet_01v8 L=0.15U W=0.42U AS=0.066P
+ AD=0.1092P PS=0.745U PD=1.36U
* device instance $934 r0 *1 54.085,46.685 sky130_fd_pr__nfet_01v8
M$934 96 853 850 850 sky130_fd_pr__nfet_01v8 L=0.15U W=0.42U AS=0.1092P
+ AD=0.10025P PS=1.36U PD=0.985U
* device instance $935 r0 *1 54.57,46.8 sky130_fd_pr__nfet_01v8
M$935 798 853 96 96 sky130_fd_pr__nfet_01v8 L=0.15U W=0.65U AS=0.10025P
+ AD=0.182P PS=0.985U PD=1.86U
* device instance $936 r0 *1 56.59,45.68 sky130_fd_pr__nfet_01v8
M$936 730 800 96 96 sky130_fd_pr__nfet_01v8 L=0.15U W=0.65U AS=0.169P
+ AD=0.08775P PS=1.82U PD=0.92U
* device instance $937 r0 *1 57.01,45.68 sky130_fd_pr__nfet_01v8
M$937 96 663 730 730 sky130_fd_pr__nfet_01v8 L=0.15U W=0.65U AS=0.08775P
+ AD=0.169P PS=0.92U PD=1.82U
* device instance $938 r0 *1 61.19,45.68 sky130_fd_pr__nfet_01v8
M$938 701 571 96 96 sky130_fd_pr__nfet_01v8 L=0.15U W=0.65U AS=0.169P
+ AD=0.08775P PS=1.82U PD=0.92U
* device instance $939 r0 *1 61.61,45.68 sky130_fd_pr__nfet_01v8
M$939 96 986 701 701 sky130_fd_pr__nfet_01v8 L=0.15U W=0.65U AS=0.08775P
+ AD=0.169P PS=0.92U PD=1.82U
* device instance $940 r0 *1 61.65,46.8 sky130_fd_pr__nfet_01v8
M$940 96 642 854 854 sky130_fd_pr__nfet_01v8 L=0.15U W=0.65U AS=0.169P
+ AD=0.08775P PS=1.82U PD=0.92U
* device instance $941 r0 *1 62.07,46.8 sky130_fd_pr__nfet_01v8
M$941 855 854 96 96 sky130_fd_pr__nfet_01v8 L=0.15U W=2.6U AS=0.351P
+ AD=0.43225P PS=3.68U PD=4.58U
* device instance $945 r0 *1 64.87,45.795 sky130_fd_pr__nfet_01v8
M$945 96 980 778 778 sky130_fd_pr__nfet_01v8 L=0.15U W=0.42U AS=0.1092P
+ AD=0.0567P PS=1.36U PD=0.69U
* device instance $946 r0 *1 65.29,45.795 sky130_fd_pr__nfet_01v8
M$946 779 778 96 96 sky130_fd_pr__nfet_01v8 L=0.15U W=0.42U AS=0.0567P
+ AD=0.1092P PS=0.69U PD=1.36U
* device instance $947 r0 *1 66.23,45.795 sky130_fd_pr__nfet_01v8
M$947 820 644 780 780 sky130_fd_pr__nfet_01v8 L=0.15U W=0.42U AS=0.1092P
+ AD=0.0441P PS=1.36U PD=0.63U
* device instance $948 r0 *1 66.59,45.795 sky130_fd_pr__nfet_01v8
M$948 96 409 820 820 sky130_fd_pr__nfet_01v8 L=0.15U W=0.42U AS=0.0441P
+ AD=0.1092P PS=0.63U PD=1.36U
* device instance $949 r0 *1 67.53,45.795 sky130_fd_pr__nfet_01v8
M$949 96 409 781 781 sky130_fd_pr__nfet_01v8 L=0.15U W=0.42U AS=0.1092P
+ AD=0.0609P PS=1.36U PD=0.71U
* device instance $950 r0 *1 67.97,45.795 sky130_fd_pr__nfet_01v8
M$950 818 781 96 96 sky130_fd_pr__nfet_01v8 L=0.15U W=0.42U AS=0.0609P
+ AD=0.0756P PS=0.71U PD=0.78U
* device instance $951 r0 *1 68.48,45.795 sky130_fd_pr__nfet_01v8
M$951 780 785 818 818 sky130_fd_pr__nfet_01v8 L=0.15U W=0.42U AS=0.0756P
+ AD=0.1446P PS=0.78U PD=1.18U
* device instance $952 r0 *1 69.39,45.825 sky130_fd_pr__nfet_01v8
M$952 782 778 780 780 sky130_fd_pr__nfet_01v8 L=0.15U W=0.36U AS=0.1446P
+ AD=0.0522P PS=1.18U PD=0.65U
* device instance $953 r0 *1 69.83,45.825 sky130_fd_pr__nfet_01v8
M$953 782 779 816 816 sky130_fd_pr__nfet_01v8 L=0.15U W=0.36U AS=0.0759P
+ AD=0.0522P PS=0.8U PD=0.65U
* device instance $954 r0 *1 70.36,45.795 sky130_fd_pr__nfet_01v8
M$954 816 783 96 96 sky130_fd_pr__nfet_01v8 L=0.15U W=0.42U AS=0.12095P
+ AD=0.0759P PS=1.085U PD=0.8U
* device instance $955 r0 *1 70.955,45.685 sky130_fd_pr__nfet_01v8
M$955 783 782 96 96 sky130_fd_pr__nfet_01v8 L=0.15U W=0.64U AS=0.12095P
+ AD=0.1664P PS=1.085U PD=1.8U
* device instance $956 r0 *1 71.895,45.795 sky130_fd_pr__nfet_01v8
M$956 815 783 96 96 sky130_fd_pr__nfet_01v8 L=0.15U W=0.42U AS=0.1092P
+ AD=0.0678P PS=1.36U PD=0.755U
* device instance $957 r0 *1 72.38,45.825 sky130_fd_pr__nfet_01v8
M$957 784 779 815 815 sky130_fd_pr__nfet_01v8 L=0.15U W=0.36U AS=0.0678P
+ AD=0.0684P PS=0.755U PD=0.74U
* device instance $958 r0 *1 72.91,45.825 sky130_fd_pr__nfet_01v8
M$958 784 778 814 814 sky130_fd_pr__nfet_01v8 L=0.15U W=0.36U AS=0.066P
+ AD=0.0684P PS=0.745U PD=0.74U
* device instance $959 r0 *1 73.385,45.795 sky130_fd_pr__nfet_01v8
M$959 96 785 814 814 sky130_fd_pr__nfet_01v8 L=0.15U W=0.42U AS=0.066P
+ AD=0.1092P PS=0.745U PD=1.36U
* device instance $960 r0 *1 74.325,45.795 sky130_fd_pr__nfet_01v8
M$960 785 784 96 96 sky130_fd_pr__nfet_01v8 L=0.15U W=0.42U AS=0.10025P
+ AD=0.1092P PS=0.985U PD=1.36U
* device instance $961 r0 *1 74.81,45.68 sky130_fd_pr__nfet_01v8
M$961 571 784 96 96 sky130_fd_pr__nfet_01v8 L=0.15U W=0.65U AS=0.10025P
+ AD=0.182P PS=0.985U PD=1.86U
* device instance $962 r0 *1 2.77,52.125 sky130_fd_pr__nfet_01v8
M$962 96 682 931 931 sky130_fd_pr__nfet_01v8 L=0.15U W=0.42U AS=0.1092P
+ AD=0.0567P PS=1.36U PD=0.69U
* device instance $963 r0 *1 3.19,52.125 sky130_fd_pr__nfet_01v8
M$963 932 931 96 96 sky130_fd_pr__nfet_01v8 L=0.15U W=0.42U AS=0.0567P
+ AD=0.1092P PS=0.69U PD=1.36U
* device instance $964 r0 *1 4.13,52.125 sky130_fd_pr__nfet_01v8
M$964 949 889 933 933 sky130_fd_pr__nfet_01v8 L=0.15U W=0.42U AS=0.1092P
+ AD=0.0441P PS=1.36U PD=0.63U
* device instance $965 r0 *1 4.49,52.125 sky130_fd_pr__nfet_01v8
M$965 96 93 949 949 sky130_fd_pr__nfet_01v8 L=0.15U W=0.42U AS=0.0441P
+ AD=0.1092P PS=0.63U PD=1.36U
* device instance $966 r0 *1 4.68,51.235 sky130_fd_pr__nfet_01v8
M$966 921 887 888 888 sky130_fd_pr__nfet_01v8 L=0.15U W=0.42U AS=0.1113P
+ AD=0.0441P PS=1.37U PD=0.63U
* device instance $967 r0 *1 5.04,51.235 sky130_fd_pr__nfet_01v8
M$967 96 114 921 921 sky130_fd_pr__nfet_01v8 L=0.15U W=0.42U AS=0.0441P
+ AD=0.0966P PS=0.63U PD=0.88U
* device instance $968 r0 *1 5.65,51.235 sky130_fd_pr__nfet_01v8
M$968 868 888 96 96 sky130_fd_pr__nfet_01v8 L=0.15U W=0.42U AS=0.0966P
+ AD=0.1113P PS=0.88U PD=1.37U
* device instance $969 r0 *1 7.29,52.095 sky130_fd_pr__nfet_01v8
M$969 936 931 933 933 sky130_fd_pr__nfet_01v8 L=0.15U W=0.36U AS=0.1446P
+ AD=0.0522P PS=1.18U PD=0.65U
* device instance $970 r0 *1 7.73,52.095 sky130_fd_pr__nfet_01v8
M$970 951 932 936 936 sky130_fd_pr__nfet_01v8 L=0.15U W=0.36U AS=0.0522P
+ AD=0.0759P PS=0.65U PD=0.8U
* device instance $971 r0 *1 5.43,52.125 sky130_fd_pr__nfet_01v8
M$971 96 93 934 934 sky130_fd_pr__nfet_01v8 L=0.15U W=0.42U AS=0.1092P
+ AD=0.0609P PS=1.36U PD=0.71U
* device instance $972 r0 *1 5.87,52.125 sky130_fd_pr__nfet_01v8
M$972 950 934 96 96 sky130_fd_pr__nfet_01v8 L=0.15U W=0.42U AS=0.0609P
+ AD=0.0756P PS=0.71U PD=0.78U
* device instance $973 r0 *1 6.38,52.125 sky130_fd_pr__nfet_01v8
M$973 933 935 950 950 sky130_fd_pr__nfet_01v8 L=0.15U W=0.42U AS=0.0756P
+ AD=0.1446P PS=0.78U PD=1.18U
* device instance $974 r0 *1 8.26,52.125 sky130_fd_pr__nfet_01v8
M$974 96 937 951 951 sky130_fd_pr__nfet_01v8 L=0.15U W=0.42U AS=0.0759P
+ AD=0.12095P PS=0.8U PD=1.085U
* device instance $975 r0 *1 8.855,52.235 sky130_fd_pr__nfet_01v8
M$975 937 936 96 96 sky130_fd_pr__nfet_01v8 L=0.15U W=0.64U AS=0.12095P
+ AD=0.1664P PS=1.085U PD=1.8U
* device instance $976 r0 *1 6.91,51.12 sky130_fd_pr__nfet_01v8
M$976 96 890 889 889 sky130_fd_pr__nfet_01v8 L=0.15U W=0.65U AS=0.169P
+ AD=0.11285P PS=1.82U PD=1.045U
* device instance $977 r0 *1 7.455,51.235 sky130_fd_pr__nfet_01v8
M$977 922 63 96 96 sky130_fd_pr__nfet_01v8 L=0.15U W=0.42U AS=0.11285P
+ AD=0.0693P PS=1.045U PD=0.75U
* device instance $978 r0 *1 7.935,51.235 sky130_fd_pr__nfet_01v8
M$978 890 916 922 922 sky130_fd_pr__nfet_01v8 L=0.15U W=0.42U AS=0.0693P
+ AD=0.09975P PS=0.75U PD=0.895U
* device instance $979 r0 *1 8.56,51.235 sky130_fd_pr__nfet_01v8
M$979 923 917 890 890 sky130_fd_pr__nfet_01v8 L=0.15U W=0.42U AS=0.09975P
+ AD=0.0693P PS=0.895U PD=0.75U
* device instance $980 r0 *1 9.04,51.235 sky130_fd_pr__nfet_01v8
M$980 96 918 923 923 sky130_fd_pr__nfet_01v8 L=0.15U W=0.42U AS=0.0693P
+ AD=0.1449P PS=0.75U PD=1.11U
* device instance $981 r0 *1 9.88,51.235 sky130_fd_pr__nfet_01v8
M$981 918 63 96 96 sky130_fd_pr__nfet_01v8 L=0.15U W=0.42U AS=0.1449P
+ AD=0.1092P PS=1.11U PD=1.36U
* device instance $982 r0 *1 10.28,52.095 sky130_fd_pr__nfet_01v8
M$982 938 932 952 952 sky130_fd_pr__nfet_01v8 L=0.15U W=0.36U AS=0.0678P
+ AD=0.0684P PS=0.755U PD=0.74U
* device instance $983 r0 *1 10.81,52.095 sky130_fd_pr__nfet_01v8
M$983 953 931 938 938 sky130_fd_pr__nfet_01v8 L=0.15U W=0.36U AS=0.0684P
+ AD=0.066P PS=0.74U PD=0.745U
* device instance $984 r0 *1 9.795,52.125 sky130_fd_pr__nfet_01v8
M$984 952 937 96 96 sky130_fd_pr__nfet_01v8 L=0.15U W=0.42U AS=0.1092P
+ AD=0.0678P PS=1.36U PD=0.755U
* device instance $985 r0 *1 11.285,52.125 sky130_fd_pr__nfet_01v8
M$985 96 935 953 953 sky130_fd_pr__nfet_01v8 L=0.15U W=0.42U AS=0.066P
+ AD=0.1092P PS=0.745U PD=1.36U
* device instance $986 r0 *1 11.09,51.12 sky130_fd_pr__nfet_01v8
M$986 891 834 96 96 sky130_fd_pr__nfet_01v8 L=0.15U W=0.65U AS=0.169P
+ AD=0.08775P PS=1.82U PD=0.92U
* device instance $987 r0 *1 11.51,51.12 sky130_fd_pr__nfet_01v8
M$987 96 917 891 891 sky130_fd_pr__nfet_01v8 L=0.15U W=0.65U AS=0.08775P
+ AD=0.08775P PS=0.92U PD=0.92U
* device instance $988 r0 *1 11.93,51.12 sky130_fd_pr__nfet_01v8
M$988 925 917 96 96 sky130_fd_pr__nfet_01v8 L=0.15U W=0.65U AS=0.08775P
+ AD=0.08775P PS=0.92U PD=0.92U
* device instance $989 r0 *1 12.35,51.12 sky130_fd_pr__nfet_01v8
M$989 869 834 925 925 sky130_fd_pr__nfet_01v8 L=0.15U W=0.65U AS=0.08775P
+ AD=0.25025P PS=0.92U PD=1.42U
* device instance $990 r0 *1 13.27,51.12 sky130_fd_pr__nfet_01v8
M$990 96 891 869 869 sky130_fd_pr__nfet_01v8 L=0.15U W=0.65U AS=0.25025P
+ AD=0.208P PS=1.42U PD=1.94U
* device instance $991 r0 *1 12.225,52.125 sky130_fd_pr__nfet_01v8
M$991 96 938 935 935 sky130_fd_pr__nfet_01v8 L=0.15U W=0.42U AS=0.1092P
+ AD=0.10025P PS=1.36U PD=0.985U
* device instance $992 r0 *1 12.71,52.24 sky130_fd_pr__nfet_01v8
M$992 837 938 96 96 sky130_fd_pr__nfet_01v8 L=0.15U W=0.65U AS=0.10025P
+ AD=0.182P PS=0.985U PD=1.86U
* device instance $993 r0 *1 13.81,52.24 sky130_fd_pr__nfet_01v8
M$993 96 870 939 939 sky130_fd_pr__nfet_01v8 L=0.15U W=0.65U AS=0.169P
+ AD=0.08775P PS=1.82U PD=0.92U
* device instance $994 r0 *1 14.23,52.24 sky130_fd_pr__nfet_01v8
M$994 917 939 96 96 sky130_fd_pr__nfet_01v8 L=0.15U W=2.6U AS=0.351P
+ AD=0.43225P PS=3.68U PD=4.58U
* device instance $998 r0 *1 17.03,52.24 sky130_fd_pr__nfet_01v8
M$998 96 837 940 940 sky130_fd_pr__nfet_01v8 L=0.15U W=0.65U AS=0.169P
+ AD=0.08775P PS=1.82U PD=0.92U
* device instance $999 r0 *1 17.45,52.24 sky130_fd_pr__nfet_01v8
M$999 834 940 96 96 sky130_fd_pr__nfet_01v8 L=0.15U W=2.6U AS=0.351P
+ AD=0.43225P PS=3.68U PD=4.58U
* device instance $1003 r0 *1 21.19,51.12 sky130_fd_pr__nfet_01v8
M$1003 919 834 96 96 sky130_fd_pr__nfet_01v8 L=0.15U W=2.6U AS=0.44525P
+ AD=0.351P PS=4.62U PD=3.68U
* device instance $1007 r0 *1 22.87,51.12 sky130_fd_pr__nfet_01v8
M$1007 919 894 96 96 sky130_fd_pr__nfet_01v8 L=0.15U W=2.6U AS=0.351P AD=0.52P
+ PS=3.68U PD=4.2U
* device instance $1011 r0 *1 25.07,51.12 sky130_fd_pr__nfet_01v8
M$1011 919 897 96 96 sky130_fd_pr__nfet_01v8 L=0.15U W=2.6U AS=0.52P AD=0.351P
+ PS=4.2U PD=3.68U
* device instance $1015 r0 *1 26.75,51.12 sky130_fd_pr__nfet_01v8
M$1015 919 362 96 96 sky130_fd_pr__nfet_01v8 L=0.15U W=2.6U AS=0.351P
+ AD=0.43225P PS=3.68U PD=4.58U
* device instance $1019 r0 *1 23.935,52.125 sky130_fd_pr__nfet_01v8
M$1019 941 297 96 96 sky130_fd_pr__nfet_01v8 L=0.15U W=1.68U AS=0.2877P
+ AD=0.2352P PS=3.47U PD=2.8U
* device instance $1023 r0 *1 25.655,52.125 sky130_fd_pr__nfet_01v8
M$1023 682 941 96 96 sky130_fd_pr__nfet_01v8 L=0.15U W=6.72U AS=0.93975P
+ AD=0.99225P PS=11.195U PD=11.865U
* device instance $1039 r0 *1 43.32,51.235 sky130_fd_pr__nfet_01v8
M$1039 930 898 899 899 sky130_fd_pr__nfet_01v8 L=0.15U W=0.42U AS=0.1113P
+ AD=0.0441P PS=1.37U PD=0.63U
* device instance $1040 r0 *1 43.68,51.235 sky130_fd_pr__nfet_01v8
M$1040 96 114 930 930 sky130_fd_pr__nfet_01v8 L=0.15U W=0.42U AS=0.0441P
+ AD=0.0966P PS=0.63U PD=0.88U
* device instance $1041 r0 *1 44.29,51.235 sky130_fd_pr__nfet_01v8
M$1041 797 899 96 96 sky130_fd_pr__nfet_01v8 L=0.15U W=0.42U AS=0.0966P
+ AD=0.1113P PS=0.88U PD=1.37U
* device instance $1042 r0 *1 56.13,52.24 sky130_fd_pr__nfet_01v8
M$1042 96 942 943 943 sky130_fd_pr__nfet_01v8 L=0.15U W=0.65U AS=0.169P
+ AD=0.08775P PS=1.82U PD=0.92U
* device instance $1043 r0 *1 56.55,52.24 sky130_fd_pr__nfet_01v8
M$1043 943 800 96 96 sky130_fd_pr__nfet_01v8 L=0.15U W=0.65U AS=0.08775P
+ AD=0.08775P PS=0.92U PD=0.92U
* device instance $1044 r0 *1 56.97,52.24 sky130_fd_pr__nfet_01v8
M$1044 96 981 943 943 sky130_fd_pr__nfet_01v8 L=0.15U W=0.65U AS=0.08775P
+ AD=0.26P PS=0.92U PD=1.45U
* device instance $1045 r0 *1 57.92,52.24 sky130_fd_pr__nfet_01v8
M$1045 944 943 96 96 sky130_fd_pr__nfet_01v8 L=0.15U W=2.6U AS=0.52325P
+ AD=0.468P PS=4.21U PD=4.69U
* device instance $1049 r0 *1 60.27,52.24 sky130_fd_pr__nfet_01v8
M$1049 96 855 945 945 sky130_fd_pr__nfet_01v8 L=0.15U W=0.65U AS=0.169P
+ AD=0.08775P PS=1.82U PD=0.92U
* device instance $1050 r0 *1 60.69,52.24 sky130_fd_pr__nfet_01v8
M$1050 942 945 96 96 sky130_fd_pr__nfet_01v8 L=0.15U W=2.6U AS=0.351P
+ AD=0.43225P PS=3.68U PD=4.58U
* device instance $1054 r0 *1 64.87,51.235 sky130_fd_pr__nfet_01v8
M$1054 96 980 900 900 sky130_fd_pr__nfet_01v8 L=0.15U W=0.42U AS=0.1092P
+ AD=0.0567P PS=1.36U PD=0.69U
* device instance $1055 r0 *1 65.29,51.235 sky130_fd_pr__nfet_01v8
M$1055 901 900 96 96 sky130_fd_pr__nfet_01v8 L=0.15U W=0.42U AS=0.0567P
+ AD=0.1092P PS=0.69U PD=1.36U
* device instance $1056 r0 *1 66.23,51.235 sky130_fd_pr__nfet_01v8
M$1056 929 903 902 902 sky130_fd_pr__nfet_01v8 L=0.15U W=0.42U AS=0.1092P
+ AD=0.0441P PS=1.36U PD=0.63U
* device instance $1057 r0 *1 66.59,51.235 sky130_fd_pr__nfet_01v8
M$1057 96 409 929 929 sky130_fd_pr__nfet_01v8 L=0.15U W=0.42U AS=0.0441P
+ AD=0.1092P PS=0.63U PD=1.36U
* device instance $1058 r0 *1 67.53,51.235 sky130_fd_pr__nfet_01v8
M$1058 96 409 904 904 sky130_fd_pr__nfet_01v8 L=0.15U W=0.42U AS=0.1092P
+ AD=0.0609P PS=1.36U PD=0.71U
* device instance $1059 r0 *1 67.97,51.235 sky130_fd_pr__nfet_01v8
M$1059 928 904 96 96 sky130_fd_pr__nfet_01v8 L=0.15U W=0.42U AS=0.0609P
+ AD=0.0756P PS=0.71U PD=0.78U
* device instance $1060 r0 *1 68.48,51.235 sky130_fd_pr__nfet_01v8
M$1060 902 908 928 928 sky130_fd_pr__nfet_01v8 L=0.15U W=0.42U AS=0.0756P
+ AD=0.1446P PS=0.78U PD=1.18U
* device instance $1061 r0 *1 69.39,51.265 sky130_fd_pr__nfet_01v8
M$1061 905 900 902 902 sky130_fd_pr__nfet_01v8 L=0.15U W=0.36U AS=0.1446P
+ AD=0.0522P PS=1.18U PD=0.65U
* device instance $1062 r0 *1 69.83,51.265 sky130_fd_pr__nfet_01v8
M$1062 905 901 927 927 sky130_fd_pr__nfet_01v8 L=0.15U W=0.36U AS=0.0759P
+ AD=0.0522P PS=0.8U PD=0.65U
* device instance $1063 r0 *1 70.36,51.235 sky130_fd_pr__nfet_01v8
M$1063 927 906 96 96 sky130_fd_pr__nfet_01v8 L=0.15U W=0.42U AS=0.12095P
+ AD=0.0759P PS=1.085U PD=0.8U
* device instance $1064 r0 *1 70.955,51.125 sky130_fd_pr__nfet_01v8
M$1064 906 905 96 96 sky130_fd_pr__nfet_01v8 L=0.15U W=0.64U AS=0.12095P
+ AD=0.1664P PS=1.085U PD=1.8U
* device instance $1065 r0 *1 68.175,52.125 sky130_fd_pr__nfet_01v8
M$1065 955 63 96 96 sky130_fd_pr__nfet_01v8 L=0.15U W=0.42U AS=0.11285P
+ AD=0.0693P PS=1.045U PD=0.75U
* device instance $1066 r0 *1 68.655,52.125 sky130_fd_pr__nfet_01v8
M$1066 946 947 955 955 sky130_fd_pr__nfet_01v8 L=0.15U W=0.42U AS=0.0693P
+ AD=0.09975P PS=0.75U PD=0.895U
* device instance $1067 r0 *1 69.28,52.125 sky130_fd_pr__nfet_01v8
M$1067 954 956 946 946 sky130_fd_pr__nfet_01v8 L=0.15U W=0.42U AS=0.09975P
+ AD=0.0693P PS=0.895U PD=0.75U
* device instance $1068 r0 *1 69.76,52.125 sky130_fd_pr__nfet_01v8
M$1068 96 948 954 954 sky130_fd_pr__nfet_01v8 L=0.15U W=0.42U AS=0.0693P
+ AD=0.1449P PS=0.75U PD=1.11U
* device instance $1069 r0 *1 70.6,52.125 sky130_fd_pr__nfet_01v8
M$1069 948 63 96 96 sky130_fd_pr__nfet_01v8 L=0.15U W=0.42U AS=0.1449P
+ AD=0.1092P PS=1.11U PD=1.36U
* device instance $1070 r0 *1 67.63,52.24 sky130_fd_pr__nfet_01v8
M$1070 96 946 903 903 sky130_fd_pr__nfet_01v8 L=0.15U W=0.65U AS=0.169P
+ AD=0.11285P PS=1.82U PD=1.045U
* device instance $1071 r0 *1 71.895,51.235 sky130_fd_pr__nfet_01v8
M$1071 926 906 96 96 sky130_fd_pr__nfet_01v8 L=0.15U W=0.42U AS=0.1092P
+ AD=0.0678P PS=1.36U PD=0.755U
* device instance $1072 r0 *1 72.38,51.265 sky130_fd_pr__nfet_01v8
M$1072 907 901 926 926 sky130_fd_pr__nfet_01v8 L=0.15U W=0.36U AS=0.0678P
+ AD=0.0684P PS=0.755U PD=0.74U
* device instance $1073 r0 *1 72.91,51.265 sky130_fd_pr__nfet_01v8
M$1073 907 900 924 924 sky130_fd_pr__nfet_01v8 L=0.15U W=0.36U AS=0.066P
+ AD=0.0684P PS=0.745U PD=0.74U
* device instance $1074 r0 *1 73.385,51.235 sky130_fd_pr__nfet_01v8
M$1074 96 908 924 924 sky130_fd_pr__nfet_01v8 L=0.15U W=0.42U AS=0.066P
+ AD=0.1092P PS=0.745U PD=1.36U
* device instance $1075 r0 *1 74.325,51.235 sky130_fd_pr__nfet_01v8
M$1075 908 907 96 96 sky130_fd_pr__nfet_01v8 L=0.15U W=0.42U AS=0.10025P
+ AD=0.1092P PS=0.985U PD=1.36U
* device instance $1076 r0 *1 74.81,51.12 sky130_fd_pr__nfet_01v8
M$1076 986 907 96 96 sky130_fd_pr__nfet_01v8 L=0.15U W=0.65U AS=0.10025P
+ AD=0.182P PS=0.985U PD=1.86U
* device instance $1077 r0 *1 9.21,56.675 sky130_fd_pr__nfet_01v8
M$1077 96 682 966 966 sky130_fd_pr__nfet_01v8 L=0.15U W=0.42U AS=0.1092P
+ AD=0.0567P PS=1.36U PD=0.69U
* device instance $1078 r0 *1 9.63,56.675 sky130_fd_pr__nfet_01v8
M$1078 967 966 96 96 sky130_fd_pr__nfet_01v8 L=0.15U W=0.42U AS=0.0567P
+ AD=0.1092P PS=0.69U PD=1.36U
* device instance $1079 r0 *1 10.57,56.675 sky130_fd_pr__nfet_01v8
M$1079 1005 874 968 968 sky130_fd_pr__nfet_01v8 L=0.15U W=0.42U AS=0.1092P
+ AD=0.0441P PS=1.36U PD=0.63U
* device instance $1080 r0 *1 10.93,56.675 sky130_fd_pr__nfet_01v8
M$1080 96 302 1005 1005 sky130_fd_pr__nfet_01v8 L=0.15U W=0.42U AS=0.0441P
+ AD=0.1092P PS=0.63U PD=1.36U
* device instance $1081 r0 *1 11.87,56.675 sky130_fd_pr__nfet_01v8
M$1081 96 302 969 969 sky130_fd_pr__nfet_01v8 L=0.15U W=0.42U AS=0.1092P
+ AD=0.0609P PS=1.36U PD=0.71U
* device instance $1082 r0 *1 12.31,56.675 sky130_fd_pr__nfet_01v8
M$1082 1006 969 96 96 sky130_fd_pr__nfet_01v8 L=0.15U W=0.42U AS=0.0609P
+ AD=0.0756P PS=0.71U PD=0.78U
* device instance $1083 r0 *1 12.82,56.675 sky130_fd_pr__nfet_01v8
M$1083 968 973 1006 1006 sky130_fd_pr__nfet_01v8 L=0.15U W=0.42U AS=0.0756P
+ AD=0.1446P PS=0.78U PD=1.18U
* device instance $1084 r0 *1 13.73,56.705 sky130_fd_pr__nfet_01v8
M$1084 970 966 968 968 sky130_fd_pr__nfet_01v8 L=0.15U W=0.36U AS=0.1446P
+ AD=0.0522P PS=1.18U PD=0.65U
* device instance $1085 r0 *1 14.17,56.705 sky130_fd_pr__nfet_01v8
M$1085 970 967 1007 1007 sky130_fd_pr__nfet_01v8 L=0.15U W=0.36U AS=0.0759P
+ AD=0.0522P PS=0.8U PD=0.65U
* device instance $1086 r0 *1 14.7,56.675 sky130_fd_pr__nfet_01v8
M$1086 1007 971 96 96 sky130_fd_pr__nfet_01v8 L=0.15U W=0.42U AS=0.12095P
+ AD=0.0759P PS=1.085U PD=0.8U
* device instance $1087 r0 *1 15.295,56.565 sky130_fd_pr__nfet_01v8
M$1087 971 970 96 96 sky130_fd_pr__nfet_01v8 L=0.15U W=0.64U AS=0.12095P
+ AD=0.1664P PS=1.085U PD=1.8U
* device instance $1088 r0 *1 16.235,56.675 sky130_fd_pr__nfet_01v8
M$1088 1009 971 96 96 sky130_fd_pr__nfet_01v8 L=0.15U W=0.42U AS=0.1092P
+ AD=0.0678P PS=1.36U PD=0.755U
* device instance $1089 r0 *1 16.72,56.705 sky130_fd_pr__nfet_01v8
M$1089 972 967 1009 1009 sky130_fd_pr__nfet_01v8 L=0.15U W=0.36U AS=0.0678P
+ AD=0.0684P PS=0.755U PD=0.74U
* device instance $1090 r0 *1 17.25,56.705 sky130_fd_pr__nfet_01v8
M$1090 972 966 1010 1010 sky130_fd_pr__nfet_01v8 L=0.15U W=0.36U AS=0.066P
+ AD=0.0684P PS=0.745U PD=0.74U
* device instance $1091 r0 *1 17.725,56.675 sky130_fd_pr__nfet_01v8
M$1091 96 973 1010 1010 sky130_fd_pr__nfet_01v8 L=0.15U W=0.42U AS=0.066P
+ AD=0.1092P PS=0.745U PD=1.36U
* device instance $1092 r0 *1 18.665,56.675 sky130_fd_pr__nfet_01v8
M$1092 973 972 96 96 sky130_fd_pr__nfet_01v8 L=0.15U W=0.42U AS=0.10025P
+ AD=0.1092P PS=0.985U PD=1.36U
* device instance $1093 r0 *1 19.15,56.56 sky130_fd_pr__nfet_01v8
M$1093 870 972 96 96 sky130_fd_pr__nfet_01v8 L=0.15U W=0.65U AS=0.10025P
+ AD=0.182P PS=0.985U PD=1.86U
* device instance $1094 r0 *1 28.305,56.675 sky130_fd_pr__nfet_01v8
M$1094 974 894 96 96 sky130_fd_pr__nfet_01v8 L=0.15U W=0.42U AS=0.10025P
+ AD=0.1092P PS=0.985U PD=1.36U
* device instance $1095 r0 *1 28.79,56.56 sky130_fd_pr__nfet_01v8
M$1095 977 994 96 96 sky130_fd_pr__nfet_01v8 L=0.15U W=0.65U AS=0.10025P
+ AD=0.08775P PS=0.985U PD=0.92U
* device instance $1096 r0 *1 29.21,56.56 sky130_fd_pr__nfet_01v8
M$1096 96 974 977 977 sky130_fd_pr__nfet_01v8 L=0.15U W=0.65U AS=0.08775P
+ AD=0.169P PS=0.92U PD=1.82U
* device instance $1097 r0 *1 30.85,56.56 sky130_fd_pr__nfet_01v8
M$1097 1000 995 96 96 sky130_fd_pr__nfet_01v8 L=0.15U W=2.6U AS=0.44525P
+ AD=0.351P PS=4.62U PD=3.68U
* device instance $1101 r0 *1 32.53,56.56 sky130_fd_pr__nfet_01v8
M$1101 1000 114 96 96 sky130_fd_pr__nfet_01v8 L=0.15U W=2.6U AS=0.351P
+ AD=0.43225P PS=3.68U PD=4.58U
* device instance $1104 r0 *1 33.79,56.56 sky130_fd_pr__nfet_01v8
M$1104 96 977 1000 1000 sky130_fd_pr__nfet_01v8 L=0.15U W=2.6U AS=0.351P
+ AD=0.351P PS=3.68U PD=3.68U
* device instance $1109 r0 *1 43.26,56.675 sky130_fd_pr__nfet_01v8
M$1109 978 980 96 96 sky130_fd_pr__nfet_01v8 L=0.15U W=0.84U AS=0.1701P
+ AD=0.168P PS=2.07U PD=2.06U
* device instance $1111 r0 *1 44.635,56.675 sky130_fd_pr__nfet_01v8
M$1111 979 297 96 96 sky130_fd_pr__nfet_01v8 L=0.15U W=1.68U AS=0.2877P
+ AD=0.2352P PS=3.47U PD=2.8U
* device instance $1115 r0 *1 46.355,56.675 sky130_fd_pr__nfet_01v8
M$1115 980 979 96 96 sky130_fd_pr__nfet_01v8 L=0.15U W=6.72U AS=0.93975P
+ AD=0.99225P PS=11.195U PD=11.865U
* device instance $1131 r0 *1 59.38,56.675 sky130_fd_pr__nfet_01v8
M$1131 96 800 1001 1001 sky130_fd_pr__nfet_01v8 L=0.15U W=0.42U AS=0.1113P
+ AD=0.0588P PS=1.37U PD=0.7U
* device instance $1132 r0 *1 59.81,56.675 sky130_fd_pr__nfet_01v8
M$1132 1001 942 96 96 sky130_fd_pr__nfet_01v8 L=0.15U W=0.42U AS=0.0588P
+ AD=0.0588P PS=0.7U PD=0.7U
* device instance $1133 r0 *1 60.24,56.675 sky130_fd_pr__nfet_01v8
M$1133 996 981 1001 1001 sky130_fd_pr__nfet_01v8 L=0.15U W=0.42U AS=0.0588P
+ AD=0.1113P PS=0.7U PD=1.37U
* device instance $1134 r0 *1 62.115,56.56 sky130_fd_pr__nfet_01v8
M$1134 1008 944 982 982 sky130_fd_pr__nfet_01v8 L=0.15U W=0.65U AS=0.17225P
+ AD=0.06825P PS=1.83U PD=0.86U
* device instance $1135 r0 *1 62.475,56.56 sky130_fd_pr__nfet_01v8
M$1135 96 996 1008 1008 sky130_fd_pr__nfet_01v8 L=0.15U W=0.65U AS=0.06825P
+ AD=0.138125P PS=0.86U PD=1.075U
* device instance $1136 r0 *1 63.05,56.56 sky130_fd_pr__nfet_01v8
M$1136 997 982 96 96 sky130_fd_pr__nfet_01v8 L=0.15U W=2.6U AS=0.411125P
+ AD=0.45825P PS=3.865U PD=4.66U
* device instance $1140 r0 *1 65.745,56.675 sky130_fd_pr__nfet_01v8
M$1140 96 987 981 981 sky130_fd_pr__nfet_01v8 L=0.15U W=0.42U AS=0.1092P
+ AD=0.1197P PS=1.36U PD=1.41U
* device instance $1141 r0 *1 66.71,56.445 sky130_fd_pr__nfet_01v8
M$1141 96 986 983 983 sky130_fd_pr__nfet_01v8 L=0.15U W=0.42U AS=0.1092P
+ AD=0.10025P PS=1.36U PD=0.985U
* device instance $1142 r0 *1 67.195,56.56 sky130_fd_pr__nfet_01v8
M$1142 1004 956 96 96 sky130_fd_pr__nfet_01v8 L=0.15U W=0.65U AS=0.10025P
+ AD=0.08775P PS=0.985U PD=0.92U
* device instance $1143 r0 *1 67.615,56.56 sky130_fd_pr__nfet_01v8
M$1143 984 983 1004 1004 sky130_fd_pr__nfet_01v8 L=0.15U W=0.65U AS=0.08775P
+ AD=0.169P PS=0.92U PD=1.82U
* device instance $1144 r0 *1 69.11,56.56 sky130_fd_pr__nfet_01v8
M$1144 1003 956 985 985 sky130_fd_pr__nfet_01v8 L=0.15U W=0.65U AS=0.169P
+ AD=0.06825P PS=1.82U PD=0.86U
* device instance $1145 r0 *1 69.47,56.56 sky130_fd_pr__nfet_01v8
M$1145 96 986 1003 1003 sky130_fd_pr__nfet_01v8 L=0.15U W=0.65U AS=0.06825P
+ AD=0.08775P PS=0.86U PD=0.92U
* device instance $1146 r0 *1 69.89,56.56 sky130_fd_pr__nfet_01v8
M$1146 1002 986 96 96 sky130_fd_pr__nfet_01v8 L=0.15U W=0.65U AS=0.08775P
+ AD=0.169P PS=0.92U PD=1.82U
* device instance $1147 r0 *1 70.83,56.56 sky130_fd_pr__nfet_01v8
M$1147 1002 956 96 96 sky130_fd_pr__nfet_01v8 L=0.15U W=0.65U AS=0.169P
+ AD=0.08775P PS=1.82U PD=0.92U
* device instance $1148 r0 *1 71.25,56.56 sky130_fd_pr__nfet_01v8
M$1148 987 985 1002 1002 sky130_fd_pr__nfet_01v8 L=0.15U W=0.65U AS=0.08775P
+ AD=0.195P PS=0.92U PD=1.9U
* device instance $1149 r0 *1 15.665,62 sky130_fd_pr__nfet_01v8
M$1149 96 1047 1048 1048 sky130_fd_pr__nfet_01v8 L=0.15U W=0.65U AS=0.169P
+ AD=0.105625P PS=1.82U PD=0.975U
* device instance $1150 r0 *1 16.14,62 sky130_fd_pr__nfet_01v8
M$1150 63 1048 96 96 sky130_fd_pr__nfet_01v8 L=0.15U W=2.6U AS=0.37375P
+ AD=0.453375P PS=3.75U PD=4.645U
* device instance $1154 r0 *1 20.73,62 sky130_fd_pr__nfet_01v8
M$1154 1050 1102 96 96 sky130_fd_pr__nfet_01v8 L=0.15U W=2.6U AS=0.44525P
+ AD=0.351P PS=4.62U PD=3.68U
* device instance $1158 r0 *1 22.41,62 sky130_fd_pr__nfet_01v8
M$1158 1050 1011 96 96 sky130_fd_pr__nfet_01v8 L=0.15U W=2.6U AS=0.351P
+ AD=0.43225P PS=3.68U PD=4.58U
* device instance $1162 r0 *1 24.85,62 sky130_fd_pr__nfet_01v8
M$1162 96 1050 1051 1051 sky130_fd_pr__nfet_01v8 L=0.15U W=1.95U AS=0.3445P
+ AD=0.26325P PS=3.66U PD=2.76U
* device instance $1165 r0 *1 26.11,62 sky130_fd_pr__nfet_01v8
M$1165 93 1051 96 96 sky130_fd_pr__nfet_01v8 L=0.15U W=5.2U AS=0.702P
+ AD=0.78325P PS=7.36U PD=8.26U
* device instance $1173 r0 *1 24.87,57.68 sky130_fd_pr__nfet_01v8
M$1173 1011 63 96 96 sky130_fd_pr__nfet_01v8 L=0.15U W=1.3U AS=0.2665P
+ AD=0.1755P PS=2.77U PD=1.84U
* device instance $1175 r0 *1 25.71,57.68 sky130_fd_pr__nfet_01v8
M$1175 1011 977 96 96 sky130_fd_pr__nfet_01v8 L=0.15U W=1.3U AS=0.1755P
+ AD=0.25675P PS=1.84U PD=2.74U
* device instance $1177 r0 *1 27.09,57.68 sky130_fd_pr__nfet_01v8
M$1177 1011 1016 96 96 sky130_fd_pr__nfet_01v8 L=0.15U W=1.3U AS=0.25675P
+ AD=0.25675P PS=2.74U PD=2.74U
* device instance $1179 r0 *1 28.65,57.68 sky130_fd_pr__nfet_01v8
M$1179 96 114 1013 1013 sky130_fd_pr__nfet_01v8 L=0.15U W=0.65U AS=0.19825P
+ AD=0.08775P PS=1.91U PD=0.92U
* device instance $1180 r0 *1 29.07,57.68 sky130_fd_pr__nfet_01v8
M$1180 91 1012 96 96 sky130_fd_pr__nfet_01v8 L=0.15U W=2.6U AS=0.351P
+ AD=0.43225P PS=3.68U PD=4.58U
* device instance $1184 r0 *1 31.27,57.68 sky130_fd_pr__nfet_01v8
M$1184 1012 1013 1014 1014 sky130_fd_pr__nfet_01v8 L=0.15U W=1.3U AS=0.25675P
+ AD=0.1755P PS=2.74U PD=1.84U
* device instance $1186 r0 *1 32.11,57.68 sky130_fd_pr__nfet_01v8
M$1186 96 1016 1014 1014 sky130_fd_pr__nfet_01v8 L=0.15U W=1.3U AS=0.1755P
+ AD=0.1755P PS=1.84U PD=1.84U
* device instance $1188 r0 *1 32.95,57.68 sky130_fd_pr__nfet_01v8
M$1188 96 977 1014 1014 sky130_fd_pr__nfet_01v8 L=0.15U W=1.3U AS=0.1755P
+ AD=0.26975P PS=1.84U PD=2.78U
* device instance $1190 r0 *1 32.21,62 sky130_fd_pr__nfet_01v8
M$1190 1052 977 96 96 sky130_fd_pr__nfet_01v8 L=0.15U W=0.65U AS=0.169P
+ AD=0.08775P PS=1.82U PD=0.92U
* device instance $1191 r0 *1 32.63,62 sky130_fd_pr__nfet_01v8
M$1191 96 1075 1052 1052 sky130_fd_pr__nfet_01v8 L=0.15U W=0.65U AS=0.08775P
+ AD=0.169P PS=0.92U PD=1.82U
* device instance $1192 r0 *1 33.825,62.115 sky130_fd_pr__nfet_01v8
M$1192 1053 994 96 96 sky130_fd_pr__nfet_01v8 L=0.15U W=0.42U AS=0.10025P
+ AD=0.1092P PS=0.985U PD=1.36U
* device instance $1193 r0 *1 34.31,62 sky130_fd_pr__nfet_01v8
M$1193 1075 894 96 96 sky130_fd_pr__nfet_01v8 L=0.15U W=0.65U AS=0.10025P
+ AD=0.08775P PS=0.985U PD=0.92U
* device instance $1194 r0 *1 34.73,62 sky130_fd_pr__nfet_01v8
M$1194 96 1053 1075 1075 sky130_fd_pr__nfet_01v8 L=0.15U W=0.65U AS=0.08775P
+ AD=0.169P PS=0.92U PD=1.82U
* device instance $1195 r0 *1 34.97,57.68 sky130_fd_pr__nfet_01v8
M$1195 96 995 1015 1015 sky130_fd_pr__nfet_01v8 L=0.15U W=0.65U AS=0.169P
+ AD=0.08775P PS=1.82U PD=0.92U
* device instance $1196 r0 *1 35.39,57.68 sky130_fd_pr__nfet_01v8
M$1196 1016 1015 96 96 sky130_fd_pr__nfet_01v8 L=0.15U W=2.6U AS=0.351P
+ AD=0.43225P PS=3.68U PD=4.58U
* device instance $1200 r0 *1 37.99,57.68 sky130_fd_pr__nfet_01v8
M$1200 1017 1000 96 96 sky130_fd_pr__nfet_01v8 L=0.15U W=1.3U AS=0.25675P
+ AD=0.1755P PS=2.74U PD=1.84U
* device instance $1202 r0 *1 38.83,57.68 sky130_fd_pr__nfet_01v8
M$1202 157 1017 96 96 sky130_fd_pr__nfet_01v8 L=0.15U W=3.9U AS=0.5265P
+ AD=0.60775P PS=5.52U PD=6.42U
* device instance $1208 r0 *1 40.03,62 sky130_fd_pr__nfet_01v8
M$1208 96 1054 1084 1084 sky130_fd_pr__nfet_01v8 L=0.15U W=1.3U AS=0.25675P
+ AD=0.1755P PS=2.74U PD=1.84U
* device instance $1210 r0 *1 40.87,62 sky130_fd_pr__nfet_01v8
M$1210 1086 1035 1084 1084 sky130_fd_pr__nfet_01v8 L=0.15U W=1.3U AS=0.1755P
+ AD=0.25675P PS=1.84U PD=2.74U
* device instance $1212 r0 *1 42.23,62 sky130_fd_pr__nfet_01v8
M$1212 1086 1056 1076 1076 sky130_fd_pr__nfet_01v8 L=0.15U W=1.3U AS=0.25675P
+ AD=0.18525P PS=2.74U PD=1.87U
* device instance $1214 r0 *1 43.1,62 sky130_fd_pr__nfet_01v8
M$1214 96 1075 1076 1076 sky130_fd_pr__nfet_01v8 L=0.15U W=1.3U AS=0.18525P
+ AD=0.25675P PS=1.87U PD=2.09U
* device instance $1216 r0 *1 44.19,62 sky130_fd_pr__nfet_01v8
M$1216 96 1077 1076 1076 sky130_fd_pr__nfet_01v8 L=0.15U W=1.3U AS=0.25675P
+ AD=0.25675P PS=2.09U PD=2.74U
* device instance $1218 r0 *1 42.79,57.68 sky130_fd_pr__nfet_01v8
M$1218 1019 1018 96 96 sky130_fd_pr__nfet_01v8 L=0.15U W=0.65U AS=0.169P
+ AD=0.08775P PS=1.82U PD=0.92U
* device instance $1219 r0 *1 43.21,57.68 sky130_fd_pr__nfet_01v8
M$1219 96 1020 1019 1019 sky130_fd_pr__nfet_01v8 L=0.15U W=0.65U AS=0.08775P
+ AD=0.169P PS=0.92U PD=1.82U
* device instance $1220 r0 *1 45.57,62 sky130_fd_pr__nfet_01v8
M$1220 1020 1056 96 96 sky130_fd_pr__nfet_01v8 L=0.15U W=0.65U AS=0.17225P
+ AD=0.091P PS=1.83U PD=0.93U
* device instance $1221 r0 *1 46,62 sky130_fd_pr__nfet_01v8
M$1221 1097 1054 1020 1020 sky130_fd_pr__nfet_01v8 L=0.15U W=0.65U AS=0.091P
+ AD=0.095875P PS=0.93U PD=0.945U
* device instance $1222 r0 *1 46.445,62 sky130_fd_pr__nfet_01v8
M$1222 96 1078 1097 1097 sky130_fd_pr__nfet_01v8 L=0.15U W=0.65U AS=0.095875P
+ AD=0.17225P PS=0.945U PD=1.83U
* device instance $1223 r0 *1 46.47,57.68 sky130_fd_pr__nfet_01v8
M$1223 96 1000 1021 1021 sky130_fd_pr__nfet_01v8 L=0.15U W=0.65U AS=0.169P
+ AD=0.08775P PS=1.82U PD=0.92U
* device instance $1224 r0 *1 46.89,57.68 sky130_fd_pr__nfet_01v8
M$1224 1022 1021 96 96 sky130_fd_pr__nfet_01v8 L=0.15U W=2.6U AS=0.351P
+ AD=0.43225P PS=3.68U PD=4.58U
* device instance $1228 r0 *1 49.69,62 sky130_fd_pr__nfet_01v8
M$1228 96 1054 1085 1085 sky130_fd_pr__nfet_01v8 L=0.15U W=1.3U AS=0.25675P
+ AD=0.1755P PS=2.74U PD=1.84U
* device instance $1230 r0 *1 50.53,62 sky130_fd_pr__nfet_01v8
M$1230 1087 1078 1085 1085 sky130_fd_pr__nfet_01v8 L=0.15U W=1.3U AS=0.1755P
+ AD=0.25675P PS=1.84U PD=2.74U
* device instance $1232 r0 *1 51.15,57.68 sky130_fd_pr__nfet_01v8
M$1232 1023 855 96 96 sky130_fd_pr__nfet_01v8 L=0.15U W=2.6U AS=0.44525P
+ AD=0.351P PS=4.62U PD=3.68U
* device instance $1236 r0 *1 52.83,57.68 sky130_fd_pr__nfet_01v8
M$1236 1023 800 96 96 sky130_fd_pr__nfet_01v8 L=0.15U W=2.6U AS=0.351P
+ AD=0.3575P PS=3.68U PD=3.7U
* device instance $1240 r0 *1 54.53,57.68 sky130_fd_pr__nfet_01v8
M$1240 1023 981 96 96 sky130_fd_pr__nfet_01v8 L=0.15U W=2.6U AS=0.3575P
+ AD=0.44525P PS=3.7U PD=4.62U
* device instance $1244 r0 *1 51.89,62 sky130_fd_pr__nfet_01v8
M$1244 1087 1056 1060 1060 sky130_fd_pr__nfet_01v8 L=0.15U W=1.3U AS=0.2665P
+ AD=0.2145P PS=2.77U PD=1.96U
* device instance $1246 r0 *1 52.85,62 sky130_fd_pr__nfet_01v8
M$1246 96 1077 1060 1060 sky130_fd_pr__nfet_01v8 L=0.15U W=1.3U AS=0.23075P
+ AD=0.28275P PS=2.01U PD=2.82U
* device instance $1248 r0 *1 56.77,57.68 sky130_fd_pr__nfet_01v8
M$1248 1023 984 1024 1024 sky130_fd_pr__nfet_01v8 L=0.15U W=2.6U AS=0.44525P
+ AD=0.351P PS=4.62U PD=3.68U
* device instance $1252 r0 *1 58.45,57.68 sky130_fd_pr__nfet_01v8
M$1252 1035 1025 1024 1024 sky130_fd_pr__nfet_01v8 L=0.15U W=2.6U AS=0.351P
+ AD=0.44525P PS=3.68U PD=4.62U
* device instance $1256 r0 *1 60.73,57.68 sky130_fd_pr__nfet_01v8
M$1256 96 1026 1027 1027 sky130_fd_pr__nfet_01v8 L=0.15U W=0.65U AS=0.169P
+ AD=0.10725P PS=1.82U PD=0.98U
* device instance $1257 r0 *1 61.21,57.68 sky130_fd_pr__nfet_01v8
M$1257 1032 986 96 96 sky130_fd_pr__nfet_01v8 L=0.15U W=0.65U AS=0.10725P
+ AD=0.06825P PS=0.98U PD=0.86U
* device instance $1258 r0 *1 61.57,57.68 sky130_fd_pr__nfet_01v8
M$1258 1027 91 1032 1032 sky130_fd_pr__nfet_01v8 L=0.15U W=0.65U AS=0.06825P
+ AD=0.169P PS=0.86U PD=1.82U
* device instance $1259 r0 *1 62.51,57.68 sky130_fd_pr__nfet_01v8
M$1259 1031 1022 1027 1027 sky130_fd_pr__nfet_01v8 L=0.15U W=0.65U AS=0.169P
+ AD=0.10725P PS=1.82U PD=0.98U
* device instance $1260 r0 *1 62.99,57.68 sky130_fd_pr__nfet_01v8
M$1260 96 997 1031 1031 sky130_fd_pr__nfet_01v8 L=0.15U W=0.65U AS=0.10725P
+ AD=0.102375P PS=0.98U PD=0.965U
* device instance $1261 r0 *1 63.455,57.68 sky130_fd_pr__nfet_01v8
M$1261 1028 1027 96 96 sky130_fd_pr__nfet_01v8 L=0.15U W=0.65U AS=0.102375P
+ AD=0.169P PS=0.965U PD=1.82U
* device instance $1262 r0 *1 64.43,57.68 sky130_fd_pr__nfet_01v8
M$1262 1030 944 96 96 sky130_fd_pr__nfet_01v8 L=0.15U W=0.65U AS=0.169P
+ AD=0.08775P PS=1.82U PD=0.92U
* device instance $1263 r0 *1 64.85,57.68 sky130_fd_pr__nfet_01v8
M$1263 1029 984 1030 1030 sky130_fd_pr__nfet_01v8 L=0.15U W=0.65U AS=0.08775P
+ AD=0.169P PS=0.92U PD=1.82U
* device instance $1264 r0 *1 72.945,62.115 sky130_fd_pr__nfet_01v8
M$1264 1068 1067 96 96 sky130_fd_pr__nfet_01v8 L=0.15U W=0.42U AS=0.10025P
+ AD=0.1092P PS=0.985U PD=1.36U
* device instance $1265 r0 *1 73.43,62 sky130_fd_pr__nfet_01v8
M$1265 956 1067 96 96 sky130_fd_pr__nfet_01v8 L=0.15U W=0.65U AS=0.10025P
+ AD=0.182P PS=0.985U PD=1.86U
* device instance $1266 r0 *1 8.245,63.005 sky130_fd_pr__nfet_01v8
M$1266 96 1129 1186 1186 sky130_fd_pr__nfet_01v8 L=0.15U W=0.42U AS=0.1092P
+ AD=0.1197P PS=1.36U PD=1.41U
* device instance $1267 r0 *1 9.21,63.12 sky130_fd_pr__nfet_01v8
M$1267 1099 1130 1098 1098 sky130_fd_pr__nfet_01v8 L=0.15U W=0.65U AS=0.169P
+ AD=0.092625P PS=1.82U PD=0.935U
* device instance $1268 r0 *1 9.645,63.12 sky130_fd_pr__nfet_01v8
M$1268 1098 1129 1099 1099 sky130_fd_pr__nfet_01v8 L=0.15U W=0.65U AS=0.092625P
+ AD=0.115375P PS=0.935U PD=1.005U
* device instance $1269 r0 *1 10.15,63.12 sky130_fd_pr__nfet_01v8
M$1269 96 1100 1098 1098 sky130_fd_pr__nfet_01v8 L=0.15U W=0.65U AS=0.115375P
+ AD=0.08775P PS=1.005U PD=0.92U
* device instance $1270 r0 *1 10.57,63.12 sky130_fd_pr__nfet_01v8
M$1270 1098 919 96 96 sky130_fd_pr__nfet_01v8 L=0.15U W=0.65U AS=0.08775P
+ AD=0.169P PS=0.92U PD=1.82U
* device instance $1271 r0 *1 9.67,62.115 sky130_fd_pr__nfet_01v8
M$1271 96 682 1042 1042 sky130_fd_pr__nfet_01v8 L=0.15U W=0.42U AS=0.1092P
+ AD=0.0567P PS=1.36U PD=0.69U
* device instance $1272 r0 *1 10.09,62.115 sky130_fd_pr__nfet_01v8
M$1272 1044 1042 96 96 sky130_fd_pr__nfet_01v8 L=0.15U W=0.42U AS=0.0567P
+ AD=0.1092P PS=0.69U PD=1.36U
* device instance $1273 r0 *1 11.03,62.115 sky130_fd_pr__nfet_01v8
M$1273 1043 1074 96 96 sky130_fd_pr__nfet_01v8 L=0.15U W=0.42U AS=0.1092P
+ AD=0.066P PS=1.36U PD=0.745U
* device instance $1274 r0 *1 11.505,62.145 sky130_fd_pr__nfet_01v8
M$1274 1045 1042 1043 1043 sky130_fd_pr__nfet_01v8 L=0.15U W=0.36U AS=0.066P
+ AD=0.0594P PS=0.745U PD=0.69U
* device instance $1275 r0 *1 11.985,62.145 sky130_fd_pr__nfet_01v8
M$1275 1045 1044 1091 1091 sky130_fd_pr__nfet_01v8 L=0.15U W=0.36U AS=0.0687P
+ AD=0.0594P PS=0.76U PD=0.69U
* device instance $1276 r0 *1 12.475,62.115 sky130_fd_pr__nfet_01v8
M$1276 1091 1046 96 96 sky130_fd_pr__nfet_01v8 L=0.15U W=0.42U AS=0.1493P
+ AD=0.0687P PS=1.22U PD=0.76U
* device instance $1277 r0 *1 13.205,62.005 sky130_fd_pr__nfet_01v8
M$1277 1046 1045 96 96 sky130_fd_pr__nfet_01v8 L=0.15U W=0.64U AS=0.1493P
+ AD=0.0989P PS=1.22U PD=0.995U
* device instance $1278 r0 *1 13.71,62.145 sky130_fd_pr__nfet_01v8
M$1278 1047 1044 1046 1046 sky130_fd_pr__nfet_01v8 L=0.15U W=0.36U AS=0.0989P
+ AD=0.0657P PS=0.995U PD=0.725U
* device instance $1279 r0 *1 14.225,62.145 sky130_fd_pr__nfet_01v8
M$1279 1047 1042 1093 1093 sky130_fd_pr__nfet_01v8 L=0.15U W=0.36U AS=0.066P
+ AD=0.0657P PS=0.745U PD=0.725U
* device instance $1280 r0 *1 14.7,62.115 sky130_fd_pr__nfet_01v8
M$1280 96 1048 1093 1093 sky130_fd_pr__nfet_01v8 L=0.15U W=0.42U AS=0.066P
+ AD=0.1197P PS=0.745U PD=1.41U
* device instance $1281 r0 *1 11.53,63.12 sky130_fd_pr__nfet_01v8
M$1281 1121 1131 96 96 sky130_fd_pr__nfet_01v8 L=0.15U W=0.65U AS=0.169P
+ AD=0.08775P PS=1.82U PD=0.92U
* device instance $1282 r0 *1 11.95,63.12 sky130_fd_pr__nfet_01v8
M$1282 114 1101 1121 1121 sky130_fd_pr__nfet_01v8 L=0.15U W=0.65U AS=0.08775P
+ AD=0.169P PS=0.92U PD=1.82U
* device instance $1283 r0 *1 13.305,63.005 sky130_fd_pr__nfet_01v8
M$1283 96 63 1101 1101 sky130_fd_pr__nfet_01v8 L=0.15U W=0.42U AS=0.1092P
+ AD=0.1197P PS=1.36U PD=1.41U
* device instance $1284 r0 *1 17.05,63.12 sky130_fd_pr__nfet_01v8
M$1284 1102 1131 96 96 sky130_fd_pr__nfet_01v8 L=0.15U W=2.6U AS=0.44525P
+ AD=0.351P PS=4.62U PD=3.68U
* device instance $1288 r0 *1 18.73,63.12 sky130_fd_pr__nfet_01v8
M$1288 1102 63 96 96 sky130_fd_pr__nfet_01v8 L=0.15U W=2.6U AS=0.351P
+ AD=0.43225P PS=3.68U PD=4.58U
* device instance $1292 r0 *1 22.255,63.12 sky130_fd_pr__nfet_01v8
M$1292 302 1102 96 96 sky130_fd_pr__nfet_01v8 L=0.15U W=5.2U AS=0.78325P
+ AD=0.78325P PS=8.26U PD=8.26U
* device instance $1300 r0 *1 26.49,63.12 sky130_fd_pr__nfet_01v8
M$1300 1103 1050 96 96 sky130_fd_pr__nfet_01v8 L=0.15U W=1.3U AS=0.25675P
+ AD=0.1755P PS=2.74U PD=1.84U
* device instance $1302 r0 *1 27.33,63.12 sky130_fd_pr__nfet_01v8
M$1302 409 1103 96 96 sky130_fd_pr__nfet_01v8 L=0.15U W=3.9U AS=0.5265P
+ AD=0.60775P PS=5.52U PD=6.42U
* device instance $1308 r0 *1 30.37,63.005 sky130_fd_pr__nfet_01v8
M$1308 96 682 1104 1104 sky130_fd_pr__nfet_01v8 L=0.15U W=0.42U AS=0.1092P
+ AD=0.0567P PS=1.36U PD=0.69U
* device instance $1309 r0 *1 30.79,63.005 sky130_fd_pr__nfet_01v8
M$1309 1106 1104 96 96 sky130_fd_pr__nfet_01v8 L=0.15U W=0.42U AS=0.0567P
+ AD=0.1092P PS=0.69U PD=1.36U
* device instance $1310 r0 *1 31.73,63.005 sky130_fd_pr__nfet_01v8
M$1310 1122 1105 1107 1107 sky130_fd_pr__nfet_01v8 L=0.15U W=0.42U AS=0.1092P
+ AD=0.0441P PS=1.36U PD=0.63U
* device instance $1311 r0 *1 32.09,63.005 sky130_fd_pr__nfet_01v8
M$1311 96 302 1122 1122 sky130_fd_pr__nfet_01v8 L=0.15U W=0.42U AS=0.0441P
+ AD=0.1092P PS=0.63U PD=1.36U
* device instance $1312 r0 *1 34.89,62.975 sky130_fd_pr__nfet_01v8
M$1312 1110 1104 1107 1107 sky130_fd_pr__nfet_01v8 L=0.15U W=0.36U AS=0.1446P
+ AD=0.0522P PS=1.18U PD=0.65U
* device instance $1313 r0 *1 35.33,62.975 sky130_fd_pr__nfet_01v8
M$1313 1125 1106 1110 1110 sky130_fd_pr__nfet_01v8 L=0.15U W=0.36U AS=0.0522P
+ AD=0.0759P PS=0.65U PD=0.8U
* device instance $1314 r0 *1 33.03,63.005 sky130_fd_pr__nfet_01v8
M$1314 96 302 1108 1108 sky130_fd_pr__nfet_01v8 L=0.15U W=0.42U AS=0.1092P
+ AD=0.0609P PS=1.36U PD=0.71U
* device instance $1315 r0 *1 33.47,63.005 sky130_fd_pr__nfet_01v8
M$1315 1124 1108 96 96 sky130_fd_pr__nfet_01v8 L=0.15U W=0.42U AS=0.0609P
+ AD=0.0756P PS=0.71U PD=0.78U
* device instance $1316 r0 *1 33.98,63.005 sky130_fd_pr__nfet_01v8
M$1316 1107 1109 1124 1124 sky130_fd_pr__nfet_01v8 L=0.15U W=0.42U AS=0.0756P
+ AD=0.1446P PS=0.78U PD=1.18U
* device instance $1317 r0 *1 35.86,63.005 sky130_fd_pr__nfet_01v8
M$1317 96 1111 1125 1125 sky130_fd_pr__nfet_01v8 L=0.15U W=0.42U AS=0.0759P
+ AD=0.12095P PS=0.8U PD=1.085U
* device instance $1318 r0 *1 36.455,63.115 sky130_fd_pr__nfet_01v8
M$1318 1111 1110 96 96 sky130_fd_pr__nfet_01v8 L=0.15U W=0.64U AS=0.12095P
+ AD=0.1664P PS=1.085U PD=1.8U
* device instance $1319 r0 *1 37.88,62.975 sky130_fd_pr__nfet_01v8
M$1319 1112 1106 1126 1126 sky130_fd_pr__nfet_01v8 L=0.15U W=0.36U AS=0.0678P
+ AD=0.0684P PS=0.755U PD=0.74U
* device instance $1320 r0 *1 38.41,62.975 sky130_fd_pr__nfet_01v8
M$1320 1127 1104 1112 1112 sky130_fd_pr__nfet_01v8 L=0.15U W=0.36U AS=0.0684P
+ AD=0.066P PS=0.74U PD=0.745U
* device instance $1321 r0 *1 37.395,63.005 sky130_fd_pr__nfet_01v8
M$1321 1126 1111 96 96 sky130_fd_pr__nfet_01v8 L=0.15U W=0.42U AS=0.1092P
+ AD=0.0678P PS=1.36U PD=0.755U
* device instance $1322 r0 *1 38.885,63.005 sky130_fd_pr__nfet_01v8
M$1322 96 1109 1127 1127 sky130_fd_pr__nfet_01v8 L=0.15U W=0.42U AS=0.066P
+ AD=0.1092P PS=0.745U PD=1.36U
* device instance $1323 r0 *1 39.825,63.005 sky130_fd_pr__nfet_01v8
M$1323 96 1112 1109 1109 sky130_fd_pr__nfet_01v8 L=0.15U W=0.42U AS=0.1092P
+ AD=0.10025P PS=1.36U PD=0.985U
* device instance $1324 r0 *1 40.31,63.12 sky130_fd_pr__nfet_01v8
M$1324 994 1112 96 96 sky130_fd_pr__nfet_01v8 L=0.15U W=0.65U AS=0.10025P
+ AD=0.182P PS=0.985U PD=1.86U
* device instance $1325 r0 *1 41.41,63.12 sky130_fd_pr__nfet_01v8
M$1325 96 1076 1113 1113 sky130_fd_pr__nfet_01v8 L=0.15U W=0.65U AS=0.169P
+ AD=0.08775P PS=1.82U PD=0.92U
* device instance $1326 r0 *1 41.83,63.12 sky130_fd_pr__nfet_01v8
M$1326 995 1113 96 96 sky130_fd_pr__nfet_01v8 L=0.15U W=2.6U AS=0.351P
+ AD=0.43225P PS=3.68U PD=4.58U
* device instance $1330 r0 *1 45.65,63.12 sky130_fd_pr__nfet_01v8
M$1330 1128 1135 1114 1114 sky130_fd_pr__nfet_01v8 L=0.15U W=0.65U AS=0.169P
+ AD=0.06825P PS=1.82U PD=0.86U
* device instance $1331 r0 *1 46.01,63.12 sky130_fd_pr__nfet_01v8
M$1331 96 1115 1128 1128 sky130_fd_pr__nfet_01v8 L=0.15U W=0.65U AS=0.06825P
+ AD=0.08775P PS=0.86U PD=0.92U
* device instance $1332 r0 *1 46.43,63.12 sky130_fd_pr__nfet_01v8
M$1332 1116 1115 96 96 sky130_fd_pr__nfet_01v8 L=0.15U W=0.65U AS=0.08775P
+ AD=0.169P PS=0.92U PD=1.82U
* device instance $1333 r0 *1 47.37,63.12 sky130_fd_pr__nfet_01v8
M$1333 1116 1135 96 96 sky130_fd_pr__nfet_01v8 L=0.15U W=0.65U AS=0.169P
+ AD=0.08775P PS=1.82U PD=0.92U
* device instance $1334 r0 *1 47.79,63.12 sky130_fd_pr__nfet_01v8
M$1334 1056 1114 1116 1116 sky130_fd_pr__nfet_01v8 L=0.15U W=0.65U AS=0.08775P
+ AD=0.195P PS=0.92U PD=1.9U
* device instance $1335 r0 *1 47.39,62.115 sky130_fd_pr__nfet_01v8
M$1335 1096 1056 1079 1079 sky130_fd_pr__nfet_01v8 L=0.15U W=0.42U AS=0.1092P
+ AD=0.0441P PS=1.36U PD=0.63U
* device instance $1336 r0 *1 47.75,62.115 sky130_fd_pr__nfet_01v8
M$1336 1095 1054 1096 1096 sky130_fd_pr__nfet_01v8 L=0.15U W=0.42U AS=0.0441P
+ AD=0.0441P PS=0.63U PD=0.63U
* device instance $1337 r0 *1 48.11,62.115 sky130_fd_pr__nfet_01v8
M$1337 1095 1078 96 96 sky130_fd_pr__nfet_01v8 L=0.15U W=0.42U AS=0.13165P
+ AD=0.0441P PS=1.14U PD=0.63U
* device instance $1338 r0 *1 48.75,62 sky130_fd_pr__nfet_01v8
M$1338 1018 1079 96 96 sky130_fd_pr__nfet_01v8 L=0.15U W=0.65U AS=0.13165P
+ AD=0.169P PS=1.14U PD=1.82U
* device instance $1339 r0 *1 48.77,63.12 sky130_fd_pr__nfet_01v8
M$1339 96 1035 1117 1117 sky130_fd_pr__nfet_01v8 L=0.15U W=0.65U AS=0.169P
+ AD=0.08775P PS=1.82U PD=0.92U
* device instance $1340 r0 *1 49.19,63.12 sky130_fd_pr__nfet_01v8
M$1340 1078 1117 96 96 sky130_fd_pr__nfet_01v8 L=0.15U W=2.6U AS=0.351P
+ AD=0.43225P PS=3.68U PD=4.58U
* device instance $1344 r0 *1 51.765,63.005 sky130_fd_pr__nfet_01v8
M$1344 96 1115 1118 1118 sky130_fd_pr__nfet_01v8 L=0.15U W=0.42U AS=0.1092P
+ AD=0.10025P PS=1.36U PD=0.985U
* device instance $1345 r0 *1 52.25,63.12 sky130_fd_pr__nfet_01v8
M$1345 1077 1135 96 96 sky130_fd_pr__nfet_01v8 L=0.15U W=0.65U AS=0.10025P
+ AD=0.08775P PS=0.985U PD=0.92U
* device instance $1346 r0 *1 52.67,63.12 sky130_fd_pr__nfet_01v8
M$1346 96 1118 1077 1077 sky130_fd_pr__nfet_01v8 L=0.15U W=0.65U AS=0.08775P
+ AD=0.169P PS=0.92U PD=1.82U
* device instance $1347 r0 *1 63.49,62.115 sky130_fd_pr__nfet_01v8
M$1347 96 980 1061 1061 sky130_fd_pr__nfet_01v8 L=0.15U W=0.42U AS=0.1092P
+ AD=0.0567P PS=1.36U PD=0.69U
* device instance $1348 r0 *1 63.91,62.115 sky130_fd_pr__nfet_01v8
M$1348 1062 1061 96 96 sky130_fd_pr__nfet_01v8 L=0.15U W=0.42U AS=0.0567P
+ AD=0.1092P PS=0.69U PD=1.36U
* device instance $1349 r0 *1 64.85,62.115 sky130_fd_pr__nfet_01v8
M$1349 1094 1028 1063 1063 sky130_fd_pr__nfet_01v8 L=0.15U W=0.42U AS=0.1092P
+ AD=0.0441P PS=1.36U PD=0.63U
* device instance $1350 r0 *1 65.21,62.115 sky130_fd_pr__nfet_01v8
M$1350 96 302 1094 1094 sky130_fd_pr__nfet_01v8 L=0.15U W=0.42U AS=0.0441P
+ AD=0.1092P PS=0.63U PD=1.36U
* device instance $1351 r0 *1 64.41,63.235 sky130_fd_pr__nfet_01v8
M$1351 1119 1132 96 96 sky130_fd_pr__nfet_01v8 L=0.15U W=0.42U AS=0.10025P
+ AD=0.1092P PS=0.985U PD=1.36U
* device instance $1352 r0 *1 64.895,63.12 sky130_fd_pr__nfet_01v8
M$1352 1123 1133 96 96 sky130_fd_pr__nfet_01v8 L=0.15U W=0.65U AS=0.10025P
+ AD=0.08775P PS=0.985U PD=0.92U
* device instance $1353 r0 *1 65.315,63.12 sky130_fd_pr__nfet_01v8
M$1353 1054 1119 1123 1123 sky130_fd_pr__nfet_01v8 L=0.15U W=0.65U AS=0.08775P
+ AD=0.169P PS=0.92U PD=1.82U
* device instance $1354 r0 *1 66.15,62.115 sky130_fd_pr__nfet_01v8
M$1354 96 302 1064 1064 sky130_fd_pr__nfet_01v8 L=0.15U W=0.42U AS=0.1092P
+ AD=0.0609P PS=1.36U PD=0.71U
* device instance $1355 r0 *1 66.59,62.115 sky130_fd_pr__nfet_01v8
M$1355 1092 1064 96 96 sky130_fd_pr__nfet_01v8 L=0.15U W=0.42U AS=0.0609P
+ AD=0.0756P PS=0.71U PD=0.78U
* device instance $1356 r0 *1 67.1,62.115 sky130_fd_pr__nfet_01v8
M$1356 1063 1068 1092 1092 sky130_fd_pr__nfet_01v8 L=0.15U W=0.42U AS=0.0756P
+ AD=0.1446P PS=0.78U PD=1.18U
* device instance $1357 r0 *1 68.01,62.145 sky130_fd_pr__nfet_01v8
M$1357 1065 1061 1063 1063 sky130_fd_pr__nfet_01v8 L=0.15U W=0.36U AS=0.1446P
+ AD=0.0522P PS=1.18U PD=0.65U
* device instance $1358 r0 *1 68.45,62.145 sky130_fd_pr__nfet_01v8
M$1358 1065 1062 1090 1090 sky130_fd_pr__nfet_01v8 L=0.15U W=0.36U AS=0.0759P
+ AD=0.0522P PS=0.8U PD=0.65U
* device instance $1359 r0 *1 68.98,62.115 sky130_fd_pr__nfet_01v8
M$1359 1090 1066 96 96 sky130_fd_pr__nfet_01v8 L=0.15U W=0.42U AS=0.12095P
+ AD=0.0759P PS=1.085U PD=0.8U
* device instance $1360 r0 *1 69.575,62.005 sky130_fd_pr__nfet_01v8
M$1360 1066 1065 96 96 sky130_fd_pr__nfet_01v8 L=0.15U W=0.64U AS=0.12095P
+ AD=0.1664P PS=1.085U PD=1.8U
* device instance $1361 r0 *1 66.71,63.12 sky130_fd_pr__nfet_01v8
M$1361 96 1133 1120 1120 sky130_fd_pr__nfet_01v8 L=0.15U W=0.65U AS=0.169P
+ AD=0.08775P PS=1.82U PD=0.92U
* device instance $1362 r0 *1 67.13,63.12 sky130_fd_pr__nfet_01v8
M$1362 373 1120 96 96 sky130_fd_pr__nfet_01v8 L=0.15U W=2.6U AS=0.351P
+ AD=0.43225P PS=3.68U PD=4.58U
* device instance $1366 r0 *1 70.515,62.115 sky130_fd_pr__nfet_01v8
M$1366 1089 1066 96 96 sky130_fd_pr__nfet_01v8 L=0.15U W=0.42U AS=0.1092P
+ AD=0.0678P PS=1.36U PD=0.755U
* device instance $1367 r0 *1 71,62.145 sky130_fd_pr__nfet_01v8
M$1367 1067 1062 1089 1089 sky130_fd_pr__nfet_01v8 L=0.15U W=0.36U AS=0.0678P
+ AD=0.0684P PS=0.755U PD=0.74U
* device instance $1368 r0 *1 71.53,62.145 sky130_fd_pr__nfet_01v8
M$1368 1067 1061 1088 1088 sky130_fd_pr__nfet_01v8 L=0.15U W=0.36U AS=0.066P
+ AD=0.0684P PS=0.745U PD=0.74U
* device instance $1369 r0 *1 72.005,62.115 sky130_fd_pr__nfet_01v8
M$1369 96 1068 1088 1088 sky130_fd_pr__nfet_01v8 L=0.15U W=0.42U AS=0.066P
+ AD=0.1092P PS=0.745U PD=1.36U
* device instance $1370 r0 *1 5.09,67.44 sky130_fd_pr__nfet_01v8
M$1370 1208 1145 96 96 sky130_fd_pr__nfet_01v8 L=0.15U W=0.65U AS=0.169P
+ AD=0.08775P PS=1.82U PD=0.92U
* device instance $1371 r0 *1 5.51,67.44 sky130_fd_pr__nfet_01v8
M$1371 1130 63 1208 1208 sky130_fd_pr__nfet_01v8 L=0.15U W=0.65U AS=0.08775P
+ AD=0.169P PS=0.92U PD=1.82U
* device instance $1372 r0 *1 8.78,67.555 sky130_fd_pr__nfet_01v8
M$1372 96 1101 1203 1203 sky130_fd_pr__nfet_01v8 L=0.15U W=0.42U AS=0.1113P
+ AD=0.0588P PS=1.37U PD=0.7U
* device instance $1373 r0 *1 9.21,67.555 sky130_fd_pr__nfet_01v8
M$1373 1203 1145 96 96 sky130_fd_pr__nfet_01v8 L=0.15U W=0.42U AS=0.0588P
+ AD=0.0588P PS=0.7U PD=0.7U
* device instance $1374 r0 *1 9.64,67.555 sky130_fd_pr__nfet_01v8
M$1374 1074 1146 1203 1203 sky130_fd_pr__nfet_01v8 L=0.15U W=0.42U AS=0.0588P
+ AD=0.1113P PS=0.7U PD=1.37U
* device instance $1375 r0 *1 10.61,67.44 sky130_fd_pr__nfet_01v8
M$1375 1211 1186 96 96 sky130_fd_pr__nfet_01v8 L=0.15U W=0.65U AS=0.169P
+ AD=0.08775P PS=1.82U PD=0.92U
* device instance $1376 r0 *1 11.03,67.44 sky130_fd_pr__nfet_01v8
M$1376 1100 1131 1211 1211 sky130_fd_pr__nfet_01v8 L=0.15U W=0.65U AS=0.08775P
+ AD=0.169P PS=0.92U PD=1.82U
* device instance $1377 r0 *1 12.04,67.44 sky130_fd_pr__nfet_01v8
M$1377 96 1187 1147 1147 sky130_fd_pr__nfet_01v8 L=0.15U W=0.65U AS=0.2145P
+ AD=0.167375P PS=1.96U PD=1.165U
* device instance $1378 r0 *1 12.705,67.44 sky130_fd_pr__nfet_01v8
M$1378 1213 919 96 96 sky130_fd_pr__nfet_01v8 L=0.15U W=0.65U AS=0.167375P
+ AD=0.0975P PS=1.165U PD=0.95U
* device instance $1379 r0 *1 13.155,67.44 sky130_fd_pr__nfet_01v8
M$1379 1214 1186 1213 1213 sky130_fd_pr__nfet_01v8 L=0.15U W=0.65U AS=0.0975P
+ AD=0.14625P PS=0.95U PD=1.1U
* device instance $1380 r0 *1 13.755,67.44 sky130_fd_pr__nfet_01v8
M$1380 1187 1131 1214 1214 sky130_fd_pr__nfet_01v8 L=0.15U W=0.65U AS=0.14625P
+ AD=0.143P PS=1.1U PD=1.09U
* device instance $1381 r0 *1 14.345,67.44 sky130_fd_pr__nfet_01v8
M$1381 1215 1146 1187 1187 sky130_fd_pr__nfet_01v8 L=0.15U W=0.65U AS=0.143P
+ AD=0.06825P PS=1.09U PD=0.86U
* device instance $1382 r0 *1 14.705,67.44 sky130_fd_pr__nfet_01v8
M$1382 96 1188 1215 1215 sky130_fd_pr__nfet_01v8 L=0.15U W=0.65U AS=0.06825P
+ AD=0.17225P PS=0.86U PD=1.83U
* device instance $1383 r0 *1 15.83,67.415 sky130_fd_pr__nfet_01v8
M$1383 1217 1188 1149 1149 sky130_fd_pr__nfet_01v8 L=0.15U W=0.42U AS=0.1176P
+ AD=0.0567P PS=1.4U PD=0.69U
* device instance $1384 r0 *1 16.25,67.415 sky130_fd_pr__nfet_01v8
M$1384 1217 1102 96 96 sky130_fd_pr__nfet_01v8 L=0.15U W=0.42U AS=0.1118P
+ AD=0.0567P PS=1.04U PD=0.69U
* device instance $1385 r0 *1 16.79,67.44 sky130_fd_pr__nfet_01v8
M$1385 1230 1149 96 96 sky130_fd_pr__nfet_01v8 L=0.15U W=0.65U AS=0.1118P
+ AD=0.182P PS=1.04U PD=1.86U
* device instance $1386 r0 *1 24.46,67.555 sky130_fd_pr__nfet_01v8
M$1386 1221 1189 1150 1150 sky130_fd_pr__nfet_01v8 L=0.15U W=0.42U AS=0.1113P
+ AD=0.0441P PS=1.37U PD=0.63U
* device instance $1387 r0 *1 24.82,67.555 sky130_fd_pr__nfet_01v8
M$1387 96 114 1221 1221 sky130_fd_pr__nfet_01v8 L=0.15U W=0.42U AS=0.0441P
+ AD=0.0966P PS=0.63U PD=0.88U
* device instance $1388 r0 *1 25.43,67.555 sky130_fd_pr__nfet_01v8
M$1388 1151 1150 96 96 sky130_fd_pr__nfet_01v8 L=0.15U W=0.42U AS=0.0966P
+ AD=0.1113P PS=0.88U PD=1.37U
* device instance $1389 r0 *1 26.69,67.44 sky130_fd_pr__nfet_01v8
M$1389 96 1151 1152 1152 sky130_fd_pr__nfet_01v8 L=0.15U W=0.65U AS=0.169P
+ AD=0.10725P PS=1.82U PD=0.98U
* device instance $1390 r0 *1 27.17,67.44 sky130_fd_pr__nfet_01v8
M$1390 1223 894 96 96 sky130_fd_pr__nfet_01v8 L=0.15U W=0.65U AS=0.10725P
+ AD=0.06825P PS=0.98U PD=0.86U
* device instance $1391 r0 *1 27.53,67.44 sky130_fd_pr__nfet_01v8
M$1391 1152 91 1223 1223 sky130_fd_pr__nfet_01v8 L=0.15U W=0.65U AS=0.06825P
+ AD=0.169P PS=0.86U PD=1.82U
* device instance $1392 r0 *1 28.47,67.44 sky130_fd_pr__nfet_01v8
M$1392 1225 1155 1152 1152 sky130_fd_pr__nfet_01v8 L=0.15U W=0.65U AS=0.169P
+ AD=0.10725P PS=1.82U PD=0.98U
* device instance $1393 r0 *1 28.95,67.44 sky130_fd_pr__nfet_01v8
M$1393 96 1000 1225 1225 sky130_fd_pr__nfet_01v8 L=0.15U W=0.65U AS=0.10725P
+ AD=0.102375P PS=0.98U PD=0.965U
* device instance $1394 r0 *1 29.415,67.44 sky130_fd_pr__nfet_01v8
M$1394 1105 1152 96 96 sky130_fd_pr__nfet_01v8 L=0.15U W=0.65U AS=0.102375P
+ AD=0.169P PS=0.965U PD=1.82U
* device instance $1395 r0 *1 32.31,67.44 sky130_fd_pr__nfet_01v8
M$1395 1227 1060 1156 1156 sky130_fd_pr__nfet_01v8 L=0.15U W=0.65U AS=0.169P
+ AD=0.06825P PS=1.82U PD=0.86U
* device instance $1396 r0 *1 32.67,67.44 sky130_fd_pr__nfet_01v8
M$1396 96 1052 1227 1227 sky130_fd_pr__nfet_01v8 L=0.15U W=0.65U AS=0.06825P
+ AD=0.08775P PS=0.86U PD=0.92U
* device instance $1397 r0 *1 33.09,67.44 sky130_fd_pr__nfet_01v8
M$1397 1204 1052 96 96 sky130_fd_pr__nfet_01v8 L=0.15U W=0.65U AS=0.08775P
+ AD=0.169P PS=0.92U PD=1.82U
* device instance $1398 r0 *1 34.03,67.44 sky130_fd_pr__nfet_01v8
M$1398 1204 1060 96 96 sky130_fd_pr__nfet_01v8 L=0.15U W=0.65U AS=0.169P
+ AD=0.08775P PS=1.82U PD=0.92U
* device instance $1399 r0 *1 34.45,67.44 sky130_fd_pr__nfet_01v8
M$1399 1155 1156 1204 1204 sky130_fd_pr__nfet_01v8 L=0.15U W=0.65U AS=0.08775P
+ AD=0.195P PS=0.92U PD=1.9U
* device instance $1400 r0 *1 36.81,67.44 sky130_fd_pr__nfet_01v8
M$1400 96 1190 1157 1157 sky130_fd_pr__nfet_01v8 L=0.15U W=0.65U AS=0.169P
+ AD=0.10725P PS=1.82U PD=0.98U
* device instance $1401 r0 *1 37.29,67.44 sky130_fd_pr__nfet_01v8
M$1401 1229 1135 96 96 sky130_fd_pr__nfet_01v8 L=0.15U W=0.65U AS=0.10725P
+ AD=0.06825P PS=0.98U PD=0.86U
* device instance $1402 r0 *1 37.65,67.44 sky130_fd_pr__nfet_01v8
M$1402 1157 91 1229 1229 sky130_fd_pr__nfet_01v8 L=0.15U W=0.65U AS=0.06825P
+ AD=0.169P PS=0.86U PD=1.82U
* device instance $1403 r0 *1 38.59,67.44 sky130_fd_pr__nfet_01v8
M$1403 1228 1191 1157 1157 sky130_fd_pr__nfet_01v8 L=0.15U W=0.65U AS=0.169P
+ AD=0.10725P PS=1.82U PD=0.98U
* device instance $1404 r0 *1 39.07,67.44 sky130_fd_pr__nfet_01v8
M$1404 96 1019 1228 1228 sky130_fd_pr__nfet_01v8 L=0.15U W=0.65U AS=0.10725P
+ AD=0.102375P PS=0.98U PD=0.965U
* device instance $1405 r0 *1 39.535,67.44 sky130_fd_pr__nfet_01v8
M$1405 1205 1157 96 96 sky130_fd_pr__nfet_01v8 L=0.15U W=0.65U AS=0.102375P
+ AD=0.169P PS=0.965U PD=1.82U
* device instance $1406 r0 *1 40.49,67.555 sky130_fd_pr__nfet_01v8
M$1406 96 980 1160 1160 sky130_fd_pr__nfet_01v8 L=0.15U W=0.42U AS=0.1092P
+ AD=0.0567P PS=1.36U PD=0.69U
* device instance $1407 r0 *1 40.91,67.555 sky130_fd_pr__nfet_01v8
M$1407 1161 1160 96 96 sky130_fd_pr__nfet_01v8 L=0.15U W=0.42U AS=0.0567P
+ AD=0.1092P PS=0.69U PD=1.36U
* device instance $1408 r0 *1 41.85,67.555 sky130_fd_pr__nfet_01v8
M$1408 1226 1192 1162 1162 sky130_fd_pr__nfet_01v8 L=0.15U W=0.42U AS=0.1092P
+ AD=0.0441P PS=1.36U PD=0.63U
* device instance $1409 r0 *1 42.21,67.555 sky130_fd_pr__nfet_01v8
M$1409 96 409 1226 1226 sky130_fd_pr__nfet_01v8 L=0.15U W=0.42U AS=0.0441P
+ AD=0.1092P PS=0.63U PD=1.36U
* device instance $1410 r0 *1 43.15,67.555 sky130_fd_pr__nfet_01v8
M$1410 96 409 1163 1163 sky130_fd_pr__nfet_01v8 L=0.15U W=0.42U AS=0.1092P
+ AD=0.0609P PS=1.36U PD=0.71U
* device instance $1411 r0 *1 43.59,67.555 sky130_fd_pr__nfet_01v8
M$1411 1224 1163 96 96 sky130_fd_pr__nfet_01v8 L=0.15U W=0.42U AS=0.0609P
+ AD=0.0756P PS=0.71U PD=0.78U
* device instance $1412 r0 *1 44.1,67.555 sky130_fd_pr__nfet_01v8
M$1412 1162 1167 1224 1224 sky130_fd_pr__nfet_01v8 L=0.15U W=0.42U AS=0.0756P
+ AD=0.1446P PS=0.78U PD=1.18U
* device instance $1413 r0 *1 45.01,67.585 sky130_fd_pr__nfet_01v8
M$1413 1164 1160 1162 1162 sky130_fd_pr__nfet_01v8 L=0.15U W=0.36U AS=0.1446P
+ AD=0.0522P PS=1.18U PD=0.65U
* device instance $1414 r0 *1 45.45,67.585 sky130_fd_pr__nfet_01v8
M$1414 1164 1161 1222 1222 sky130_fd_pr__nfet_01v8 L=0.15U W=0.36U AS=0.0759P
+ AD=0.0522P PS=0.8U PD=0.65U
* device instance $1415 r0 *1 45.98,67.555 sky130_fd_pr__nfet_01v8
M$1415 1222 1165 96 96 sky130_fd_pr__nfet_01v8 L=0.15U W=0.42U AS=0.12095P
+ AD=0.0759P PS=1.085U PD=0.8U
* device instance $1416 r0 *1 46.575,67.445 sky130_fd_pr__nfet_01v8
M$1416 1165 1164 96 96 sky130_fd_pr__nfet_01v8 L=0.15U W=0.64U AS=0.12095P
+ AD=0.1664P PS=1.085U PD=1.8U
* device instance $1417 r0 *1 47.515,67.555 sky130_fd_pr__nfet_01v8
M$1417 1220 1165 96 96 sky130_fd_pr__nfet_01v8 L=0.15U W=0.42U AS=0.1092P
+ AD=0.0678P PS=1.36U PD=0.755U
* device instance $1418 r0 *1 48,67.585 sky130_fd_pr__nfet_01v8
M$1418 1166 1161 1220 1220 sky130_fd_pr__nfet_01v8 L=0.15U W=0.36U AS=0.0678P
+ AD=0.0684P PS=0.755U PD=0.74U
* device instance $1419 r0 *1 48.53,67.585 sky130_fd_pr__nfet_01v8
M$1419 1166 1160 1219 1219 sky130_fd_pr__nfet_01v8 L=0.15U W=0.36U AS=0.066P
+ AD=0.0684P PS=0.745U PD=0.74U
* device instance $1420 r0 *1 49.005,67.555 sky130_fd_pr__nfet_01v8
M$1420 96 1167 1219 1219 sky130_fd_pr__nfet_01v8 L=0.15U W=0.42U AS=0.066P
+ AD=0.1092P PS=0.745U PD=1.36U
* device instance $1421 r0 *1 49.945,67.555 sky130_fd_pr__nfet_01v8
M$1421 1167 1166 96 96 sky130_fd_pr__nfet_01v8 L=0.15U W=0.42U AS=0.10025P
+ AD=0.1092P PS=0.985U PD=1.36U
* device instance $1422 r0 *1 50.43,67.44 sky130_fd_pr__nfet_01v8
M$1422 1135 1166 96 96 sky130_fd_pr__nfet_01v8 L=0.15U W=0.65U AS=0.10025P
+ AD=0.182P PS=0.985U PD=1.86U
* device instance $1423 r0 *1 60.34,67.555 sky130_fd_pr__nfet_01v8
M$1423 1218 1025 1168 1168 sky130_fd_pr__nfet_01v8 L=0.15U W=0.42U AS=0.1113P
+ AD=0.0441P PS=1.37U PD=0.63U
* device instance $1424 r0 *1 60.7,67.555 sky130_fd_pr__nfet_01v8
M$1424 96 1054 1218 1218 sky130_fd_pr__nfet_01v8 L=0.15U W=0.42U AS=0.0441P
+ AD=0.0966P PS=0.63U PD=0.88U
* device instance $1425 r0 *1 61.31,67.555 sky130_fd_pr__nfet_01v8
M$1425 1169 1168 96 96 sky130_fd_pr__nfet_01v8 L=0.15U W=0.42U AS=0.0966P
+ AD=0.1113P PS=0.88U PD=1.37U
* device instance $1426 r0 *1 62.61,67.44 sky130_fd_pr__nfet_01v8
M$1426 1170 1029 96 96 sky130_fd_pr__nfet_01v8 L=0.15U W=0.65U AS=0.169P
+ AD=0.08775P PS=1.82U PD=0.92U
* device instance $1427 r0 *1 63.03,67.44 sky130_fd_pr__nfet_01v8
M$1427 96 1169 1170 1170 sky130_fd_pr__nfet_01v8 L=0.15U W=0.65U AS=0.08775P
+ AD=0.08775P PS=0.92U PD=0.92U
* device instance $1428 r0 *1 63.45,67.44 sky130_fd_pr__nfet_01v8
M$1428 1216 1169 96 96 sky130_fd_pr__nfet_01v8 L=0.15U W=0.65U AS=0.08775P
+ AD=0.08775P PS=0.92U PD=0.92U
* device instance $1429 r0 *1 63.87,67.44 sky130_fd_pr__nfet_01v8
M$1429 1193 1029 1216 1216 sky130_fd_pr__nfet_01v8 L=0.15U W=0.65U AS=0.08775P
+ AD=0.25025P PS=0.92U PD=1.42U
* device instance $1430 r0 *1 64.79,67.44 sky130_fd_pr__nfet_01v8
M$1430 96 1170 1193 1193 sky130_fd_pr__nfet_01v8 L=0.15U W=0.65U AS=0.25025P
+ AD=0.208P PS=1.42U PD=1.94U
* device instance $1431 r0 *1 65.79,67.555 sky130_fd_pr__nfet_01v8
M$1431 96 980 1172 1172 sky130_fd_pr__nfet_01v8 L=0.15U W=0.42U AS=0.1092P
+ AD=0.0567P PS=1.36U PD=0.69U
* device instance $1432 r0 *1 66.21,67.555 sky130_fd_pr__nfet_01v8
M$1432 1173 1172 96 96 sky130_fd_pr__nfet_01v8 L=0.15U W=0.42U AS=0.0567P
+ AD=0.1092P PS=0.69U PD=1.36U
* device instance $1433 r0 *1 67.15,67.555 sky130_fd_pr__nfet_01v8
M$1433 1212 1194 1174 1174 sky130_fd_pr__nfet_01v8 L=0.15U W=0.42U AS=0.1092P
+ AD=0.0441P PS=1.36U PD=0.63U
* device instance $1434 r0 *1 67.51,67.555 sky130_fd_pr__nfet_01v8
M$1434 96 409 1212 1212 sky130_fd_pr__nfet_01v8 L=0.15U W=0.42U AS=0.0441P
+ AD=0.1092P PS=0.63U PD=1.36U
* device instance $1435 r0 *1 68.45,67.555 sky130_fd_pr__nfet_01v8
M$1435 96 409 1175 1175 sky130_fd_pr__nfet_01v8 L=0.15U W=0.42U AS=0.1092P
+ AD=0.0609P PS=1.36U PD=0.71U
* device instance $1436 r0 *1 68.89,67.555 sky130_fd_pr__nfet_01v8
M$1436 1210 1175 96 96 sky130_fd_pr__nfet_01v8 L=0.15U W=0.42U AS=0.0609P
+ AD=0.0756P PS=0.71U PD=0.78U
* device instance $1437 r0 *1 69.4,67.555 sky130_fd_pr__nfet_01v8
M$1437 1174 1179 1210 1210 sky130_fd_pr__nfet_01v8 L=0.15U W=0.42U AS=0.0756P
+ AD=0.1446P PS=0.78U PD=1.18U
* device instance $1438 r0 *1 70.31,67.585 sky130_fd_pr__nfet_01v8
M$1438 1176 1172 1174 1174 sky130_fd_pr__nfet_01v8 L=0.15U W=0.36U AS=0.1446P
+ AD=0.0522P PS=1.18U PD=0.65U
* device instance $1439 r0 *1 70.75,67.585 sky130_fd_pr__nfet_01v8
M$1439 1176 1173 1209 1209 sky130_fd_pr__nfet_01v8 L=0.15U W=0.36U AS=0.0759P
+ AD=0.0522P PS=0.8U PD=0.65U
* device instance $1440 r0 *1 71.28,67.555 sky130_fd_pr__nfet_01v8
M$1440 1209 1177 96 96 sky130_fd_pr__nfet_01v8 L=0.15U W=0.42U AS=0.12095P
+ AD=0.0759P PS=1.085U PD=0.8U
* device instance $1441 r0 *1 71.875,67.445 sky130_fd_pr__nfet_01v8
M$1441 1177 1176 96 96 sky130_fd_pr__nfet_01v8 L=0.15U W=0.64U AS=0.12095P
+ AD=0.1664P PS=1.085U PD=1.8U
* device instance $1442 r0 *1 72.815,67.555 sky130_fd_pr__nfet_01v8
M$1442 1207 1177 96 96 sky130_fd_pr__nfet_01v8 L=0.15U W=0.42U AS=0.1092P
+ AD=0.0678P PS=1.36U PD=0.755U
* device instance $1443 r0 *1 73.3,67.585 sky130_fd_pr__nfet_01v8
M$1443 1178 1173 1207 1207 sky130_fd_pr__nfet_01v8 L=0.15U W=0.36U AS=0.0678P
+ AD=0.0684P PS=0.755U PD=0.74U
* device instance $1444 r0 *1 73.83,67.585 sky130_fd_pr__nfet_01v8
M$1444 1178 1172 1206 1206 sky130_fd_pr__nfet_01v8 L=0.15U W=0.36U AS=0.066P
+ AD=0.0684P PS=0.745U PD=0.74U
* device instance $1445 r0 *1 74.305,67.555 sky130_fd_pr__nfet_01v8
M$1445 96 1179 1206 1206 sky130_fd_pr__nfet_01v8 L=0.15U W=0.42U AS=0.066P
+ AD=0.1092P PS=0.745U PD=1.36U
* device instance $1446 r0 *1 75.245,67.555 sky130_fd_pr__nfet_01v8
M$1446 1179 1178 96 96 sky130_fd_pr__nfet_01v8 L=0.15U W=0.42U AS=0.10025P
+ AD=0.1092P PS=0.985U PD=1.36U
* device instance $1447 r0 *1 75.73,67.44 sky130_fd_pr__nfet_01v8
M$1447 1133 1178 96 96 sky130_fd_pr__nfet_01v8 L=0.15U W=0.65U AS=0.10025P
+ AD=0.182P PS=0.985U PD=1.86U
* device instance $1448 r0 *1 5.555,68.56 sky130_fd_pr__nfet_01v8
M$1448 1281 1202 96 96 sky130_fd_pr__nfet_01v8 L=0.15U W=0.65U AS=0.18525P
+ AD=0.089375P PS=1.87U PD=0.925U
* device instance $1449 r0 *1 5.98,68.56 sky130_fd_pr__nfet_01v8
M$1449 1146 1230 1281 1281 sky130_fd_pr__nfet_01v8 L=0.15U W=0.65U AS=0.089375P
+ AD=0.091P PS=0.925U PD=0.93U
* device instance $1450 r0 *1 6.41,68.56 sky130_fd_pr__nfet_01v8
M$1450 1283 1230 1146 1146 sky130_fd_pr__nfet_01v8 L=0.15U W=0.65U AS=0.091P
+ AD=0.06825P PS=0.93U PD=0.86U
* device instance $1451 r0 *1 6.77,68.56 sky130_fd_pr__nfet_01v8
M$1451 96 1202 1283 1283 sky130_fd_pr__nfet_01v8 L=0.15U W=0.65U AS=0.06825P
+ AD=0.10725P PS=0.86U PD=0.98U
* device instance $1452 r0 *1 7.25,68.56 sky130_fd_pr__nfet_01v8
M$1452 1146 1129 96 96 sky130_fd_pr__nfet_01v8 L=0.15U W=1.3U AS=0.195P
+ AD=0.34775P PS=1.9U PD=3.02U
* device instance $1454 r0 *1 8.75,68.445 sky130_fd_pr__nfet_01v8
M$1454 96 682 1231 1231 sky130_fd_pr__nfet_01v8 L=0.15U W=0.42U AS=0.1092P
+ AD=0.0567P PS=1.36U PD=0.69U
* device instance $1455 r0 *1 9.17,68.445 sky130_fd_pr__nfet_01v8
M$1455 1232 1231 96 96 sky130_fd_pr__nfet_01v8 L=0.15U W=0.42U AS=0.0567P
+ AD=0.1092P PS=0.69U PD=1.36U
* device instance $1456 r0 *1 10.67,68.415 sky130_fd_pr__nfet_01v8
M$1456 1234 1231 1233 1233 sky130_fd_pr__nfet_01v8 L=0.15U W=0.36U AS=0.0813P
+ AD=0.0621P PS=0.83U PD=0.705U
* device instance $1457 r0 *1 11.165,68.415 sky130_fd_pr__nfet_01v8
M$1457 1259 1232 1234 1234 sky130_fd_pr__nfet_01v8 L=0.15U W=0.36U AS=0.0621P
+ AD=0.0696P PS=0.705U PD=0.765U
* device instance $1458 r0 *1 12.76,68.415 sky130_fd_pr__nfet_01v8
M$1458 1236 1232 1235 1235 sky130_fd_pr__nfet_01v8 L=0.15U W=0.36U AS=0.0989P
+ AD=0.0684P PS=0.995U PD=0.74U
* device instance $1459 r0 *1 13.29,68.415 sky130_fd_pr__nfet_01v8
M$1459 1260 1231 1236 1236 sky130_fd_pr__nfet_01v8 L=0.15U W=0.36U AS=0.0684P
+ AD=0.066P PS=0.74U PD=0.745U
* device instance $1460 r0 *1 10.11,68.445 sky130_fd_pr__nfet_01v8
M$1460 1233 1147 96 96 sky130_fd_pr__nfet_01v8 L=0.15U W=0.42U AS=0.1092P
+ AD=0.0813P PS=1.36U PD=0.83U
* device instance $1461 r0 *1 11.66,68.445 sky130_fd_pr__nfet_01v8
M$1461 96 1235 1259 1259 sky130_fd_pr__nfet_01v8 L=0.15U W=0.42U AS=0.0696P
+ AD=0.12095P PS=0.765U PD=1.085U
* device instance $1462 r0 *1 13.765,68.445 sky130_fd_pr__nfet_01v8
M$1462 96 1237 1260 1260 sky130_fd_pr__nfet_01v8 L=0.15U W=0.42U AS=0.066P
+ AD=0.1092P PS=0.745U PD=1.36U
* device instance $1463 r0 *1 12.255,68.555 sky130_fd_pr__nfet_01v8
M$1463 1235 1234 96 96 sky130_fd_pr__nfet_01v8 L=0.15U W=0.64U AS=0.12095P
+ AD=0.0989P PS=1.085U PD=0.995U
* device instance $1464 r0 *1 14.71,68.56 sky130_fd_pr__nfet_01v8
M$1464 96 1236 1237 1237 sky130_fd_pr__nfet_01v8 L=0.15U W=0.65U AS=0.169P
+ AD=0.08775P PS=1.82U PD=0.92U
* device instance $1465 r0 *1 15.13,68.56 sky130_fd_pr__nfet_01v8
M$1465 1188 1237 96 96 sky130_fd_pr__nfet_01v8 L=0.15U W=0.65U AS=0.08775P
+ AD=0.169P PS=0.92U PD=1.82U
* device instance $1466 r0 *1 22.09,68.445 sky130_fd_pr__nfet_01v8
M$1466 96 682 1238 1238 sky130_fd_pr__nfet_01v8 L=0.15U W=0.42U AS=0.1092P
+ AD=0.0567P PS=1.36U PD=0.69U
* device instance $1467 r0 *1 22.51,68.445 sky130_fd_pr__nfet_01v8
M$1467 1239 1238 96 96 sky130_fd_pr__nfet_01v8 L=0.15U W=0.42U AS=0.0567P
+ AD=0.1092P PS=0.69U PD=1.36U
* device instance $1468 r0 *1 23.45,68.445 sky130_fd_pr__nfet_01v8
M$1468 1263 1275 1240 1240 sky130_fd_pr__nfet_01v8 L=0.15U W=0.42U AS=0.1092P
+ AD=0.0441P PS=1.36U PD=0.63U
* device instance $1469 r0 *1 23.81,68.445 sky130_fd_pr__nfet_01v8
M$1469 96 409 1263 1263 sky130_fd_pr__nfet_01v8 L=0.15U W=0.42U AS=0.0441P
+ AD=0.1092P PS=0.63U PD=1.36U
* device instance $1470 r0 *1 26.61,68.415 sky130_fd_pr__nfet_01v8
M$1470 1242 1238 1240 1240 sky130_fd_pr__nfet_01v8 L=0.15U W=0.36U AS=0.1446P
+ AD=0.0522P PS=1.18U PD=0.65U
* device instance $1471 r0 *1 27.05,68.415 sky130_fd_pr__nfet_01v8
M$1471 1265 1239 1242 1242 sky130_fd_pr__nfet_01v8 L=0.15U W=0.36U AS=0.0522P
+ AD=0.0759P PS=0.65U PD=0.8U
* device instance $1472 r0 *1 24.75,68.445 sky130_fd_pr__nfet_01v8
M$1472 96 409 1241 1241 sky130_fd_pr__nfet_01v8 L=0.15U W=0.42U AS=0.1092P
+ AD=0.0609P PS=1.36U PD=0.71U
* device instance $1473 r0 *1 25.19,68.445 sky130_fd_pr__nfet_01v8
M$1473 1264 1241 96 96 sky130_fd_pr__nfet_01v8 L=0.15U W=0.42U AS=0.0609P
+ AD=0.0756P PS=0.71U PD=0.78U
* device instance $1474 r0 *1 25.7,68.445 sky130_fd_pr__nfet_01v8
M$1474 1240 1276 1264 1264 sky130_fd_pr__nfet_01v8 L=0.15U W=0.42U AS=0.0756P
+ AD=0.1446P PS=0.78U PD=1.18U
* device instance $1475 r0 *1 27.58,68.445 sky130_fd_pr__nfet_01v8
M$1475 96 1243 1265 1265 sky130_fd_pr__nfet_01v8 L=0.15U W=0.42U AS=0.0759P
+ AD=0.12095P PS=0.8U PD=1.085U
* device instance $1476 r0 *1 28.175,68.555 sky130_fd_pr__nfet_01v8
M$1476 1243 1242 96 96 sky130_fd_pr__nfet_01v8 L=0.15U W=0.64U AS=0.12095P
+ AD=0.1664P PS=1.085U PD=1.8U
* device instance $1477 r0 *1 29.6,68.415 sky130_fd_pr__nfet_01v8
M$1477 1244 1239 1266 1266 sky130_fd_pr__nfet_01v8 L=0.15U W=0.36U AS=0.0678P
+ AD=0.0684P PS=0.755U PD=0.74U
* device instance $1478 r0 *1 30.13,68.415 sky130_fd_pr__nfet_01v8
M$1478 1267 1238 1244 1244 sky130_fd_pr__nfet_01v8 L=0.15U W=0.36U AS=0.0684P
+ AD=0.066P PS=0.74U PD=0.745U
* device instance $1479 r0 *1 29.115,68.445 sky130_fd_pr__nfet_01v8
M$1479 1266 1243 96 96 sky130_fd_pr__nfet_01v8 L=0.15U W=0.42U AS=0.1092P
+ AD=0.0678P PS=1.36U PD=0.755U
* device instance $1480 r0 *1 30.605,68.445 sky130_fd_pr__nfet_01v8
M$1480 96 1276 1267 1267 sky130_fd_pr__nfet_01v8 L=0.15U W=0.42U AS=0.066P
+ AD=0.1092P PS=0.745U PD=1.36U
* device instance $1481 r0 *1 31.545,68.445 sky130_fd_pr__nfet_01v8
M$1481 96 1244 1276 1276 sky130_fd_pr__nfet_01v8 L=0.15U W=0.42U AS=0.1092P
+ AD=0.10025P PS=1.36U PD=0.985U
* device instance $1482 r0 *1 32.03,68.56 sky130_fd_pr__nfet_01v8
M$1482 894 1244 96 96 sky130_fd_pr__nfet_01v8 L=0.15U W=0.65U AS=0.10025P
+ AD=0.182P PS=0.985U PD=1.86U
* device instance $1483 r0 *1 33.13,68.56 sky130_fd_pr__nfet_01v8
M$1483 96 1000 1245 1245 sky130_fd_pr__nfet_01v8 L=0.15U W=0.65U AS=0.169P
+ AD=0.08775P PS=1.82U PD=0.92U
* device instance $1484 r0 *1 33.55,68.56 sky130_fd_pr__nfet_01v8
M$1484 1191 1245 96 96 sky130_fd_pr__nfet_01v8 L=0.15U W=2.6U AS=0.351P
+ AD=0.43225P PS=3.68U PD=4.58U
* device instance $1488 r0 *1 40.51,68.56 sky130_fd_pr__nfet_01v8
M$1488 1286 1277 96 96 sky130_fd_pr__nfet_01v8 L=0.15U W=0.65U AS=0.169P
+ AD=0.08775P PS=1.82U PD=0.92U
* device instance $1489 r0 *1 40.93,68.56 sky130_fd_pr__nfet_01v8
M$1489 846 63 1286 1286 sky130_fd_pr__nfet_01v8 L=0.15U W=0.65U AS=0.08775P
+ AD=0.169P PS=0.92U PD=1.82U
* device instance $1490 r0 *1 41.94,68.445 sky130_fd_pr__nfet_01v8
M$1490 1268 1287 1246 1246 sky130_fd_pr__nfet_01v8 L=0.15U W=0.42U AS=0.1113P
+ AD=0.0441P PS=1.37U PD=0.63U
* device instance $1491 r0 *1 42.3,68.445 sky130_fd_pr__nfet_01v8
M$1491 96 114 1268 1268 sky130_fd_pr__nfet_01v8 L=0.15U W=0.42U AS=0.0441P
+ AD=0.0966P PS=0.63U PD=0.88U
* device instance $1492 r0 *1 42.91,68.445 sky130_fd_pr__nfet_01v8
M$1492 1190 1246 96 96 sky130_fd_pr__nfet_01v8 L=0.15U W=0.42U AS=0.0966P
+ AD=0.1113P PS=0.88U PD=1.37U
* device instance $1493 r0 *1 44.63,68.445 sky130_fd_pr__nfet_01v8
M$1493 96 980 1247 1247 sky130_fd_pr__nfet_01v8 L=0.15U W=0.42U AS=0.1092P
+ AD=0.0567P PS=1.36U PD=0.69U
* device instance $1494 r0 *1 45.05,68.445 sky130_fd_pr__nfet_01v8
M$1494 1248 1247 96 96 sky130_fd_pr__nfet_01v8 L=0.15U W=0.42U AS=0.0567P
+ AD=0.1092P PS=0.69U PD=1.36U
* device instance $1495 r0 *1 45.99,68.445 sky130_fd_pr__nfet_01v8
M$1495 1270 1205 1249 1249 sky130_fd_pr__nfet_01v8 L=0.15U W=0.42U AS=0.1092P
+ AD=0.0441P PS=1.36U PD=0.63U
* device instance $1496 r0 *1 46.35,68.445 sky130_fd_pr__nfet_01v8
M$1496 96 302 1270 1270 sky130_fd_pr__nfet_01v8 L=0.15U W=0.42U AS=0.0441P
+ AD=0.1092P PS=0.63U PD=1.36U
* device instance $1497 r0 *1 49.15,68.415 sky130_fd_pr__nfet_01v8
M$1497 1251 1247 1249 1249 sky130_fd_pr__nfet_01v8 L=0.15U W=0.36U AS=0.1446P
+ AD=0.0522P PS=1.18U PD=0.65U
* device instance $1498 r0 *1 49.59,68.415 sky130_fd_pr__nfet_01v8
M$1498 1272 1248 1251 1251 sky130_fd_pr__nfet_01v8 L=0.15U W=0.36U AS=0.0522P
+ AD=0.0759P PS=0.65U PD=0.8U
* device instance $1499 r0 *1 47.29,68.445 sky130_fd_pr__nfet_01v8
M$1499 96 302 1250 1250 sky130_fd_pr__nfet_01v8 L=0.15U W=0.42U AS=0.1092P
+ AD=0.0609P PS=1.36U PD=0.71U
* device instance $1500 r0 *1 47.73,68.445 sky130_fd_pr__nfet_01v8
M$1500 1271 1250 96 96 sky130_fd_pr__nfet_01v8 L=0.15U W=0.42U AS=0.0609P
+ AD=0.0756P PS=0.71U PD=0.78U
* device instance $1501 r0 *1 48.24,68.445 sky130_fd_pr__nfet_01v8
M$1501 1249 1278 1271 1271 sky130_fd_pr__nfet_01v8 L=0.15U W=0.42U AS=0.0756P
+ AD=0.1446P PS=0.78U PD=1.18U
* device instance $1502 r0 *1 50.12,68.445 sky130_fd_pr__nfet_01v8
M$1502 96 1252 1272 1272 sky130_fd_pr__nfet_01v8 L=0.15U W=0.42U AS=0.0759P
+ AD=0.12095P PS=0.8U PD=1.085U
* device instance $1503 r0 *1 50.715,68.555 sky130_fd_pr__nfet_01v8
M$1503 1252 1251 96 96 sky130_fd_pr__nfet_01v8 L=0.15U W=0.64U AS=0.12095P
+ AD=0.1664P PS=1.085U PD=1.8U
* device instance $1504 r0 *1 52.14,68.415 sky130_fd_pr__nfet_01v8
M$1504 1253 1248 1274 1274 sky130_fd_pr__nfet_01v8 L=0.15U W=0.36U AS=0.0678P
+ AD=0.0684P PS=0.755U PD=0.74U
* device instance $1505 r0 *1 52.67,68.415 sky130_fd_pr__nfet_01v8
M$1505 1273 1247 1253 1253 sky130_fd_pr__nfet_01v8 L=0.15U W=0.36U AS=0.0684P
+ AD=0.066P PS=0.74U PD=0.745U
* device instance $1506 r0 *1 51.655,68.445 sky130_fd_pr__nfet_01v8
M$1506 1274 1252 96 96 sky130_fd_pr__nfet_01v8 L=0.15U W=0.42U AS=0.1092P
+ AD=0.0678P PS=1.36U PD=0.755U
* device instance $1507 r0 *1 53.145,68.445 sky130_fd_pr__nfet_01v8
M$1507 96 1278 1273 1273 sky130_fd_pr__nfet_01v8 L=0.15U W=0.42U AS=0.066P
+ AD=0.1092P PS=0.745U PD=1.36U
* device instance $1508 r0 *1 54.085,68.445 sky130_fd_pr__nfet_01v8
M$1508 96 1253 1278 1278 sky130_fd_pr__nfet_01v8 L=0.15U W=0.42U AS=0.1092P
+ AD=0.10025P PS=1.36U PD=0.985U
* device instance $1509 r0 *1 54.57,68.56 sky130_fd_pr__nfet_01v8
M$1509 1115 1253 96 96 sky130_fd_pr__nfet_01v8 L=0.15U W=0.65U AS=0.10025P
+ AD=0.182P PS=0.985U PD=1.86U
* device instance $1510 r0 *1 57.12,68.445 sky130_fd_pr__nfet_01v8
M$1510 1269 1288 1254 1254 sky130_fd_pr__nfet_01v8 L=0.15U W=0.42U AS=0.1113P
+ AD=0.0441P PS=1.37U PD=0.63U
* device instance $1511 r0 *1 57.48,68.445 sky130_fd_pr__nfet_01v8
M$1511 96 114 1269 1269 sky130_fd_pr__nfet_01v8 L=0.15U W=0.42U AS=0.0441P
+ AD=0.0966P PS=0.63U PD=0.88U
* device instance $1512 r0 *1 58.09,68.445 sky130_fd_pr__nfet_01v8
M$1512 1026 1254 96 96 sky130_fd_pr__nfet_01v8 L=0.15U W=0.42U AS=0.0966P
+ AD=0.1113P PS=0.88U PD=1.37U
* device instance $1513 r0 *1 60.27,68.56 sky130_fd_pr__nfet_01v8
M$1513 96 1279 1255 1255 sky130_fd_pr__nfet_01v8 L=0.15U W=0.65U AS=0.169P
+ AD=0.10725P PS=1.82U PD=0.98U
* device instance $1514 r0 *1 60.75,68.56 sky130_fd_pr__nfet_01v8
M$1514 1285 1280 96 96 sky130_fd_pr__nfet_01v8 L=0.15U W=0.65U AS=0.10725P
+ AD=0.06825P PS=0.98U PD=0.86U
* device instance $1515 r0 *1 61.11,68.56 sky130_fd_pr__nfet_01v8
M$1515 1255 91 1285 1285 sky130_fd_pr__nfet_01v8 L=0.15U W=0.65U AS=0.06825P
+ AD=0.169P PS=0.86U PD=1.82U
* device instance $1516 r0 *1 62.05,68.56 sky130_fd_pr__nfet_01v8
M$1516 1284 1022 1255 1255 sky130_fd_pr__nfet_01v8 L=0.15U W=0.65U AS=0.169P
+ AD=0.10725P PS=1.82U PD=0.98U
* device instance $1517 r0 *1 62.53,68.56 sky130_fd_pr__nfet_01v8
M$1517 96 1193 1284 1284 sky130_fd_pr__nfet_01v8 L=0.15U W=0.65U AS=0.10725P
+ AD=0.102375P PS=0.98U PD=0.965U
* device instance $1518 r0 *1 62.995,68.56 sky130_fd_pr__nfet_01v8
M$1518 1290 1255 96 96 sky130_fd_pr__nfet_01v8 L=0.15U W=0.65U AS=0.102375P
+ AD=0.169P PS=0.965U PD=1.82U
* device instance $1519 r0 *1 63.95,68.675 sky130_fd_pr__nfet_01v8
M$1519 1256 1133 96 96 sky130_fd_pr__nfet_01v8 L=0.15U W=0.42U AS=0.10025P
+ AD=0.1092P PS=0.985U PD=1.36U
* device instance $1520 r0 *1 64.435,68.56 sky130_fd_pr__nfet_01v8
M$1520 1282 1132 96 96 sky130_fd_pr__nfet_01v8 L=0.15U W=0.65U AS=0.10025P
+ AD=0.08775P PS=0.985U PD=0.92U
* device instance $1521 r0 *1 64.855,68.56 sky130_fd_pr__nfet_01v8
M$1521 1025 1256 1282 1282 sky130_fd_pr__nfet_01v8 L=0.15U W=0.65U AS=0.08775P
+ AD=0.169P PS=0.92U PD=1.82U
* device instance $1522 r0 *1 68.175,68.445 sky130_fd_pr__nfet_01v8
M$1522 1262 63 96 96 sky130_fd_pr__nfet_01v8 L=0.15U W=0.42U AS=0.11285P
+ AD=0.0693P PS=1.045U PD=0.75U
* device instance $1523 r0 *1 68.655,68.445 sky130_fd_pr__nfet_01v8
M$1523 1257 1291 1262 1262 sky130_fd_pr__nfet_01v8 L=0.15U W=0.42U AS=0.0693P
+ AD=0.09975P PS=0.75U PD=0.895U
* device instance $1524 r0 *1 69.28,68.445 sky130_fd_pr__nfet_01v8
M$1524 1261 1132 1257 1257 sky130_fd_pr__nfet_01v8 L=0.15U W=0.42U AS=0.09975P
+ AD=0.0693P PS=0.895U PD=0.75U
* device instance $1525 r0 *1 69.76,68.445 sky130_fd_pr__nfet_01v8
M$1525 96 1258 1261 1261 sky130_fd_pr__nfet_01v8 L=0.15U W=0.42U AS=0.0693P
+ AD=0.1449P PS=0.75U PD=1.11U
* device instance $1526 r0 *1 70.6,68.445 sky130_fd_pr__nfet_01v8
M$1526 1258 63 96 96 sky130_fd_pr__nfet_01v8 L=0.15U W=0.42U AS=0.1449P
+ AD=0.1092P PS=1.11U PD=1.36U
* device instance $1527 r0 *1 67.63,68.56 sky130_fd_pr__nfet_01v8
M$1527 96 1257 1194 1194 sky130_fd_pr__nfet_01v8 L=0.15U W=0.65U AS=0.169P
+ AD=0.11285P PS=1.82U PD=1.045U
* device instance $1528 r0 *1 8.29,72.995 sky130_fd_pr__nfet_01v8
M$1528 96 682 1308 1308 sky130_fd_pr__nfet_01v8 L=0.15U W=0.42U AS=0.1092P
+ AD=0.0567P PS=1.36U PD=0.69U
* device instance $1529 r0 *1 8.71,72.995 sky130_fd_pr__nfet_01v8
M$1529 1309 1308 96 96 sky130_fd_pr__nfet_01v8 L=0.15U W=0.42U AS=0.0567P
+ AD=0.1092P PS=0.69U PD=1.36U
* device instance $1530 r0 *1 9.65,72.995 sky130_fd_pr__nfet_01v8
M$1530 1310 1099 96 96 sky130_fd_pr__nfet_01v8 L=0.15U W=0.42U AS=0.1092P
+ AD=0.0813P PS=1.36U PD=0.83U
* device instance $1531 r0 *1 10.21,73.025 sky130_fd_pr__nfet_01v8
M$1531 1311 1308 1310 1310 sky130_fd_pr__nfet_01v8 L=0.15U W=0.36U AS=0.0813P
+ AD=0.0621P PS=0.83U PD=0.705U
* device instance $1532 r0 *1 10.705,73.025 sky130_fd_pr__nfet_01v8
M$1532 1311 1309 1345 1345 sky130_fd_pr__nfet_01v8 L=0.15U W=0.36U AS=0.0696P
+ AD=0.0621P PS=0.765U PD=0.705U
* device instance $1533 r0 *1 11.2,72.995 sky130_fd_pr__nfet_01v8
M$1533 1345 1312 96 96 sky130_fd_pr__nfet_01v8 L=0.15U W=0.42U AS=0.12095P
+ AD=0.0696P PS=1.085U PD=0.765U
* device instance $1534 r0 *1 11.795,72.885 sky130_fd_pr__nfet_01v8
M$1534 1312 1311 96 96 sky130_fd_pr__nfet_01v8 L=0.15U W=0.64U AS=0.12095P
+ AD=0.0989P PS=1.085U PD=0.995U
* device instance $1535 r0 *1 12.3,73.025 sky130_fd_pr__nfet_01v8
M$1535 1313 1309 1312 1312 sky130_fd_pr__nfet_01v8 L=0.15U W=0.36U AS=0.0989P
+ AD=0.0684P PS=0.995U PD=0.74U
* device instance $1536 r0 *1 12.83,73.025 sky130_fd_pr__nfet_01v8
M$1536 1313 1308 1347 1347 sky130_fd_pr__nfet_01v8 L=0.15U W=0.36U AS=0.066P
+ AD=0.0684P PS=0.745U PD=0.74U
* device instance $1537 r0 *1 13.305,72.995 sky130_fd_pr__nfet_01v8
M$1537 96 1314 1347 1347 sky130_fd_pr__nfet_01v8 L=0.15U W=0.42U AS=0.066P
+ AD=0.1092P PS=0.745U PD=1.36U
* device instance $1538 r0 *1 14.25,72.88 sky130_fd_pr__nfet_01v8
M$1538 96 1313 1314 1314 sky130_fd_pr__nfet_01v8 L=0.15U W=0.65U AS=0.169P
+ AD=0.08775P PS=1.82U PD=0.92U
* device instance $1539 r0 *1 14.67,72.88 sky130_fd_pr__nfet_01v8
M$1539 1131 1314 96 96 sky130_fd_pr__nfet_01v8 L=0.15U W=0.65U AS=0.08775P
+ AD=0.169P PS=0.92U PD=1.82U
* device instance $1540 r0 *1 26.23,72.88 sky130_fd_pr__nfet_01v8
M$1540 96 1315 1275 1275 sky130_fd_pr__nfet_01v8 L=0.15U W=0.65U AS=0.169P
+ AD=0.11285P PS=1.82U PD=1.045U
* device instance $1541 r0 *1 26.775,72.995 sky130_fd_pr__nfet_01v8
M$1541 1352 63 96 96 sky130_fd_pr__nfet_01v8 L=0.15U W=0.42U AS=0.11285P
+ AD=0.0693P PS=1.045U PD=0.75U
* device instance $1542 r0 *1 27.255,72.995 sky130_fd_pr__nfet_01v8
M$1542 1315 1316 1352 1352 sky130_fd_pr__nfet_01v8 L=0.15U W=0.42U AS=0.0693P
+ AD=0.09975P PS=0.75U PD=0.895U
* device instance $1543 r0 *1 27.88,72.995 sky130_fd_pr__nfet_01v8
M$1543 1353 994 1315 1315 sky130_fd_pr__nfet_01v8 L=0.15U W=0.42U AS=0.09975P
+ AD=0.0693P PS=0.895U PD=0.75U
* device instance $1544 r0 *1 28.36,72.995 sky130_fd_pr__nfet_01v8
M$1544 96 1340 1353 1353 sky130_fd_pr__nfet_01v8 L=0.15U W=0.42U AS=0.0693P
+ AD=0.1449P PS=0.75U PD=1.11U
* device instance $1545 r0 *1 29.2,72.995 sky130_fd_pr__nfet_01v8
M$1545 1340 63 96 96 sky130_fd_pr__nfet_01v8 L=0.15U W=0.42U AS=0.1449P
+ AD=0.1092P PS=1.11U PD=1.36U
* device instance $1546 r0 *1 44.63,72.88 sky130_fd_pr__nfet_01v8
M$1546 96 1317 1192 1192 sky130_fd_pr__nfet_01v8 L=0.15U W=0.65U AS=0.169P
+ AD=0.11285P PS=1.82U PD=1.045U
* device instance $1547 r0 *1 45.175,72.995 sky130_fd_pr__nfet_01v8
M$1547 1351 63 96 96 sky130_fd_pr__nfet_01v8 L=0.15U W=0.42U AS=0.11285P
+ AD=0.0693P PS=1.045U PD=0.75U
* device instance $1548 r0 *1 45.655,72.995 sky130_fd_pr__nfet_01v8
M$1548 1317 1318 1351 1351 sky130_fd_pr__nfet_01v8 L=0.15U W=0.42U AS=0.0693P
+ AD=0.09975P PS=0.75U PD=0.895U
* device instance $1549 r0 *1 46.28,72.995 sky130_fd_pr__nfet_01v8
M$1549 1350 1115 1317 1317 sky130_fd_pr__nfet_01v8 L=0.15U W=0.42U AS=0.09975P
+ AD=0.0693P PS=0.895U PD=0.75U
* device instance $1550 r0 *1 46.76,72.995 sky130_fd_pr__nfet_01v8
M$1550 96 1341 1350 1350 sky130_fd_pr__nfet_01v8 L=0.15U W=0.42U AS=0.0693P
+ AD=0.1449P PS=0.75U PD=1.11U
* device instance $1551 r0 *1 47.6,72.995 sky130_fd_pr__nfet_01v8
M$1551 1341 63 96 96 sky130_fd_pr__nfet_01v8 L=0.15U W=0.42U AS=0.1449P
+ AD=0.1092P PS=1.11U PD=1.36U
* device instance $1552 r0 *1 58.5,72.995 sky130_fd_pr__nfet_01v8
M$1552 1349 1319 1320 1320 sky130_fd_pr__nfet_01v8 L=0.15U W=0.42U AS=0.1113P
+ AD=0.0441P PS=1.37U PD=0.63U
* device instance $1553 r0 *1 58.86,72.995 sky130_fd_pr__nfet_01v8
M$1553 96 114 1349 1349 sky130_fd_pr__nfet_01v8 L=0.15U W=0.42U AS=0.0441P
+ AD=0.0966P PS=0.63U PD=0.88U
* device instance $1554 r0 *1 59.47,72.995 sky130_fd_pr__nfet_01v8
M$1554 1279 1320 96 96 sky130_fd_pr__nfet_01v8 L=0.15U W=0.42U AS=0.0966P
+ AD=0.1113P PS=0.88U PD=1.37U
* device instance $1555 r0 *1 60.73,72.995 sky130_fd_pr__nfet_01v8
M$1555 96 980 1321 1321 sky130_fd_pr__nfet_01v8 L=0.15U W=0.42U AS=0.1092P
+ AD=0.0567P PS=1.36U PD=0.69U
* device instance $1556 r0 *1 61.15,72.995 sky130_fd_pr__nfet_01v8
M$1556 1322 1321 96 96 sky130_fd_pr__nfet_01v8 L=0.15U W=0.42U AS=0.0567P
+ AD=0.1092P PS=0.69U PD=1.36U
* device instance $1557 r0 *1 62.09,72.995 sky130_fd_pr__nfet_01v8
M$1557 1348 1290 1323 1323 sky130_fd_pr__nfet_01v8 L=0.15U W=0.42U AS=0.1092P
+ AD=0.0441P PS=1.36U PD=0.63U
* device instance $1558 r0 *1 62.45,72.995 sky130_fd_pr__nfet_01v8
M$1558 96 302 1348 1348 sky130_fd_pr__nfet_01v8 L=0.15U W=0.42U AS=0.0441P
+ AD=0.1092P PS=0.63U PD=1.36U
* device instance $1559 r0 *1 63.39,72.995 sky130_fd_pr__nfet_01v8
M$1559 96 302 1324 1324 sky130_fd_pr__nfet_01v8 L=0.15U W=0.42U AS=0.1092P
+ AD=0.0609P PS=1.36U PD=0.71U
* device instance $1560 r0 *1 63.83,72.995 sky130_fd_pr__nfet_01v8
M$1560 1346 1324 96 96 sky130_fd_pr__nfet_01v8 L=0.15U W=0.42U AS=0.0609P
+ AD=0.0756P PS=0.71U PD=0.78U
* device instance $1561 r0 *1 64.34,72.995 sky130_fd_pr__nfet_01v8
M$1561 1323 1328 1346 1346 sky130_fd_pr__nfet_01v8 L=0.15U W=0.42U AS=0.0756P
+ AD=0.1446P PS=0.78U PD=1.18U
* device instance $1562 r0 *1 65.25,73.025 sky130_fd_pr__nfet_01v8
M$1562 1325 1321 1323 1323 sky130_fd_pr__nfet_01v8 L=0.15U W=0.36U AS=0.1446P
+ AD=0.0522P PS=1.18U PD=0.65U
* device instance $1563 r0 *1 65.69,73.025 sky130_fd_pr__nfet_01v8
M$1563 1325 1322 1344 1344 sky130_fd_pr__nfet_01v8 L=0.15U W=0.36U AS=0.0759P
+ AD=0.0522P PS=0.8U PD=0.65U
* device instance $1564 r0 *1 66.22,72.995 sky130_fd_pr__nfet_01v8
M$1564 1344 1326 96 96 sky130_fd_pr__nfet_01v8 L=0.15U W=0.42U AS=0.12095P
+ AD=0.0759P PS=1.085U PD=0.8U
* device instance $1565 r0 *1 66.815,72.885 sky130_fd_pr__nfet_01v8
M$1565 1326 1325 96 96 sky130_fd_pr__nfet_01v8 L=0.15U W=0.64U AS=0.12095P
+ AD=0.1664P PS=1.085U PD=1.8U
* device instance $1566 r0 *1 65.79,74 sky130_fd_pr__nfet_01v8
M$1566 96 1133 1354 1354 sky130_fd_pr__nfet_01v8 L=0.15U W=0.65U AS=0.169P
+ AD=0.08775P PS=1.82U PD=0.92U
* device instance $1567 r0 *1 66.21,74 sky130_fd_pr__nfet_01v8
M$1567 1280 1354 96 96 sky130_fd_pr__nfet_01v8 L=0.15U W=2.6U AS=0.351P
+ AD=0.43225P PS=3.68U PD=4.58U
* device instance $1571 r0 *1 67.755,72.995 sky130_fd_pr__nfet_01v8
M$1571 1343 1326 96 96 sky130_fd_pr__nfet_01v8 L=0.15U W=0.42U AS=0.1092P
+ AD=0.0678P PS=1.36U PD=0.755U
* device instance $1572 r0 *1 68.24,73.025 sky130_fd_pr__nfet_01v8
M$1572 1327 1322 1343 1343 sky130_fd_pr__nfet_01v8 L=0.15U W=0.36U AS=0.0678P
+ AD=0.0684P PS=0.755U PD=0.74U
* device instance $1573 r0 *1 68.77,73.025 sky130_fd_pr__nfet_01v8
M$1573 1327 1321 1342 1342 sky130_fd_pr__nfet_01v8 L=0.15U W=0.36U AS=0.066P
+ AD=0.0684P PS=0.745U PD=0.74U
* device instance $1574 r0 *1 69.245,72.995 sky130_fd_pr__nfet_01v8
M$1574 96 1328 1342 1342 sky130_fd_pr__nfet_01v8 L=0.15U W=0.42U AS=0.066P
+ AD=0.1092P PS=0.745U PD=1.36U
* device instance $1575 r0 *1 70.185,72.995 sky130_fd_pr__nfet_01v8
M$1575 1328 1327 96 96 sky130_fd_pr__nfet_01v8 L=0.15U W=0.42U AS=0.10025P
+ AD=0.1092P PS=0.985U PD=1.36U
* device instance $1576 r0 *1 70.67,72.88 sky130_fd_pr__nfet_01v8
M$1576 1132 1327 96 96 sky130_fd_pr__nfet_01v8 L=0.15U W=0.65U AS=0.10025P
+ AD=0.182P PS=0.985U PD=1.86U
* device instance $1577 r0 *1 14.525,4.885 sky130_fd_pr__pfet_01v8
M$1577 8 11 36 36 sky130_fd_pr__pfet_01v8 L=0.15U W=0.64U AS=0.154P AD=0.1728P
+ PS=1.335U PD=1.82U
* device instance $1578 r0 *1 15.01,4.705 sky130_fd_pr__pfet_01v8
M$1578 12 11 36 36 sky130_fd_pr__pfet_01v8 L=0.15U W=1U AS=0.154P AD=0.28P
+ PS=1.335U PD=2.56U
* device instance $1579 r0 *1 70.185,4.885 sky130_fd_pr__pfet_01v8
M$1579 16 19 36 36 sky130_fd_pr__pfet_01v8 L=0.15U W=0.64U AS=0.154P AD=0.1728P
+ PS=1.335U PD=1.82U
* device instance $1580 r0 *1 70.67,4.705 sky130_fd_pr__pfet_01v8
M$1580 20 19 36 36 sky130_fd_pr__pfet_01v8 L=0.15U W=1U AS=0.154P AD=0.28P
+ PS=1.335U PD=2.56U
* device instance $1581 r0 *1 5.07,4.855 sky130_fd_pr__pfet_01v8
M$1581 36 31 5 5 sky130_fd_pr__pfet_01v8 L=0.15U W=0.64U AS=0.1664P AD=0.0864P
+ PS=1.8U PD=0.91U
* device instance $1582 r0 *1 5.49,4.855 sky130_fd_pr__pfet_01v8
M$1582 6 5 36 36 sky130_fd_pr__pfet_01v8 L=0.15U W=0.64U AS=0.0864P AD=0.1664P
+ PS=0.91U PD=1.8U
* device instance $1583 r0 *1 6.43,4.885 sky130_fd_pr__pfet_01v8
M$1583 37 32 7 7 sky130_fd_pr__pfet_01v8 L=0.15U W=0.64U AS=0.1664P AD=0.0672P
+ PS=1.8U PD=0.85U
* device instance $1584 r0 *1 6.79,4.885 sky130_fd_pr__pfet_01v8
M$1584 36 33 37 37 sky130_fd_pr__pfet_01v8 L=0.15U W=0.64U AS=0.0672P
+ AD=0.1664P PS=0.85U PD=1.8U
* device instance $1585 r0 *1 7.73,4.885 sky130_fd_pr__pfet_01v8
M$1585 36 93 33 33 sky130_fd_pr__pfet_01v8 L=0.15U W=0.64U AS=0.1664P
+ AD=0.0928P PS=1.8U PD=0.93U
* device instance $1586 r0 *1 8.17,4.885 sky130_fd_pr__pfet_01v8
M$1586 40 93 36 36 sky130_fd_pr__pfet_01v8 L=0.15U W=0.64U AS=0.0928P
+ AD=0.1152P PS=0.93U PD=1U
* device instance $1587 r0 *1 8.68,4.885 sky130_fd_pr__pfet_01v8
M$1587 7 8 40 40 sky130_fd_pr__pfet_01v8 L=0.15U W=0.64U AS=0.1152P AD=0.15985P
+ PS=1U PD=1.265U
* device instance $1588 r0 *1 9.455,4.995 sky130_fd_pr__pfet_01v8
M$1588 9 6 7 7 sky130_fd_pr__pfet_01v8 L=0.15U W=0.42U AS=0.15985P AD=0.06405P
+ PS=1.265U PD=0.725U
* device instance $1589 r0 *1 9.91,4.995 sky130_fd_pr__pfet_01v8
M$1589 41 5 9 9 sky130_fd_pr__pfet_01v8 L=0.15U W=0.42U AS=0.06405P AD=0.07665P
+ PS=0.725U PD=0.785U
* device instance $1590 r0 *1 10.425,4.995 sky130_fd_pr__pfet_01v8
M$1590 41 10 36 36 sky130_fd_pr__pfet_01v8 L=0.15U W=0.42U AS=0.178875P
+ AD=0.07665P PS=1.26U PD=0.785U
* device instance $1591 r0 *1 11.085,4.83 sky130_fd_pr__pfet_01v8
M$1591 10 9 36 36 sky130_fd_pr__pfet_01v8 L=0.15U W=0.75U AS=0.178875P
+ AD=0.195P PS=1.26U PD=2.02U
* device instance $1592 r0 *1 60.73,4.855 sky130_fd_pr__pfet_01v8
M$1592 36 333 13 13 sky130_fd_pr__pfet_01v8 L=0.15U W=0.64U AS=0.1664P
+ AD=0.0864P PS=1.8U PD=0.91U
* device instance $1593 r0 *1 61.15,4.855 sky130_fd_pr__pfet_01v8
M$1593 14 13 36 36 sky130_fd_pr__pfet_01v8 L=0.15U W=0.64U AS=0.0864P
+ AD=0.1664P PS=0.91U PD=1.8U
* device instance $1594 r0 *1 62.09,4.885 sky130_fd_pr__pfet_01v8
M$1594 46 34 15 15 sky130_fd_pr__pfet_01v8 L=0.15U W=0.64U AS=0.1664P
+ AD=0.0672P PS=1.8U PD=0.85U
* device instance $1595 r0 *1 62.45,4.885 sky130_fd_pr__pfet_01v8
M$1595 36 35 46 46 sky130_fd_pr__pfet_01v8 L=0.15U W=0.64U AS=0.0672P
+ AD=0.1664P PS=0.85U PD=1.8U
* device instance $1596 r0 *1 63.39,4.885 sky130_fd_pr__pfet_01v8
M$1596 36 302 35 35 sky130_fd_pr__pfet_01v8 L=0.15U W=0.64U AS=0.1664P
+ AD=0.0928P PS=1.8U PD=0.93U
* device instance $1597 r0 *1 63.83,4.885 sky130_fd_pr__pfet_01v8
M$1597 44 302 36 36 sky130_fd_pr__pfet_01v8 L=0.15U W=0.64U AS=0.0928P
+ AD=0.1152P PS=0.93U PD=1U
* device instance $1598 r0 *1 64.34,4.885 sky130_fd_pr__pfet_01v8
M$1598 15 16 44 44 sky130_fd_pr__pfet_01v8 L=0.15U W=0.64U AS=0.1152P
+ AD=0.15985P PS=1U PD=1.265U
* device instance $1599 r0 *1 65.115,4.995 sky130_fd_pr__pfet_01v8
M$1599 17 14 15 15 sky130_fd_pr__pfet_01v8 L=0.15U W=0.42U AS=0.15985P
+ AD=0.06405P PS=1.265U PD=0.725U
* device instance $1600 r0 *1 65.57,4.995 sky130_fd_pr__pfet_01v8
M$1600 42 13 17 17 sky130_fd_pr__pfet_01v8 L=0.15U W=0.42U AS=0.06405P
+ AD=0.07665P PS=0.725U PD=0.785U
* device instance $1601 r0 *1 66.085,4.995 sky130_fd_pr__pfet_01v8
M$1601 42 18 36 36 sky130_fd_pr__pfet_01v8 L=0.15U W=0.42U AS=0.178875P
+ AD=0.07665P PS=1.26U PD=0.785U
* device instance $1602 r0 *1 66.745,4.83 sky130_fd_pr__pfet_01v8
M$1602 18 17 36 36 sky130_fd_pr__pfet_01v8 L=0.15U W=0.75U AS=0.178875P
+ AD=0.195P PS=1.26U PD=2.02U
* device instance $1603 r0 *1 6.89,5.995 sky130_fd_pr__pfet_01v8
M$1603 79 50 49 49 sky130_fd_pr__pfet_01v8 L=0.15U W=0.64U AS=0.1664P
+ AD=0.0672P PS=1.8U PD=0.85U
* device instance $1604 r0 *1 7.25,5.995 sky130_fd_pr__pfet_01v8
M$1604 36 51 79 79 sky130_fd_pr__pfet_01v8 L=0.15U W=0.64U AS=0.0672P
+ AD=0.1664P PS=0.85U PD=1.8U
* device instance $1605 r0 *1 9.915,5.885 sky130_fd_pr__pfet_01v8
M$1605 52 48 49 49 sky130_fd_pr__pfet_01v8 L=0.15U W=0.42U AS=0.15985P
+ AD=0.06405P PS=1.265U PD=0.725U
* device instance $1606 r0 *1 10.37,5.885 sky130_fd_pr__pfet_01v8
M$1606 83 47 52 52 sky130_fd_pr__pfet_01v8 L=0.15U W=0.42U AS=0.06405P
+ AD=0.07665P PS=0.725U PD=0.785U
* device instance $1607 r0 *1 10.885,5.885 sky130_fd_pr__pfet_01v8
M$1607 36 53 83 83 sky130_fd_pr__pfet_01v8 L=0.15U W=0.42U AS=0.07665P
+ AD=0.178875P PS=0.785U PD=1.26U
* device instance $1608 r0 *1 8.19,5.995 sky130_fd_pr__pfet_01v8
M$1608 36 302 51 51 sky130_fd_pr__pfet_01v8 L=0.15U W=0.64U AS=0.1664P
+ AD=0.0928P PS=1.8U PD=0.93U
* device instance $1609 r0 *1 8.63,5.995 sky130_fd_pr__pfet_01v8
M$1609 81 302 36 36 sky130_fd_pr__pfet_01v8 L=0.15U W=0.64U AS=0.0928P
+ AD=0.1152P PS=0.93U PD=1U
* device instance $1610 r0 *1 9.14,5.995 sky130_fd_pr__pfet_01v8
M$1610 49 55 81 81 sky130_fd_pr__pfet_01v8 L=0.15U W=0.64U AS=0.1152P
+ AD=0.15985P PS=1U PD=1.265U
* device instance $1611 r0 *1 11.545,6.05 sky130_fd_pr__pfet_01v8
M$1611 53 52 36 36 sky130_fd_pr__pfet_01v8 L=0.15U W=0.75U AS=0.178875P
+ AD=0.195P PS=1.26U PD=2.02U
* device instance $1612 r0 *1 12.025,4.995 sky130_fd_pr__pfet_01v8
M$1612 43 10 36 36 sky130_fd_pr__pfet_01v8 L=0.15U W=0.42U AS=0.1092P
+ AD=0.06405P PS=1.36U PD=0.725U
* device instance $1613 r0 *1 12.48,4.995 sky130_fd_pr__pfet_01v8
M$1613 11 5 43 43 sky130_fd_pr__pfet_01v8 L=0.15U W=0.42U AS=0.06405P
+ AD=0.0567P PS=0.725U PD=0.69U
* device instance $1614 r0 *1 12.9,4.995 sky130_fd_pr__pfet_01v8
M$1614 45 6 11 11 sky130_fd_pr__pfet_01v8 L=0.15U W=0.42U AS=0.0567P AD=0.0882P
+ PS=0.69U PD=0.84U
* device instance $1615 r0 *1 13.47,4.995 sky130_fd_pr__pfet_01v8
M$1615 36 8 45 45 sky130_fd_pr__pfet_01v8 L=0.15U W=0.42U AS=0.0882P AD=0.1113P
+ PS=0.84U PD=1.37U
* device instance $1616 r0 *1 12.485,5.885 sky130_fd_pr__pfet_01v8
M$1616 84 53 36 36 sky130_fd_pr__pfet_01v8 L=0.15U W=0.42U AS=0.1092P
+ AD=0.06405P PS=1.36U PD=0.725U
* device instance $1617 r0 *1 12.94,5.885 sky130_fd_pr__pfet_01v8
M$1617 54 47 84 84 sky130_fd_pr__pfet_01v8 L=0.15U W=0.42U AS=0.06405P
+ AD=0.0567P PS=0.725U PD=0.69U
* device instance $1618 r0 *1 13.36,5.885 sky130_fd_pr__pfet_01v8
M$1618 85 48 54 54 sky130_fd_pr__pfet_01v8 L=0.15U W=0.42U AS=0.0567P
+ AD=0.0882P PS=0.69U PD=0.84U
* device instance $1619 r0 *1 13.93,5.885 sky130_fd_pr__pfet_01v8
M$1619 36 55 85 85 sky130_fd_pr__pfet_01v8 L=0.15U W=0.42U AS=0.0882P
+ AD=0.1113P PS=0.84U PD=1.37U
* device instance $1620 r0 *1 14.985,5.995 sky130_fd_pr__pfet_01v8
M$1620 36 54 55 55 sky130_fd_pr__pfet_01v8 L=0.15U W=0.64U AS=0.1728P AD=0.154P
+ PS=1.82U PD=1.335U
* device instance $1621 r0 *1 15.47,6.175 sky130_fd_pr__pfet_01v8
M$1621 56 54 36 36 sky130_fd_pr__pfet_01v8 L=0.15U W=1U AS=0.154P AD=0.28P
+ PS=1.335U PD=2.56U
* device instance $1622 r0 *1 23.47,6.175 sky130_fd_pr__pfet_01v8
M$1622 58 90 57 57 sky130_fd_pr__pfet_01v8 L=0.15U W=1U AS=0.26P AD=0.135P
+ PS=2.52U PD=1.27U
* device instance $1623 r0 *1 23.89,6.175 sky130_fd_pr__pfet_01v8
M$1623 59 218 58 58 sky130_fd_pr__pfet_01v8 L=0.15U W=1U AS=0.135P AD=0.135P
+ PS=1.27U PD=1.27U
* device instance $1624 r0 *1 24.31,6.175 sky130_fd_pr__pfet_01v8
M$1624 58 91 59 59 sky130_fd_pr__pfet_01v8 L=0.15U W=1U AS=0.135P AD=0.26P
+ PS=1.27U PD=2.52U
* device instance $1625 r0 *1 25.25,6.175 sky130_fd_pr__pfet_01v8
M$1625 59 157 36 36 sky130_fd_pr__pfet_01v8 L=0.15U W=1U AS=0.26P AD=0.165P
+ PS=2.52U PD=1.33U
* device instance $1626 r0 *1 25.73,6.175 sky130_fd_pr__pfet_01v8
M$1626 36 92 59 59 sky130_fd_pr__pfet_01v8 L=0.15U W=1U AS=0.165P AD=0.1575P
+ PS=1.33U PD=1.315U
* device instance $1627 r0 *1 26.195,6.175 sky130_fd_pr__pfet_01v8
M$1627 61 57 36 36 sky130_fd_pr__pfet_01v8 L=0.15U W=1U AS=0.1575P AD=0.26P
+ PS=1.315U PD=2.52U
* device instance $1628 r0 *1 27.665,5.995 sky130_fd_pr__pfet_01v8
M$1628 89 62 36 36 sky130_fd_pr__pfet_01v8 L=0.15U W=0.64U AS=0.1696P
+ AD=0.0768P PS=1.81U PD=0.88U
* device instance $1629 r0 *1 28.055,5.995 sky130_fd_pr__pfet_01v8
M$1629 60 63 89 89 sky130_fd_pr__pfet_01v8 L=0.15U W=0.64U AS=0.0768P
+ AD=0.0896P PS=0.88U PD=0.92U
* device instance $1630 r0 *1 28.485,5.995 sky130_fd_pr__pfet_01v8
M$1630 36 64 60 60 sky130_fd_pr__pfet_01v8 L=0.15U W=0.64U AS=0.0896P
+ AD=0.1824P PS=0.92U PD=1.85U
* device instance $1631 r0 *1 44.67,6.175 sky130_fd_pr__pfet_01v8
M$1631 94 66 65 65 sky130_fd_pr__pfet_01v8 L=0.15U W=1U AS=0.26P AD=0.135P
+ PS=2.52U PD=1.27U
* device instance $1632 r0 *1 45.09,6.175 sky130_fd_pr__pfet_01v8
M$1632 36 67 94 94 sky130_fd_pr__pfet_01v8 L=0.15U W=1U AS=0.135P AD=0.135P
+ PS=1.27U PD=1.27U
* device instance $1633 r0 *1 45.51,6.175 sky130_fd_pr__pfet_01v8
M$1633 68 67 36 36 sky130_fd_pr__pfet_01v8 L=0.15U W=1U AS=0.135P AD=0.135P
+ PS=1.27U PD=1.27U
* device instance $1634 r0 *1 45.93,6.175 sky130_fd_pr__pfet_01v8
M$1634 36 66 68 68 sky130_fd_pr__pfet_01v8 L=0.15U W=1U AS=0.135P AD=0.26P
+ PS=1.27U PD=2.52U
* device instance $1635 r0 *1 46.87,6.175 sky130_fd_pr__pfet_01v8
M$1635 69 65 68 68 sky130_fd_pr__pfet_01v8 L=0.15U W=1U AS=0.26P AD=0.3P
+ PS=2.52U PD=2.6U
* device instance $1636 r0 *1 66.23,5.995 sky130_fd_pr__pfet_01v8
M$1636 88 73 72 72 sky130_fd_pr__pfet_01v8 L=0.15U W=0.64U AS=0.1664P
+ AD=0.0672P PS=1.8U PD=0.85U
* device instance $1637 r0 *1 66.59,5.995 sky130_fd_pr__pfet_01v8
M$1637 36 74 88 88 sky130_fd_pr__pfet_01v8 L=0.15U W=0.64U AS=0.0672P
+ AD=0.1664P PS=0.85U PD=1.8U
* device instance $1638 r0 *1 69.255,5.885 sky130_fd_pr__pfet_01v8
M$1638 75 71 72 72 sky130_fd_pr__pfet_01v8 L=0.15U W=0.42U AS=0.15985P
+ AD=0.06405P PS=1.265U PD=0.725U
* device instance $1639 r0 *1 69.71,5.885 sky130_fd_pr__pfet_01v8
M$1639 86 70 75 75 sky130_fd_pr__pfet_01v8 L=0.15U W=0.42U AS=0.06405P
+ AD=0.07665P PS=0.725U PD=0.785U
* device instance $1640 r0 *1 70.225,5.885 sky130_fd_pr__pfet_01v8
M$1640 36 76 86 86 sky130_fd_pr__pfet_01v8 L=0.15U W=0.42U AS=0.07665P
+ AD=0.178875P PS=0.785U PD=1.26U
* device instance $1641 r0 *1 67.53,5.995 sky130_fd_pr__pfet_01v8
M$1641 36 93 74 74 sky130_fd_pr__pfet_01v8 L=0.15U W=0.64U AS=0.1664P
+ AD=0.0928P PS=1.8U PD=0.93U
* device instance $1642 r0 *1 67.97,5.995 sky130_fd_pr__pfet_01v8
M$1642 87 93 36 36 sky130_fd_pr__pfet_01v8 L=0.15U W=0.64U AS=0.0928P
+ AD=0.1152P PS=0.93U PD=1U
* device instance $1643 r0 *1 68.48,5.995 sky130_fd_pr__pfet_01v8
M$1643 72 78 87 87 sky130_fd_pr__pfet_01v8 L=0.15U W=0.64U AS=0.1152P
+ AD=0.15985P PS=1U PD=1.265U
* device instance $1644 r0 *1 70.885,6.05 sky130_fd_pr__pfet_01v8
M$1644 76 75 36 36 sky130_fd_pr__pfet_01v8 L=0.15U W=0.75U AS=0.178875P
+ AD=0.195P PS=1.26U PD=2.02U
* device instance $1645 r0 *1 67.685,4.995 sky130_fd_pr__pfet_01v8
M$1645 39 18 36 36 sky130_fd_pr__pfet_01v8 L=0.15U W=0.42U AS=0.1092P
+ AD=0.06405P PS=1.36U PD=0.725U
* device instance $1646 r0 *1 68.14,4.995 sky130_fd_pr__pfet_01v8
M$1646 19 13 39 39 sky130_fd_pr__pfet_01v8 L=0.15U W=0.42U AS=0.06405P
+ AD=0.0567P PS=0.725U PD=0.69U
* device instance $1647 r0 *1 68.56,4.995 sky130_fd_pr__pfet_01v8
M$1647 38 14 19 19 sky130_fd_pr__pfet_01v8 L=0.15U W=0.42U AS=0.0567P
+ AD=0.0882P PS=0.69U PD=0.84U
* device instance $1648 r0 *1 69.13,4.995 sky130_fd_pr__pfet_01v8
M$1648 36 16 38 38 sky130_fd_pr__pfet_01v8 L=0.15U W=0.42U AS=0.0882P
+ AD=0.1113P PS=0.84U PD=1.37U
* device instance $1649 r0 *1 71.825,5.885 sky130_fd_pr__pfet_01v8
M$1649 82 76 36 36 sky130_fd_pr__pfet_01v8 L=0.15U W=0.42U AS=0.1092P
+ AD=0.06405P PS=1.36U PD=0.725U
* device instance $1650 r0 *1 72.28,5.885 sky130_fd_pr__pfet_01v8
M$1650 77 70 82 82 sky130_fd_pr__pfet_01v8 L=0.15U W=0.42U AS=0.06405P
+ AD=0.0567P PS=0.725U PD=0.69U
* device instance $1651 r0 *1 72.7,5.885 sky130_fd_pr__pfet_01v8
M$1651 80 71 77 77 sky130_fd_pr__pfet_01v8 L=0.15U W=0.42U AS=0.0567P
+ AD=0.0882P PS=0.69U PD=0.84U
* device instance $1652 r0 *1 73.27,5.885 sky130_fd_pr__pfet_01v8
M$1652 36 78 80 80 sky130_fd_pr__pfet_01v8 L=0.15U W=0.42U AS=0.0882P
+ AD=0.1113P PS=0.84U PD=1.37U
* device instance $1653 r0 *1 74.325,5.995 sky130_fd_pr__pfet_01v8
M$1653 36 77 78 78 sky130_fd_pr__pfet_01v8 L=0.15U W=0.64U AS=0.1728P AD=0.154P
+ PS=1.82U PD=1.335U
* device instance $1654 r0 *1 74.81,6.175 sky130_fd_pr__pfet_01v8
M$1654 161 77 36 36 sky130_fd_pr__pfet_01v8 L=0.15U W=1U AS=0.154P AD=0.28P
+ PS=1.335U PD=2.56U
* device instance $1655 r0 *1 5.53,6.025 sky130_fd_pr__pfet_01v8
M$1655 36 31 47 47 sky130_fd_pr__pfet_01v8 L=0.15U W=0.64U AS=0.1664P
+ AD=0.0864P PS=1.8U PD=0.91U
* device instance $1656 r0 *1 5.95,6.025 sky130_fd_pr__pfet_01v8
M$1656 48 47 36 36 sky130_fd_pr__pfet_01v8 L=0.15U W=0.64U AS=0.0864P
+ AD=0.1664P PS=0.91U PD=1.8U
* device instance $1657 r0 *1 9.21,10.145 sky130_fd_pr__pfet_01v8
M$1657 166 111 112 112 sky130_fd_pr__pfet_01v8 L=0.15U W=1U AS=0.26P AD=0.135P
+ PS=2.52U PD=1.27U
* device instance $1658 r0 *1 9.63,10.145 sky130_fd_pr__pfet_01v8
M$1658 162 12 166 166 sky130_fd_pr__pfet_01v8 L=0.15U W=1U AS=0.135P AD=0.135P
+ PS=1.27U PD=1.27U
* device instance $1659 r0 *1 10.05,10.145 sky130_fd_pr__pfet_01v8
M$1659 166 91 162 162 sky130_fd_pr__pfet_01v8 L=0.15U W=1U AS=0.135P AD=0.26P
+ PS=1.27U PD=2.52U
* device instance $1660 r0 *1 10.99,10.145 sky130_fd_pr__pfet_01v8
M$1660 162 157 36 36 sky130_fd_pr__pfet_01v8 L=0.15U W=1U AS=0.26P AD=0.165P
+ PS=2.52U PD=1.33U
* device instance $1661 r0 *1 11.47,10.145 sky130_fd_pr__pfet_01v8
M$1661 36 158 162 162 sky130_fd_pr__pfet_01v8 L=0.15U W=1U AS=0.165P AD=0.1575P
+ PS=1.33U PD=1.315U
* device instance $1662 r0 *1 11.935,10.145 sky130_fd_pr__pfet_01v8
M$1662 50 112 36 36 sky130_fd_pr__pfet_01v8 L=0.15U W=1U AS=0.1575P AD=0.26P
+ PS=1.315U PD=2.52U
* device instance $1663 r0 *1 25.31,10.295 sky130_fd_pr__pfet_01v8
M$1663 36 31 115 115 sky130_fd_pr__pfet_01v8 L=0.15U W=0.64U AS=0.1664P
+ AD=0.0864P PS=1.8U PD=0.91U
* device instance $1664 r0 *1 25.73,10.295 sky130_fd_pr__pfet_01v8
M$1664 116 115 36 36 sky130_fd_pr__pfet_01v8 L=0.15U W=0.64U AS=0.0864P
+ AD=0.1664P PS=0.91U PD=1.8U
* device instance $1665 r0 *1 26.67,10.325 sky130_fd_pr__pfet_01v8
M$1665 173 60 117 117 sky130_fd_pr__pfet_01v8 L=0.15U W=0.64U AS=0.1664P
+ AD=0.0672P PS=1.8U PD=0.85U
* device instance $1666 r0 *1 27.03,10.325 sky130_fd_pr__pfet_01v8
M$1666 36 118 173 173 sky130_fd_pr__pfet_01v8 L=0.15U W=0.64U AS=0.0672P
+ AD=0.1664P PS=0.85U PD=1.8U
* device instance $1667 r0 *1 27.97,10.325 sky130_fd_pr__pfet_01v8
M$1667 36 93 118 118 sky130_fd_pr__pfet_01v8 L=0.15U W=0.64U AS=0.1664P
+ AD=0.0928P PS=1.8U PD=0.93U
* device instance $1668 r0 *1 28.41,10.325 sky130_fd_pr__pfet_01v8
M$1668 174 93 36 36 sky130_fd_pr__pfet_01v8 L=0.15U W=0.64U AS=0.0928P
+ AD=0.1152P PS=0.93U PD=1U
* device instance $1669 r0 *1 28.92,10.325 sky130_fd_pr__pfet_01v8
M$1669 117 119 174 174 sky130_fd_pr__pfet_01v8 L=0.15U W=0.64U AS=0.1152P
+ AD=0.15985P PS=1U PD=1.265U
* device instance $1670 r0 *1 29.695,10.435 sky130_fd_pr__pfet_01v8
M$1670 120 116 117 117 sky130_fd_pr__pfet_01v8 L=0.15U W=0.42U AS=0.15985P
+ AD=0.06405P PS=1.265U PD=0.725U
* device instance $1671 r0 *1 30.15,10.435 sky130_fd_pr__pfet_01v8
M$1671 177 115 120 120 sky130_fd_pr__pfet_01v8 L=0.15U W=0.42U AS=0.06405P
+ AD=0.07665P PS=0.725U PD=0.785U
* device instance $1672 r0 *1 30.665,10.435 sky130_fd_pr__pfet_01v8
M$1672 177 121 36 36 sky130_fd_pr__pfet_01v8 L=0.15U W=0.42U AS=0.178875P
+ AD=0.07665P PS=1.26U PD=0.785U
* device instance $1673 r0 *1 31.325,10.27 sky130_fd_pr__pfet_01v8
M$1673 121 120 36 36 sky130_fd_pr__pfet_01v8 L=0.15U W=0.75U AS=0.178875P
+ AD=0.195P PS=1.26U PD=2.02U
* device instance $1674 r0 *1 34.765,10.325 sky130_fd_pr__pfet_01v8
M$1674 119 122 36 36 sky130_fd_pr__pfet_01v8 L=0.15U W=0.64U AS=0.154P
+ AD=0.1728P PS=1.335U PD=1.82U
* device instance $1675 r0 *1 35.25,10.145 sky130_fd_pr__pfet_01v8
M$1675 218 122 36 36 sky130_fd_pr__pfet_01v8 L=0.15U W=1U AS=0.154P AD=0.28P
+ PS=1.335U PD=2.56U
* device instance $1676 r0 *1 47.475,10.24 sky130_fd_pr__pfet_01v8
M$1676 172 63 36 36 sky130_fd_pr__pfet_01v8 L=0.15U W=0.42U AS=0.15835P
+ AD=0.07665P PS=1.395U PD=0.785U
* device instance $1677 r0 *1 47.99,10.24 sky130_fd_pr__pfet_01v8
M$1677 127 128 172 172 sky130_fd_pr__pfet_01v8 L=0.15U W=0.42U AS=0.07665P
+ AD=0.1932P PS=0.785U PD=1.34U
* device instance $1678 r0 *1 49.06,10.24 sky130_fd_pr__pfet_01v8
M$1678 171 129 127 127 sky130_fd_pr__pfet_01v8 L=0.15U W=0.42U AS=0.1932P
+ AD=0.0441P PS=1.34U PD=0.63U
* device instance $1679 r0 *1 49.42,10.24 sky130_fd_pr__pfet_01v8
M$1679 36 130 171 171 sky130_fd_pr__pfet_01v8 L=0.15U W=0.42U AS=0.0441P
+ AD=0.0693P PS=0.63U PD=0.75U
* device instance $1680 r0 *1 49.9,10.24 sky130_fd_pr__pfet_01v8
M$1680 130 63 36 36 sky130_fd_pr__pfet_01v8 L=0.15U W=0.42U AS=0.0693P
+ AD=0.1176P PS=0.75U PD=1.4U
* device instance $1681 r0 *1 46.93,10.145 sky130_fd_pr__pfet_01v8
M$1681 36 127 126 126 sky130_fd_pr__pfet_01v8 L=0.15U W=1U AS=0.26P AD=0.15835P
+ PS=2.52U PD=1.395U
* device instance $1682 r0 *1 59.81,10.145 sky130_fd_pr__pfet_01v8
M$1682 168 132 133 133 sky130_fd_pr__pfet_01v8 L=0.15U W=1U AS=0.26P AD=0.135P
+ PS=2.52U PD=1.27U
* device instance $1683 r0 *1 60.23,10.145 sky130_fd_pr__pfet_01v8
M$1683 165 161 168 168 sky130_fd_pr__pfet_01v8 L=0.15U W=1U AS=0.135P AD=0.135P
+ PS=1.27U PD=1.27U
* device instance $1684 r0 *1 60.65,10.145 sky130_fd_pr__pfet_01v8
M$1684 168 91 165 165 sky130_fd_pr__pfet_01v8 L=0.15U W=1U AS=0.135P AD=0.26P
+ PS=1.27U PD=2.52U
* device instance $1685 r0 *1 61.59,10.145 sky130_fd_pr__pfet_01v8
M$1685 165 134 36 36 sky130_fd_pr__pfet_01v8 L=0.15U W=1U AS=0.26P AD=0.165P
+ PS=2.52U PD=1.33U
* device instance $1686 r0 *1 62.07,10.145 sky130_fd_pr__pfet_01v8
M$1686 36 4 165 165 sky130_fd_pr__pfet_01v8 L=0.15U W=1U AS=0.165P AD=0.1575P
+ PS=1.33U PD=1.315U
* device instance $1687 r0 *1 62.535,10.145 sky130_fd_pr__pfet_01v8
M$1687 34 133 36 36 sky130_fd_pr__pfet_01v8 L=0.15U W=1U AS=0.1575P AD=0.26P
+ PS=1.315U PD=2.52U
* device instance $1688 r0 *1 64.87,6.025 sky130_fd_pr__pfet_01v8
M$1688 36 333 70 70 sky130_fd_pr__pfet_01v8 L=0.15U W=0.64U AS=0.1664P
+ AD=0.0864P PS=1.8U PD=0.91U
* device instance $1689 r0 *1 65.29,6.025 sky130_fd_pr__pfet_01v8
M$1689 71 70 36 36 sky130_fd_pr__pfet_01v8 L=0.15U W=0.64U AS=0.0864P
+ AD=0.1664P PS=0.91U PD=1.8U
* device instance $1690 r0 *1 68.175,10.24 sky130_fd_pr__pfet_01v8
M$1690 170 63 36 36 sky130_fd_pr__pfet_01v8 L=0.15U W=0.42U AS=0.15835P
+ AD=0.07665P PS=1.395U PD=0.785U
* device instance $1691 r0 *1 68.69,10.24 sky130_fd_pr__pfet_01v8
M$1691 135 20 170 170 sky130_fd_pr__pfet_01v8 L=0.15U W=0.42U AS=0.07665P
+ AD=0.1932P PS=0.785U PD=1.34U
* device instance $1692 r0 *1 69.76,10.24 sky130_fd_pr__pfet_01v8
M$1692 169 136 135 135 sky130_fd_pr__pfet_01v8 L=0.15U W=0.42U AS=0.1932P
+ AD=0.0441P PS=1.34U PD=0.63U
* device instance $1693 r0 *1 70.12,10.24 sky130_fd_pr__pfet_01v8
M$1693 36 137 169 169 sky130_fd_pr__pfet_01v8 L=0.15U W=0.42U AS=0.0441P
+ AD=0.0693P PS=0.63U PD=0.75U
* device instance $1694 r0 *1 70.6,10.24 sky130_fd_pr__pfet_01v8
M$1694 137 63 36 36 sky130_fd_pr__pfet_01v8 L=0.15U W=0.42U AS=0.0693P
+ AD=0.1176P PS=0.75U PD=1.4U
* device instance $1695 r0 *1 67.63,10.145 sky130_fd_pr__pfet_01v8
M$1695 36 135 73 73 sky130_fd_pr__pfet_01v8 L=0.15U W=1U AS=0.26P AD=0.15835P
+ PS=2.52U PD=1.395U
* device instance $1696 r0 *1 6.98,10.435 sky130_fd_pr__pfet_01v8
M$1696 110 156 36 36 sky130_fd_pr__pfet_01v8 L=0.15U W=0.42U AS=0.1113P
+ AD=0.0609P PS=1.37U PD=0.71U
* device instance $1697 r0 *1 7.42,10.435 sky130_fd_pr__pfet_01v8
M$1697 110 114 36 36 sky130_fd_pr__pfet_01v8 L=0.15U W=0.42U AS=0.1841P
+ AD=0.0609P PS=1.26U PD=0.71U
* device instance $1698 r0 *1 8.19,10.325 sky130_fd_pr__pfet_01v8
M$1698 111 110 36 36 sky130_fd_pr__pfet_01v8 L=0.15U W=0.64U AS=0.1841P
+ AD=0.1696P PS=1.26U PD=1.81U
* device instance $1699 r0 *1 8.375,11.52 sky130_fd_pr__pfet_01v8
M$1699 222 63 36 36 sky130_fd_pr__pfet_01v8 L=0.15U W=0.42U AS=0.15835P
+ AD=0.07665P PS=1.395U PD=0.785U
* device instance $1700 r0 *1 8.89,11.52 sky130_fd_pr__pfet_01v8
M$1700 178 56 222 222 sky130_fd_pr__pfet_01v8 L=0.15U W=0.42U AS=0.07665P
+ AD=0.1932P PS=0.785U PD=1.34U
* device instance $1701 r0 *1 9.96,11.52 sky130_fd_pr__pfet_01v8
M$1701 223 1 178 178 sky130_fd_pr__pfet_01v8 L=0.15U W=0.42U AS=0.1932P
+ AD=0.0441P PS=1.34U PD=0.63U
* device instance $1702 r0 *1 10.32,11.52 sky130_fd_pr__pfet_01v8
M$1702 36 232 223 223 sky130_fd_pr__pfet_01v8 L=0.15U W=0.42U AS=0.0441P
+ AD=0.0693P PS=0.63U PD=0.75U
* device instance $1703 r0 *1 10.8,11.52 sky130_fd_pr__pfet_01v8
M$1703 232 63 36 36 sky130_fd_pr__pfet_01v8 L=0.15U W=0.42U AS=0.0693P
+ AD=0.1176P PS=0.75U PD=1.4U
* device instance $1704 r0 *1 7.83,11.615 sky130_fd_pr__pfet_01v8
M$1704 36 178 32 32 sky130_fd_pr__pfet_01v8 L=0.15U W=1U AS=0.26P AD=0.15835P
+ PS=2.52U PD=1.395U
* device instance $1705 r0 *1 12.47,11.615 sky130_fd_pr__pfet_01v8
M$1705 179 217 36 36 sky130_fd_pr__pfet_01v8 L=0.15U W=1U AS=0.3P AD=0.135P
+ PS=2.6U PD=1.27U
* device instance $1706 r0 *1 12.89,11.615 sky130_fd_pr__pfet_01v8
M$1706 36 180 179 179 sky130_fd_pr__pfet_01v8 L=0.15U W=1U AS=0.135P AD=0.365P
+ PS=1.27U PD=1.73U
* device instance $1707 r0 *1 13.77,11.615 sky130_fd_pr__pfet_01v8
M$1707 224 180 36 36 sky130_fd_pr__pfet_01v8 L=0.15U W=1U AS=0.365P AD=0.105P
+ PS=1.73U PD=1.21U
* device instance $1708 r0 *1 14.13,11.615 sky130_fd_pr__pfet_01v8
M$1708 158 217 224 224 sky130_fd_pr__pfet_01v8 L=0.15U W=1U AS=0.105P AD=0.165P
+ PS=1.21U PD=1.33U
* device instance $1709 r0 *1 14.61,11.615 sky130_fd_pr__pfet_01v8
M$1709 36 179 158 158 sky130_fd_pr__pfet_01v8 L=0.15U W=1U AS=0.165P AD=0.36P
+ PS=1.33U PD=2.72U
* device instance $1710 r0 *1 15.69,11.615 sky130_fd_pr__pfet_01v8
M$1710 225 56 181 181 sky130_fd_pr__pfet_01v8 L=0.15U W=1U AS=0.26P AD=0.135P
+ PS=2.52U PD=1.27U
* device instance $1711 r0 *1 16.11,11.615 sky130_fd_pr__pfet_01v8
M$1711 36 12 225 225 sky130_fd_pr__pfet_01v8 L=0.15U W=1U AS=0.135P AD=0.135P
+ PS=1.27U PD=1.27U
* device instance $1712 r0 *1 16.53,11.615 sky130_fd_pr__pfet_01v8
M$1712 182 12 36 36 sky130_fd_pr__pfet_01v8 L=0.15U W=1U AS=0.135P AD=0.135P
+ PS=1.27U PD=1.27U
* device instance $1713 r0 *1 16.95,11.615 sky130_fd_pr__pfet_01v8
M$1713 36 56 182 182 sky130_fd_pr__pfet_01v8 L=0.15U W=1U AS=0.135P AD=0.26P
+ PS=1.27U PD=2.52U
* device instance $1714 r0 *1 17.89,11.615 sky130_fd_pr__pfet_01v8
M$1714 217 181 182 182 sky130_fd_pr__pfet_01v8 L=0.15U W=1U AS=0.26P AD=0.3P
+ PS=2.52U PD=2.6U
* device instance $1715 r0 *1 20.69,11.435 sky130_fd_pr__pfet_01v8
M$1715 227 61 185 185 sky130_fd_pr__pfet_01v8 L=0.15U W=0.64U AS=0.1664P
+ AD=0.0672P PS=1.8U PD=0.85U
* device instance $1716 r0 *1 21.05,11.435 sky130_fd_pr__pfet_01v8
M$1716 36 186 227 227 sky130_fd_pr__pfet_01v8 L=0.15U W=0.64U AS=0.0672P
+ AD=0.1664P PS=0.85U PD=1.8U
* device instance $1717 r0 *1 23.715,11.325 sky130_fd_pr__pfet_01v8
M$1717 187 184 185 185 sky130_fd_pr__pfet_01v8 L=0.15U W=0.42U AS=0.15985P
+ AD=0.06405P PS=1.265U PD=0.725U
* device instance $1718 r0 *1 24.17,11.325 sky130_fd_pr__pfet_01v8
M$1718 211 183 187 187 sky130_fd_pr__pfet_01v8 L=0.15U W=0.42U AS=0.06405P
+ AD=0.07665P PS=0.725U PD=0.785U
* device instance $1719 r0 *1 24.685,11.325 sky130_fd_pr__pfet_01v8
M$1719 36 188 211 211 sky130_fd_pr__pfet_01v8 L=0.15U W=0.42U AS=0.07665P
+ AD=0.178875P PS=0.785U PD=1.26U
* device instance $1720 r0 *1 21.99,11.435 sky130_fd_pr__pfet_01v8
M$1720 36 302 186 186 sky130_fd_pr__pfet_01v8 L=0.15U W=0.64U AS=0.1664P
+ AD=0.0928P PS=1.8U PD=0.93U
* device instance $1721 r0 *1 22.43,11.435 sky130_fd_pr__pfet_01v8
M$1721 228 302 36 36 sky130_fd_pr__pfet_01v8 L=0.15U W=0.64U AS=0.0928P
+ AD=0.1152P PS=0.93U PD=1U
* device instance $1722 r0 *1 22.94,11.435 sky130_fd_pr__pfet_01v8
M$1722 185 190 228 228 sky130_fd_pr__pfet_01v8 L=0.15U W=0.64U AS=0.1152P
+ AD=0.15985P PS=1U PD=1.265U
* device instance $1723 r0 *1 25.345,11.49 sky130_fd_pr__pfet_01v8
M$1723 188 187 36 36 sky130_fd_pr__pfet_01v8 L=0.15U W=0.75U AS=0.178875P
+ AD=0.195P PS=1.26U PD=2.02U
* device instance $1724 r0 *1 23.08,10.435 sky130_fd_pr__pfet_01v8
M$1724 113 159 36 36 sky130_fd_pr__pfet_01v8 L=0.15U W=0.42U AS=0.1113P
+ AD=0.0609P PS=1.37U PD=0.71U
* device instance $1725 r0 *1 23.52,10.435 sky130_fd_pr__pfet_01v8
M$1725 113 114 36 36 sky130_fd_pr__pfet_01v8 L=0.15U W=0.42U AS=0.1841P
+ AD=0.0609P PS=1.26U PD=0.71U
* device instance $1726 r0 *1 24.29,10.325 sky130_fd_pr__pfet_01v8
M$1726 90 113 36 36 sky130_fd_pr__pfet_01v8 L=0.15U W=0.64U AS=0.1841P
+ AD=0.1696P PS=1.26U PD=1.81U
* device instance $1727 r0 *1 26.285,11.325 sky130_fd_pr__pfet_01v8
M$1727 212 188 36 36 sky130_fd_pr__pfet_01v8 L=0.15U W=0.42U AS=0.1092P
+ AD=0.06405P PS=1.36U PD=0.725U
* device instance $1728 r0 *1 26.74,11.325 sky130_fd_pr__pfet_01v8
M$1728 189 183 212 212 sky130_fd_pr__pfet_01v8 L=0.15U W=0.42U AS=0.06405P
+ AD=0.0567P PS=0.725U PD=0.69U
* device instance $1729 r0 *1 27.16,11.325 sky130_fd_pr__pfet_01v8
M$1729 213 184 189 189 sky130_fd_pr__pfet_01v8 L=0.15U W=0.42U AS=0.0567P
+ AD=0.0882P PS=0.69U PD=0.84U
* device instance $1730 r0 *1 27.73,11.325 sky130_fd_pr__pfet_01v8
M$1730 36 190 213 213 sky130_fd_pr__pfet_01v8 L=0.15U W=0.42U AS=0.0882P
+ AD=0.1113P PS=0.84U PD=1.37U
* device instance $1731 r0 *1 28.785,11.435 sky130_fd_pr__pfet_01v8
M$1731 36 189 190 190 sky130_fd_pr__pfet_01v8 L=0.15U W=0.64U AS=0.1728P
+ AD=0.154P PS=1.82U PD=1.335U
* device instance $1732 r0 *1 29.27,11.615 sky130_fd_pr__pfet_01v8
M$1732 191 189 36 36 sky130_fd_pr__pfet_01v8 L=0.15U W=1U AS=0.154P AD=0.28P
+ PS=1.335U PD=2.56U
* device instance $1733 r0 *1 30.85,11.615 sky130_fd_pr__pfet_01v8
M$1733 64 2 36 36 sky130_fd_pr__pfet_01v8 L=0.15U W=1U AS=0.26P AD=0.135P
+ PS=2.52U PD=1.27U
* device instance $1734 r0 *1 31.27,11.615 sky130_fd_pr__pfet_01v8
M$1734 36 63 64 64 sky130_fd_pr__pfet_01v8 L=0.15U W=1U AS=0.135P AD=0.26P
+ PS=1.27U PD=2.52U
* device instance $1735 r0 *1 32.21,11.535 sky130_fd_pr__pfet_01v8
M$1735 62 191 36 36 sky130_fd_pr__pfet_01v8 L=0.15U W=1.68U AS=0.3318P
+ AD=0.3486P PS=3.31U PD=3.35U
* device instance $1737 r0 *1 32.265,10.435 sky130_fd_pr__pfet_01v8
M$1737 176 121 36 36 sky130_fd_pr__pfet_01v8 L=0.15U W=0.42U AS=0.1092P
+ AD=0.06405P PS=1.36U PD=0.725U
* device instance $1738 r0 *1 32.72,10.435 sky130_fd_pr__pfet_01v8
M$1738 122 115 176 176 sky130_fd_pr__pfet_01v8 L=0.15U W=0.42U AS=0.06405P
+ AD=0.0567P PS=0.725U PD=0.69U
* device instance $1739 r0 *1 33.14,10.435 sky130_fd_pr__pfet_01v8
M$1739 175 116 122 122 sky130_fd_pr__pfet_01v8 L=0.15U W=0.42U AS=0.0567P
+ AD=0.0882P PS=0.69U PD=0.84U
* device instance $1740 r0 *1 33.71,10.435 sky130_fd_pr__pfet_01v8
M$1740 36 119 175 175 sky130_fd_pr__pfet_01v8 L=0.15U W=0.42U AS=0.0882P
+ AD=0.1113P PS=0.84U PD=1.37U
* device instance $1741 r0 *1 33.605,11.615 sky130_fd_pr__pfet_01v8
M$1741 192 218 36 36 sky130_fd_pr__pfet_01v8 L=0.15U W=2U AS=0.44P AD=0.3P
+ PS=3.88U PD=2.6U
* device instance $1742 r0 *1 34.035,11.615 sky130_fd_pr__pfet_01v8
M$1742 66 62 192 192 sky130_fd_pr__pfet_01v8 L=0.15U W=2U AS=0.28P AD=0.315P
+ PS=2.56U PD=2.63U
* device instance $1745 r0 *1 35.435,11.615 sky130_fd_pr__pfet_01v8
M$1745 66 259 36 36 sky130_fd_pr__pfet_01v8 L=0.15U W=2U AS=0.3P AD=0.405P
+ PS=2.6U PD=3.81U
* device instance $1747 r0 *1 37.34,10.435 sky130_fd_pr__pfet_01v8
M$1747 123 163 36 36 sky130_fd_pr__pfet_01v8 L=0.15U W=0.42U AS=0.1113P
+ AD=0.0609P PS=1.37U PD=0.71U
* device instance $1748 r0 *1 37.78,10.435 sky130_fd_pr__pfet_01v8
M$1748 123 114 36 36 sky130_fd_pr__pfet_01v8 L=0.15U W=0.42U AS=0.1841P
+ AD=0.0609P PS=1.26U PD=0.71U
* device instance $1749 r0 *1 38.55,10.325 sky130_fd_pr__pfet_01v8
M$1749 124 123 36 36 sky130_fd_pr__pfet_01v8 L=0.15U W=0.64U AS=0.1841P
+ AD=0.1696P PS=1.26U PD=1.81U
* device instance $1750 r0 *1 40.95,11.615 sky130_fd_pr__pfet_01v8
M$1750 194 167 193 193 sky130_fd_pr__pfet_01v8 L=0.15U W=1U AS=0.26P AD=0.135P
+ PS=2.52U PD=1.27U
* device instance $1751 r0 *1 41.37,11.615 sky130_fd_pr__pfet_01v8
M$1751 196 195 194 194 sky130_fd_pr__pfet_01v8 L=0.15U W=1U AS=0.135P AD=0.135P
+ PS=1.27U PD=1.27U
* device instance $1752 r0 *1 41.79,11.615 sky130_fd_pr__pfet_01v8
M$1752 194 91 196 196 sky130_fd_pr__pfet_01v8 L=0.15U W=1U AS=0.135P AD=0.26P
+ PS=1.27U PD=2.52U
* device instance $1753 r0 *1 42.73,11.615 sky130_fd_pr__pfet_01v8
M$1753 196 134 36 36 sky130_fd_pr__pfet_01v8 L=0.15U W=1U AS=0.26P AD=0.165P
+ PS=2.52U PD=1.33U
* device instance $1754 r0 *1 43.21,11.615 sky130_fd_pr__pfet_01v8
M$1754 36 69 196 196 sky130_fd_pr__pfet_01v8 L=0.15U W=1U AS=0.165P AD=0.1575P
+ PS=1.33U PD=1.315U
* device instance $1755 r0 *1 43.675,11.615 sky130_fd_pr__pfet_01v8
M$1755 197 193 36 36 sky130_fd_pr__pfet_01v8 L=0.15U W=1U AS=0.1575P AD=0.26P
+ PS=1.315U PD=2.52U
* device instance $1756 r0 *1 44.7,10.435 sky130_fd_pr__pfet_01v8
M$1756 125 160 36 36 sky130_fd_pr__pfet_01v8 L=0.15U W=0.42U AS=0.1113P
+ AD=0.0609P PS=1.37U PD=0.71U
* device instance $1757 r0 *1 45.14,10.435 sky130_fd_pr__pfet_01v8
M$1757 125 114 36 36 sky130_fd_pr__pfet_01v8 L=0.15U W=0.42U AS=0.1841P
+ AD=0.0609P PS=1.26U PD=0.71U
* device instance $1758 r0 *1 45.91,10.325 sky130_fd_pr__pfet_01v8
M$1758 167 125 36 36 sky130_fd_pr__pfet_01v8 L=0.15U W=0.64U AS=0.1841P
+ AD=0.1696P PS=1.26U PD=1.81U
* device instance $1759 r0 *1 48.29,11.435 sky130_fd_pr__pfet_01v8
M$1759 231 126 200 200 sky130_fd_pr__pfet_01v8 L=0.15U W=0.64U AS=0.1664P
+ AD=0.0672P PS=1.8U PD=0.85U
* device instance $1760 r0 *1 48.65,11.435 sky130_fd_pr__pfet_01v8
M$1760 36 201 231 231 sky130_fd_pr__pfet_01v8 L=0.15U W=0.64U AS=0.0672P
+ AD=0.1664P PS=0.85U PD=1.8U
* device instance $1761 r0 *1 51.315,11.325 sky130_fd_pr__pfet_01v8
M$1761 202 199 200 200 sky130_fd_pr__pfet_01v8 L=0.15U W=0.42U AS=0.15985P
+ AD=0.06405P PS=1.265U PD=0.725U
* device instance $1762 r0 *1 51.77,11.325 sky130_fd_pr__pfet_01v8
M$1762 216 198 202 202 sky130_fd_pr__pfet_01v8 L=0.15U W=0.42U AS=0.06405P
+ AD=0.07665P PS=0.725U PD=0.785U
* device instance $1763 r0 *1 52.285,11.325 sky130_fd_pr__pfet_01v8
M$1763 36 203 216 216 sky130_fd_pr__pfet_01v8 L=0.15U W=0.42U AS=0.07665P
+ AD=0.178875P PS=0.785U PD=1.26U
* device instance $1764 r0 *1 49.59,11.435 sky130_fd_pr__pfet_01v8
M$1764 36 93 201 201 sky130_fd_pr__pfet_01v8 L=0.15U W=0.64U AS=0.1664P
+ AD=0.0928P PS=1.8U PD=0.93U
* device instance $1765 r0 *1 50.03,11.435 sky130_fd_pr__pfet_01v8
M$1765 230 93 36 36 sky130_fd_pr__pfet_01v8 L=0.15U W=0.64U AS=0.0928P
+ AD=0.1152P PS=0.93U PD=1U
* device instance $1766 r0 *1 50.54,11.435 sky130_fd_pr__pfet_01v8
M$1766 200 205 230 230 sky130_fd_pr__pfet_01v8 L=0.15U W=0.64U AS=0.1152P
+ AD=0.15985P PS=1U PD=1.265U
* device instance $1767 r0 *1 52.945,11.49 sky130_fd_pr__pfet_01v8
M$1767 203 202 36 36 sky130_fd_pr__pfet_01v8 L=0.15U W=0.75U AS=0.178875P
+ AD=0.195P PS=1.26U PD=2.02U
* device instance $1768 r0 *1 53.885,11.325 sky130_fd_pr__pfet_01v8
M$1768 215 203 36 36 sky130_fd_pr__pfet_01v8 L=0.15U W=0.42U AS=0.1092P
+ AD=0.06405P PS=1.36U PD=0.725U
* device instance $1769 r0 *1 54.34,11.325 sky130_fd_pr__pfet_01v8
M$1769 204 198 215 215 sky130_fd_pr__pfet_01v8 L=0.15U W=0.42U AS=0.06405P
+ AD=0.0567P PS=0.725U PD=0.69U
* device instance $1770 r0 *1 54.76,11.325 sky130_fd_pr__pfet_01v8
M$1770 214 199 204 204 sky130_fd_pr__pfet_01v8 L=0.15U W=0.42U AS=0.0567P
+ AD=0.0882P PS=0.69U PD=0.84U
* device instance $1771 r0 *1 55.33,11.325 sky130_fd_pr__pfet_01v8
M$1771 36 205 214 214 sky130_fd_pr__pfet_01v8 L=0.15U W=0.42U AS=0.0882P
+ AD=0.1113P PS=0.84U PD=1.37U
* device instance $1772 r0 *1 56.385,11.435 sky130_fd_pr__pfet_01v8
M$1772 36 204 205 205 sky130_fd_pr__pfet_01v8 L=0.15U W=0.64U AS=0.1728P
+ AD=0.154P PS=1.82U PD=1.335U
* device instance $1773 r0 *1 56.87,11.615 sky130_fd_pr__pfet_01v8
M$1773 195 204 36 36 sky130_fd_pr__pfet_01v8 L=0.15U W=1U AS=0.154P AD=0.28P
+ PS=1.335U PD=2.56U
* device instance $1774 r0 *1 57.58,10.435 sky130_fd_pr__pfet_01v8
M$1774 131 164 36 36 sky130_fd_pr__pfet_01v8 L=0.15U W=0.42U AS=0.1113P
+ AD=0.0609P PS=1.37U PD=0.71U
* device instance $1775 r0 *1 58.02,10.435 sky130_fd_pr__pfet_01v8
M$1775 131 114 36 36 sky130_fd_pr__pfet_01v8 L=0.15U W=0.42U AS=0.1841P
+ AD=0.0609P PS=1.26U PD=0.71U
* device instance $1776 r0 *1 58.79,10.325 sky130_fd_pr__pfet_01v8
M$1776 132 131 36 36 sky130_fd_pr__pfet_01v8 L=0.15U W=0.64U AS=0.1841P
+ AD=0.1696P PS=1.26U PD=1.81U
* device instance $1777 r0 *1 61.69,11.615 sky130_fd_pr__pfet_01v8
M$1777 229 219 206 206 sky130_fd_pr__pfet_01v8 L=0.15U W=1U AS=0.26P AD=0.135P
+ PS=2.52U PD=1.27U
* device instance $1778 r0 *1 62.11,11.615 sky130_fd_pr__pfet_01v8
M$1778 36 220 229 229 sky130_fd_pr__pfet_01v8 L=0.15U W=1U AS=0.135P AD=0.135P
+ PS=1.27U PD=1.27U
* device instance $1779 r0 *1 62.53,11.615 sky130_fd_pr__pfet_01v8
M$1779 207 220 36 36 sky130_fd_pr__pfet_01v8 L=0.15U W=1U AS=0.135P AD=0.135P
+ PS=1.27U PD=1.27U
* device instance $1780 r0 *1 62.95,11.615 sky130_fd_pr__pfet_01v8
M$1780 36 219 207 207 sky130_fd_pr__pfet_01v8 L=0.15U W=1U AS=0.135P AD=0.26P
+ PS=1.27U PD=2.52U
* device instance $1781 r0 *1 63.89,11.615 sky130_fd_pr__pfet_01v8
M$1781 4 206 207 207 sky130_fd_pr__pfet_01v8 L=0.15U W=1U AS=0.26P AD=0.3P
+ PS=2.52U PD=2.6U
* device instance $1782 r0 *1 66.29,11.615 sky130_fd_pr__pfet_01v8
M$1782 226 20 208 208 sky130_fd_pr__pfet_01v8 L=0.15U W=1U AS=0.26P AD=0.135P
+ PS=2.52U PD=1.27U
* device instance $1783 r0 *1 66.71,11.615 sky130_fd_pr__pfet_01v8
M$1783 36 161 226 226 sky130_fd_pr__pfet_01v8 L=0.15U W=1U AS=0.135P AD=0.135P
+ PS=1.27U PD=1.27U
* device instance $1784 r0 *1 67.13,11.615 sky130_fd_pr__pfet_01v8
M$1784 209 161 36 36 sky130_fd_pr__pfet_01v8 L=0.15U W=1U AS=0.135P AD=0.135P
+ PS=1.27U PD=1.27U
* device instance $1785 r0 *1 67.55,11.615 sky130_fd_pr__pfet_01v8
M$1785 36 20 209 209 sky130_fd_pr__pfet_01v8 L=0.15U W=1U AS=0.135P AD=0.26P
+ PS=1.27U PD=2.52U
* device instance $1786 r0 *1 68.49,11.615 sky130_fd_pr__pfet_01v8
M$1786 220 208 209 209 sky130_fd_pr__pfet_01v8 L=0.15U W=1U AS=0.26P AD=0.3P
+ PS=2.52U PD=2.6U
* device instance $1787 r0 *1 69.47,11.905 sky130_fd_pr__pfet_01v8
M$1787 221 161 36 36 sky130_fd_pr__pfet_01v8 L=0.15U W=0.42U AS=0.14575P
+ AD=0.1092P PS=1.335U PD=1.36U
* device instance $1788 r0 *1 69.955,11.615 sky130_fd_pr__pfet_01v8
M$1788 210 20 36 36 sky130_fd_pr__pfet_01v8 L=0.15U W=1U AS=0.14575P AD=0.135P
+ PS=1.335U PD=1.27U
* device instance $1789 r0 *1 70.375,11.615 sky130_fd_pr__pfet_01v8
M$1789 36 221 210 210 sky130_fd_pr__pfet_01v8 L=0.15U W=1U AS=0.135P AD=0.265P
+ PS=1.27U PD=2.53U
* device instance $1790 r0 *1 12.67,15.295 sky130_fd_pr__pfet_01v8
M$1790 36 56 255 255 sky130_fd_pr__pfet_01v8 L=0.15U W=0.42U AS=0.1092P
+ AD=0.1573P PS=1.36U PD=1.39U
* device instance $1791 r0 *1 13.21,15.585 sky130_fd_pr__pfet_01v8
M$1791 285 12 36 36 sky130_fd_pr__pfet_01v8 L=0.15U W=1U AS=0.1573P AD=0.105P
+ PS=1.39U PD=1.21U
* device instance $1792 r0 *1 13.57,15.585 sky130_fd_pr__pfet_01v8
M$1792 282 255 285 285 sky130_fd_pr__pfet_01v8 L=0.15U W=1U AS=0.105P AD=0.26P
+ PS=1.21U PD=2.52U
* device instance $1793 r0 *1 13.82,17.055 sky130_fd_pr__pfet_01v8
M$1793 36 294 293 293 sky130_fd_pr__pfet_01v8 L=0.15U W=1U AS=0.26P AD=0.26P
+ PS=2.52U PD=2.52U
* device instance $1794 r0 *1 14.73,15.665 sky130_fd_pr__pfet_01v8
M$1794 256 217 36 36 sky130_fd_pr__pfet_01v8 L=0.15U W=1.68U AS=0.3318P
+ AD=0.3486P PS=3.31U PD=3.35U
* device instance $1796 r0 *1 14.76,17.055 sky130_fd_pr__pfet_01v8
M$1796 295 282 294 294 sky130_fd_pr__pfet_01v8 L=0.15U W=1U AS=0.26P AD=0.1375P
+ PS=2.52U PD=1.275U
* device instance $1797 r0 *1 15.185,17.055 sky130_fd_pr__pfet_01v8
M$1797 36 180 295 295 sky130_fd_pr__pfet_01v8 L=0.15U W=1U AS=0.1375P AD=0.14P
+ PS=1.275U PD=1.28U
* device instance $1798 r0 *1 15.615,17.055 sky130_fd_pr__pfet_01v8
M$1798 295 256 36 36 sky130_fd_pr__pfet_01v8 L=0.15U W=1U AS=0.14P AD=0.265P
+ PS=1.28U PD=2.53U
* device instance $1799 r0 *1 19.33,11.465 sky130_fd_pr__pfet_01v8
M$1799 36 31 183 183 sky130_fd_pr__pfet_01v8 L=0.15U W=0.64U AS=0.1664P
+ AD=0.0864P PS=1.8U PD=0.91U
* device instance $1800 r0 *1 19.75,11.465 sky130_fd_pr__pfet_01v8
M$1800 184 183 36 36 sky130_fd_pr__pfet_01v8 L=0.15U W=0.64U AS=0.0864P
+ AD=0.1664P PS=0.91U PD=1.8U
* device instance $1801 r0 *1 28.57,15.585 sky130_fd_pr__pfet_01v8
M$1801 257 191 36 36 sky130_fd_pr__pfet_01v8 L=0.15U W=1U AS=0.3P AD=0.135P
+ PS=2.6U PD=1.27U
* device instance $1802 r0 *1 28.99,15.585 sky130_fd_pr__pfet_01v8
M$1802 36 218 257 257 sky130_fd_pr__pfet_01v8 L=0.15U W=1U AS=0.135P AD=0.365P
+ PS=1.27U PD=1.73U
* device instance $1803 r0 *1 29.87,15.585 sky130_fd_pr__pfet_01v8
M$1803 286 218 36 36 sky130_fd_pr__pfet_01v8 L=0.15U W=1U AS=0.365P AD=0.105P
+ PS=1.73U PD=1.21U
* device instance $1804 r0 *1 30.23,15.585 sky130_fd_pr__pfet_01v8
M$1804 262 191 286 286 sky130_fd_pr__pfet_01v8 L=0.15U W=1U AS=0.105P AD=0.165P
+ PS=1.21U PD=1.33U
* device instance $1805 r0 *1 30.71,15.585 sky130_fd_pr__pfet_01v8
M$1805 36 257 262 262 sky130_fd_pr__pfet_01v8 L=0.15U W=1U AS=0.165P AD=0.36P
+ PS=1.33U PD=2.72U
* device instance $1806 r0 *1 31.99,15.295 sky130_fd_pr__pfet_01v8
M$1806 36 259 261 261 sky130_fd_pr__pfet_01v8 L=0.15U W=0.42U AS=0.1092P
+ AD=0.1573P PS=1.36U PD=1.39U
* device instance $1807 r0 *1 32.53,15.585 sky130_fd_pr__pfet_01v8
M$1807 287 260 36 36 sky130_fd_pr__pfet_01v8 L=0.15U W=1U AS=0.1573P AD=0.105P
+ PS=1.39U PD=1.21U
* device instance $1808 r0 *1 32.89,15.585 sky130_fd_pr__pfet_01v8
M$1808 92 261 287 287 sky130_fd_pr__pfet_01v8 L=0.15U W=1U AS=0.105P AD=0.26P
+ PS=1.21U PD=2.52U
* device instance $1809 r0 *1 34.05,15.585 sky130_fd_pr__pfet_01v8
M$1809 259 262 36 36 sky130_fd_pr__pfet_01v8 L=0.15U W=2U AS=0.395P AD=0.27P
+ PS=3.79U PD=2.54U
* device instance $1811 r0 *1 34.89,15.585 sky130_fd_pr__pfet_01v8
M$1811 259 264 36 36 sky130_fd_pr__pfet_01v8 L=0.15U W=2U AS=0.27P AD=0.395P
+ PS=2.54U PD=3.79U
* device instance $1813 r0 *1 34.07,17.055 sky130_fd_pr__pfet_01v8
M$1813 296 262 260 260 sky130_fd_pr__pfet_01v8 L=0.15U W=1U AS=0.265P AD=0.14P
+ PS=2.53U PD=1.28U
* device instance $1814 r0 *1 34.5,17.055 sky130_fd_pr__pfet_01v8
M$1814 36 264 296 296 sky130_fd_pr__pfet_01v8 L=0.15U W=1U AS=0.14P AD=0.1475P
+ PS=1.28U PD=1.295U
* device instance $1815 r0 *1 34.945,17.055 sky130_fd_pr__pfet_01v8
M$1815 296 266 36 36 sky130_fd_pr__pfet_01v8 L=0.15U W=1U AS=0.1475P AD=0.265P
+ PS=1.295U PD=2.53U
* device instance $1816 r0 *1 35.89,17.055 sky130_fd_pr__pfet_01v8
M$1816 311 62 271 271 sky130_fd_pr__pfet_01v8 L=0.15U W=1U AS=0.26P AD=0.105P
+ PS=2.52U PD=1.21U
* device instance $1817 r0 *1 36.25,17.055 sky130_fd_pr__pfet_01v8
M$1817 36 218 311 311 sky130_fd_pr__pfet_01v8 L=0.15U W=1U AS=0.105P AD=0.26P
+ PS=1.21U PD=2.52U
* device instance $1818 r0 *1 36.25,15.585 sky130_fd_pr__pfet_01v8
M$1818 259 266 36 36 sky130_fd_pr__pfet_01v8 L=0.15U W=2U AS=0.395P AD=0.445P
+ PS=3.79U PD=3.89U
* device instance $1820 r0 *1 37.73,15.585 sky130_fd_pr__pfet_01v8
M$1820 283 264 36 36 sky130_fd_pr__pfet_01v8 L=0.15U W=2U AS=0.395P AD=0.27P
+ PS=3.79U PD=2.54U
* device instance $1822 r0 *1 38.57,15.585 sky130_fd_pr__pfet_01v8
M$1822 283 268 36 36 sky130_fd_pr__pfet_01v8 L=0.15U W=2U AS=0.275P AD=0.285P
+ PS=2.55U PD=2.57U
* device instance $1824 r0 *1 39.44,15.585 sky130_fd_pr__pfet_01v8
M$1824 283 262 36 36 sky130_fd_pr__pfet_01v8 L=0.15U W=2U AS=0.28P AD=0.395P
+ PS=2.56U PD=3.79U
* device instance $1826 r0 *1 40.8,15.585 sky130_fd_pr__pfet_01v8
M$1826 283 271 284 284 sky130_fd_pr__pfet_01v8 L=0.15U W=2U AS=0.395P AD=0.395P
+ PS=3.79U PD=2.79U
* device instance $1828 r0 *1 41.89,15.585 sky130_fd_pr__pfet_01v8
M$1828 270 272 284 284 sky130_fd_pr__pfet_01v8 L=0.15U W=2U AS=0.395P AD=0.395P
+ PS=2.79U PD=3.79U
* device instance $1830 r0 *1 45.33,15.295 sky130_fd_pr__pfet_01v8
M$1830 36 128 273 273 sky130_fd_pr__pfet_01v8 L=0.15U W=0.42U AS=0.1092P
+ AD=0.1573P PS=1.36U PD=1.39U
* device instance $1831 r0 *1 45.87,15.585 sky130_fd_pr__pfet_01v8
M$1831 290 195 36 36 sky130_fd_pr__pfet_01v8 L=0.15U W=1U AS=0.1573P AD=0.105P
+ PS=1.39U PD=1.21U
* device instance $1832 r0 *1 46.23,15.585 sky130_fd_pr__pfet_01v8
M$1832 272 273 290 290 sky130_fd_pr__pfet_01v8 L=0.15U W=1U AS=0.105P AD=0.26P
+ PS=1.21U PD=2.52U
* device instance $1833 r0 *1 45.53,16.875 sky130_fd_pr__pfet_01v8
M$1833 312 197 300 300 sky130_fd_pr__pfet_01v8 L=0.15U W=0.64U AS=0.1664P
+ AD=0.0672P PS=1.8U PD=0.85U
* device instance $1834 r0 *1 45.89,16.875 sky130_fd_pr__pfet_01v8
M$1834 36 301 312 312 sky130_fd_pr__pfet_01v8 L=0.15U W=0.64U AS=0.0672P
+ AD=0.1664P PS=0.85U PD=1.8U
* device instance $1835 r0 *1 48.555,16.765 sky130_fd_pr__pfet_01v8
M$1835 303 299 300 300 sky130_fd_pr__pfet_01v8 L=0.15U W=0.42U AS=0.15985P
+ AD=0.06405P PS=1.265U PD=0.725U
* device instance $1836 r0 *1 49.01,16.765 sky130_fd_pr__pfet_01v8
M$1836 314 298 303 303 sky130_fd_pr__pfet_01v8 L=0.15U W=0.42U AS=0.06405P
+ AD=0.07665P PS=0.725U PD=0.785U
* device instance $1837 r0 *1 49.525,16.765 sky130_fd_pr__pfet_01v8
M$1837 36 304 314 314 sky130_fd_pr__pfet_01v8 L=0.15U W=0.42U AS=0.07665P
+ AD=0.178875P PS=0.785U PD=1.26U
* device instance $1838 r0 *1 46.83,16.875 sky130_fd_pr__pfet_01v8
M$1838 36 302 301 301 sky130_fd_pr__pfet_01v8 L=0.15U W=0.64U AS=0.1664P
+ AD=0.0928P PS=1.8U PD=0.93U
* device instance $1839 r0 *1 47.27,16.875 sky130_fd_pr__pfet_01v8
M$1839 313 302 36 36 sky130_fd_pr__pfet_01v8 L=0.15U W=0.64U AS=0.0928P
+ AD=0.1152P PS=0.93U PD=1U
* device instance $1840 r0 *1 47.78,16.875 sky130_fd_pr__pfet_01v8
M$1840 300 306 313 313 sky130_fd_pr__pfet_01v8 L=0.15U W=0.64U AS=0.1152P
+ AD=0.15985P PS=1U PD=1.265U
* device instance $1841 r0 *1 50.185,16.93 sky130_fd_pr__pfet_01v8
M$1841 304 303 36 36 sky130_fd_pr__pfet_01v8 L=0.15U W=0.75U AS=0.178875P
+ AD=0.195P PS=1.26U PD=2.02U
* device instance $1842 r0 *1 46.93,11.465 sky130_fd_pr__pfet_01v8
M$1842 36 333 198 198 sky130_fd_pr__pfet_01v8 L=0.15U W=0.64U AS=0.1664P
+ AD=0.0864P PS=1.8U PD=0.91U
* device instance $1843 r0 *1 47.35,11.465 sky130_fd_pr__pfet_01v8
M$1843 199 198 36 36 sky130_fd_pr__pfet_01v8 L=0.15U W=0.64U AS=0.0864P
+ AD=0.1664P PS=0.91U PD=1.8U
* device instance $1844 r0 *1 47.39,15.585 sky130_fd_pr__pfet_01v8
M$1844 291 274 67 67 sky130_fd_pr__pfet_01v8 L=0.15U W=1U AS=0.26P AD=0.105P
+ PS=2.52U PD=1.21U
* device instance $1845 r0 *1 47.75,15.585 sky130_fd_pr__pfet_01v8
M$1845 36 272 291 291 sky130_fd_pr__pfet_01v8 L=0.15U W=1U AS=0.105P AD=0.26P
+ PS=1.21U PD=2.52U
* device instance $1846 r0 *1 50.39,15.295 sky130_fd_pr__pfet_01v8
M$1846 36 195 275 275 sky130_fd_pr__pfet_01v8 L=0.15U W=0.42U AS=0.1092P
+ AD=0.1573P PS=1.36U PD=1.39U
* device instance $1847 r0 *1 50.93,15.585 sky130_fd_pr__pfet_01v8
M$1847 292 128 36 36 sky130_fd_pr__pfet_01v8 L=0.15U W=1U AS=0.1573P AD=0.105P
+ PS=1.39U PD=1.21U
* device instance $1848 r0 *1 51.29,15.585 sky130_fd_pr__pfet_01v8
M$1848 274 275 292 292 sky130_fd_pr__pfet_01v8 L=0.15U W=1U AS=0.105P AD=0.26P
+ PS=1.21U PD=2.52U
* device instance $1849 r0 *1 51.125,16.765 sky130_fd_pr__pfet_01v8
M$1849 315 304 36 36 sky130_fd_pr__pfet_01v8 L=0.15U W=0.42U AS=0.1092P
+ AD=0.06405P PS=1.36U PD=0.725U
* device instance $1850 r0 *1 51.58,16.765 sky130_fd_pr__pfet_01v8
M$1850 305 298 315 315 sky130_fd_pr__pfet_01v8 L=0.15U W=0.42U AS=0.06405P
+ AD=0.0567P PS=0.725U PD=0.69U
* device instance $1851 r0 *1 52,16.765 sky130_fd_pr__pfet_01v8
M$1851 316 299 305 305 sky130_fd_pr__pfet_01v8 L=0.15U W=0.42U AS=0.0567P
+ AD=0.0882P PS=0.69U PD=0.84U
* device instance $1852 r0 *1 52.57,16.765 sky130_fd_pr__pfet_01v8
M$1852 36 306 316 316 sky130_fd_pr__pfet_01v8 L=0.15U W=0.42U AS=0.0882P
+ AD=0.1113P PS=0.84U PD=1.37U
* device instance $1853 r0 *1 53.625,16.875 sky130_fd_pr__pfet_01v8
M$1853 36 305 306 306 sky130_fd_pr__pfet_01v8 L=0.15U W=0.64U AS=0.1728P
+ AD=0.154P PS=1.82U PD=1.335U
* device instance $1854 r0 *1 54.11,17.055 sky130_fd_pr__pfet_01v8
M$1854 128 305 36 36 sky130_fd_pr__pfet_01v8 L=0.15U W=1U AS=0.154P AD=0.28P
+ PS=1.335U PD=2.56U
* device instance $1855 r0 *1 57.715,15.295 sky130_fd_pr__pfet_01v8
M$1855 289 274 276 276 sky130_fd_pr__pfet_01v8 L=0.15U W=0.42U AS=0.1092P
+ AD=0.0441P PS=1.36U PD=0.63U
* device instance $1856 r0 *1 58.075,15.295 sky130_fd_pr__pfet_01v8
M$1856 36 270 289 289 sky130_fd_pr__pfet_01v8 L=0.15U W=0.42U AS=0.0441P
+ AD=0.14575P PS=0.63U PD=1.335U
* device instance $1857 r0 *1 58.56,15.585 sky130_fd_pr__pfet_01v8
M$1857 277 276 36 36 sky130_fd_pr__pfet_01v8 L=0.15U W=1U AS=0.14575P AD=0.34P
+ PS=1.335U PD=2.68U
* device instance $1858 r0 *1 59.93,17.055 sky130_fd_pr__pfet_01v8
M$1858 36 220 308 308 sky130_fd_pr__pfet_01v8 L=0.15U W=2U AS=0.395P AD=0.27P
+ PS=3.79U PD=2.54U
* device instance $1860 r0 *1 60.77,17.055 sky130_fd_pr__pfet_01v8
M$1860 309 270 308 308 sky130_fd_pr__pfet_01v8 L=0.15U W=2U AS=0.27P AD=0.395P
+ PS=2.54U PD=3.79U
* device instance $1862 r0 *1 62.13,17.055 sky130_fd_pr__pfet_01v8
M$1862 309 274 307 307 sky130_fd_pr__pfet_01v8 L=0.15U W=2U AS=0.395P AD=0.27P
+ PS=3.79U PD=2.54U
* device instance $1864 r0 *1 62.97,17.055 sky130_fd_pr__pfet_01v8
M$1864 36 210 307 307 sky130_fd_pr__pfet_01v8 L=0.15U W=2U AS=0.44P AD=0.51P
+ PS=2.88U PD=3.02U
* device instance $1866 r0 *1 64.29,17.055 sky130_fd_pr__pfet_01v8
M$1866 36 310 307 307 sky130_fd_pr__pfet_01v8 L=0.15U W=2U AS=0.34P AD=0.395P
+ PS=2.68U PD=3.79U
* device instance $1868 r0 *1 63.545,15.765 sky130_fd_pr__pfet_01v8
M$1868 288 220 36 36 sky130_fd_pr__pfet_01v8 L=0.15U W=0.64U AS=0.1696P
+ AD=0.0768P PS=1.81U PD=0.88U
* device instance $1869 r0 *1 63.935,15.765 sky130_fd_pr__pfet_01v8
M$1869 279 277 288 288 sky130_fd_pr__pfet_01v8 L=0.15U W=0.64U AS=0.0768P
+ AD=0.0896P PS=0.88U PD=0.92U
* device instance $1870 r0 *1 64.365,15.765 sky130_fd_pr__pfet_01v8
M$1870 36 210 279 279 sky130_fd_pr__pfet_01v8 L=0.15U W=0.64U AS=0.0896P
+ AD=0.1824P PS=0.92U PD=1.85U
* device instance $1871 r0 *1 65.33,15.585 sky130_fd_pr__pfet_01v8
M$1871 36 277 280 280 sky130_fd_pr__pfet_01v8 L=0.15U W=1U AS=0.26P AD=0.135P
+ PS=2.52U PD=1.27U
* device instance $1872 r0 *1 65.75,15.585 sky130_fd_pr__pfet_01v8
M$1872 219 280 36 36 sky130_fd_pr__pfet_01v8 L=0.15U W=4U AS=0.54P AD=0.665P
+ PS=5.08U PD=6.33U
* device instance $1876 r0 *1 17.03,21.025 sky130_fd_pr__pfet_01v8
M$1876 36 341 326 326 sky130_fd_pr__pfet_01v8 L=0.15U W=1U AS=0.26P AD=0.135P
+ PS=2.52U PD=1.27U
* device instance $1877 r0 *1 17.45,21.025 sky130_fd_pr__pfet_01v8
M$1877 180 326 36 36 sky130_fd_pr__pfet_01v8 L=0.15U W=4U AS=0.54P AD=0.665P
+ PS=5.08U PD=6.33U
* device instance $1881 r0 *1 19.79,21.025 sky130_fd_pr__pfet_01v8
M$1881 36 341 345 345 sky130_fd_pr__pfet_01v8 L=0.15U W=4U AS=0.665P AD=0.54P
+ PS=6.33U PD=5.08U
* device instance $1884 r0 *1 21.05,21.025 sky130_fd_pr__pfet_01v8
M$1884 345 256 36 36 sky130_fd_pr__pfet_01v8 L=0.15U W=4U AS=0.54P AD=0.54P
+ PS=5.08U PD=5.08U
* device instance $1889 r0 *1 23.15,21.025 sky130_fd_pr__pfet_01v8
M$1889 346 329 345 345 sky130_fd_pr__pfet_01v8 L=0.15U W=2U AS=0.27P AD=0.27P
+ PS=2.54U PD=2.54U
* device instance $1891 r0 *1 23.99,21.025 sky130_fd_pr__pfet_01v8
M$1891 349 329 345 345 sky130_fd_pr__pfet_01v8 L=0.15U W=1U AS=0.135P AD=0.15P
+ PS=1.27U PD=1.3U
* device instance $1892 r0 *1 24.44,21.025 sky130_fd_pr__pfet_01v8
M$1892 328 282 349 349 sky130_fd_pr__pfet_01v8 L=0.15U W=1U AS=0.15P AD=0.14P
+ PS=1.3U PD=1.28U
* device instance $1893 r0 *1 24.87,21.025 sky130_fd_pr__pfet_01v8
M$1893 346 282 328 328 sky130_fd_pr__pfet_01v8 L=0.15U W=2U AS=0.28P AD=0.29P
+ PS=2.56U PD=2.58U
* device instance $1895 r0 *1 25.75,21.025 sky130_fd_pr__pfet_01v8
M$1895 350 282 328 328 sky130_fd_pr__pfet_01v8 L=0.15U W=1U AS=0.15P AD=0.155P
+ PS=1.3U PD=1.31U
* device instance $1896 r0 *1 26.21,21.025 sky130_fd_pr__pfet_01v8
M$1896 345 329 350 350 sky130_fd_pr__pfet_01v8 L=0.15U W=1U AS=0.155P AD=0.26P
+ PS=1.31U PD=2.52U
* device instance $1897 r0 *1 27.155,21.025 sky130_fd_pr__pfet_01v8
M$1897 330 297 36 36 sky130_fd_pr__pfet_01v8 L=0.15U W=4U AS=0.685P AD=0.56P
+ PS=6.37U PD=5.12U
* device instance $1901 r0 *1 28.875,21.025 sky130_fd_pr__pfet_01v8
M$1901 31 330 36 36 sky130_fd_pr__pfet_01v8 L=0.15U W=16U AS=2.2375P AD=2.3625P
+ PS=20.475U PD=21.725U
* device instance $1917 r0 *1 36.35,21.025 sky130_fd_pr__pfet_01v8
M$1917 36 268 331 331 sky130_fd_pr__pfet_01v8 L=0.15U W=1U AS=0.26P AD=0.135P
+ PS=2.52U PD=1.27U
* device instance $1918 r0 *1 36.77,21.025 sky130_fd_pr__pfet_01v8
M$1918 266 331 36 36 sky130_fd_pr__pfet_01v8 L=0.15U W=4U AS=0.54P AD=0.665P
+ PS=5.08U PD=6.33U
* device instance $1922 r0 *1 44.17,16.905 sky130_fd_pr__pfet_01v8
M$1922 36 333 298 298 sky130_fd_pr__pfet_01v8 L=0.15U W=0.64U AS=0.1664P
+ AD=0.0864P PS=1.8U PD=0.91U
* device instance $1923 r0 *1 44.59,16.905 sky130_fd_pr__pfet_01v8
M$1923 299 298 36 36 sky130_fd_pr__pfet_01v8 L=0.15U W=0.64U AS=0.0864P
+ AD=0.1664P PS=0.91U PD=1.8U
* device instance $1924 r0 *1 46.475,21.025 sky130_fd_pr__pfet_01v8
M$1924 332 297 36 36 sky130_fd_pr__pfet_01v8 L=0.15U W=4U AS=0.685P AD=0.56P
+ PS=6.37U PD=5.12U
* device instance $1928 r0 *1 48.195,21.025 sky130_fd_pr__pfet_01v8
M$1928 333 332 36 36 sky130_fd_pr__pfet_01v8 L=0.15U W=16U AS=2.2375P
+ AD=2.3625P PS=20.475U PD=21.725U
* device instance $1944 r0 *1 63.51,21.025 sky130_fd_pr__pfet_01v8
M$1944 334 342 36 36 sky130_fd_pr__pfet_01v8 L=0.15U W=1U AS=0.26P AD=0.135P
+ PS=2.52U PD=1.27U
* device instance $1945 r0 *1 63.93,21.025 sky130_fd_pr__pfet_01v8
M$1945 36 310 334 334 sky130_fd_pr__pfet_01v8 L=0.15U W=1U AS=0.135P AD=0.26P
+ PS=1.27U PD=2.52U
* device instance $1946 r0 *1 64.91,21.025 sky130_fd_pr__pfet_01v8
M$1946 335 279 36 36 sky130_fd_pr__pfet_01v8 L=0.15U W=1U AS=0.3P AD=0.135P
+ PS=2.6U PD=1.27U
* device instance $1947 r0 *1 65.33,21.025 sky130_fd_pr__pfet_01v8
M$1947 36 334 335 335 sky130_fd_pr__pfet_01v8 L=0.15U W=1U AS=0.135P AD=0.365P
+ PS=1.27U PD=1.73U
* device instance $1948 r0 *1 66.21,21.025 sky130_fd_pr__pfet_01v8
M$1948 351 334 36 36 sky130_fd_pr__pfet_01v8 L=0.15U W=1U AS=0.365P AD=0.105P
+ PS=1.73U PD=1.21U
* device instance $1949 r0 *1 66.57,21.025 sky130_fd_pr__pfet_01v8
M$1949 347 279 351 351 sky130_fd_pr__pfet_01v8 L=0.15U W=1U AS=0.105P AD=0.165P
+ PS=1.21U PD=1.33U
* device instance $1950 r0 *1 67.05,21.025 sky130_fd_pr__pfet_01v8
M$1950 36 335 347 347 sky130_fd_pr__pfet_01v8 L=0.15U W=1U AS=0.165P AD=0.36P
+ PS=1.33U PD=2.72U
* device instance $1951 r0 *1 68.33,20.735 sky130_fd_pr__pfet_01v8
M$1951 36 343 337 337 sky130_fd_pr__pfet_01v8 L=0.15U W=0.42U AS=0.1092P
+ AD=0.1573P PS=1.36U PD=1.39U
* device instance $1952 r0 *1 68.87,21.025 sky130_fd_pr__pfet_01v8
M$1952 348 344 36 36 sky130_fd_pr__pfet_01v8 L=0.15U W=1U AS=0.1573P AD=0.105P
+ PS=1.39U PD=1.21U
* device instance $1953 r0 *1 69.23,21.025 sky130_fd_pr__pfet_01v8
M$1953 338 337 348 348 sky130_fd_pr__pfet_01v8 L=0.15U W=1U AS=0.105P AD=0.26P
+ PS=1.21U PD=2.52U
* device instance $1954 r0 *1 6.98,22.205 sky130_fd_pr__pfet_01v8
M$1954 353 352 36 36 sky130_fd_pr__pfet_01v8 L=0.15U W=0.42U AS=0.1113P
+ AD=0.0609P PS=1.37U PD=0.71U
* device instance $1955 r0 *1 7.42,22.205 sky130_fd_pr__pfet_01v8
M$1955 36 114 353 353 sky130_fd_pr__pfet_01v8 L=0.15U W=0.42U AS=0.0609P
+ AD=0.1841P PS=0.71U PD=1.26U
* device instance $1956 r0 *1 8.19,22.315 sky130_fd_pr__pfet_01v8
M$1956 354 353 36 36 sky130_fd_pr__pfet_01v8 L=0.15U W=0.64U AS=0.1841P
+ AD=0.1696P PS=1.26U PD=1.81U
* device instance $1957 r0 *1 9.21,22.495 sky130_fd_pr__pfet_01v8
M$1957 356 354 355 355 sky130_fd_pr__pfet_01v8 L=0.15U W=1U AS=0.26P AD=0.135P
+ PS=2.52U PD=1.27U
* device instance $1958 r0 *1 9.63,22.495 sky130_fd_pr__pfet_01v8
M$1958 357 398 356 356 sky130_fd_pr__pfet_01v8 L=0.15U W=1U AS=0.135P AD=0.135P
+ PS=1.27U PD=1.27U
* device instance $1959 r0 *1 10.05,22.495 sky130_fd_pr__pfet_01v8
M$1959 356 91 357 357 sky130_fd_pr__pfet_01v8 L=0.15U W=1U AS=0.135P AD=0.26P
+ PS=1.27U PD=2.52U
* device instance $1960 r0 *1 10.99,22.495 sky130_fd_pr__pfet_01v8
M$1960 357 157 36 36 sky130_fd_pr__pfet_01v8 L=0.15U W=1U AS=0.26P AD=0.165P
+ PS=2.52U PD=1.33U
* device instance $1961 r0 *1 11.47,22.495 sky130_fd_pr__pfet_01v8
M$1961 36 360 357 357 sky130_fd_pr__pfet_01v8 L=0.15U W=1U AS=0.165P AD=0.1575P
+ PS=1.33U PD=1.315U
* device instance $1962 r0 *1 11.935,22.495 sky130_fd_pr__pfet_01v8
M$1962 410 355 36 36 sky130_fd_pr__pfet_01v8 L=0.15U W=1U AS=0.1575P AD=0.26P
+ PS=1.315U PD=2.52U
* device instance $1963 r0 *1 12.93,22.495 sky130_fd_pr__pfet_01v8
M$1963 403 399 358 358 sky130_fd_pr__pfet_01v8 L=0.15U W=1U AS=0.26P AD=0.135P
+ PS=2.52U PD=1.27U
* device instance $1964 r0 *1 13.35,22.495 sky130_fd_pr__pfet_01v8
M$1964 36 293 403 403 sky130_fd_pr__pfet_01v8 L=0.15U W=1U AS=0.135P AD=0.135P
+ PS=1.27U PD=1.27U
* device instance $1965 r0 *1 13.77,22.495 sky130_fd_pr__pfet_01v8
M$1965 359 293 36 36 sky130_fd_pr__pfet_01v8 L=0.15U W=1U AS=0.135P AD=0.135P
+ PS=1.27U PD=1.27U
* device instance $1966 r0 *1 14.19,22.495 sky130_fd_pr__pfet_01v8
M$1966 36 399 359 359 sky130_fd_pr__pfet_01v8 L=0.15U W=1U AS=0.135P AD=0.26P
+ PS=1.27U PD=2.52U
* device instance $1967 r0 *1 15.13,22.495 sky130_fd_pr__pfet_01v8
M$1967 360 358 359 359 sky130_fd_pr__pfet_01v8 L=0.15U W=1U AS=0.26P AD=0.3P
+ PS=2.52U PD=2.6U
* device instance $1968 r0 *1 17.49,22.785 sky130_fd_pr__pfet_01v8
M$1968 404 407 361 361 sky130_fd_pr__pfet_01v8 L=0.15U W=0.42U AS=0.1092P
+ AD=0.0693P PS=1.36U PD=0.75U
* device instance $1969 r0 *1 17.97,22.785 sky130_fd_pr__pfet_01v8
M$1969 405 12 404 404 sky130_fd_pr__pfet_01v8 L=0.15U W=0.42U AS=0.0693P
+ AD=0.0441P PS=0.75U PD=0.63U
* device instance $1970 r0 *1 18.33,22.785 sky130_fd_pr__pfet_01v8
M$1970 406 398 405 405 sky130_fd_pr__pfet_01v8 L=0.15U W=0.42U AS=0.0441P
+ AD=0.0693P PS=0.63U PD=0.75U
* device instance $1971 r0 *1 18.81,22.785 sky130_fd_pr__pfet_01v8
M$1971 406 218 36 36 sky130_fd_pr__pfet_01v8 L=0.15U W=0.42U AS=0.14825P
+ AD=0.0693P PS=1.34U PD=0.75U
* device instance $1972 r0 *1 19.3,22.495 sky130_fd_pr__pfet_01v8
M$1972 362 361 36 36 sky130_fd_pr__pfet_01v8 L=0.15U W=1U AS=0.14825P AD=0.27P
+ PS=1.34U PD=2.54U
* device instance $1973 r0 *1 27.195,22.495 sky130_fd_pr__pfet_01v8
M$1973 363 31 36 36 sky130_fd_pr__pfet_01v8 L=0.15U W=6U AS=1.005P AD=1.045P
+ PS=9.01U PD=9.09U
* device instance $1979 r0 *1 41.41,22.345 sky130_fd_pr__pfet_01v8
M$1979 36 333 364 364 sky130_fd_pr__pfet_01v8 L=0.15U W=0.64U AS=0.1664P
+ AD=0.0864P PS=1.8U PD=0.91U
* device instance $1980 r0 *1 41.83,22.345 sky130_fd_pr__pfet_01v8
M$1980 365 364 36 36 sky130_fd_pr__pfet_01v8 L=0.15U W=0.64U AS=0.0864P
+ AD=0.1664P PS=0.91U PD=1.8U
* device instance $1981 r0 *1 42.77,22.315 sky130_fd_pr__pfet_01v8
M$1981 391 400 366 366 sky130_fd_pr__pfet_01v8 L=0.15U W=0.64U AS=0.1664P
+ AD=0.0672P PS=1.8U PD=0.85U
* device instance $1982 r0 *1 43.13,22.315 sky130_fd_pr__pfet_01v8
M$1982 36 367 391 391 sky130_fd_pr__pfet_01v8 L=0.15U W=0.64U AS=0.0672P
+ AD=0.1664P PS=0.85U PD=1.8U
* device instance $1983 r0 *1 45.795,22.205 sky130_fd_pr__pfet_01v8
M$1983 368 365 366 366 sky130_fd_pr__pfet_01v8 L=0.15U W=0.42U AS=0.15985P
+ AD=0.06405P PS=1.265U PD=0.725U
* device instance $1984 r0 *1 46.25,22.205 sky130_fd_pr__pfet_01v8
M$1984 394 364 368 368 sky130_fd_pr__pfet_01v8 L=0.15U W=0.42U AS=0.06405P
+ AD=0.07665P PS=0.725U PD=0.785U
* device instance $1985 r0 *1 46.765,22.205 sky130_fd_pr__pfet_01v8
M$1985 36 369 394 394 sky130_fd_pr__pfet_01v8 L=0.15U W=0.42U AS=0.07665P
+ AD=0.178875P PS=0.785U PD=1.26U
* device instance $1986 r0 *1 44.07,22.315 sky130_fd_pr__pfet_01v8
M$1986 36 93 367 367 sky130_fd_pr__pfet_01v8 L=0.15U W=0.64U AS=0.1664P
+ AD=0.0928P PS=1.8U PD=0.93U
* device instance $1987 r0 *1 44.51,22.315 sky130_fd_pr__pfet_01v8
M$1987 393 93 36 36 sky130_fd_pr__pfet_01v8 L=0.15U W=0.64U AS=0.0928P
+ AD=0.1152P PS=0.93U PD=1U
* device instance $1988 r0 *1 45.02,22.315 sky130_fd_pr__pfet_01v8
M$1988 366 371 393 393 sky130_fd_pr__pfet_01v8 L=0.15U W=0.64U AS=0.1152P
+ AD=0.15985P PS=1U PD=1.265U
* device instance $1989 r0 *1 47.425,22.37 sky130_fd_pr__pfet_01v8
M$1989 369 368 36 36 sky130_fd_pr__pfet_01v8 L=0.15U W=0.75U AS=0.178875P
+ AD=0.195P PS=1.26U PD=2.02U
* device instance $1990 r0 *1 48.365,22.205 sky130_fd_pr__pfet_01v8
M$1990 396 369 36 36 sky130_fd_pr__pfet_01v8 L=0.15U W=0.42U AS=0.1092P
+ AD=0.06405P PS=1.36U PD=0.725U
* device instance $1991 r0 *1 48.82,22.205 sky130_fd_pr__pfet_01v8
M$1991 370 364 396 396 sky130_fd_pr__pfet_01v8 L=0.15U W=0.42U AS=0.06405P
+ AD=0.0567P PS=0.725U PD=0.69U
* device instance $1992 r0 *1 49.24,22.205 sky130_fd_pr__pfet_01v8
M$1992 397 365 370 370 sky130_fd_pr__pfet_01v8 L=0.15U W=0.42U AS=0.0567P
+ AD=0.0882P PS=0.69U PD=0.84U
* device instance $1993 r0 *1 49.81,22.205 sky130_fd_pr__pfet_01v8
M$1993 36 371 397 397 sky130_fd_pr__pfet_01v8 L=0.15U W=0.42U AS=0.0882P
+ AD=0.1113P PS=0.84U PD=1.37U
* device instance $1994 r0 *1 50.865,22.315 sky130_fd_pr__pfet_01v8
M$1994 36 370 371 371 sky130_fd_pr__pfet_01v8 L=0.15U W=0.64U AS=0.1728P
+ AD=0.154P PS=1.82U PD=1.335U
* device instance $1995 r0 *1 51.35,22.495 sky130_fd_pr__pfet_01v8
M$1995 411 370 36 36 sky130_fd_pr__pfet_01v8 L=0.15U W=1U AS=0.154P AD=0.28P
+ PS=1.335U PD=2.56U
* device instance $1996 r0 *1 53.39,22.495 sky130_fd_pr__pfet_01v8
M$1996 36 373 372 372 sky130_fd_pr__pfet_01v8 L=0.15U W=2U AS=0.415P AD=0.27P
+ PS=3.83U PD=2.54U
* device instance $1998 r0 *1 54.23,22.495 sky130_fd_pr__pfet_01v8
M$1998 374 344 372 372 sky130_fd_pr__pfet_01v8 L=0.15U W=2U AS=0.27P AD=0.415P
+ PS=2.54U PD=3.83U
* device instance $2000 r0 *1 55.63,22.495 sky130_fd_pr__pfet_01v8
M$2000 374 161 375 375 sky130_fd_pr__pfet_01v8 L=0.15U W=2U AS=0.415P AD=0.27P
+ PS=3.83U PD=2.54U
* device instance $2002 r0 *1 56.47,22.495 sky130_fd_pr__pfet_01v8
M$2002 408 195 375 375 sky130_fd_pr__pfet_01v8 L=0.15U W=2U AS=0.27P AD=0.395P
+ PS=2.54U PD=3.79U
* device instance $2004 r0 *1 60.73,22.495 sky130_fd_pr__pfet_01v8
M$2004 377 401 376 376 sky130_fd_pr__pfet_01v8 L=0.15U W=1U AS=0.26P AD=0.135P
+ PS=2.52U PD=1.27U
* device instance $2005 r0 *1 61.15,22.495 sky130_fd_pr__pfet_01v8
M$2005 378 344 377 377 sky130_fd_pr__pfet_01v8 L=0.15U W=1U AS=0.135P AD=0.135P
+ PS=1.27U PD=1.27U
* device instance $2006 r0 *1 61.57,22.495 sky130_fd_pr__pfet_01v8
M$2006 377 91 378 378 sky130_fd_pr__pfet_01v8 L=0.15U W=1U AS=0.135P AD=0.26P
+ PS=1.27U PD=2.52U
* device instance $2007 r0 *1 62.51,22.495 sky130_fd_pr__pfet_01v8
M$2007 378 134 36 36 sky130_fd_pr__pfet_01v8 L=0.15U W=1U AS=0.26P AD=0.165P
+ PS=2.52U PD=1.33U
* device instance $2008 r0 *1 62.99,22.495 sky130_fd_pr__pfet_01v8
M$2008 36 347 378 378 sky130_fd_pr__pfet_01v8 L=0.15U W=1U AS=0.165P AD=0.1575P
+ PS=1.33U PD=1.315U
* device instance $2009 r0 *1 63.455,22.495 sky130_fd_pr__pfet_01v8
M$2009 379 376 36 36 sky130_fd_pr__pfet_01v8 L=0.15U W=1U AS=0.1575P AD=0.26P
+ PS=1.315U PD=2.52U
* device instance $2010 r0 *1 64.41,22.345 sky130_fd_pr__pfet_01v8
M$2010 36 333 380 380 sky130_fd_pr__pfet_01v8 L=0.15U W=0.64U AS=0.1664P
+ AD=0.0864P PS=1.8U PD=0.91U
* device instance $2011 r0 *1 64.83,22.345 sky130_fd_pr__pfet_01v8
M$2011 381 380 36 36 sky130_fd_pr__pfet_01v8 L=0.15U W=0.64U AS=0.0864P
+ AD=0.1664P PS=0.91U PD=1.8U
* device instance $2012 r0 *1 65.77,22.315 sky130_fd_pr__pfet_01v8
M$2012 395 402 382 382 sky130_fd_pr__pfet_01v8 L=0.15U W=0.64U AS=0.1664P
+ AD=0.0672P PS=1.8U PD=0.85U
* device instance $2013 r0 *1 66.13,22.315 sky130_fd_pr__pfet_01v8
M$2013 36 383 395 395 sky130_fd_pr__pfet_01v8 L=0.15U W=0.64U AS=0.0672P
+ AD=0.1664P PS=0.85U PD=1.8U
* device instance $2014 r0 *1 68.795,22.205 sky130_fd_pr__pfet_01v8
M$2014 384 381 382 382 sky130_fd_pr__pfet_01v8 L=0.15U W=0.42U AS=0.15985P
+ AD=0.06405P PS=1.265U PD=0.725U
* device instance $2015 r0 *1 69.25,22.205 sky130_fd_pr__pfet_01v8
M$2015 390 380 384 384 sky130_fd_pr__pfet_01v8 L=0.15U W=0.42U AS=0.06405P
+ AD=0.07665P PS=0.725U PD=0.785U
* device instance $2016 r0 *1 69.765,22.205 sky130_fd_pr__pfet_01v8
M$2016 36 385 390 390 sky130_fd_pr__pfet_01v8 L=0.15U W=0.42U AS=0.07665P
+ AD=0.178875P PS=0.785U PD=1.26U
* device instance $2017 r0 *1 67.07,22.315 sky130_fd_pr__pfet_01v8
M$2017 36 409 383 383 sky130_fd_pr__pfet_01v8 L=0.15U W=0.64U AS=0.1664P
+ AD=0.0928P PS=1.8U PD=0.93U
* device instance $2018 r0 *1 67.51,22.315 sky130_fd_pr__pfet_01v8
M$2018 392 409 36 36 sky130_fd_pr__pfet_01v8 L=0.15U W=0.64U AS=0.0928P
+ AD=0.1152P PS=0.93U PD=1U
* device instance $2019 r0 *1 68.02,22.315 sky130_fd_pr__pfet_01v8
M$2019 382 387 392 392 sky130_fd_pr__pfet_01v8 L=0.15U W=0.64U AS=0.1152P
+ AD=0.15985P PS=1U PD=1.265U
* device instance $2020 r0 *1 70.425,22.37 sky130_fd_pr__pfet_01v8
M$2020 385 384 36 36 sky130_fd_pr__pfet_01v8 L=0.15U W=0.75U AS=0.178875P
+ AD=0.195P PS=1.26U PD=2.02U
* device instance $2021 r0 *1 71.365,22.205 sky130_fd_pr__pfet_01v8
M$2021 389 385 36 36 sky130_fd_pr__pfet_01v8 L=0.15U W=0.42U AS=0.1092P
+ AD=0.06405P PS=1.36U PD=0.725U
* device instance $2022 r0 *1 71.82,22.205 sky130_fd_pr__pfet_01v8
M$2022 386 380 389 389 sky130_fd_pr__pfet_01v8 L=0.15U W=0.42U AS=0.06405P
+ AD=0.0567P PS=0.725U PD=0.69U
* device instance $2023 r0 *1 72.24,22.205 sky130_fd_pr__pfet_01v8
M$2023 388 381 386 386 sky130_fd_pr__pfet_01v8 L=0.15U W=0.42U AS=0.0567P
+ AD=0.0882P PS=0.69U PD=0.84U
* device instance $2024 r0 *1 72.81,22.205 sky130_fd_pr__pfet_01v8
M$2024 36 387 388 388 sky130_fd_pr__pfet_01v8 L=0.15U W=0.42U AS=0.0882P
+ AD=0.1113P PS=0.84U PD=1.37U
* device instance $2025 r0 *1 73.865,22.315 sky130_fd_pr__pfet_01v8
M$2025 36 386 387 387 sky130_fd_pr__pfet_01v8 L=0.15U W=0.64U AS=0.1728P
+ AD=0.154P PS=1.82U PD=1.335U
* device instance $2026 r0 *1 74.35,22.495 sky130_fd_pr__pfet_01v8
M$2026 344 386 36 36 sky130_fd_pr__pfet_01v8 L=0.15U W=1U AS=0.154P AD=0.28P
+ PS=1.335U PD=2.56U
* device instance $2027 r0 *1 4.61,26.615 sky130_fd_pr__pfet_01v8
M$2027 36 31 428 428 sky130_fd_pr__pfet_01v8 L=0.15U W=0.64U AS=0.1664P
+ AD=0.0864P PS=1.8U PD=0.91U
* device instance $2028 r0 *1 5.03,26.615 sky130_fd_pr__pfet_01v8
M$2028 429 428 36 36 sky130_fd_pr__pfet_01v8 L=0.15U W=0.64U AS=0.0864P
+ AD=0.1664P PS=0.91U PD=1.8U
* device instance $2029 r0 *1 5.97,26.645 sky130_fd_pr__pfet_01v8
M$2029 467 459 430 430 sky130_fd_pr__pfet_01v8 L=0.15U W=0.64U AS=0.1664P
+ AD=0.0672P PS=1.8U PD=0.85U
* device instance $2030 r0 *1 6.33,26.645 sky130_fd_pr__pfet_01v8
M$2030 36 460 467 467 sky130_fd_pr__pfet_01v8 L=0.15U W=0.64U AS=0.0672P
+ AD=0.1664P PS=0.85U PD=1.8U
* device instance $2031 r0 *1 7.27,26.645 sky130_fd_pr__pfet_01v8
M$2031 36 93 460 460 sky130_fd_pr__pfet_01v8 L=0.15U W=0.64U AS=0.1664P
+ AD=0.0928P PS=1.8U PD=0.93U
* device instance $2032 r0 *1 7.71,26.645 sky130_fd_pr__pfet_01v8
M$2032 469 93 36 36 sky130_fd_pr__pfet_01v8 L=0.15U W=0.64U AS=0.0928P
+ AD=0.1152P PS=0.93U PD=1U
* device instance $2033 r0 *1 8.22,26.645 sky130_fd_pr__pfet_01v8
M$2033 430 431 469 469 sky130_fd_pr__pfet_01v8 L=0.15U W=0.64U AS=0.1152P
+ AD=0.15985P PS=1U PD=1.265U
* device instance $2034 r0 *1 8.995,26.755 sky130_fd_pr__pfet_01v8
M$2034 432 429 430 430 sky130_fd_pr__pfet_01v8 L=0.15U W=0.42U AS=0.15985P
+ AD=0.06405P PS=1.265U PD=0.725U
* device instance $2035 r0 *1 9.45,26.755 sky130_fd_pr__pfet_01v8
M$2035 470 428 432 432 sky130_fd_pr__pfet_01v8 L=0.15U W=0.42U AS=0.06405P
+ AD=0.07665P PS=0.725U PD=0.785U
* device instance $2036 r0 *1 9.965,26.755 sky130_fd_pr__pfet_01v8
M$2036 470 433 36 36 sky130_fd_pr__pfet_01v8 L=0.15U W=0.42U AS=0.178875P
+ AD=0.07665P PS=1.26U PD=0.785U
* device instance $2037 r0 *1 10.625,26.59 sky130_fd_pr__pfet_01v8
M$2037 433 432 36 36 sky130_fd_pr__pfet_01v8 L=0.15U W=0.75U AS=0.178875P
+ AD=0.195P PS=1.26U PD=2.02U
* device instance $2038 r0 *1 14.065,26.645 sky130_fd_pr__pfet_01v8
M$2038 431 434 36 36 sky130_fd_pr__pfet_01v8 L=0.15U W=0.64U AS=0.154P
+ AD=0.1728P PS=1.335U PD=1.82U
* device instance $2039 r0 *1 14.55,26.465 sky130_fd_pr__pfet_01v8
M$2039 398 434 36 36 sky130_fd_pr__pfet_01v8 L=0.15U W=1U AS=0.154P AD=0.28P
+ PS=1.335U PD=2.56U
* device instance $2040 r0 *1 18.19,26.175 sky130_fd_pr__pfet_01v8
M$2040 36 398 435 435 sky130_fd_pr__pfet_01v8 L=0.15U W=0.42U AS=0.1092P
+ AD=0.1573P PS=1.36U PD=1.39U
* device instance $2041 r0 *1 18.73,26.465 sky130_fd_pr__pfet_01v8
M$2041 473 461 36 36 sky130_fd_pr__pfet_01v8 L=0.15U W=1U AS=0.1573P AD=0.105P
+ PS=1.39U PD=1.21U
* device instance $2042 r0 *1 19.09,26.465 sky130_fd_pr__pfet_01v8
M$2042 436 435 473 473 sky130_fd_pr__pfet_01v8 L=0.15U W=1U AS=0.105P AD=0.26P
+ PS=1.21U PD=2.52U
* device instance $2043 r0 *1 20.25,26.465 sky130_fd_pr__pfet_01v8
M$2043 474 436 399 399 sky130_fd_pr__pfet_01v8 L=0.15U W=1U AS=0.26P AD=0.105P
+ PS=2.52U PD=1.21U
* device instance $2044 r0 *1 20.61,26.465 sky130_fd_pr__pfet_01v8
M$2044 36 329 474 474 sky130_fd_pr__pfet_01v8 L=0.15U W=1U AS=0.105P AD=0.26P
+ PS=1.21U PD=2.52U
* device instance $2045 r0 *1 21.87,26.175 sky130_fd_pr__pfet_01v8
M$2045 36 461 437 437 sky130_fd_pr__pfet_01v8 L=0.15U W=0.42U AS=0.1092P
+ AD=0.1573P PS=1.36U PD=1.39U
* device instance $2046 r0 *1 22.41,26.465 sky130_fd_pr__pfet_01v8
M$2046 475 398 36 36 sky130_fd_pr__pfet_01v8 L=0.15U W=1U AS=0.1573P AD=0.105P
+ PS=1.39U PD=1.21U
* device instance $2047 r0 *1 22.77,26.465 sky130_fd_pr__pfet_01v8
M$2047 329 437 475 475 sky130_fd_pr__pfet_01v8 L=0.15U W=1U AS=0.105P AD=0.26P
+ PS=1.21U PD=2.52U
* device instance $2048 r0 *1 34.985,26.465 sky130_fd_pr__pfet_01v8
M$2048 36 440 439 439 sky130_fd_pr__pfet_01v8 L=0.15U W=2U AS=0.41P AD=0.27P
+ PS=3.82U PD=2.54U
* device instance $2050 r0 *1 35.825,26.465 sky130_fd_pr__pfet_01v8
M$2050 36 441 439 439 sky130_fd_pr__pfet_01v8 L=0.15U W=2U AS=0.27P AD=0.415P
+ PS=2.54U PD=3.83U
* device instance $2052 r0 *1 37.225,26.465 sky130_fd_pr__pfet_01v8
M$2052 36 441 465 465 sky130_fd_pr__pfet_01v8 L=0.15U W=2U AS=0.415P AD=0.27P
+ PS=3.83U PD=2.54U
* device instance $2054 r0 *1 38.065,26.465 sky130_fd_pr__pfet_01v8
M$2054 3 440 465 465 sky130_fd_pr__pfet_01v8 L=0.15U W=2U AS=0.2875P AD=0.4125P
+ PS=2.575U PD=3.825U
* device instance $2056 r0 *1 39.46,26.465 sky130_fd_pr__pfet_01v8
M$2056 3 439 36 36 sky130_fd_pr__pfet_01v8 L=0.15U W=2U AS=0.395P AD=0.415P
+ PS=3.79U PD=3.83U
* device instance $2058 r0 *1 46.47,26.465 sky130_fd_pr__pfet_01v8
M$2058 36 333 443 443 sky130_fd_pr__pfet_01v8 L=0.15U W=3U AS=0.53P AD=0.405P
+ PS=5.06U PD=3.81U
* device instance $2061 r0 *1 47.73,26.465 sky130_fd_pr__pfet_01v8
M$2061 444 443 36 36 sky130_fd_pr__pfet_01v8 L=0.15U W=6U AS=0.81P AD=0.81P
+ PS=7.62U PD=7.62U
* device instance $2067 r0 *1 50.25,26.465 sky130_fd_pr__pfet_01v8
M$2067 445 444 36 36 sky130_fd_pr__pfet_01v8 L=0.15U W=16U AS=2.16P AD=2.285P
+ PS=20.32U PD=21.57U
* device instance $2083 r0 *1 63.95,26.545 sky130_fd_pr__pfet_01v8
M$2083 310 338 36 36 sky130_fd_pr__pfet_01v8 L=0.15U W=1.68U AS=0.3318P
+ AD=0.3486P PS=3.31U PD=3.35U
* device instance $2085 r0 *1 65.33,26.175 sky130_fd_pr__pfet_01v8
M$2085 36 343 447 447 sky130_fd_pr__pfet_01v8 L=0.15U W=0.42U AS=0.1092P
+ AD=0.14575P PS=1.36U PD=1.335U
* device instance $2086 r0 *1 65.815,26.465 sky130_fd_pr__pfet_01v8
M$2086 342 344 36 36 sky130_fd_pr__pfet_01v8 L=0.15U W=1U AS=0.14575P AD=0.135P
+ PS=1.335U PD=1.27U
* device instance $2087 r0 *1 66.235,26.465 sky130_fd_pr__pfet_01v8
M$2087 36 447 342 342 sky130_fd_pr__pfet_01v8 L=0.15U W=1U AS=0.135P AD=0.265P
+ PS=1.27U PD=2.53U
* device instance $2088 r0 *1 68.175,26.56 sky130_fd_pr__pfet_01v8
M$2088 468 63 36 36 sky130_fd_pr__pfet_01v8 L=0.15U W=0.42U AS=0.15835P
+ AD=0.07665P PS=1.395U PD=0.785U
* device instance $2089 r0 *1 68.69,26.56 sky130_fd_pr__pfet_01v8
M$2089 448 343 468 468 sky130_fd_pr__pfet_01v8 L=0.15U W=0.42U AS=0.07665P
+ AD=0.1932P PS=0.785U PD=1.34U
* device instance $2090 r0 *1 69.76,26.56 sky130_fd_pr__pfet_01v8
M$2090 466 449 448 448 sky130_fd_pr__pfet_01v8 L=0.15U W=0.42U AS=0.1932P
+ AD=0.0441P PS=1.34U PD=0.63U
* device instance $2091 r0 *1 70.12,26.56 sky130_fd_pr__pfet_01v8
M$2091 36 450 466 466 sky130_fd_pr__pfet_01v8 L=0.15U W=0.42U AS=0.0441P
+ AD=0.0693P PS=0.63U PD=0.75U
* device instance $2092 r0 *1 70.6,26.56 sky130_fd_pr__pfet_01v8
M$2092 450 63 36 36 sky130_fd_pr__pfet_01v8 L=0.15U W=0.42U AS=0.0693P
+ AD=0.1176P PS=0.75U PD=1.4U
* device instance $2093 r0 *1 67.63,26.465 sky130_fd_pr__pfet_01v8
M$2093 36 448 402 402 sky130_fd_pr__pfet_01v8 L=0.15U W=1U AS=0.26P AD=0.15835P
+ PS=2.52U PD=1.395U
* device instance $2094 r0 *1 5.615,27.84 sky130_fd_pr__pfet_01v8
M$2094 499 63 36 36 sky130_fd_pr__pfet_01v8 L=0.15U W=0.42U AS=0.15835P
+ AD=0.07665P PS=1.395U PD=0.785U
* device instance $2095 r0 *1 6.13,27.84 sky130_fd_pr__pfet_01v8
M$2095 476 461 499 499 sky130_fd_pr__pfet_01v8 L=0.15U W=0.42U AS=0.07665P
+ AD=0.1932P PS=0.785U PD=1.34U
* device instance $2096 r0 *1 7.2,27.84 sky130_fd_pr__pfet_01v8
M$2096 500 464 476 476 sky130_fd_pr__pfet_01v8 L=0.15U W=0.42U AS=0.1932P
+ AD=0.0441P PS=1.34U PD=0.63U
* device instance $2097 r0 *1 7.56,27.84 sky130_fd_pr__pfet_01v8
M$2097 36 515 500 500 sky130_fd_pr__pfet_01v8 L=0.15U W=0.42U AS=0.0441P
+ AD=0.0693P PS=0.63U PD=0.75U
* device instance $2098 r0 *1 8.04,27.84 sky130_fd_pr__pfet_01v8
M$2098 515 63 36 36 sky130_fd_pr__pfet_01v8 L=0.15U W=0.42U AS=0.0693P
+ AD=0.1176P PS=0.75U PD=1.4U
* device instance $2099 r0 *1 5.07,27.935 sky130_fd_pr__pfet_01v8
M$2099 36 476 459 459 sky130_fd_pr__pfet_01v8 L=0.15U W=1U AS=0.26P AD=0.15835P
+ PS=2.52U PD=1.395U
* device instance $2100 r0 *1 10.57,27.755 sky130_fd_pr__pfet_01v8
M$2100 501 410 479 479 sky130_fd_pr__pfet_01v8 L=0.15U W=0.64U AS=0.1664P
+ AD=0.0672P PS=1.8U PD=0.85U
* device instance $2101 r0 *1 10.93,27.755 sky130_fd_pr__pfet_01v8
M$2101 36 480 501 501 sky130_fd_pr__pfet_01v8 L=0.15U W=0.64U AS=0.0672P
+ AD=0.1664P PS=0.85U PD=1.8U
* device instance $2102 r0 *1 11.565,26.755 sky130_fd_pr__pfet_01v8
M$2102 471 433 36 36 sky130_fd_pr__pfet_01v8 L=0.15U W=0.42U AS=0.1092P
+ AD=0.06405P PS=1.36U PD=0.725U
* device instance $2103 r0 *1 12.02,26.755 sky130_fd_pr__pfet_01v8
M$2103 434 428 471 471 sky130_fd_pr__pfet_01v8 L=0.15U W=0.42U AS=0.06405P
+ AD=0.0567P PS=0.725U PD=0.69U
* device instance $2104 r0 *1 12.44,26.755 sky130_fd_pr__pfet_01v8
M$2104 472 429 434 434 sky130_fd_pr__pfet_01v8 L=0.15U W=0.42U AS=0.0567P
+ AD=0.0882P PS=0.69U PD=0.84U
* device instance $2105 r0 *1 13.01,26.755 sky130_fd_pr__pfet_01v8
M$2105 36 431 472 472 sky130_fd_pr__pfet_01v8 L=0.15U W=0.42U AS=0.0882P
+ AD=0.1113P PS=0.84U PD=1.37U
* device instance $2106 r0 *1 13.595,27.645 sky130_fd_pr__pfet_01v8
M$2106 481 478 479 479 sky130_fd_pr__pfet_01v8 L=0.15U W=0.42U AS=0.15985P
+ AD=0.06405P PS=1.265U PD=0.725U
* device instance $2107 r0 *1 14.05,27.645 sky130_fd_pr__pfet_01v8
M$2107 503 477 481 481 sky130_fd_pr__pfet_01v8 L=0.15U W=0.42U AS=0.06405P
+ AD=0.07665P PS=0.725U PD=0.785U
* device instance $2108 r0 *1 14.565,27.645 sky130_fd_pr__pfet_01v8
M$2108 36 482 503 503 sky130_fd_pr__pfet_01v8 L=0.15U W=0.42U AS=0.07665P
+ AD=0.178875P PS=0.785U PD=1.26U
* device instance $2109 r0 *1 11.87,27.755 sky130_fd_pr__pfet_01v8
M$2109 36 302 480 480 sky130_fd_pr__pfet_01v8 L=0.15U W=0.64U AS=0.1664P
+ AD=0.0928P PS=1.8U PD=0.93U
* device instance $2110 r0 *1 12.31,27.755 sky130_fd_pr__pfet_01v8
M$2110 502 302 36 36 sky130_fd_pr__pfet_01v8 L=0.15U W=0.64U AS=0.0928P
+ AD=0.1152P PS=0.93U PD=1U
* device instance $2111 r0 *1 12.82,27.755 sky130_fd_pr__pfet_01v8
M$2111 479 484 502 502 sky130_fd_pr__pfet_01v8 L=0.15U W=0.64U AS=0.1152P
+ AD=0.15985P PS=1U PD=1.265U
* device instance $2112 r0 *1 15.225,27.81 sky130_fd_pr__pfet_01v8
M$2112 482 481 36 36 sky130_fd_pr__pfet_01v8 L=0.15U W=0.75U AS=0.178875P
+ AD=0.195P PS=1.26U PD=2.02U
* device instance $2113 r0 *1 16.165,27.645 sky130_fd_pr__pfet_01v8
M$2113 504 482 36 36 sky130_fd_pr__pfet_01v8 L=0.15U W=0.42U AS=0.1092P
+ AD=0.06405P PS=1.36U PD=0.725U
* device instance $2114 r0 *1 16.62,27.645 sky130_fd_pr__pfet_01v8
M$2114 483 477 504 504 sky130_fd_pr__pfet_01v8 L=0.15U W=0.42U AS=0.06405P
+ AD=0.0567P PS=0.725U PD=0.69U
* device instance $2115 r0 *1 17.04,27.645 sky130_fd_pr__pfet_01v8
M$2115 506 478 483 483 sky130_fd_pr__pfet_01v8 L=0.15U W=0.42U AS=0.0567P
+ AD=0.0882P PS=0.69U PD=0.84U
* device instance $2116 r0 *1 17.61,27.645 sky130_fd_pr__pfet_01v8
M$2116 36 484 506 506 sky130_fd_pr__pfet_01v8 L=0.15U W=0.42U AS=0.0882P
+ AD=0.1113P PS=0.84U PD=1.37U
* device instance $2117 r0 *1 18.665,27.755 sky130_fd_pr__pfet_01v8
M$2117 36 483 484 484 sky130_fd_pr__pfet_01v8 L=0.15U W=0.64U AS=0.1728P
+ AD=0.154P PS=1.82U PD=1.335U
* device instance $2118 r0 *1 19.15,27.935 sky130_fd_pr__pfet_01v8
M$2118 461 483 36 36 sky130_fd_pr__pfet_01v8 L=0.15U W=1U AS=0.154P AD=0.28P
+ PS=1.335U PD=2.56U
* device instance $2119 r0 *1 30.91,27.935 sky130_fd_pr__pfet_01v8
M$2119 36 328 485 485 sky130_fd_pr__pfet_01v8 L=0.15U W=4U AS=0.685P AD=0.54P
+ PS=6.37U PD=5.08U
* device instance $2123 r0 *1 32.59,27.935 sky130_fd_pr__pfet_01v8
M$2123 486 436 485 485 sky130_fd_pr__pfet_01v8 L=0.15U W=4U AS=0.54P AD=0.665P
+ PS=5.08U PD=6.33U
* device instance $2127 r0 *1 34.79,27.935 sky130_fd_pr__pfet_01v8
M$2127 486 535 268 268 sky130_fd_pr__pfet_01v8 L=0.15U W=4U AS=0.665P AD=0.55P
+ PS=6.33U PD=5.1U
* device instance $2131 r0 *1 36.49,27.935 sky130_fd_pr__pfet_01v8
M$2131 36 513 268 268 sky130_fd_pr__pfet_01v8 L=0.15U W=4U AS=0.55P AD=0.54P
+ PS=5.1U PD=5.08U
* device instance $2135 r0 *1 38.17,27.935 sky130_fd_pr__pfet_01v8
M$2135 36 487 268 268 sky130_fd_pr__pfet_01v8 L=0.15U W=4U AS=0.54P AD=0.665P
+ PS=5.08U PD=6.33U
* device instance $2139 r0 *1 41.87,28.225 sky130_fd_pr__pfet_01v8
M$2139 488 514 36 36 sky130_fd_pr__pfet_01v8 L=0.15U W=0.42U AS=0.14575P
+ AD=0.1092P PS=1.335U PD=1.36U
* device instance $2140 r0 *1 42.355,27.935 sky130_fd_pr__pfet_01v8
M$2140 264 411 36 36 sky130_fd_pr__pfet_01v8 L=0.15U W=1U AS=0.14575P AD=0.135P
+ PS=1.335U PD=1.27U
* device instance $2141 r0 *1 42.775,27.935 sky130_fd_pr__pfet_01v8
M$2141 36 488 264 264 sky130_fd_pr__pfet_01v8 L=0.15U W=1U AS=0.135P AD=0.265P
+ PS=1.27U PD=2.53U
* device instance $2142 r0 *1 44.715,27.84 sky130_fd_pr__pfet_01v8
M$2142 511 63 36 36 sky130_fd_pr__pfet_01v8 L=0.15U W=0.42U AS=0.15835P
+ AD=0.07665P PS=1.395U PD=0.785U
* device instance $2143 r0 *1 45.23,27.84 sky130_fd_pr__pfet_01v8
M$2143 489 514 511 511 sky130_fd_pr__pfet_01v8 L=0.15U W=0.42U AS=0.07665P
+ AD=0.1932P PS=0.785U PD=1.34U
* device instance $2144 r0 *1 46.3,27.84 sky130_fd_pr__pfet_01v8
M$2144 512 490 489 489 sky130_fd_pr__pfet_01v8 L=0.15U W=0.42U AS=0.1932P
+ AD=0.0441P PS=1.34U PD=0.63U
* device instance $2145 r0 *1 46.66,27.84 sky130_fd_pr__pfet_01v8
M$2145 36 517 512 512 sky130_fd_pr__pfet_01v8 L=0.15U W=0.42U AS=0.0441P
+ AD=0.0693P PS=0.63U PD=0.75U
* device instance $2146 r0 *1 47.14,27.84 sky130_fd_pr__pfet_01v8
M$2146 517 63 36 36 sky130_fd_pr__pfet_01v8 L=0.15U W=0.42U AS=0.0693P
+ AD=0.1176P PS=0.75U PD=1.4U
* device instance $2147 r0 *1 44.17,27.935 sky130_fd_pr__pfet_01v8
M$2147 36 489 400 400 sky130_fd_pr__pfet_01v8 L=0.15U W=1U AS=0.26P AD=0.15835P
+ PS=2.52U PD=1.395U
* device instance $2148 r0 *1 61.26,26.755 sky130_fd_pr__pfet_01v8
M$2148 446 462 36 36 sky130_fd_pr__pfet_01v8 L=0.15U W=0.42U AS=0.1113P
+ AD=0.0609P PS=1.37U PD=0.71U
* device instance $2149 r0 *1 61.7,26.755 sky130_fd_pr__pfet_01v8
M$2149 446 114 36 36 sky130_fd_pr__pfet_01v8 L=0.15U W=0.42U AS=0.1841P
+ AD=0.0609P PS=1.26U PD=0.71U
* device instance $2150 r0 *1 62.47,26.645 sky130_fd_pr__pfet_01v8
M$2150 401 446 36 36 sky130_fd_pr__pfet_01v8 L=0.15U W=0.64U AS=0.1841P
+ AD=0.1696P PS=1.26U PD=1.81U
* device instance $2151 r0 *1 62.09,27.755 sky130_fd_pr__pfet_01v8
M$2151 510 379 493 493 sky130_fd_pr__pfet_01v8 L=0.15U W=0.64U AS=0.1664P
+ AD=0.0672P PS=1.8U PD=0.85U
* device instance $2152 r0 *1 62.45,27.755 sky130_fd_pr__pfet_01v8
M$2152 36 494 510 510 sky130_fd_pr__pfet_01v8 L=0.15U W=0.64U AS=0.0672P
+ AD=0.1664P PS=0.85U PD=1.8U
* device instance $2153 r0 *1 65.115,27.645 sky130_fd_pr__pfet_01v8
M$2153 495 492 493 493 sky130_fd_pr__pfet_01v8 L=0.15U W=0.42U AS=0.15985P
+ AD=0.06405P PS=1.265U PD=0.725U
* device instance $2154 r0 *1 65.57,27.645 sky130_fd_pr__pfet_01v8
M$2154 508 491 495 495 sky130_fd_pr__pfet_01v8 L=0.15U W=0.42U AS=0.06405P
+ AD=0.07665P PS=0.725U PD=0.785U
* device instance $2155 r0 *1 66.085,27.645 sky130_fd_pr__pfet_01v8
M$2155 36 496 508 508 sky130_fd_pr__pfet_01v8 L=0.15U W=0.42U AS=0.07665P
+ AD=0.178875P PS=0.785U PD=1.26U
* device instance $2156 r0 *1 63.39,27.755 sky130_fd_pr__pfet_01v8
M$2156 36 302 494 494 sky130_fd_pr__pfet_01v8 L=0.15U W=0.64U AS=0.1664P
+ AD=0.0928P PS=1.8U PD=0.93U
* device instance $2157 r0 *1 63.83,27.755 sky130_fd_pr__pfet_01v8
M$2157 509 302 36 36 sky130_fd_pr__pfet_01v8 L=0.15U W=0.64U AS=0.0928P
+ AD=0.1152P PS=0.93U PD=1U
* device instance $2158 r0 *1 64.34,27.755 sky130_fd_pr__pfet_01v8
M$2158 493 498 509 509 sky130_fd_pr__pfet_01v8 L=0.15U W=0.64U AS=0.1152P
+ AD=0.15985P PS=1U PD=1.265U
* device instance $2159 r0 *1 66.745,27.81 sky130_fd_pr__pfet_01v8
M$2159 496 495 36 36 sky130_fd_pr__pfet_01v8 L=0.15U W=0.75U AS=0.178875P
+ AD=0.195P PS=1.26U PD=2.02U
* device instance $2160 r0 *1 67.685,27.645 sky130_fd_pr__pfet_01v8
M$2160 507 496 36 36 sky130_fd_pr__pfet_01v8 L=0.15U W=0.42U AS=0.1092P
+ AD=0.06405P PS=1.36U PD=0.725U
* device instance $2161 r0 *1 68.14,27.645 sky130_fd_pr__pfet_01v8
M$2161 497 491 507 507 sky130_fd_pr__pfet_01v8 L=0.15U W=0.42U AS=0.06405P
+ AD=0.0567P PS=0.725U PD=0.69U
* device instance $2162 r0 *1 68.56,27.645 sky130_fd_pr__pfet_01v8
M$2162 505 492 497 497 sky130_fd_pr__pfet_01v8 L=0.15U W=0.42U AS=0.0567P
+ AD=0.0882P PS=0.69U PD=0.84U
* device instance $2163 r0 *1 69.13,27.645 sky130_fd_pr__pfet_01v8
M$2163 36 498 505 505 sky130_fd_pr__pfet_01v8 L=0.15U W=0.42U AS=0.0882P
+ AD=0.1113P PS=0.84U PD=1.37U
* device instance $2164 r0 *1 70.185,27.755 sky130_fd_pr__pfet_01v8
M$2164 36 497 498 498 sky130_fd_pr__pfet_01v8 L=0.15U W=0.64U AS=0.1728P
+ AD=0.154P PS=1.82U PD=1.335U
* device instance $2165 r0 *1 70.67,27.935 sky130_fd_pr__pfet_01v8
M$2165 343 497 36 36 sky130_fd_pr__pfet_01v8 L=0.15U W=1U AS=0.154P AD=0.28P
+ PS=1.335U PD=2.56U
* device instance $2166 r0 *1 9.21,27.785 sky130_fd_pr__pfet_01v8
M$2166 36 31 477 477 sky130_fd_pr__pfet_01v8 L=0.15U W=0.64U AS=0.1664P
+ AD=0.0864P PS=1.8U PD=0.91U
* device instance $2167 r0 *1 9.63,27.785 sky130_fd_pr__pfet_01v8
M$2167 478 477 36 36 sky130_fd_pr__pfet_01v8 L=0.15U W=0.64U AS=0.0864P
+ AD=0.1664P PS=0.91U PD=1.8U
* device instance $2168 r0 *1 13.35,33.295 sky130_fd_pr__pfet_01v8
M$2168 556 555 36 36 sky130_fd_pr__pfet_01v8 L=0.15U W=1.68U AS=0.3318P
+ AD=0.3486P PS=3.31U PD=3.35U
* device instance $2170 r0 *1 26.285,32.085 sky130_fd_pr__pfet_01v8
M$2170 554 436 36 36 sky130_fd_pr__pfet_01v8 L=0.15U W=0.64U AS=0.1696P
+ AD=0.0768P PS=1.81U PD=0.88U
* device instance $2171 r0 *1 26.675,32.085 sky130_fd_pr__pfet_01v8
M$2171 547 328 554 554 sky130_fd_pr__pfet_01v8 L=0.15U W=0.64U AS=0.0768P
+ AD=0.0896P PS=0.88U PD=0.92U
* device instance $2172 r0 *1 27.105,32.085 sky130_fd_pr__pfet_01v8
M$2172 36 535 547 547 sky130_fd_pr__pfet_01v8 L=0.15U W=0.64U AS=0.0896P
+ AD=0.1824P PS=0.92U PD=1.85U
* device instance $2173 r0 *1 27.155,33.375 sky130_fd_pr__pfet_01v8
M$2173 557 537 36 36 sky130_fd_pr__pfet_01v8 L=0.15U W=1U AS=0.265P AD=0.14P
+ PS=2.53U PD=1.28U
* device instance $2174 r0 *1 27.585,33.375 sky130_fd_pr__pfet_01v8
M$2174 36 547 557 557 sky130_fd_pr__pfet_01v8 L=0.15U W=1U AS=0.14P AD=0.1775P
+ PS=1.28U PD=1.355U
* device instance $2175 r0 *1 28.09,33.375 sky130_fd_pr__pfet_01v8
M$2175 558 557 36 36 sky130_fd_pr__pfet_01v8 L=0.15U W=4U AS=0.5975P AD=0.705P
+ PS=5.195U PD=6.41U
* device instance $2179 r0 *1 28.08,31.615 sky130_fd_pr__pfet_01v8
M$2179 551 328 536 536 sky130_fd_pr__pfet_01v8 L=0.15U W=0.42U AS=0.1092P
+ AD=0.0441P PS=1.36U PD=0.63U
* device instance $2180 r0 *1 28.44,31.615 sky130_fd_pr__pfet_01v8
M$2180 552 436 551 551 sky130_fd_pr__pfet_01v8 L=0.15U W=0.42U AS=0.0441P
+ AD=0.0693P PS=0.63U PD=0.75U
* device instance $2181 r0 *1 28.92,31.615 sky130_fd_pr__pfet_01v8
M$2181 36 535 552 552 sky130_fd_pr__pfet_01v8 L=0.15U W=0.42U AS=0.0693P
+ AD=0.14825P PS=0.75U PD=1.34U
* device instance $2182 r0 *1 29.41,31.905 sky130_fd_pr__pfet_01v8
M$2182 537 536 36 36 sky130_fd_pr__pfet_01v8 L=0.15U W=1U AS=0.14825P AD=0.28P
+ PS=1.34U PD=2.56U
* device instance $2183 r0 *1 31.77,31.905 sky130_fd_pr__pfet_01v8
M$2183 441 537 36 36 sky130_fd_pr__pfet_01v8 L=0.15U W=1U AS=0.26P AD=0.135P
+ PS=2.52U PD=1.27U
* device instance $2184 r0 *1 32.19,31.905 sky130_fd_pr__pfet_01v8
M$2184 36 513 441 441 sky130_fd_pr__pfet_01v8 L=0.15U W=2U AS=0.315P AD=0.45P
+ PS=2.63U PD=3.9U
* device instance $2186 r0 *1 35.91,31.905 sky130_fd_pr__pfet_01v8
M$2186 440 264 36 36 sky130_fd_pr__pfet_01v8 L=0.15U W=1U AS=0.26P AD=0.135P
+ PS=2.52U PD=1.27U
* device instance $2187 r0 *1 36.33,31.905 sky130_fd_pr__pfet_01v8
M$2187 36 487 440 440 sky130_fd_pr__pfet_01v8 L=0.15U W=1U AS=0.135P AD=0.26P
+ PS=1.27U PD=2.52U
* device instance $2188 r0 *1 38.19,31.905 sky130_fd_pr__pfet_01v8
M$2188 548 124 538 538 sky130_fd_pr__pfet_01v8 L=0.15U W=1U AS=0.26P AD=0.135P
+ PS=2.52U PD=1.27U
* device instance $2189 r0 *1 38.61,31.905 sky130_fd_pr__pfet_01v8
M$2189 549 411 548 548 sky130_fd_pr__pfet_01v8 L=0.15U W=1U AS=0.135P AD=0.135P
+ PS=1.27U PD=1.27U
* device instance $2190 r0 *1 39.03,31.905 sky130_fd_pr__pfet_01v8
M$2190 548 91 549 549 sky130_fd_pr__pfet_01v8 L=0.15U W=1U AS=0.135P AD=0.26P
+ PS=1.27U PD=2.52U
* device instance $2191 r0 *1 39.97,31.905 sky130_fd_pr__pfet_01v8
M$2191 549 134 36 36 sky130_fd_pr__pfet_01v8 L=0.15U W=1U AS=0.26P AD=0.165P
+ PS=2.52U PD=1.33U
* device instance $2192 r0 *1 40.45,31.905 sky130_fd_pr__pfet_01v8
M$2192 36 3 549 549 sky130_fd_pr__pfet_01v8 L=0.15U W=1U AS=0.165P AD=0.1575P
+ PS=1.33U PD=1.315U
* device instance $2193 r0 *1 40.915,31.905 sky130_fd_pr__pfet_01v8
M$2193 550 538 36 36 sky130_fd_pr__pfet_01v8 L=0.15U W=1U AS=0.1575P AD=0.26P
+ PS=1.315U PD=2.52U
* device instance $2194 r0 *1 41.85,33.195 sky130_fd_pr__pfet_01v8
M$2194 575 550 562 562 sky130_fd_pr__pfet_01v8 L=0.15U W=0.64U AS=0.1664P
+ AD=0.0672P PS=1.8U PD=0.85U
* device instance $2195 r0 *1 42.21,33.195 sky130_fd_pr__pfet_01v8
M$2195 36 561 575 575 sky130_fd_pr__pfet_01v8 L=0.15U W=0.64U AS=0.0672P
+ AD=0.1664P PS=0.85U PD=1.8U
* device instance $2196 r0 *1 41.87,31.985 sky130_fd_pr__pfet_01v8
M$2196 487 539 36 36 sky130_fd_pr__pfet_01v8 L=0.15U W=1.68U AS=0.3318P
+ AD=0.3486P PS=3.31U PD=3.35U
* device instance $2198 r0 *1 44.875,33.085 sky130_fd_pr__pfet_01v8
M$2198 563 560 562 562 sky130_fd_pr__pfet_01v8 L=0.15U W=0.42U AS=0.15985P
+ AD=0.06405P PS=1.265U PD=0.725U
* device instance $2199 r0 *1 45.33,33.085 sky130_fd_pr__pfet_01v8
M$2199 577 559 563 563 sky130_fd_pr__pfet_01v8 L=0.15U W=0.42U AS=0.06405P
+ AD=0.07665P PS=0.725U PD=0.785U
* device instance $2200 r0 *1 45.845,33.085 sky130_fd_pr__pfet_01v8
M$2200 36 564 577 577 sky130_fd_pr__pfet_01v8 L=0.15U W=0.42U AS=0.07665P
+ AD=0.178875P PS=0.785U PD=1.26U
* device instance $2201 r0 *1 43.15,33.195 sky130_fd_pr__pfet_01v8
M$2201 36 302 561 561 sky130_fd_pr__pfet_01v8 L=0.15U W=0.64U AS=0.1664P
+ AD=0.0928P PS=1.8U PD=0.93U
* device instance $2202 r0 *1 43.59,33.195 sky130_fd_pr__pfet_01v8
M$2202 576 302 36 36 sky130_fd_pr__pfet_01v8 L=0.15U W=0.64U AS=0.0928P
+ AD=0.1152P PS=0.93U PD=1U
* device instance $2203 r0 *1 44.1,33.195 sky130_fd_pr__pfet_01v8
M$2203 562 566 576 576 sky130_fd_pr__pfet_01v8 L=0.15U W=0.64U AS=0.1152P
+ AD=0.15985P PS=1U PD=1.265U
* device instance $2204 r0 *1 46.505,33.25 sky130_fd_pr__pfet_01v8
M$2204 564 563 36 36 sky130_fd_pr__pfet_01v8 L=0.15U W=0.75U AS=0.178875P
+ AD=0.195P PS=1.26U PD=2.02U
* device instance $2205 r0 *1 44.87,31.615 sky130_fd_pr__pfet_01v8
M$2205 36 514 540 540 sky130_fd_pr__pfet_01v8 L=0.15U W=0.42U AS=0.1092P
+ AD=0.1573P PS=1.36U PD=1.39U
* device instance $2206 r0 *1 45.41,31.905 sky130_fd_pr__pfet_01v8
M$2206 553 411 36 36 sky130_fd_pr__pfet_01v8 L=0.15U W=1U AS=0.1573P AD=0.105P
+ PS=1.39U PD=1.21U
* device instance $2207 r0 *1 45.77,31.905 sky130_fd_pr__pfet_01v8
M$2207 539 540 553 553 sky130_fd_pr__pfet_01v8 L=0.15U W=1U AS=0.105P AD=0.26P
+ PS=1.21U PD=2.52U
* device instance $2208 r0 *1 47.19,31.905 sky130_fd_pr__pfet_01v8
M$2208 541 1000 36 36 sky130_fd_pr__pfet_01v8 L=0.15U W=2U AS=0.395P AD=0.27P
+ PS=3.79U PD=2.54U
* device instance $2210 r0 *1 48.03,31.905 sky130_fd_pr__pfet_01v8
M$2210 134 541 36 36 sky130_fd_pr__pfet_01v8 L=0.15U W=6U AS=0.81P AD=0.935P
+ PS=7.62U PD=8.87U
* device instance $2216 r0 *1 47.445,33.085 sky130_fd_pr__pfet_01v8
M$2216 578 564 36 36 sky130_fd_pr__pfet_01v8 L=0.15U W=0.42U AS=0.1092P
+ AD=0.06405P PS=1.36U PD=0.725U
* device instance $2217 r0 *1 47.9,33.085 sky130_fd_pr__pfet_01v8
M$2217 565 559 578 578 sky130_fd_pr__pfet_01v8 L=0.15U W=0.42U AS=0.06405P
+ AD=0.0567P PS=0.725U PD=0.69U
* device instance $2218 r0 *1 48.32,33.085 sky130_fd_pr__pfet_01v8
M$2218 579 560 565 565 sky130_fd_pr__pfet_01v8 L=0.15U W=0.42U AS=0.0567P
+ AD=0.0882P PS=0.69U PD=0.84U
* device instance $2219 r0 *1 48.89,33.085 sky130_fd_pr__pfet_01v8
M$2219 36 566 579 579 sky130_fd_pr__pfet_01v8 L=0.15U W=0.42U AS=0.0882P
+ AD=0.1113P PS=0.84U PD=1.37U
* device instance $2220 r0 *1 49.945,33.195 sky130_fd_pr__pfet_01v8
M$2220 36 565 566 566 sky130_fd_pr__pfet_01v8 L=0.15U W=0.64U AS=0.1728P
+ AD=0.154P PS=1.82U PD=1.335U
* device instance $2221 r0 *1 50.43,33.375 sky130_fd_pr__pfet_01v8
M$2221 514 565 36 36 sky130_fd_pr__pfet_01v8 L=0.15U W=1U AS=0.154P AD=0.28P
+ PS=1.335U PD=2.56U
* device instance $2222 r0 *1 59.81,33.375 sky130_fd_pr__pfet_01v8
M$2222 36 307 567 567 sky130_fd_pr__pfet_01v8 L=0.15U W=1U AS=0.26P AD=0.135P
+ PS=2.52U PD=1.27U
* device instance $2223 r0 *1 60.23,33.375 sky130_fd_pr__pfet_01v8
M$2223 580 567 36 36 sky130_fd_pr__pfet_01v8 L=0.15U W=4U AS=0.54P AD=0.665P
+ PS=5.08U PD=6.33U
* device instance $2227 r0 *1 60.73,27.785 sky130_fd_pr__pfet_01v8
M$2227 36 333 491 491 sky130_fd_pr__pfet_01v8 L=0.15U W=0.64U AS=0.1664P
+ AD=0.0864P PS=1.8U PD=0.91U
* device instance $2228 r0 *1 61.15,27.785 sky130_fd_pr__pfet_01v8
M$2228 492 491 36 36 sky130_fd_pr__pfet_01v8 L=0.15U W=0.64U AS=0.0864P
+ AD=0.1664P PS=0.91U PD=1.8U
* device instance $2229 r0 *1 62.57,33.375 sky130_fd_pr__pfet_01v8
M$2229 570 568 569 569 sky130_fd_pr__pfet_01v8 L=0.15U W=1U AS=0.26P AD=0.135P
+ PS=2.52U PD=1.27U
* device instance $2230 r0 *1 62.99,33.375 sky130_fd_pr__pfet_01v8
M$2230 572 571 570 570 sky130_fd_pr__pfet_01v8 L=0.15U W=1U AS=0.135P AD=0.135P
+ PS=1.27U PD=1.27U
* device instance $2231 r0 *1 63.41,33.375 sky130_fd_pr__pfet_01v8
M$2231 570 91 572 572 sky130_fd_pr__pfet_01v8 L=0.15U W=1U AS=0.135P AD=0.26P
+ PS=1.27U PD=2.52U
* device instance $2232 r0 *1 64.35,33.375 sky130_fd_pr__pfet_01v8
M$2232 572 157 36 36 sky130_fd_pr__pfet_01v8 L=0.15U W=1U AS=0.26P AD=0.165P
+ PS=2.52U PD=1.33U
* device instance $2233 r0 *1 64.83,33.375 sky130_fd_pr__pfet_01v8
M$2233 36 574 572 572 sky130_fd_pr__pfet_01v8 L=0.15U W=1U AS=0.165P AD=0.1575P
+ PS=1.33U PD=1.315U
* device instance $2234 r0 *1 65.295,33.375 sky130_fd_pr__pfet_01v8
M$2234 573 569 36 36 sky130_fd_pr__pfet_01v8 L=0.15U W=1U AS=0.1575P AD=0.26P
+ PS=1.315U PD=2.52U
* device instance $2235 r0 *1 8.75,37.345 sky130_fd_pr__pfet_01v8
M$2235 616 589 590 590 sky130_fd_pr__pfet_01v8 L=0.15U W=1U AS=0.26P AD=0.135P
+ PS=2.52U PD=1.27U
* device instance $2236 r0 *1 9.17,37.345 sky130_fd_pr__pfet_01v8
M$2236 617 407 616 616 sky130_fd_pr__pfet_01v8 L=0.15U W=1U AS=0.135P AD=0.135P
+ PS=1.27U PD=1.27U
* device instance $2237 r0 *1 9.59,37.345 sky130_fd_pr__pfet_01v8
M$2237 616 91 617 617 sky130_fd_pr__pfet_01v8 L=0.15U W=1U AS=0.135P AD=0.26P
+ PS=1.27U PD=2.52U
* device instance $2238 r0 *1 10.53,37.345 sky130_fd_pr__pfet_01v8
M$2238 617 157 36 36 sky130_fd_pr__pfet_01v8 L=0.15U W=1U AS=0.26P AD=0.165P
+ PS=2.52U PD=1.33U
* device instance $2239 r0 *1 11.01,37.345 sky130_fd_pr__pfet_01v8
M$2239 36 591 617 617 sky130_fd_pr__pfet_01v8 L=0.15U W=1U AS=0.165P AD=0.1575P
+ PS=1.33U PD=1.315U
* device instance $2240 r0 *1 11.475,37.345 sky130_fd_pr__pfet_01v8
M$2240 592 590 36 36 sky130_fd_pr__pfet_01v8 L=0.15U W=1U AS=0.1575P AD=0.26P
+ PS=1.315U PD=2.52U
* device instance $2241 r0 *1 12.53,37.525 sky130_fd_pr__pfet_01v8
M$2241 620 556 593 593 sky130_fd_pr__pfet_01v8 L=0.15U W=0.64U AS=0.1664P
+ AD=0.0672P PS=1.8U PD=0.85U
* device instance $2242 r0 *1 12.89,37.525 sky130_fd_pr__pfet_01v8
M$2242 36 594 620 620 sky130_fd_pr__pfet_01v8 L=0.15U W=0.64U AS=0.0672P
+ AD=0.0864P PS=0.85U PD=0.91U
* device instance $2243 r0 *1 13.31,37.525 sky130_fd_pr__pfet_01v8
M$2243 621 594 36 36 sky130_fd_pr__pfet_01v8 L=0.15U W=0.64U AS=0.0864P
+ AD=0.0672P PS=0.91U PD=0.85U
* device instance $2244 r0 *1 13.67,37.525 sky130_fd_pr__pfet_01v8
M$2244 593 595 621 621 sky130_fd_pr__pfet_01v8 L=0.15U W=0.64U AS=0.0672P
+ AD=0.0864P PS=0.85U PD=0.91U
* device instance $2245 r0 *1 14.09,37.525 sky130_fd_pr__pfet_01v8
M$2245 622 595 593 593 sky130_fd_pr__pfet_01v8 L=0.15U W=0.64U AS=0.0864P
+ AD=0.0672P PS=0.91U PD=0.85U
* device instance $2246 r0 *1 14.45,37.525 sky130_fd_pr__pfet_01v8
M$2246 622 556 36 36 sky130_fd_pr__pfet_01v8 L=0.15U W=0.64U AS=0.237P
+ AD=0.0672P PS=1.6U PD=0.85U
* device instance $2247 r0 *1 15.2,37.345 sky130_fd_pr__pfet_01v8
M$2247 341 593 36 36 sky130_fd_pr__pfet_01v8 L=0.15U W=2U AS=0.372P AD=0.405P
+ PS=2.87U PD=3.81U
* device instance $2249 r0 *1 31.29,37.425 sky130_fd_pr__pfet_01v8
M$2249 535 596 36 36 sky130_fd_pr__pfet_01v8 L=0.15U W=1.68U AS=0.3318P
+ AD=0.3486P PS=3.31U PD=3.35U
* device instance $2251 r0 *1 34.05,37.055 sky130_fd_pr__pfet_01v8
M$2251 36 652 597 597 sky130_fd_pr__pfet_01v8 L=0.15U W=0.42U AS=0.1092P
+ AD=0.14575P PS=1.36U PD=1.335U
* device instance $2252 r0 *1 34.535,37.345 sky130_fd_pr__pfet_01v8
M$2252 513 598 36 36 sky130_fd_pr__pfet_01v8 L=0.15U W=1U AS=0.14575P AD=0.135P
+ PS=1.335U PD=1.27U
* device instance $2253 r0 *1 34.955,37.345 sky130_fd_pr__pfet_01v8
M$2253 36 597 513 513 sky130_fd_pr__pfet_01v8 L=0.15U W=1U AS=0.135P AD=0.265P
+ PS=1.27U PD=2.53U
* device instance $2254 r0 *1 40.49,33.225 sky130_fd_pr__pfet_01v8
M$2254 36 333 559 559 sky130_fd_pr__pfet_01v8 L=0.15U W=0.64U AS=0.1664P
+ AD=0.0864P PS=1.8U PD=0.91U
* device instance $2255 r0 *1 40.91,33.225 sky130_fd_pr__pfet_01v8
M$2255 560 559 36 36 sky130_fd_pr__pfet_01v8 L=0.15U W=0.64U AS=0.0864P
+ AD=0.1664P PS=0.91U PD=1.8U
* device instance $2256 r0 *1 59.42,37.635 sky130_fd_pr__pfet_01v8
M$2256 599 600 36 36 sky130_fd_pr__pfet_01v8 L=0.15U W=0.42U AS=0.1113P
+ AD=0.0609P PS=1.37U PD=0.71U
* device instance $2257 r0 *1 59.86,37.635 sky130_fd_pr__pfet_01v8
M$2257 599 114 36 36 sky130_fd_pr__pfet_01v8 L=0.15U W=0.42U AS=0.1841P
+ AD=0.0609P PS=1.26U PD=0.71U
* device instance $2258 r0 *1 60.63,37.525 sky130_fd_pr__pfet_01v8
M$2258 568 599 36 36 sky130_fd_pr__pfet_01v8 L=0.15U W=0.64U AS=0.1841P
+ AD=0.1696P PS=1.26U PD=1.81U
* device instance $2259 r0 *1 61.67,37.345 sky130_fd_pr__pfet_01v8
M$2259 601 580 36 36 sky130_fd_pr__pfet_01v8 L=0.15U W=1U AS=0.26P AD=0.135P
+ PS=2.52U PD=1.27U
* device instance $2260 r0 *1 62.09,37.345 sky130_fd_pr__pfet_01v8
M$2260 36 342 601 601 sky130_fd_pr__pfet_01v8 L=0.15U W=1U AS=0.135P AD=0.26P
+ PS=1.27U PD=2.52U
* device instance $2261 r0 *1 63.07,37.345 sky130_fd_pr__pfet_01v8
M$2261 602 601 36 36 sky130_fd_pr__pfet_01v8 L=0.15U W=1U AS=0.3P AD=0.135P
+ PS=2.6U PD=1.27U
* device instance $2262 r0 *1 63.49,37.345 sky130_fd_pr__pfet_01v8
M$2262 36 603 602 602 sky130_fd_pr__pfet_01v8 L=0.15U W=1U AS=0.135P AD=0.365P
+ PS=1.27U PD=1.73U
* device instance $2263 r0 *1 64.37,37.345 sky130_fd_pr__pfet_01v8
M$2263 619 603 36 36 sky130_fd_pr__pfet_01v8 L=0.15U W=1U AS=0.365P AD=0.105P
+ PS=1.73U PD=1.21U
* device instance $2264 r0 *1 64.73,37.345 sky130_fd_pr__pfet_01v8
M$2264 574 601 619 619 sky130_fd_pr__pfet_01v8 L=0.15U W=1U AS=0.105P AD=0.165P
+ PS=1.21U PD=1.33U
* device instance $2265 r0 *1 65.21,37.345 sky130_fd_pr__pfet_01v8
M$2265 36 602 574 574 sky130_fd_pr__pfet_01v8 L=0.15U W=1U AS=0.165P AD=0.36P
+ PS=1.33U PD=2.72U
* device instance $2266 r0 *1 66.49,37.055 sky130_fd_pr__pfet_01v8
M$2266 36 653 605 605 sky130_fd_pr__pfet_01v8 L=0.15U W=0.42U AS=0.1092P
+ AD=0.1573P PS=1.36U PD=1.39U
* device instance $2267 r0 *1 67.03,37.345 sky130_fd_pr__pfet_01v8
M$2267 618 571 36 36 sky130_fd_pr__pfet_01v8 L=0.15U W=1U AS=0.1573P AD=0.105P
+ PS=1.39U PD=1.21U
* device instance $2268 r0 *1 67.39,37.345 sky130_fd_pr__pfet_01v8
M$2268 606 605 618 618 sky130_fd_pr__pfet_01v8 L=0.15U W=1U AS=0.105P AD=0.26P
+ PS=1.21U PD=2.52U
* device instance $2269 r0 *1 4.68,38.525 sky130_fd_pr__pfet_01v8
M$2269 624 623 36 36 sky130_fd_pr__pfet_01v8 L=0.15U W=0.42U AS=0.1113P
+ AD=0.0609P PS=1.37U PD=0.71U
* device instance $2270 r0 *1 5.12,38.525 sky130_fd_pr__pfet_01v8
M$2270 36 114 624 624 sky130_fd_pr__pfet_01v8 L=0.15U W=0.42U AS=0.0609P
+ AD=0.1841P PS=0.71U PD=1.26U
* device instance $2271 r0 *1 5.89,38.635 sky130_fd_pr__pfet_01v8
M$2271 589 624 36 36 sky130_fd_pr__pfet_01v8 L=0.15U W=0.64U AS=0.1841P
+ AD=0.1696P PS=1.26U PD=1.81U
* device instance $2272 r0 *1 7.455,38.72 sky130_fd_pr__pfet_01v8
M$2272 647 63 36 36 sky130_fd_pr__pfet_01v8 L=0.15U W=0.42U AS=0.15835P
+ AD=0.07665P PS=1.395U PD=0.785U
* device instance $2273 r0 *1 7.97,38.72 sky130_fd_pr__pfet_01v8
M$2273 626 595 647 647 sky130_fd_pr__pfet_01v8 L=0.15U W=0.42U AS=0.07665P
+ AD=0.1932P PS=0.785U PD=1.34U
* device instance $2274 r0 *1 9.04,38.72 sky130_fd_pr__pfet_01v8
M$2274 648 627 626 626 sky130_fd_pr__pfet_01v8 L=0.15U W=0.42U AS=0.1932P
+ AD=0.0441P PS=1.34U PD=0.63U
* device instance $2275 r0 *1 9.4,38.72 sky130_fd_pr__pfet_01v8
M$2275 36 659 648 648 sky130_fd_pr__pfet_01v8 L=0.15U W=0.42U AS=0.0441P
+ AD=0.0693P PS=0.63U PD=0.75U
* device instance $2276 r0 *1 9.88,38.72 sky130_fd_pr__pfet_01v8
M$2276 659 63 36 36 sky130_fd_pr__pfet_01v8 L=0.15U W=0.42U AS=0.0693P
+ AD=0.1176P PS=0.75U PD=1.4U
* device instance $2277 r0 *1 6.91,38.815 sky130_fd_pr__pfet_01v8
M$2277 36 626 625 625 sky130_fd_pr__pfet_01v8 L=0.15U W=1U AS=0.26P AD=0.15835P
+ PS=2.52U PD=1.395U
* device instance $2278 r0 *1 11.09,38.815 sky130_fd_pr__pfet_01v8
M$2278 628 632 36 36 sky130_fd_pr__pfet_01v8 L=0.15U W=1U AS=0.3P AD=0.135P
+ PS=2.6U PD=1.27U
* device instance $2279 r0 *1 11.51,38.815 sky130_fd_pr__pfet_01v8
M$2279 36 629 628 628 sky130_fd_pr__pfet_01v8 L=0.15U W=1U AS=0.135P AD=0.365P
+ PS=1.27U PD=1.73U
* device instance $2280 r0 *1 12.39,38.815 sky130_fd_pr__pfet_01v8
M$2280 656 629 36 36 sky130_fd_pr__pfet_01v8 L=0.15U W=1U AS=0.365P AD=0.105P
+ PS=1.73U PD=1.21U
* device instance $2281 r0 *1 12.75,38.815 sky130_fd_pr__pfet_01v8
M$2281 591 632 656 656 sky130_fd_pr__pfet_01v8 L=0.15U W=1U AS=0.105P AD=0.165P
+ PS=1.21U PD=1.33U
* device instance $2282 r0 *1 13.23,38.815 sky130_fd_pr__pfet_01v8
M$2282 36 628 591 591 sky130_fd_pr__pfet_01v8 L=0.15U W=1U AS=0.165P AD=0.36P
+ PS=1.33U PD=2.72U
* device instance $2283 r0 *1 14.31,38.815 sky130_fd_pr__pfet_01v8
M$2283 657 595 630 630 sky130_fd_pr__pfet_01v8 L=0.15U W=1U AS=0.26P AD=0.135P
+ PS=2.52U PD=1.27U
* device instance $2284 r0 *1 14.73,38.815 sky130_fd_pr__pfet_01v8
M$2284 36 407 657 657 sky130_fd_pr__pfet_01v8 L=0.15U W=1U AS=0.135P AD=0.135P
+ PS=1.27U PD=1.27U
* device instance $2285 r0 *1 15.15,38.815 sky130_fd_pr__pfet_01v8
M$2285 631 407 36 36 sky130_fd_pr__pfet_01v8 L=0.15U W=1U AS=0.135P AD=0.135P
+ PS=1.27U PD=1.27U
* device instance $2286 r0 *1 15.57,38.815 sky130_fd_pr__pfet_01v8
M$2286 36 595 631 631 sky130_fd_pr__pfet_01v8 L=0.15U W=1U AS=0.135P AD=0.26P
+ PS=1.27U PD=2.52U
* device instance $2287 r0 *1 16.51,38.815 sky130_fd_pr__pfet_01v8
M$2287 632 630 631 631 sky130_fd_pr__pfet_01v8 L=0.15U W=1U AS=0.26P AD=0.3P
+ PS=2.52U PD=2.6U
* device instance $2288 r0 *1 25.77,38.815 sky130_fd_pr__pfet_01v8
M$2288 634 651 633 633 sky130_fd_pr__pfet_01v8 L=0.15U W=1U AS=0.26P AD=0.135P
+ PS=2.52U PD=1.27U
* device instance $2289 r0 *1 26.19,38.815 sky130_fd_pr__pfet_01v8
M$2289 635 652 634 634 sky130_fd_pr__pfet_01v8 L=0.15U W=1U AS=0.135P AD=0.135P
+ PS=1.27U PD=1.27U
* device instance $2290 r0 *1 26.61,38.815 sky130_fd_pr__pfet_01v8
M$2290 634 91 635 635 sky130_fd_pr__pfet_01v8 L=0.15U W=1U AS=0.135P AD=0.26P
+ PS=1.27U PD=2.52U
* device instance $2291 r0 *1 27.55,38.815 sky130_fd_pr__pfet_01v8
M$2291 635 134 36 36 sky130_fd_pr__pfet_01v8 L=0.15U W=1U AS=0.26P AD=0.165P
+ PS=2.52U PD=1.33U
* device instance $2292 r0 *1 28.03,38.815 sky130_fd_pr__pfet_01v8
M$2292 36 558 635 635 sky130_fd_pr__pfet_01v8 L=0.15U W=1U AS=0.165P AD=0.1575P
+ PS=1.33U PD=1.315U
* device instance $2293 r0 *1 28.495,38.815 sky130_fd_pr__pfet_01v8
M$2293 636 633 36 36 sky130_fd_pr__pfet_01v8 L=0.15U W=1U AS=0.1575P AD=0.26P
+ PS=1.315U PD=2.52U
* device instance $2294 r0 *1 30.87,38.815 sky130_fd_pr__pfet_01v8
M$2294 637 598 36 36 sky130_fd_pr__pfet_01v8 L=0.15U W=1U AS=0.3P AD=0.135P
+ PS=2.6U PD=1.27U
* device instance $2295 r0 *1 31.29,38.815 sky130_fd_pr__pfet_01v8
M$2295 36 652 637 637 sky130_fd_pr__pfet_01v8 L=0.15U W=1U AS=0.135P AD=0.365P
+ PS=1.27U PD=1.73U
* device instance $2296 r0 *1 32.17,38.815 sky130_fd_pr__pfet_01v8
M$2296 658 652 36 36 sky130_fd_pr__pfet_01v8 L=0.15U W=1U AS=0.365P AD=0.105P
+ PS=1.73U PD=1.21U
* device instance $2297 r0 *1 32.53,38.815 sky130_fd_pr__pfet_01v8
M$2297 596 598 658 658 sky130_fd_pr__pfet_01v8 L=0.15U W=1U AS=0.105P AD=0.165P
+ PS=1.21U PD=1.33U
* device instance $2298 r0 *1 33.01,38.815 sky130_fd_pr__pfet_01v8
M$2298 36 637 596 596 sky130_fd_pr__pfet_01v8 L=0.15U W=1U AS=0.165P AD=0.36P
+ PS=1.33U PD=2.72U
* device instance $2299 r0 *1 35.435,38.815 sky130_fd_pr__pfet_01v8
M$2299 638 662 36 36 sky130_fd_pr__pfet_01v8 L=0.15U W=4U AS=0.685P AD=0.56P
+ PS=6.37U PD=5.12U
* device instance $2303 r0 *1 37.155,38.815 sky130_fd_pr__pfet_01v8
M$2303 297 638 36 36 sky130_fd_pr__pfet_01v8 L=0.15U W=16U AS=2.2375P
+ AD=2.3625P PS=20.475U PD=21.725U
* device instance $2319 r0 *1 55.67,38.815 sky130_fd_pr__pfet_01v8
M$2319 639 580 36 36 sky130_fd_pr__pfet_01v8 L=0.15U W=1U AS=0.26P AD=0.135P
+ PS=2.52U PD=1.27U
* device instance $2320 r0 *1 56.09,38.815 sky130_fd_pr__pfet_01v8
M$2320 36 342 639 639 sky130_fd_pr__pfet_01v8 L=0.15U W=1U AS=0.135P AD=0.1525P
+ PS=1.27U PD=1.305U
* device instance $2321 r0 *1 56.545,38.815 sky130_fd_pr__pfet_01v8
M$2321 639 603 36 36 sky130_fd_pr__pfet_01v8 L=0.15U W=1U AS=0.1525P AD=0.1625P
+ PS=1.305U PD=1.325U
* device instance $2322 r0 *1 57.02,38.815 sky130_fd_pr__pfet_01v8
M$2322 640 606 639 639 sky130_fd_pr__pfet_01v8 L=0.15U W=1U AS=0.1625P AD=0.27P
+ PS=1.325U PD=2.54U
* device instance $2323 r0 *1 59.35,38.815 sky130_fd_pr__pfet_01v8
M$2323 641 342 36 36 sky130_fd_pr__pfet_01v8 L=0.15U W=1U AS=0.26P AD=0.1375P
+ PS=2.52U PD=1.275U
* device instance $2324 r0 *1 59.775,38.815 sky130_fd_pr__pfet_01v8
M$2324 36 307 641 641 sky130_fd_pr__pfet_01v8 L=0.15U W=1U AS=0.1375P AD=0.14P
+ PS=1.275U PD=1.28U
* device instance $2325 r0 *1 60.205,38.815 sky130_fd_pr__pfet_01v8
M$2325 641 603 36 36 sky130_fd_pr__pfet_01v8 L=0.15U W=1U AS=0.14P AD=0.165P
+ PS=1.28U PD=1.33U
* device instance $2326 r0 *1 60.685,38.815 sky130_fd_pr__pfet_01v8
M$2326 655 606 641 641 sky130_fd_pr__pfet_01v8 L=0.15U W=1U AS=0.165P
+ AD=0.1725P PS=1.33U PD=1.345U
* device instance $2327 r0 *1 61.18,38.815 sky130_fd_pr__pfet_01v8
M$2327 642 663 655 655 sky130_fd_pr__pfet_01v8 L=0.15U W=1U AS=0.1725P AD=0.26P
+ PS=1.345U PD=2.52U
* device instance $2328 r0 *1 64.45,38.815 sky130_fd_pr__pfet_01v8
M$2328 643 653 36 36 sky130_fd_pr__pfet_01v8 L=0.15U W=1U AS=0.3P AD=0.135P
+ PS=2.6U PD=1.27U
* device instance $2329 r0 *1 64.87,38.815 sky130_fd_pr__pfet_01v8
M$2329 36 571 643 643 sky130_fd_pr__pfet_01v8 L=0.15U W=1U AS=0.135P AD=0.365P
+ PS=1.27U PD=1.73U
* device instance $2330 r0 *1 65.75,38.815 sky130_fd_pr__pfet_01v8
M$2330 654 571 36 36 sky130_fd_pr__pfet_01v8 L=0.15U W=1U AS=0.365P AD=0.105P
+ PS=1.73U PD=1.21U
* device instance $2331 r0 *1 66.11,38.815 sky130_fd_pr__pfet_01v8
M$2331 603 653 654 654 sky130_fd_pr__pfet_01v8 L=0.15U W=1U AS=0.105P AD=0.165P
+ PS=1.21U PD=1.33U
* device instance $2332 r0 *1 66.59,38.815 sky130_fd_pr__pfet_01v8
M$2332 36 643 603 603 sky130_fd_pr__pfet_01v8 L=0.15U W=1U AS=0.165P AD=0.36P
+ PS=1.33U PD=2.72U
* device instance $2333 r0 *1 68.635,38.72 sky130_fd_pr__pfet_01v8
M$2333 650 63 36 36 sky130_fd_pr__pfet_01v8 L=0.15U W=0.42U AS=0.15835P
+ AD=0.07665P PS=1.395U PD=0.785U
* device instance $2334 r0 *1 69.15,38.72 sky130_fd_pr__pfet_01v8
M$2334 645 653 650 650 sky130_fd_pr__pfet_01v8 L=0.15U W=0.42U AS=0.07665P
+ AD=0.1932P PS=0.785U PD=1.34U
* device instance $2335 r0 *1 70.22,38.72 sky130_fd_pr__pfet_01v8
M$2335 649 646 645 645 sky130_fd_pr__pfet_01v8 L=0.15U W=0.42U AS=0.1932P
+ AD=0.0441P PS=1.34U PD=0.63U
* device instance $2336 r0 *1 70.58,38.72 sky130_fd_pr__pfet_01v8
M$2336 36 665 649 649 sky130_fd_pr__pfet_01v8 L=0.15U W=0.42U AS=0.0441P
+ AD=0.0693P PS=0.63U PD=0.75U
* device instance $2337 r0 *1 71.06,38.72 sky130_fd_pr__pfet_01v8
M$2337 665 63 36 36 sky130_fd_pr__pfet_01v8 L=0.15U W=0.42U AS=0.0693P
+ AD=0.1176P PS=0.75U PD=1.4U
* device instance $2338 r0 *1 68.09,38.815 sky130_fd_pr__pfet_01v8
M$2338 36 645 644 644 sky130_fd_pr__pfet_01v8 L=0.15U W=1U AS=0.26P AD=0.15835P
+ PS=2.52U PD=1.395U
* device instance $2339 r0 *1 2.77,42.935 sky130_fd_pr__pfet_01v8
M$2339 36 682 681 681 sky130_fd_pr__pfet_01v8 L=0.15U W=0.64U AS=0.1664P
+ AD=0.0864P PS=1.8U PD=0.91U
* device instance $2340 r0 *1 3.19,42.935 sky130_fd_pr__pfet_01v8
M$2340 683 681 36 36 sky130_fd_pr__pfet_01v8 L=0.15U W=0.64U AS=0.0864P
+ AD=0.1664P PS=0.91U PD=1.8U
* device instance $2341 r0 *1 4.13,42.965 sky130_fd_pr__pfet_01v8
M$2341 738 625 684 684 sky130_fd_pr__pfet_01v8 L=0.15U W=0.64U AS=0.1664P
+ AD=0.0672P PS=1.8U PD=0.85U
* device instance $2342 r0 *1 4.49,42.965 sky130_fd_pr__pfet_01v8
M$2342 36 685 738 738 sky130_fd_pr__pfet_01v8 L=0.15U W=0.64U AS=0.0672P
+ AD=0.1664P PS=0.85U PD=1.8U
* device instance $2343 r0 *1 5.43,42.965 sky130_fd_pr__pfet_01v8
M$2343 36 93 685 685 sky130_fd_pr__pfet_01v8 L=0.15U W=0.64U AS=0.1664P
+ AD=0.0928P PS=1.8U PD=0.93U
* device instance $2344 r0 *1 5.87,42.965 sky130_fd_pr__pfet_01v8
M$2344 740 93 36 36 sky130_fd_pr__pfet_01v8 L=0.15U W=0.64U AS=0.0928P
+ AD=0.1152P PS=0.93U PD=1U
* device instance $2345 r0 *1 6.38,42.965 sky130_fd_pr__pfet_01v8
M$2345 684 686 740 740 sky130_fd_pr__pfet_01v8 L=0.15U W=0.64U AS=0.1152P
+ AD=0.15985P PS=1U PD=1.265U
* device instance $2346 r0 *1 7.155,43.075 sky130_fd_pr__pfet_01v8
M$2346 687 683 684 684 sky130_fd_pr__pfet_01v8 L=0.15U W=0.42U AS=0.15985P
+ AD=0.06405P PS=1.265U PD=0.725U
* device instance $2347 r0 *1 7.61,43.075 sky130_fd_pr__pfet_01v8
M$2347 743 681 687 687 sky130_fd_pr__pfet_01v8 L=0.15U W=0.42U AS=0.06405P
+ AD=0.07665P PS=0.725U PD=0.785U
* device instance $2348 r0 *1 8.125,43.075 sky130_fd_pr__pfet_01v8
M$2348 743 688 36 36 sky130_fd_pr__pfet_01v8 L=0.15U W=0.42U AS=0.178875P
+ AD=0.07665P PS=1.26U PD=0.785U
* device instance $2349 r0 *1 8.785,42.91 sky130_fd_pr__pfet_01v8
M$2349 688 687 36 36 sky130_fd_pr__pfet_01v8 L=0.15U W=0.75U AS=0.178875P
+ AD=0.195P PS=1.26U PD=2.02U
* device instance $2350 r0 *1 12.225,42.965 sky130_fd_pr__pfet_01v8
M$2350 686 689 36 36 sky130_fd_pr__pfet_01v8 L=0.15U W=0.64U AS=0.154P
+ AD=0.1728P PS=1.335U PD=1.82U
* device instance $2351 r0 *1 12.71,42.785 sky130_fd_pr__pfet_01v8
M$2351 555 689 36 36 sky130_fd_pr__pfet_01v8 L=0.15U W=1U AS=0.154P AD=0.28P
+ PS=1.335U PD=2.56U
* device instance $2352 r0 *1 13.81,42.785 sky130_fd_pr__pfet_01v8
M$2352 36 555 690 690 sky130_fd_pr__pfet_01v8 L=0.15U W=1U AS=0.26P AD=0.135P
+ PS=2.52U PD=1.27U
* device instance $2353 r0 *1 14.23,42.785 sky130_fd_pr__pfet_01v8
M$2353 407 690 36 36 sky130_fd_pr__pfet_01v8 L=0.15U W=4U AS=0.54P AD=0.665P
+ PS=5.08U PD=6.33U
* device instance $2357 r0 *1 17.03,42.785 sky130_fd_pr__pfet_01v8
M$2357 36 594 691 691 sky130_fd_pr__pfet_01v8 L=0.15U W=1U AS=0.26P AD=0.135P
+ PS=2.52U PD=1.27U
* device instance $2358 r0 *1 17.45,42.785 sky130_fd_pr__pfet_01v8
M$2358 629 691 36 36 sky130_fd_pr__pfet_01v8 L=0.15U W=4U AS=0.54P AD=0.665P
+ PS=5.08U PD=6.33U
* device instance $2362 r0 *1 26.23,42.935 sky130_fd_pr__pfet_01v8
M$2362 36 682 693 693 sky130_fd_pr__pfet_01v8 L=0.15U W=0.64U AS=0.1664P
+ AD=0.0864P PS=1.8U PD=0.91U
* device instance $2363 r0 *1 26.65,42.935 sky130_fd_pr__pfet_01v8
M$2363 694 693 36 36 sky130_fd_pr__pfet_01v8 L=0.15U W=0.64U AS=0.0864P
+ AD=0.1664P PS=0.91U PD=1.8U
* device instance $2364 r0 *1 27.59,42.965 sky130_fd_pr__pfet_01v8
M$2364 755 728 695 695 sky130_fd_pr__pfet_01v8 L=0.15U W=0.64U AS=0.1664P
+ AD=0.0672P PS=1.8U PD=0.85U
* device instance $2365 r0 *1 27.95,42.965 sky130_fd_pr__pfet_01v8
M$2365 36 696 755 755 sky130_fd_pr__pfet_01v8 L=0.15U W=0.64U AS=0.0672P
+ AD=0.1664P PS=0.85U PD=1.8U
* device instance $2366 r0 *1 28.89,42.965 sky130_fd_pr__pfet_01v8
M$2366 36 93 696 696 sky130_fd_pr__pfet_01v8 L=0.15U W=0.64U AS=0.1664P
+ AD=0.0928P PS=1.8U PD=0.93U
* device instance $2367 r0 *1 29.33,42.965 sky130_fd_pr__pfet_01v8
M$2367 754 93 36 36 sky130_fd_pr__pfet_01v8 L=0.15U W=0.64U AS=0.0928P
+ AD=0.1152P PS=0.93U PD=1U
* device instance $2368 r0 *1 29.84,42.965 sky130_fd_pr__pfet_01v8
M$2368 695 697 754 754 sky130_fd_pr__pfet_01v8 L=0.15U W=0.64U AS=0.1152P
+ AD=0.15985P PS=1U PD=1.265U
* device instance $2369 r0 *1 30.615,43.075 sky130_fd_pr__pfet_01v8
M$2369 698 694 695 695 sky130_fd_pr__pfet_01v8 L=0.15U W=0.42U AS=0.15985P
+ AD=0.06405P PS=1.265U PD=0.725U
* device instance $2370 r0 *1 31.07,43.075 sky130_fd_pr__pfet_01v8
M$2370 753 693 698 698 sky130_fd_pr__pfet_01v8 L=0.15U W=0.42U AS=0.06405P
+ AD=0.07665P PS=0.725U PD=0.785U
* device instance $2371 r0 *1 31.585,43.075 sky130_fd_pr__pfet_01v8
M$2371 753 699 36 36 sky130_fd_pr__pfet_01v8 L=0.15U W=0.42U AS=0.178875P
+ AD=0.07665P PS=1.26U PD=0.785U
* device instance $2372 r0 *1 32.245,42.91 sky130_fd_pr__pfet_01v8
M$2372 699 698 36 36 sky130_fd_pr__pfet_01v8 L=0.15U W=0.75U AS=0.178875P
+ AD=0.195P PS=1.26U PD=2.02U
* device instance $2373 r0 *1 35.685,42.965 sky130_fd_pr__pfet_01v8
M$2373 697 700 36 36 sky130_fd_pr__pfet_01v8 L=0.15U W=0.64U AS=0.154P
+ AD=0.1728P PS=1.335U PD=1.82U
* device instance $2374 r0 *1 36.17,42.785 sky130_fd_pr__pfet_01v8
M$2374 652 700 36 36 sky130_fd_pr__pfet_01v8 L=0.15U W=1U AS=0.154P AD=0.28P
+ PS=1.335U PD=2.56U
* device instance $2375 r0 *1 44.63,42.785 sky130_fd_pr__pfet_01v8
M$2375 750 652 735 735 sky130_fd_pr__pfet_01v8 L=0.15U W=1U AS=0.26P AD=0.13P
+ PS=2.52U PD=1.26U
* device instance $2376 r0 *1 45.04,42.785 sky130_fd_pr__pfet_01v8
M$2376 749 411 750 750 sky130_fd_pr__pfet_01v8 L=0.15U W=1U AS=0.13P AD=0.19P
+ PS=1.26U PD=1.38U
* device instance $2377 r0 *1 45.57,42.785 sky130_fd_pr__pfet_01v8
M$2377 748 729 749 749 sky130_fd_pr__pfet_01v8 L=0.15U W=1U AS=0.19P AD=0.135P
+ PS=1.38U PD=1.27U
* device instance $2378 r0 *1 45.99,42.785 sky130_fd_pr__pfet_01v8
M$2378 36 1135 748 748 sky130_fd_pr__pfet_01v8 L=0.15U W=1U AS=0.135P AD=0.26P
+ PS=1.27U PD=2.52U
* device instance $2379 r0 *1 49.23,42.785 sky130_fd_pr__pfet_01v8
M$2379 897 735 36 36 sky130_fd_pr__pfet_01v8 L=0.15U W=1U AS=0.26P AD=0.135P
+ PS=2.52U PD=1.27U
* device instance $2380 r0 *1 49.65,42.785 sky130_fd_pr__pfet_01v8
M$2380 36 701 897 897 sky130_fd_pr__pfet_01v8 L=0.15U W=1U AS=0.135P AD=0.165P
+ PS=1.27U PD=1.33U
* device instance $2381 r0 *1 50.13,42.785 sky130_fd_pr__pfet_01v8
M$2381 897 408 36 36 sky130_fd_pr__pfet_01v8 L=0.15U W=1U AS=0.165P AD=0.26P
+ PS=1.33U PD=2.52U
* device instance $2382 r0 *1 57.55,42.785 sky130_fd_pr__pfet_01v8
M$2382 731 730 36 36 sky130_fd_pr__pfet_01v8 L=0.15U W=1U AS=0.3P AD=0.135P
+ PS=2.6U PD=1.27U
* device instance $2383 r0 *1 57.97,42.785 sky130_fd_pr__pfet_01v8
M$2383 36 640 731 731 sky130_fd_pr__pfet_01v8 L=0.15U W=1U AS=0.135P AD=0.365P
+ PS=1.27U PD=1.73U
* device instance $2384 r0 *1 58.85,42.785 sky130_fd_pr__pfet_01v8
M$2384 747 640 36 36 sky130_fd_pr__pfet_01v8 L=0.15U W=1U AS=0.365P AD=0.105P
+ PS=1.73U PD=1.21U
* device instance $2385 r0 *1 59.21,42.785 sky130_fd_pr__pfet_01v8
M$2385 736 730 747 747 sky130_fd_pr__pfet_01v8 L=0.15U W=1U AS=0.105P AD=0.165P
+ PS=1.21U PD=1.33U
* device instance $2386 r0 *1 59.69,42.785 sky130_fd_pr__pfet_01v8
M$2386 36 731 736 736 sky130_fd_pr__pfet_01v8 L=0.15U W=1U AS=0.165P AD=0.36P
+ PS=1.33U PD=2.72U
* device instance $2387 r0 *1 60.73,42.935 sky130_fd_pr__pfet_01v8
M$2387 36 980 703 703 sky130_fd_pr__pfet_01v8 L=0.15U W=0.64U AS=0.1664P
+ AD=0.0864P PS=1.8U PD=0.91U
* device instance $2388 r0 *1 61.15,42.935 sky130_fd_pr__pfet_01v8
M$2388 704 703 36 36 sky130_fd_pr__pfet_01v8 L=0.15U W=0.64U AS=0.0864P
+ AD=0.1664P PS=0.91U PD=1.8U
* device instance $2389 r0 *1 62.09,42.965 sky130_fd_pr__pfet_01v8
M$2389 744 573 705 705 sky130_fd_pr__pfet_01v8 L=0.15U W=0.64U AS=0.1664P
+ AD=0.0672P PS=1.8U PD=0.85U
* device instance $2390 r0 *1 62.45,42.965 sky130_fd_pr__pfet_01v8
M$2390 36 706 744 744 sky130_fd_pr__pfet_01v8 L=0.15U W=0.64U AS=0.0672P
+ AD=0.1664P PS=0.85U PD=1.8U
* device instance $2391 r0 *1 63.39,42.965 sky130_fd_pr__pfet_01v8
M$2391 36 302 706 706 sky130_fd_pr__pfet_01v8 L=0.15U W=0.64U AS=0.1664P
+ AD=0.0928P PS=1.8U PD=0.93U
* device instance $2392 r0 *1 63.83,42.965 sky130_fd_pr__pfet_01v8
M$2392 742 302 36 36 sky130_fd_pr__pfet_01v8 L=0.15U W=0.64U AS=0.0928P
+ AD=0.1152P PS=0.93U PD=1U
* device instance $2393 r0 *1 64.34,42.965 sky130_fd_pr__pfet_01v8
M$2393 705 707 742 742 sky130_fd_pr__pfet_01v8 L=0.15U W=0.64U AS=0.1152P
+ AD=0.15985P PS=1U PD=1.265U
* device instance $2394 r0 *1 65.115,43.075 sky130_fd_pr__pfet_01v8
M$2394 708 704 705 705 sky130_fd_pr__pfet_01v8 L=0.15U W=0.42U AS=0.15985P
+ AD=0.06405P PS=1.265U PD=0.725U
* device instance $2395 r0 *1 65.57,43.075 sky130_fd_pr__pfet_01v8
M$2395 741 703 708 708 sky130_fd_pr__pfet_01v8 L=0.15U W=0.42U AS=0.06405P
+ AD=0.07665P PS=0.725U PD=0.785U
* device instance $2396 r0 *1 66.085,43.075 sky130_fd_pr__pfet_01v8
M$2396 741 709 36 36 sky130_fd_pr__pfet_01v8 L=0.15U W=0.42U AS=0.178875P
+ AD=0.07665P PS=1.26U PD=0.785U
* device instance $2397 r0 *1 66.745,42.91 sky130_fd_pr__pfet_01v8
M$2397 709 708 36 36 sky130_fd_pr__pfet_01v8 L=0.15U W=0.75U AS=0.178875P
+ AD=0.195P PS=1.26U PD=2.02U
* device instance $2398 r0 *1 70.185,42.965 sky130_fd_pr__pfet_01v8
M$2398 707 710 36 36 sky130_fd_pr__pfet_01v8 L=0.15U W=0.64U AS=0.154P
+ AD=0.1728P PS=1.335U PD=1.82U
* device instance $2399 r0 *1 70.67,42.785 sky130_fd_pr__pfet_01v8
M$2399 653 710 36 36 sky130_fd_pr__pfet_01v8 L=0.15U W=1U AS=0.154P AD=0.28P
+ PS=1.335U PD=2.56U
* device instance $2400 r0 *1 9.725,43.075 sky130_fd_pr__pfet_01v8
M$2400 745 688 36 36 sky130_fd_pr__pfet_01v8 L=0.15U W=0.42U AS=0.1092P
+ AD=0.06405P PS=1.36U PD=0.725U
* device instance $2401 r0 *1 10.18,43.075 sky130_fd_pr__pfet_01v8
M$2401 689 681 745 745 sky130_fd_pr__pfet_01v8 L=0.15U W=0.42U AS=0.06405P
+ AD=0.0567P PS=0.725U PD=0.69U
* device instance $2402 r0 *1 10.6,43.075 sky130_fd_pr__pfet_01v8
M$2402 746 683 689 689 sky130_fd_pr__pfet_01v8 L=0.15U W=0.42U AS=0.0567P
+ AD=0.0882P PS=0.69U PD=0.84U
* device instance $2403 r0 *1 11.17,43.075 sky130_fd_pr__pfet_01v8
M$2403 36 686 746 746 sky130_fd_pr__pfet_01v8 L=0.15U W=0.42U AS=0.0882P
+ AD=0.1113P PS=0.84U PD=1.37U
* device instance $2404 r0 *1 10.57,44.075 sky130_fd_pr__pfet_01v8
M$2404 801 592 758 758 sky130_fd_pr__pfet_01v8 L=0.15U W=0.64U AS=0.1664P
+ AD=0.0672P PS=1.8U PD=0.85U
* device instance $2405 r0 *1 10.93,44.075 sky130_fd_pr__pfet_01v8
M$2405 36 759 801 801 sky130_fd_pr__pfet_01v8 L=0.15U W=0.64U AS=0.0672P
+ AD=0.1664P PS=0.85U PD=1.8U
* device instance $2406 r0 *1 13.595,43.965 sky130_fd_pr__pfet_01v8
M$2406 760 757 758 758 sky130_fd_pr__pfet_01v8 L=0.15U W=0.42U AS=0.15985P
+ AD=0.06405P PS=1.265U PD=0.725U
* device instance $2407 r0 *1 14.05,43.965 sky130_fd_pr__pfet_01v8
M$2407 788 756 760 760 sky130_fd_pr__pfet_01v8 L=0.15U W=0.42U AS=0.06405P
+ AD=0.07665P PS=0.725U PD=0.785U
* device instance $2408 r0 *1 14.565,43.965 sky130_fd_pr__pfet_01v8
M$2408 36 761 788 788 sky130_fd_pr__pfet_01v8 L=0.15U W=0.42U AS=0.07665P
+ AD=0.178875P PS=0.785U PD=1.26U
* device instance $2409 r0 *1 11.87,44.075 sky130_fd_pr__pfet_01v8
M$2409 36 302 759 759 sky130_fd_pr__pfet_01v8 L=0.15U W=0.64U AS=0.1664P
+ AD=0.0928P PS=1.8U PD=0.93U
* device instance $2410 r0 *1 12.31,44.075 sky130_fd_pr__pfet_01v8
M$2410 802 302 36 36 sky130_fd_pr__pfet_01v8 L=0.15U W=0.64U AS=0.0928P
+ AD=0.1152P PS=0.93U PD=1U
* device instance $2411 r0 *1 12.82,44.075 sky130_fd_pr__pfet_01v8
M$2411 758 763 802 802 sky130_fd_pr__pfet_01v8 L=0.15U W=0.64U AS=0.1152P
+ AD=0.15985P PS=1U PD=1.265U
* device instance $2412 r0 *1 15.225,44.13 sky130_fd_pr__pfet_01v8
M$2412 761 760 36 36 sky130_fd_pr__pfet_01v8 L=0.15U W=0.75U AS=0.178875P
+ AD=0.195P PS=1.26U PD=2.02U
* device instance $2413 r0 *1 16.165,43.965 sky130_fd_pr__pfet_01v8
M$2413 790 761 36 36 sky130_fd_pr__pfet_01v8 L=0.15U W=0.42U AS=0.1092P
+ AD=0.06405P PS=1.36U PD=0.725U
* device instance $2414 r0 *1 16.62,43.965 sky130_fd_pr__pfet_01v8
M$2414 762 756 790 790 sky130_fd_pr__pfet_01v8 L=0.15U W=0.42U AS=0.06405P
+ AD=0.0567P PS=0.725U PD=0.69U
* device instance $2415 r0 *1 17.04,43.965 sky130_fd_pr__pfet_01v8
M$2415 791 757 762 762 sky130_fd_pr__pfet_01v8 L=0.15U W=0.42U AS=0.0567P
+ AD=0.0882P PS=0.69U PD=0.84U
* device instance $2416 r0 *1 17.61,43.965 sky130_fd_pr__pfet_01v8
M$2416 36 763 791 791 sky130_fd_pr__pfet_01v8 L=0.15U W=0.42U AS=0.0882P
+ AD=0.1113P PS=0.84U PD=1.37U
* device instance $2417 r0 *1 18.665,44.075 sky130_fd_pr__pfet_01v8
M$2417 36 762 763 763 sky130_fd_pr__pfet_01v8 L=0.15U W=0.64U AS=0.1728P
+ AD=0.154P PS=1.82U PD=1.335U
* device instance $2418 r0 *1 19.15,44.255 sky130_fd_pr__pfet_01v8
M$2418 595 762 36 36 sky130_fd_pr__pfet_01v8 L=0.15U W=1U AS=0.154P AD=0.28P
+ PS=1.335U PD=2.56U
* device instance $2419 r0 *1 23.08,43.075 sky130_fd_pr__pfet_01v8
M$2419 692 727 36 36 sky130_fd_pr__pfet_01v8 L=0.15U W=0.42U AS=0.1113P
+ AD=0.0609P PS=1.37U PD=0.71U
* device instance $2420 r0 *1 23.52,43.075 sky130_fd_pr__pfet_01v8
M$2420 692 114 36 36 sky130_fd_pr__pfet_01v8 L=0.15U W=0.42U AS=0.1841P
+ AD=0.0609P PS=1.26U PD=0.71U
* device instance $2421 r0 *1 24.29,42.965 sky130_fd_pr__pfet_01v8
M$2421 651 692 36 36 sky130_fd_pr__pfet_01v8 L=0.15U W=0.64U AS=0.1841P
+ AD=0.1696P PS=1.26U PD=1.81U
* device instance $2422 r0 *1 26.775,44.16 sky130_fd_pr__pfet_01v8
M$2422 805 63 36 36 sky130_fd_pr__pfet_01v8 L=0.15U W=0.42U AS=0.15835P
+ AD=0.07665P PS=1.395U PD=0.785U
* device instance $2423 r0 *1 27.29,44.16 sky130_fd_pr__pfet_01v8
M$2423 764 598 805 805 sky130_fd_pr__pfet_01v8 L=0.15U W=0.42U AS=0.07665P
+ AD=0.1932P PS=0.785U PD=1.34U
* device instance $2424 r0 *1 28.36,44.16 sky130_fd_pr__pfet_01v8
M$2424 806 795 764 764 sky130_fd_pr__pfet_01v8 L=0.15U W=0.42U AS=0.1932P
+ AD=0.0441P PS=1.34U PD=0.63U
* device instance $2425 r0 *1 28.72,44.16 sky130_fd_pr__pfet_01v8
M$2425 36 813 806 806 sky130_fd_pr__pfet_01v8 L=0.15U W=0.42U AS=0.0441P
+ AD=0.0693P PS=0.63U PD=0.75U
* device instance $2426 r0 *1 29.2,44.16 sky130_fd_pr__pfet_01v8
M$2426 813 63 36 36 sky130_fd_pr__pfet_01v8 L=0.15U W=0.42U AS=0.0693P
+ AD=0.1176P PS=0.75U PD=1.4U
* device instance $2427 r0 *1 26.23,44.255 sky130_fd_pr__pfet_01v8
M$2427 36 764 728 728 sky130_fd_pr__pfet_01v8 L=0.15U W=1U AS=0.26P AD=0.15835P
+ PS=2.52U PD=1.395U
* device instance $2428 r0 *1 33.185,43.075 sky130_fd_pr__pfet_01v8
M$2428 752 699 36 36 sky130_fd_pr__pfet_01v8 L=0.15U W=0.42U AS=0.1092P
+ AD=0.06405P PS=1.36U PD=0.725U
* device instance $2429 r0 *1 33.64,43.075 sky130_fd_pr__pfet_01v8
M$2429 700 693 752 752 sky130_fd_pr__pfet_01v8 L=0.15U W=0.42U AS=0.06405P
+ AD=0.0567P PS=0.725U PD=0.69U
* device instance $2430 r0 *1 34.06,43.075 sky130_fd_pr__pfet_01v8
M$2430 751 694 700 700 sky130_fd_pr__pfet_01v8 L=0.15U W=0.42U AS=0.0567P
+ AD=0.0882P PS=0.69U PD=0.84U
* device instance $2431 r0 *1 34.63,43.075 sky130_fd_pr__pfet_01v8
M$2431 36 697 751 751 sky130_fd_pr__pfet_01v8 L=0.15U W=0.42U AS=0.0882P
+ AD=0.1113P PS=0.84U PD=1.37U
* device instance $2432 r0 *1 34.95,44.075 sky130_fd_pr__pfet_01v8
M$2432 809 796 767 767 sky130_fd_pr__pfet_01v8 L=0.15U W=0.64U AS=0.1664P
+ AD=0.0672P PS=1.8U PD=0.85U
* device instance $2433 r0 *1 35.31,44.075 sky130_fd_pr__pfet_01v8
M$2433 36 768 809 809 sky130_fd_pr__pfet_01v8 L=0.15U W=0.64U AS=0.0672P
+ AD=0.1664P PS=0.85U PD=1.8U
* device instance $2434 r0 *1 37.975,43.965 sky130_fd_pr__pfet_01v8
M$2434 769 766 767 767 sky130_fd_pr__pfet_01v8 L=0.15U W=0.42U AS=0.15985P
+ AD=0.06405P PS=1.265U PD=0.725U
* device instance $2435 r0 *1 38.43,43.965 sky130_fd_pr__pfet_01v8
M$2435 792 765 769 769 sky130_fd_pr__pfet_01v8 L=0.15U W=0.42U AS=0.06405P
+ AD=0.07665P PS=0.725U PD=0.785U
* device instance $2436 r0 *1 38.945,43.965 sky130_fd_pr__pfet_01v8
M$2436 36 770 792 792 sky130_fd_pr__pfet_01v8 L=0.15U W=0.42U AS=0.07665P
+ AD=0.178875P PS=0.785U PD=1.26U
* device instance $2437 r0 *1 36.25,44.075 sky130_fd_pr__pfet_01v8
M$2437 36 93 768 768 sky130_fd_pr__pfet_01v8 L=0.15U W=0.64U AS=0.1664P
+ AD=0.0928P PS=1.8U PD=0.93U
* device instance $2438 r0 *1 36.69,44.075 sky130_fd_pr__pfet_01v8
M$2438 810 93 36 36 sky130_fd_pr__pfet_01v8 L=0.15U W=0.64U AS=0.0928P
+ AD=0.1152P PS=0.93U PD=1U
* device instance $2439 r0 *1 37.2,44.075 sky130_fd_pr__pfet_01v8
M$2439 767 772 810 810 sky130_fd_pr__pfet_01v8 L=0.15U W=0.64U AS=0.1152P
+ AD=0.15985P PS=1U PD=1.265U
* device instance $2440 r0 *1 39.605,44.13 sky130_fd_pr__pfet_01v8
M$2440 770 769 36 36 sky130_fd_pr__pfet_01v8 L=0.15U W=0.75U AS=0.178875P
+ AD=0.195P PS=1.26U PD=2.02U
* device instance $2441 r0 *1 40.545,43.965 sky130_fd_pr__pfet_01v8
M$2441 793 770 36 36 sky130_fd_pr__pfet_01v8 L=0.15U W=0.42U AS=0.1092P
+ AD=0.06405P PS=1.36U PD=0.725U
* device instance $2442 r0 *1 41,43.965 sky130_fd_pr__pfet_01v8
M$2442 771 765 793 793 sky130_fd_pr__pfet_01v8 L=0.15U W=0.42U AS=0.06405P
+ AD=0.0567P PS=0.725U PD=0.69U
* device instance $2443 r0 *1 41.42,43.965 sky130_fd_pr__pfet_01v8
M$2443 794 766 771 771 sky130_fd_pr__pfet_01v8 L=0.15U W=0.42U AS=0.0567P
+ AD=0.0882P PS=0.69U PD=0.84U
* device instance $2444 r0 *1 41.99,43.965 sky130_fd_pr__pfet_01v8
M$2444 36 772 794 794 sky130_fd_pr__pfet_01v8 L=0.15U W=0.42U AS=0.0882P
+ AD=0.1113P PS=0.84U PD=1.37U
* device instance $2445 r0 *1 43.045,44.075 sky130_fd_pr__pfet_01v8
M$2445 36 771 772 772 sky130_fd_pr__pfet_01v8 L=0.15U W=0.64U AS=0.1728P
+ AD=0.154P PS=1.82U PD=1.335U
* device instance $2446 r0 *1 43.53,44.255 sky130_fd_pr__pfet_01v8
M$2446 729 771 36 36 sky130_fd_pr__pfet_01v8 L=0.15U W=1U AS=0.154P AD=0.28P
+ PS=1.335U PD=2.56U
* device instance $2447 r0 *1 44.63,44.255 sky130_fd_pr__pfet_01v8
M$2447 774 797 773 773 sky130_fd_pr__pfet_01v8 L=0.15U W=1U AS=0.26P AD=0.135P
+ PS=2.52U PD=1.27U
* device instance $2448 r0 *1 45.05,44.255 sky130_fd_pr__pfet_01v8
M$2448 776 729 774 774 sky130_fd_pr__pfet_01v8 L=0.15U W=1U AS=0.135P AD=0.135P
+ PS=1.27U PD=1.27U
* device instance $2449 r0 *1 45.47,44.255 sky130_fd_pr__pfet_01v8
M$2449 774 91 776 776 sky130_fd_pr__pfet_01v8 L=0.15U W=1U AS=0.135P AD=0.26P
+ PS=1.27U PD=2.52U
* device instance $2450 r0 *1 46.41,44.255 sky130_fd_pr__pfet_01v8
M$2450 776 134 36 36 sky130_fd_pr__pfet_01v8 L=0.15U W=1U AS=0.26P AD=0.165P
+ PS=2.52U PD=1.33U
* device instance $2451 r0 *1 46.89,44.255 sky130_fd_pr__pfet_01v8
M$2451 36 736 776 776 sky130_fd_pr__pfet_01v8 L=0.15U W=1U AS=0.165P AD=0.1575P
+ PS=1.33U PD=1.315U
* device instance $2452 r0 *1 47.355,44.255 sky130_fd_pr__pfet_01v8
M$2452 775 773 36 36 sky130_fd_pr__pfet_01v8 L=0.15U W=1U AS=0.1575P AD=0.26P
+ PS=1.315U PD=2.52U
* device instance $2453 r0 *1 48.31,44.175 sky130_fd_pr__pfet_01v8
M$2453 777 798 36 36 sky130_fd_pr__pfet_01v8 L=0.15U W=1.68U AS=0.3318P
+ AD=0.3486P PS=3.31U PD=3.35U
* device instance $2455 r0 *1 49.69,44.255 sky130_fd_pr__pfet_01v8
M$2455 812 777 663 663 sky130_fd_pr__pfet_01v8 L=0.15U W=1U AS=0.26P AD=0.105P
+ PS=2.52U PD=1.21U
* device instance $2456 r0 *1 50.05,44.255 sky130_fd_pr__pfet_01v8
M$2456 36 729 812 812 sky130_fd_pr__pfet_01v8 L=0.15U W=1U AS=0.105P AD=0.26P
+ PS=1.21U PD=2.52U
* device instance $2457 r0 *1 51.31,44.545 sky130_fd_pr__pfet_01v8
M$2457 799 729 36 36 sky130_fd_pr__pfet_01v8 L=0.15U W=0.42U AS=0.1573P
+ AD=0.1092P PS=1.39U PD=1.36U
* device instance $2458 r0 *1 51.85,44.255 sky130_fd_pr__pfet_01v8
M$2458 811 798 36 36 sky130_fd_pr__pfet_01v8 L=0.15U W=1U AS=0.1573P AD=0.105P
+ PS=1.39U PD=1.21U
* device instance $2459 r0 *1 52.21,44.255 sky130_fd_pr__pfet_01v8
M$2459 800 799 811 811 sky130_fd_pr__pfet_01v8 L=0.15U W=1U AS=0.105P AD=0.26P
+ PS=1.21U PD=2.52U
* device instance $2460 r0 *1 56.59,44.255 sky130_fd_pr__pfet_01v8
M$2460 808 800 730 730 sky130_fd_pr__pfet_01v8 L=0.15U W=1U AS=0.26P AD=0.105P
+ PS=2.52U PD=1.21U
* device instance $2461 r0 *1 56.95,44.255 sky130_fd_pr__pfet_01v8
M$2461 36 663 808 808 sky130_fd_pr__pfet_01v8 L=0.15U W=1U AS=0.105P AD=0.26P
+ PS=1.21U PD=2.52U
* device instance $2462 r0 *1 61.19,44.255 sky130_fd_pr__pfet_01v8
M$2462 807 571 701 701 sky130_fd_pr__pfet_01v8 L=0.15U W=1U AS=0.26P AD=0.105P
+ PS=2.52U PD=1.21U
* device instance $2463 r0 *1 61.55,44.255 sky130_fd_pr__pfet_01v8
M$2463 36 986 807 807 sky130_fd_pr__pfet_01v8 L=0.15U W=1U AS=0.105P AD=0.26P
+ PS=1.21U PD=2.52U
* device instance $2464 r0 *1 66.23,44.075 sky130_fd_pr__pfet_01v8
M$2464 804 644 780 780 sky130_fd_pr__pfet_01v8 L=0.15U W=0.64U AS=0.1664P
+ AD=0.0672P PS=1.8U PD=0.85U
* device instance $2465 r0 *1 66.59,44.075 sky130_fd_pr__pfet_01v8
M$2465 36 781 804 804 sky130_fd_pr__pfet_01v8 L=0.15U W=0.64U AS=0.0672P
+ AD=0.1664P PS=0.85U PD=1.8U
* device instance $2466 r0 *1 69.255,43.965 sky130_fd_pr__pfet_01v8
M$2466 782 779 780 780 sky130_fd_pr__pfet_01v8 L=0.15U W=0.42U AS=0.15985P
+ AD=0.06405P PS=1.265U PD=0.725U
* device instance $2467 r0 *1 69.71,43.965 sky130_fd_pr__pfet_01v8
M$2467 789 778 782 782 sky130_fd_pr__pfet_01v8 L=0.15U W=0.42U AS=0.06405P
+ AD=0.07665P PS=0.725U PD=0.785U
* device instance $2468 r0 *1 70.225,43.965 sky130_fd_pr__pfet_01v8
M$2468 36 783 789 789 sky130_fd_pr__pfet_01v8 L=0.15U W=0.42U AS=0.07665P
+ AD=0.178875P PS=0.785U PD=1.26U
* device instance $2469 r0 *1 67.53,44.075 sky130_fd_pr__pfet_01v8
M$2469 36 409 781 781 sky130_fd_pr__pfet_01v8 L=0.15U W=0.64U AS=0.1664P
+ AD=0.0928P PS=1.8U PD=0.93U
* device instance $2470 r0 *1 67.97,44.075 sky130_fd_pr__pfet_01v8
M$2470 803 409 36 36 sky130_fd_pr__pfet_01v8 L=0.15U W=0.64U AS=0.0928P
+ AD=0.1152P PS=0.93U PD=1U
* device instance $2471 r0 *1 68.48,44.075 sky130_fd_pr__pfet_01v8
M$2471 780 785 803 803 sky130_fd_pr__pfet_01v8 L=0.15U W=0.64U AS=0.1152P
+ AD=0.15985P PS=1U PD=1.265U
* device instance $2472 r0 *1 70.885,44.13 sky130_fd_pr__pfet_01v8
M$2472 783 782 36 36 sky130_fd_pr__pfet_01v8 L=0.15U W=0.75U AS=0.178875P
+ AD=0.195P PS=1.26U PD=2.02U
* device instance $2473 r0 *1 67.685,43.075 sky130_fd_pr__pfet_01v8
M$2473 739 709 36 36 sky130_fd_pr__pfet_01v8 L=0.15U W=0.42U AS=0.1092P
+ AD=0.06405P PS=1.36U PD=0.725U
* device instance $2474 r0 *1 68.14,43.075 sky130_fd_pr__pfet_01v8
M$2474 710 703 739 739 sky130_fd_pr__pfet_01v8 L=0.15U W=0.42U AS=0.06405P
+ AD=0.0567P PS=0.725U PD=0.69U
* device instance $2475 r0 *1 68.56,43.075 sky130_fd_pr__pfet_01v8
M$2475 737 704 710 710 sky130_fd_pr__pfet_01v8 L=0.15U W=0.42U AS=0.0567P
+ AD=0.0882P PS=0.69U PD=0.84U
* device instance $2476 r0 *1 69.13,43.075 sky130_fd_pr__pfet_01v8
M$2476 36 707 737 737 sky130_fd_pr__pfet_01v8 L=0.15U W=0.42U AS=0.0882P
+ AD=0.1113P PS=0.84U PD=1.37U
* device instance $2477 r0 *1 71.825,43.965 sky130_fd_pr__pfet_01v8
M$2477 787 783 36 36 sky130_fd_pr__pfet_01v8 L=0.15U W=0.42U AS=0.1092P
+ AD=0.06405P PS=1.36U PD=0.725U
* device instance $2478 r0 *1 72.28,43.965 sky130_fd_pr__pfet_01v8
M$2478 784 778 787 787 sky130_fd_pr__pfet_01v8 L=0.15U W=0.42U AS=0.06405P
+ AD=0.0567P PS=0.725U PD=0.69U
* device instance $2479 r0 *1 72.7,43.965 sky130_fd_pr__pfet_01v8
M$2479 786 779 784 784 sky130_fd_pr__pfet_01v8 L=0.15U W=0.42U AS=0.0567P
+ AD=0.0882P PS=0.69U PD=0.84U
* device instance $2480 r0 *1 73.27,43.965 sky130_fd_pr__pfet_01v8
M$2480 36 785 786 786 sky130_fd_pr__pfet_01v8 L=0.15U W=0.42U AS=0.0882P
+ AD=0.1113P PS=0.84U PD=1.37U
* device instance $2481 r0 *1 74.325,44.075 sky130_fd_pr__pfet_01v8
M$2481 36 784 785 785 sky130_fd_pr__pfet_01v8 L=0.15U W=0.64U AS=0.1728P
+ AD=0.154P PS=1.82U PD=1.335U
* device instance $2482 r0 *1 74.81,44.255 sky130_fd_pr__pfet_01v8
M$2482 571 784 36 36 sky130_fd_pr__pfet_01v8 L=0.15U W=1U AS=0.154P AD=0.28P
+ PS=1.335U PD=2.56U
* device instance $2483 r0 *1 7.83,48.225 sky130_fd_pr__pfet_01v8
M$2483 875 868 833 833 sky130_fd_pr__pfet_01v8 L=0.15U W=1U AS=0.26P AD=0.135P
+ PS=2.52U PD=1.27U
* device instance $2484 r0 *1 8.25,48.225 sky130_fd_pr__pfet_01v8
M$2484 873 834 875 875 sky130_fd_pr__pfet_01v8 L=0.15U W=1U AS=0.135P AD=0.135P
+ PS=1.27U PD=1.27U
* device instance $2485 r0 *1 8.67,48.225 sky130_fd_pr__pfet_01v8
M$2485 875 91 873 873 sky130_fd_pr__pfet_01v8 L=0.15U W=1U AS=0.135P AD=0.26P
+ PS=1.27U PD=2.52U
* device instance $2486 r0 *1 9.21,44.105 sky130_fd_pr__pfet_01v8
M$2486 36 682 756 756 sky130_fd_pr__pfet_01v8 L=0.15U W=0.64U AS=0.1664P
+ AD=0.0864P PS=1.8U PD=0.91U
* device instance $2487 r0 *1 9.63,44.105 sky130_fd_pr__pfet_01v8
M$2487 757 756 36 36 sky130_fd_pr__pfet_01v8 L=0.15U W=0.64U AS=0.0864P
+ AD=0.1664P PS=0.91U PD=1.8U
* device instance $2488 r0 *1 9.61,48.225 sky130_fd_pr__pfet_01v8
M$2488 873 157 36 36 sky130_fd_pr__pfet_01v8 L=0.15U W=1U AS=0.26P AD=0.165P
+ PS=2.52U PD=1.33U
* device instance $2489 r0 *1 10.09,48.225 sky130_fd_pr__pfet_01v8
M$2489 36 869 873 873 sky130_fd_pr__pfet_01v8 L=0.15U W=1U AS=0.165P AD=0.1575P
+ PS=1.33U PD=1.315U
* device instance $2490 r0 *1 10.555,48.225 sky130_fd_pr__pfet_01v8
M$2490 874 833 36 36 sky130_fd_pr__pfet_01v8 L=0.15U W=1U AS=0.1575P AD=0.26P
+ PS=1.315U PD=2.52U
* device instance $2491 r0 *1 11.51,48.225 sky130_fd_pr__pfet_01v8
M$2491 36 870 836 836 sky130_fd_pr__pfet_01v8 L=0.15U W=1U AS=0.26P AD=0.26P
+ PS=2.52U PD=2.52U
* device instance $2492 r0 *1 12.45,48.225 sky130_fd_pr__pfet_01v8
M$2492 594 836 36 36 sky130_fd_pr__pfet_01v8 L=0.15U W=4U AS=0.665P AD=0.5475P
+ PS=6.33U PD=5.095U
* device instance $2496 r0 *1 14.145,48.225 sky130_fd_pr__pfet_01v8
M$2496 594 837 36 36 sky130_fd_pr__pfet_01v8 L=0.15U W=4U AS=0.5475P AD=0.795P
+ PS=5.095U PD=6.59U
* device instance $2500 r0 *1 25.77,48.375 sky130_fd_pr__pfet_01v8
M$2500 36 682 838 838 sky130_fd_pr__pfet_01v8 L=0.15U W=0.64U AS=0.1664P
+ AD=0.0864P PS=1.8U PD=0.91U
* device instance $2501 r0 *1 26.19,48.375 sky130_fd_pr__pfet_01v8
M$2501 871 838 36 36 sky130_fd_pr__pfet_01v8 L=0.15U W=0.64U AS=0.0864P
+ AD=0.1664P PS=0.91U PD=1.8U
* device instance $2502 r0 *1 27.13,48.405 sky130_fd_pr__pfet_01v8
M$2502 882 636 839 839 sky130_fd_pr__pfet_01v8 L=0.15U W=0.64U AS=0.1664P
+ AD=0.0672P PS=1.8U PD=0.85U
* device instance $2503 r0 *1 27.49,48.405 sky130_fd_pr__pfet_01v8
M$2503 36 840 882 882 sky130_fd_pr__pfet_01v8 L=0.15U W=0.64U AS=0.0672P
+ AD=0.1664P PS=0.85U PD=1.8U
* device instance $2504 r0 *1 28.43,48.405 sky130_fd_pr__pfet_01v8
M$2504 36 302 840 840 sky130_fd_pr__pfet_01v8 L=0.15U W=0.64U AS=0.1664P
+ AD=0.0928P PS=1.8U PD=0.93U
* device instance $2505 r0 *1 28.87,48.405 sky130_fd_pr__pfet_01v8
M$2505 884 302 36 36 sky130_fd_pr__pfet_01v8 L=0.15U W=0.64U AS=0.0928P
+ AD=0.1152P PS=0.93U PD=1U
* device instance $2506 r0 *1 29.38,48.405 sky130_fd_pr__pfet_01v8
M$2506 839 841 884 884 sky130_fd_pr__pfet_01v8 L=0.15U W=0.64U AS=0.1152P
+ AD=0.15985P PS=1U PD=1.265U
* device instance $2507 r0 *1 30.155,48.515 sky130_fd_pr__pfet_01v8
M$2507 842 871 839 839 sky130_fd_pr__pfet_01v8 L=0.15U W=0.42U AS=0.15985P
+ AD=0.06405P PS=1.265U PD=0.725U
* device instance $2508 r0 *1 30.61,48.515 sky130_fd_pr__pfet_01v8
M$2508 886 838 842 842 sky130_fd_pr__pfet_01v8 L=0.15U W=0.42U AS=0.06405P
+ AD=0.07665P PS=0.725U PD=0.785U
* device instance $2509 r0 *1 31.125,48.515 sky130_fd_pr__pfet_01v8
M$2509 886 843 36 36 sky130_fd_pr__pfet_01v8 L=0.15U W=0.42U AS=0.178875P
+ AD=0.07665P PS=1.26U PD=0.785U
* device instance $2510 r0 *1 31.785,48.35 sky130_fd_pr__pfet_01v8
M$2510 843 842 36 36 sky130_fd_pr__pfet_01v8 L=0.15U W=0.75U AS=0.178875P
+ AD=0.195P PS=1.26U PD=2.02U
* device instance $2511 r0 *1 32.725,48.515 sky130_fd_pr__pfet_01v8
M$2511 885 843 36 36 sky130_fd_pr__pfet_01v8 L=0.15U W=0.42U AS=0.1092P
+ AD=0.06405P PS=1.36U PD=0.725U
* device instance $2512 r0 *1 33.18,48.515 sky130_fd_pr__pfet_01v8
M$2512 844 838 885 885 sky130_fd_pr__pfet_01v8 L=0.15U W=0.42U AS=0.06405P
+ AD=0.0567P PS=0.725U PD=0.69U
* device instance $2513 r0 *1 33.6,48.515 sky130_fd_pr__pfet_01v8
M$2513 883 871 844 844 sky130_fd_pr__pfet_01v8 L=0.15U W=0.42U AS=0.0567P
+ AD=0.0882P PS=0.69U PD=0.84U
* device instance $2514 r0 *1 34.17,48.515 sky130_fd_pr__pfet_01v8
M$2514 36 841 883 883 sky130_fd_pr__pfet_01v8 L=0.15U W=0.42U AS=0.0882P
+ AD=0.1113P PS=0.84U PD=1.37U
* device instance $2515 r0 *1 33.59,44.105 sky130_fd_pr__pfet_01v8
M$2515 36 682 765 765 sky130_fd_pr__pfet_01v8 L=0.15U W=0.64U AS=0.1664P
+ AD=0.0864P PS=1.8U PD=0.91U
* device instance $2516 r0 *1 34.01,44.105 sky130_fd_pr__pfet_01v8
M$2516 766 765 36 36 sky130_fd_pr__pfet_01v8 L=0.15U W=0.64U AS=0.0864P
+ AD=0.1664P PS=0.91U PD=1.8U
* device instance $2517 r0 *1 35.225,48.405 sky130_fd_pr__pfet_01v8
M$2517 841 844 36 36 sky130_fd_pr__pfet_01v8 L=0.15U W=0.64U AS=0.154P
+ AD=0.1728P PS=1.335U PD=1.82U
* device instance $2518 r0 *1 35.71,48.225 sky130_fd_pr__pfet_01v8
M$2518 598 844 36 36 sky130_fd_pr__pfet_01v8 L=0.15U W=1U AS=0.154P AD=0.28P
+ PS=1.335U PD=2.56U
* device instance $2519 r0 *1 41.005,48.405 sky130_fd_pr__pfet_01v8
M$2519 881 777 36 36 sky130_fd_pr__pfet_01v8 L=0.15U W=0.64U AS=0.1696P
+ AD=0.0768P PS=1.81U PD=0.88U
* device instance $2520 r0 *1 41.395,48.405 sky130_fd_pr__pfet_01v8
M$2520 796 63 881 881 sky130_fd_pr__pfet_01v8 L=0.15U W=0.64U AS=0.0768P
+ AD=0.0896P PS=0.88U PD=0.92U
* device instance $2521 r0 *1 41.825,48.405 sky130_fd_pr__pfet_01v8
M$2521 36 846 796 796 sky130_fd_pr__pfet_01v8 L=0.15U W=0.64U AS=0.0896P
+ AD=0.1824P PS=0.92U PD=1.85U
* device instance $2522 r0 *1 44.63,48.375 sky130_fd_pr__pfet_01v8
M$2522 36 980 847 847 sky130_fd_pr__pfet_01v8 L=0.15U W=0.64U AS=0.1664P
+ AD=0.0864P PS=1.8U PD=0.91U
* device instance $2523 r0 *1 45.05,48.375 sky130_fd_pr__pfet_01v8
M$2523 872 847 36 36 sky130_fd_pr__pfet_01v8 L=0.15U W=0.64U AS=0.0864P
+ AD=0.1664P PS=0.91U PD=1.8U
* device instance $2524 r0 *1 45.99,48.405 sky130_fd_pr__pfet_01v8
M$2524 880 775 848 848 sky130_fd_pr__pfet_01v8 L=0.15U W=0.64U AS=0.1664P
+ AD=0.0672P PS=1.8U PD=0.85U
* device instance $2525 r0 *1 46.35,48.405 sky130_fd_pr__pfet_01v8
M$2525 36 849 880 880 sky130_fd_pr__pfet_01v8 L=0.15U W=0.64U AS=0.0672P
+ AD=0.1664P PS=0.85U PD=1.8U
* device instance $2526 r0 *1 47.29,48.405 sky130_fd_pr__pfet_01v8
M$2526 36 302 849 849 sky130_fd_pr__pfet_01v8 L=0.15U W=0.64U AS=0.1664P
+ AD=0.0928P PS=1.8U PD=0.93U
* device instance $2527 r0 *1 47.73,48.405 sky130_fd_pr__pfet_01v8
M$2527 879 302 36 36 sky130_fd_pr__pfet_01v8 L=0.15U W=0.64U AS=0.0928P
+ AD=0.1152P PS=0.93U PD=1U
* device instance $2528 r0 *1 48.24,48.405 sky130_fd_pr__pfet_01v8
M$2528 848 850 879 879 sky130_fd_pr__pfet_01v8 L=0.15U W=0.64U AS=0.1152P
+ AD=0.15985P PS=1U PD=1.265U
* device instance $2529 r0 *1 49.015,48.515 sky130_fd_pr__pfet_01v8
M$2529 851 872 848 848 sky130_fd_pr__pfet_01v8 L=0.15U W=0.42U AS=0.15985P
+ AD=0.06405P PS=1.265U PD=0.725U
* device instance $2530 r0 *1 49.47,48.515 sky130_fd_pr__pfet_01v8
M$2530 878 847 851 851 sky130_fd_pr__pfet_01v8 L=0.15U W=0.42U AS=0.06405P
+ AD=0.07665P PS=0.725U PD=0.785U
* device instance $2531 r0 *1 49.985,48.515 sky130_fd_pr__pfet_01v8
M$2531 878 852 36 36 sky130_fd_pr__pfet_01v8 L=0.15U W=0.42U AS=0.178875P
+ AD=0.07665P PS=1.26U PD=0.785U
* device instance $2532 r0 *1 50.645,48.35 sky130_fd_pr__pfet_01v8
M$2532 852 851 36 36 sky130_fd_pr__pfet_01v8 L=0.15U W=0.75U AS=0.178875P
+ AD=0.195P PS=1.26U PD=2.02U
* device instance $2533 r0 *1 51.585,48.515 sky130_fd_pr__pfet_01v8
M$2533 877 852 36 36 sky130_fd_pr__pfet_01v8 L=0.15U W=0.42U AS=0.1092P
+ AD=0.06405P PS=1.36U PD=0.725U
* device instance $2534 r0 *1 52.04,48.515 sky130_fd_pr__pfet_01v8
M$2534 853 847 877 877 sky130_fd_pr__pfet_01v8 L=0.15U W=0.42U AS=0.06405P
+ AD=0.0567P PS=0.725U PD=0.69U
* device instance $2535 r0 *1 52.46,48.515 sky130_fd_pr__pfet_01v8
M$2535 876 872 853 853 sky130_fd_pr__pfet_01v8 L=0.15U W=0.42U AS=0.0567P
+ AD=0.0882P PS=0.69U PD=0.84U
* device instance $2536 r0 *1 53.03,48.515 sky130_fd_pr__pfet_01v8
M$2536 36 850 876 876 sky130_fd_pr__pfet_01v8 L=0.15U W=0.42U AS=0.0882P
+ AD=0.1113P PS=0.84U PD=1.37U
* device instance $2537 r0 *1 54.085,48.405 sky130_fd_pr__pfet_01v8
M$2537 850 853 36 36 sky130_fd_pr__pfet_01v8 L=0.15U W=0.64U AS=0.154P
+ AD=0.1728P PS=1.335U PD=1.82U
* device instance $2538 r0 *1 54.57,48.225 sky130_fd_pr__pfet_01v8
M$2538 798 853 36 36 sky130_fd_pr__pfet_01v8 L=0.15U W=1U AS=0.154P AD=0.28P
+ PS=1.335U PD=2.56U
* device instance $2539 r0 *1 61.65,48.225 sky130_fd_pr__pfet_01v8
M$2539 36 642 854 854 sky130_fd_pr__pfet_01v8 L=0.15U W=1U AS=0.26P AD=0.135P
+ PS=2.52U PD=1.27U
* device instance $2540 r0 *1 62.07,48.225 sky130_fd_pr__pfet_01v8
M$2540 855 854 36 36 sky130_fd_pr__pfet_01v8 L=0.15U W=4U AS=0.54P AD=0.665P
+ PS=5.08U PD=6.33U
* device instance $2544 r0 *1 64.87,44.105 sky130_fd_pr__pfet_01v8
M$2544 36 980 778 778 sky130_fd_pr__pfet_01v8 L=0.15U W=0.64U AS=0.1664P
+ AD=0.0864P PS=1.8U PD=0.91U
* device instance $2545 r0 *1 65.29,44.105 sky130_fd_pr__pfet_01v8
M$2545 779 778 36 36 sky130_fd_pr__pfet_01v8 L=0.15U W=0.64U AS=0.0864P
+ AD=0.1664P PS=0.91U PD=1.8U
* device instance $2546 r0 *1 4.68,49.405 sky130_fd_pr__pfet_01v8
M$2546 888 887 36 36 sky130_fd_pr__pfet_01v8 L=0.15U W=0.42U AS=0.1113P
+ AD=0.0609P PS=1.37U PD=0.71U
* device instance $2547 r0 *1 5.12,49.405 sky130_fd_pr__pfet_01v8
M$2547 36 114 888 888 sky130_fd_pr__pfet_01v8 L=0.15U W=0.42U AS=0.0609P
+ AD=0.1841P PS=0.71U PD=1.26U
* device instance $2548 r0 *1 5.89,49.515 sky130_fd_pr__pfet_01v8
M$2548 868 888 36 36 sky130_fd_pr__pfet_01v8 L=0.15U W=0.64U AS=0.1841P
+ AD=0.1696P PS=1.26U PD=1.81U
* device instance $2549 r0 *1 7.455,49.6 sky130_fd_pr__pfet_01v8
M$2549 909 63 36 36 sky130_fd_pr__pfet_01v8 L=0.15U W=0.42U AS=0.15835P
+ AD=0.07665P PS=1.395U PD=0.785U
* device instance $2550 r0 *1 7.97,49.6 sky130_fd_pr__pfet_01v8
M$2550 890 917 909 909 sky130_fd_pr__pfet_01v8 L=0.15U W=0.42U AS=0.07665P
+ AD=0.1932P PS=0.785U PD=1.34U
* device instance $2551 r0 *1 9.04,49.6 sky130_fd_pr__pfet_01v8
M$2551 910 916 890 890 sky130_fd_pr__pfet_01v8 L=0.15U W=0.42U AS=0.1932P
+ AD=0.0441P PS=1.34U PD=0.63U
* device instance $2552 r0 *1 9.4,49.6 sky130_fd_pr__pfet_01v8
M$2552 36 918 910 910 sky130_fd_pr__pfet_01v8 L=0.15U W=0.42U AS=0.0441P
+ AD=0.0693P PS=0.63U PD=0.75U
* device instance $2553 r0 *1 9.88,49.6 sky130_fd_pr__pfet_01v8
M$2553 918 63 36 36 sky130_fd_pr__pfet_01v8 L=0.15U W=0.42U AS=0.0693P
+ AD=0.1176P PS=0.75U PD=1.4U
* device instance $2554 r0 *1 6.91,49.695 sky130_fd_pr__pfet_01v8
M$2554 36 890 889 889 sky130_fd_pr__pfet_01v8 L=0.15U W=1U AS=0.26P AD=0.15835P
+ PS=2.52U PD=1.395U
* device instance $2555 r0 *1 11.09,49.695 sky130_fd_pr__pfet_01v8
M$2555 920 834 891 891 sky130_fd_pr__pfet_01v8 L=0.15U W=1U AS=0.26P AD=0.135P
+ PS=2.52U PD=1.27U
* device instance $2556 r0 *1 11.51,49.695 sky130_fd_pr__pfet_01v8
M$2556 36 917 920 920 sky130_fd_pr__pfet_01v8 L=0.15U W=1U AS=0.135P AD=0.135P
+ PS=1.27U PD=1.27U
* device instance $2557 r0 *1 11.93,49.695 sky130_fd_pr__pfet_01v8
M$2557 892 917 36 36 sky130_fd_pr__pfet_01v8 L=0.15U W=1U AS=0.135P AD=0.135P
+ PS=1.27U PD=1.27U
* device instance $2558 r0 *1 12.35,49.695 sky130_fd_pr__pfet_01v8
M$2558 36 834 892 892 sky130_fd_pr__pfet_01v8 L=0.15U W=1U AS=0.135P AD=0.26P
+ PS=1.27U PD=2.52U
* device instance $2559 r0 *1 12.225,53.845 sky130_fd_pr__pfet_01v8
M$2559 935 938 36 36 sky130_fd_pr__pfet_01v8 L=0.15U W=0.64U AS=0.154P
+ AD=0.1728P PS=1.335U PD=1.82U
* device instance $2560 r0 *1 12.71,53.665 sky130_fd_pr__pfet_01v8
M$2560 837 938 36 36 sky130_fd_pr__pfet_01v8 L=0.15U W=1U AS=0.154P AD=0.28P
+ PS=1.335U PD=2.56U
* device instance $2561 r0 *1 13.29,49.695 sky130_fd_pr__pfet_01v8
M$2561 869 891 892 892 sky130_fd_pr__pfet_01v8 L=0.15U W=1U AS=0.26P AD=0.3P
+ PS=2.52U PD=2.6U
* device instance $2562 r0 *1 13.81,53.665 sky130_fd_pr__pfet_01v8
M$2562 36 870 939 939 sky130_fd_pr__pfet_01v8 L=0.15U W=1U AS=0.26P AD=0.135P
+ PS=2.52U PD=1.27U
* device instance $2563 r0 *1 14.23,53.665 sky130_fd_pr__pfet_01v8
M$2563 917 939 36 36 sky130_fd_pr__pfet_01v8 L=0.15U W=4U AS=0.54P AD=0.665P
+ PS=5.08U PD=6.33U
* device instance $2567 r0 *1 17.03,53.665 sky130_fd_pr__pfet_01v8
M$2567 36 837 940 940 sky130_fd_pr__pfet_01v8 L=0.15U W=1U AS=0.26P AD=0.135P
+ PS=2.52U PD=1.27U
* device instance $2568 r0 *1 17.45,53.665 sky130_fd_pr__pfet_01v8
M$2568 834 940 36 36 sky130_fd_pr__pfet_01v8 L=0.15U W=4U AS=0.54P AD=0.665P
+ PS=5.08U PD=6.33U
* device instance $2572 r0 *1 21.19,49.695 sky130_fd_pr__pfet_01v8
M$2572 36 834 893 893 sky130_fd_pr__pfet_01v8 L=0.15U W=4U AS=0.685P AD=0.54P
+ PS=6.37U PD=5.08U
* device instance $2576 r0 *1 22.87,49.695 sky130_fd_pr__pfet_01v8
M$2576 895 894 893 893 sky130_fd_pr__pfet_01v8 L=0.15U W=4U AS=0.54P AD=0.665P
+ PS=5.08U PD=6.33U
* device instance $2580 r0 *1 23.935,53.665 sky130_fd_pr__pfet_01v8
M$2580 941 297 36 36 sky130_fd_pr__pfet_01v8 L=0.15U W=4U AS=0.685P AD=0.56P
+ PS=6.37U PD=5.12U
* device instance $2584 r0 *1 25.655,53.665 sky130_fd_pr__pfet_01v8
M$2584 682 941 36 36 sky130_fd_pr__pfet_01v8 L=0.15U W=16U AS=2.2375P
+ AD=2.3625P PS=20.475U PD=21.725U
* device instance $2600 r0 *1 25.07,49.695 sky130_fd_pr__pfet_01v8
M$2600 895 897 896 896 sky130_fd_pr__pfet_01v8 L=0.15U W=4U AS=0.665P AD=0.54P
+ PS=6.33U PD=5.08U
* device instance $2604 r0 *1 26.75,49.695 sky130_fd_pr__pfet_01v8
M$2604 919 362 896 896 sky130_fd_pr__pfet_01v8 L=0.15U W=4U AS=0.54P AD=0.665P
+ PS=5.08U PD=6.33U
* device instance $2608 r0 *1 43.32,49.405 sky130_fd_pr__pfet_01v8
M$2608 899 898 36 36 sky130_fd_pr__pfet_01v8 L=0.15U W=0.42U AS=0.1113P
+ AD=0.0609P PS=1.37U PD=0.71U
* device instance $2609 r0 *1 43.76,49.405 sky130_fd_pr__pfet_01v8
M$2609 36 114 899 899 sky130_fd_pr__pfet_01v8 L=0.15U W=0.42U AS=0.0609P
+ AD=0.1841P PS=0.71U PD=1.26U
* device instance $2610 r0 *1 44.53,49.515 sky130_fd_pr__pfet_01v8
M$2610 797 899 36 36 sky130_fd_pr__pfet_01v8 L=0.15U W=0.64U AS=0.1841P
+ AD=0.1696P PS=1.26U PD=1.81U
* device instance $2611 r0 *1 56.13,53.665 sky130_fd_pr__pfet_01v8
M$2611 963 942 943 943 sky130_fd_pr__pfet_01v8 L=0.15U W=1U AS=0.26P AD=0.135P
+ PS=2.52U PD=1.27U
* device instance $2612 r0 *1 56.55,53.665 sky130_fd_pr__pfet_01v8
M$2612 961 800 963 963 sky130_fd_pr__pfet_01v8 L=0.15U W=1U AS=0.135P AD=0.135P
+ PS=1.27U PD=1.27U
* device instance $2613 r0 *1 56.97,53.665 sky130_fd_pr__pfet_01v8
M$2613 36 981 961 961 sky130_fd_pr__pfet_01v8 L=0.15U W=1U AS=0.135P AD=0.4P
+ PS=1.27U PD=1.8U
* device instance $2614 r0 *1 57.92,53.665 sky130_fd_pr__pfet_01v8
M$2614 944 943 36 36 sky130_fd_pr__pfet_01v8 L=0.15U W=4U AS=0.805P AD=0.765P
+ PS=5.61U PD=6.53U
* device instance $2618 r0 *1 60.27,53.665 sky130_fd_pr__pfet_01v8
M$2618 36 855 945 945 sky130_fd_pr__pfet_01v8 L=0.15U W=1U AS=0.26P AD=0.135P
+ PS=2.52U PD=1.27U
* device instance $2619 r0 *1 60.69,53.665 sky130_fd_pr__pfet_01v8
M$2619 942 945 36 36 sky130_fd_pr__pfet_01v8 L=0.15U W=4U AS=0.54P AD=0.665P
+ PS=5.08U PD=6.33U
* device instance $2623 r0 *1 64.87,49.545 sky130_fd_pr__pfet_01v8
M$2623 36 980 900 900 sky130_fd_pr__pfet_01v8 L=0.15U W=0.64U AS=0.1664P
+ AD=0.0864P PS=1.8U PD=0.91U
* device instance $2624 r0 *1 65.29,49.545 sky130_fd_pr__pfet_01v8
M$2624 901 900 36 36 sky130_fd_pr__pfet_01v8 L=0.15U W=0.64U AS=0.0864P
+ AD=0.1664P PS=0.91U PD=1.8U
* device instance $2625 r0 *1 66.23,49.515 sky130_fd_pr__pfet_01v8
M$2625 915 903 902 902 sky130_fd_pr__pfet_01v8 L=0.15U W=0.64U AS=0.1664P
+ AD=0.0672P PS=1.8U PD=0.85U
* device instance $2626 r0 *1 66.59,49.515 sky130_fd_pr__pfet_01v8
M$2626 36 904 915 915 sky130_fd_pr__pfet_01v8 L=0.15U W=0.64U AS=0.0672P
+ AD=0.1664P PS=0.85U PD=1.8U
* device instance $2627 r0 *1 69.255,49.405 sky130_fd_pr__pfet_01v8
M$2627 905 901 902 902 sky130_fd_pr__pfet_01v8 L=0.15U W=0.42U AS=0.15985P
+ AD=0.06405P PS=1.265U PD=0.725U
* device instance $2628 r0 *1 69.71,49.405 sky130_fd_pr__pfet_01v8
M$2628 913 900 905 905 sky130_fd_pr__pfet_01v8 L=0.15U W=0.42U AS=0.06405P
+ AD=0.07665P PS=0.725U PD=0.785U
* device instance $2629 r0 *1 70.225,49.405 sky130_fd_pr__pfet_01v8
M$2629 36 906 913 913 sky130_fd_pr__pfet_01v8 L=0.15U W=0.42U AS=0.07665P
+ AD=0.178875P PS=0.785U PD=1.26U
* device instance $2630 r0 *1 67.53,49.515 sky130_fd_pr__pfet_01v8
M$2630 36 409 904 904 sky130_fd_pr__pfet_01v8 L=0.15U W=0.64U AS=0.1664P
+ AD=0.0928P PS=1.8U PD=0.93U
* device instance $2631 r0 *1 67.97,49.515 sky130_fd_pr__pfet_01v8
M$2631 914 409 36 36 sky130_fd_pr__pfet_01v8 L=0.15U W=0.64U AS=0.0928P
+ AD=0.1152P PS=0.93U PD=1U
* device instance $2632 r0 *1 68.48,49.515 sky130_fd_pr__pfet_01v8
M$2632 902 908 914 914 sky130_fd_pr__pfet_01v8 L=0.15U W=0.64U AS=0.1152P
+ AD=0.15985P PS=1U PD=1.265U
* device instance $2633 r0 *1 70.885,49.57 sky130_fd_pr__pfet_01v8
M$2633 906 905 36 36 sky130_fd_pr__pfet_01v8 L=0.15U W=0.75U AS=0.178875P
+ AD=0.195P PS=1.26U PD=2.02U
* device instance $2634 r0 *1 68.175,53.76 sky130_fd_pr__pfet_01v8
M$2634 958 63 36 36 sky130_fd_pr__pfet_01v8 L=0.15U W=0.42U AS=0.15835P
+ AD=0.07665P PS=1.395U PD=0.785U
* device instance $2635 r0 *1 68.69,53.76 sky130_fd_pr__pfet_01v8
M$2635 946 956 958 958 sky130_fd_pr__pfet_01v8 L=0.15U W=0.42U AS=0.07665P
+ AD=0.1932P PS=0.785U PD=1.34U
* device instance $2636 r0 *1 69.76,53.76 sky130_fd_pr__pfet_01v8
M$2636 957 947 946 946 sky130_fd_pr__pfet_01v8 L=0.15U W=0.42U AS=0.1932P
+ AD=0.0441P PS=1.34U PD=0.63U
* device instance $2637 r0 *1 70.12,53.76 sky130_fd_pr__pfet_01v8
M$2637 36 948 957 957 sky130_fd_pr__pfet_01v8 L=0.15U W=0.42U AS=0.0441P
+ AD=0.0693P PS=0.63U PD=0.75U
* device instance $2638 r0 *1 70.6,53.76 sky130_fd_pr__pfet_01v8
M$2638 948 63 36 36 sky130_fd_pr__pfet_01v8 L=0.15U W=0.42U AS=0.0693P
+ AD=0.1176P PS=0.75U PD=1.4U
* device instance $2639 r0 *1 67.63,53.665 sky130_fd_pr__pfet_01v8
M$2639 36 946 903 903 sky130_fd_pr__pfet_01v8 L=0.15U W=1U AS=0.26P AD=0.15835P
+ PS=2.52U PD=1.395U
* device instance $2640 r0 *1 71.825,49.405 sky130_fd_pr__pfet_01v8
M$2640 912 906 36 36 sky130_fd_pr__pfet_01v8 L=0.15U W=0.42U AS=0.1092P
+ AD=0.06405P PS=1.36U PD=0.725U
* device instance $2641 r0 *1 72.28,49.405 sky130_fd_pr__pfet_01v8
M$2641 907 900 912 912 sky130_fd_pr__pfet_01v8 L=0.15U W=0.42U AS=0.06405P
+ AD=0.0567P PS=0.725U PD=0.69U
* device instance $2642 r0 *1 72.7,49.405 sky130_fd_pr__pfet_01v8
M$2642 911 901 907 907 sky130_fd_pr__pfet_01v8 L=0.15U W=0.42U AS=0.0567P
+ AD=0.0882P PS=0.69U PD=0.84U
* device instance $2643 r0 *1 73.27,49.405 sky130_fd_pr__pfet_01v8
M$2643 36 908 911 911 sky130_fd_pr__pfet_01v8 L=0.15U W=0.42U AS=0.0882P
+ AD=0.1113P PS=0.84U PD=1.37U
* device instance $2644 r0 *1 74.325,49.515 sky130_fd_pr__pfet_01v8
M$2644 36 907 908 908 sky130_fd_pr__pfet_01v8 L=0.15U W=0.64U AS=0.1728P
+ AD=0.154P PS=1.82U PD=1.335U
* device instance $2645 r0 *1 74.81,49.695 sky130_fd_pr__pfet_01v8
M$2645 986 907 36 36 sky130_fd_pr__pfet_01v8 L=0.15U W=1U AS=0.154P AD=0.28P
+ PS=1.335U PD=2.56U
* device instance $2646 r0 *1 2.77,53.815 sky130_fd_pr__pfet_01v8
M$2646 36 682 931 931 sky130_fd_pr__pfet_01v8 L=0.15U W=0.64U AS=0.1664P
+ AD=0.0864P PS=1.8U PD=0.91U
* device instance $2647 r0 *1 3.19,53.815 sky130_fd_pr__pfet_01v8
M$2647 932 931 36 36 sky130_fd_pr__pfet_01v8 L=0.15U W=0.64U AS=0.0864P
+ AD=0.1664P PS=0.91U PD=1.8U
* device instance $2648 r0 *1 4.13,53.845 sky130_fd_pr__pfet_01v8
M$2648 959 889 933 933 sky130_fd_pr__pfet_01v8 L=0.15U W=0.64U AS=0.1664P
+ AD=0.0672P PS=1.8U PD=0.85U
* device instance $2649 r0 *1 4.49,53.845 sky130_fd_pr__pfet_01v8
M$2649 36 934 959 959 sky130_fd_pr__pfet_01v8 L=0.15U W=0.64U AS=0.0672P
+ AD=0.1664P PS=0.85U PD=1.8U
* device instance $2650 r0 *1 5.43,53.845 sky130_fd_pr__pfet_01v8
M$2650 36 93 934 934 sky130_fd_pr__pfet_01v8 L=0.15U W=0.64U AS=0.1664P
+ AD=0.0928P PS=1.8U PD=0.93U
* device instance $2651 r0 *1 5.87,53.845 sky130_fd_pr__pfet_01v8
M$2651 960 93 36 36 sky130_fd_pr__pfet_01v8 L=0.15U W=0.64U AS=0.0928P
+ AD=0.1152P PS=0.93U PD=1U
* device instance $2652 r0 *1 6.38,53.845 sky130_fd_pr__pfet_01v8
M$2652 933 935 960 960 sky130_fd_pr__pfet_01v8 L=0.15U W=0.64U AS=0.1152P
+ AD=0.15985P PS=1U PD=1.265U
* device instance $2653 r0 *1 7.155,53.955 sky130_fd_pr__pfet_01v8
M$2653 936 932 933 933 sky130_fd_pr__pfet_01v8 L=0.15U W=0.42U AS=0.15985P
+ AD=0.06405P PS=1.265U PD=0.725U
* device instance $2654 r0 *1 7.61,53.955 sky130_fd_pr__pfet_01v8
M$2654 962 931 936 936 sky130_fd_pr__pfet_01v8 L=0.15U W=0.42U AS=0.06405P
+ AD=0.07665P PS=0.725U PD=0.785U
* device instance $2655 r0 *1 8.125,53.955 sky130_fd_pr__pfet_01v8
M$2655 962 937 36 36 sky130_fd_pr__pfet_01v8 L=0.15U W=0.42U AS=0.178875P
+ AD=0.07665P PS=1.26U PD=0.785U
* device instance $2656 r0 *1 8.785,53.79 sky130_fd_pr__pfet_01v8
M$2656 937 936 36 36 sky130_fd_pr__pfet_01v8 L=0.15U W=0.75U AS=0.178875P
+ AD=0.195P PS=1.26U PD=2.02U
* device instance $2657 r0 *1 9.725,53.955 sky130_fd_pr__pfet_01v8
M$2657 964 937 36 36 sky130_fd_pr__pfet_01v8 L=0.15U W=0.42U AS=0.1092P
+ AD=0.06405P PS=1.36U PD=0.725U
* device instance $2658 r0 *1 10.18,53.955 sky130_fd_pr__pfet_01v8
M$2658 938 931 964 964 sky130_fd_pr__pfet_01v8 L=0.15U W=0.42U AS=0.06405P
+ AD=0.0567P PS=0.725U PD=0.69U
* device instance $2659 r0 *1 10.6,53.955 sky130_fd_pr__pfet_01v8
M$2659 965 932 938 938 sky130_fd_pr__pfet_01v8 L=0.15U W=0.42U AS=0.0567P
+ AD=0.0882P PS=0.69U PD=0.84U
* device instance $2660 r0 *1 11.17,53.955 sky130_fd_pr__pfet_01v8
M$2660 36 935 965 965 sky130_fd_pr__pfet_01v8 L=0.15U W=0.42U AS=0.0882P
+ AD=0.1113P PS=0.84U PD=1.37U
* device instance $2661 r0 *1 10.57,54.955 sky130_fd_pr__pfet_01v8
M$2661 988 874 968 968 sky130_fd_pr__pfet_01v8 L=0.15U W=0.64U AS=0.1664P
+ AD=0.0672P PS=1.8U PD=0.85U
* device instance $2662 r0 *1 10.93,54.955 sky130_fd_pr__pfet_01v8
M$2662 36 969 988 988 sky130_fd_pr__pfet_01v8 L=0.15U W=0.64U AS=0.0672P
+ AD=0.1664P PS=0.85U PD=1.8U
* device instance $2663 r0 *1 13.595,54.845 sky130_fd_pr__pfet_01v8
M$2663 970 967 968 968 sky130_fd_pr__pfet_01v8 L=0.15U W=0.42U AS=0.15985P
+ AD=0.06405P PS=1.265U PD=0.725U
* device instance $2664 r0 *1 14.05,54.845 sky130_fd_pr__pfet_01v8
M$2664 990 966 970 970 sky130_fd_pr__pfet_01v8 L=0.15U W=0.42U AS=0.06405P
+ AD=0.07665P PS=0.725U PD=0.785U
* device instance $2665 r0 *1 14.565,54.845 sky130_fd_pr__pfet_01v8
M$2665 36 971 990 990 sky130_fd_pr__pfet_01v8 L=0.15U W=0.42U AS=0.07665P
+ AD=0.178875P PS=0.785U PD=1.26U
* device instance $2666 r0 *1 11.87,54.955 sky130_fd_pr__pfet_01v8
M$2666 36 302 969 969 sky130_fd_pr__pfet_01v8 L=0.15U W=0.64U AS=0.1664P
+ AD=0.0928P PS=1.8U PD=0.93U
* device instance $2667 r0 *1 12.31,54.955 sky130_fd_pr__pfet_01v8
M$2667 989 302 36 36 sky130_fd_pr__pfet_01v8 L=0.15U W=0.64U AS=0.0928P
+ AD=0.1152P PS=0.93U PD=1U
* device instance $2668 r0 *1 12.82,54.955 sky130_fd_pr__pfet_01v8
M$2668 968 973 989 989 sky130_fd_pr__pfet_01v8 L=0.15U W=0.64U AS=0.1152P
+ AD=0.15985P PS=1U PD=1.265U
* device instance $2669 r0 *1 15.225,55.01 sky130_fd_pr__pfet_01v8
M$2669 971 970 36 36 sky130_fd_pr__pfet_01v8 L=0.15U W=0.75U AS=0.178875P
+ AD=0.195P PS=1.26U PD=2.02U
* device instance $2670 r0 *1 16.165,54.845 sky130_fd_pr__pfet_01v8
M$2670 991 971 36 36 sky130_fd_pr__pfet_01v8 L=0.15U W=0.42U AS=0.1092P
+ AD=0.06405P PS=1.36U PD=0.725U
* device instance $2671 r0 *1 16.62,54.845 sky130_fd_pr__pfet_01v8
M$2671 972 966 991 991 sky130_fd_pr__pfet_01v8 L=0.15U W=0.42U AS=0.06405P
+ AD=0.0567P PS=0.725U PD=0.69U
* device instance $2672 r0 *1 17.04,54.845 sky130_fd_pr__pfet_01v8
M$2672 992 967 972 972 sky130_fd_pr__pfet_01v8 L=0.15U W=0.42U AS=0.0567P
+ AD=0.0882P PS=0.69U PD=0.84U
* device instance $2673 r0 *1 17.61,54.845 sky130_fd_pr__pfet_01v8
M$2673 36 973 992 992 sky130_fd_pr__pfet_01v8 L=0.15U W=0.42U AS=0.0882P
+ AD=0.1113P PS=0.84U PD=1.37U
* device instance $2674 r0 *1 18.665,54.955 sky130_fd_pr__pfet_01v8
M$2674 36 972 973 973 sky130_fd_pr__pfet_01v8 L=0.15U W=0.64U AS=0.1728P
+ AD=0.154P PS=1.82U PD=1.335U
* device instance $2675 r0 *1 19.15,55.135 sky130_fd_pr__pfet_01v8
M$2675 870 972 36 36 sky130_fd_pr__pfet_01v8 L=0.15U W=1U AS=0.154P AD=0.28P
+ PS=1.335U PD=2.56U
* device instance $2676 r0 *1 28.31,55.425 sky130_fd_pr__pfet_01v8
M$2676 974 894 36 36 sky130_fd_pr__pfet_01v8 L=0.15U W=0.42U AS=0.1573P
+ AD=0.1092P PS=1.39U PD=1.36U
* device instance $2677 r0 *1 28.85,55.135 sky130_fd_pr__pfet_01v8
M$2677 999 994 36 36 sky130_fd_pr__pfet_01v8 L=0.15U W=1U AS=0.1573P AD=0.105P
+ PS=1.39U PD=1.21U
* device instance $2678 r0 *1 29.21,55.135 sky130_fd_pr__pfet_01v8
M$2678 977 974 999 999 sky130_fd_pr__pfet_01v8 L=0.15U W=1U AS=0.105P AD=0.26P
+ PS=1.21U PD=2.52U
* device instance $2679 r0 *1 30.85,55.135 sky130_fd_pr__pfet_01v8
M$2679 36 995 975 975 sky130_fd_pr__pfet_01v8 L=0.15U W=4U AS=0.685P AD=0.54P
+ PS=6.37U PD=5.08U
* device instance $2683 r0 *1 32.53,55.135 sky130_fd_pr__pfet_01v8
M$2683 976 114 975 975 sky130_fd_pr__pfet_01v8 L=0.15U W=4U AS=0.54P AD=0.665P
+ PS=5.08U PD=6.33U
* device instance $2686 r0 *1 33.79,55.135 sky130_fd_pr__pfet_01v8
M$2686 1000 977 976 976 sky130_fd_pr__pfet_01v8 L=0.15U W=4U AS=0.54P AD=0.54P
+ PS=5.08U PD=5.08U
* device instance $2691 r0 *1 42.815,55.135 sky130_fd_pr__pfet_01v8
M$2691 36 980 978 978 sky130_fd_pr__pfet_01v8 L=0.15U W=3U AS=0.545P AD=0.545P
+ PS=5.09U PD=5.09U
* device instance $2694 r0 *1 44.635,55.135 sky130_fd_pr__pfet_01v8
M$2694 979 297 36 36 sky130_fd_pr__pfet_01v8 L=0.15U W=4U AS=0.685P AD=0.56P
+ PS=6.37U PD=5.12U
* device instance $2698 r0 *1 46.355,55.135 sky130_fd_pr__pfet_01v8
M$2698 980 979 36 36 sky130_fd_pr__pfet_01v8 L=0.15U W=16U AS=2.2375P
+ AD=2.3625P PS=20.475U PD=21.725U
* device instance $2714 r0 *1 59.405,54.955 sky130_fd_pr__pfet_01v8
M$2714 993 800 36 36 sky130_fd_pr__pfet_01v8 L=0.15U W=0.64U AS=0.1696P
+ AD=0.0768P PS=1.81U PD=0.88U
* device instance $2715 r0 *1 59.795,54.955 sky130_fd_pr__pfet_01v8
M$2715 996 942 993 993 sky130_fd_pr__pfet_01v8 L=0.15U W=0.64U AS=0.0768P
+ AD=0.0896P PS=0.88U PD=0.92U
* device instance $2716 r0 *1 60.225,54.955 sky130_fd_pr__pfet_01v8
M$2716 36 981 996 996 sky130_fd_pr__pfet_01v8 L=0.15U W=0.64U AS=0.0896P
+ AD=0.1824P PS=0.92U PD=1.85U
* device instance $2717 r0 *1 62.115,55.135 sky130_fd_pr__pfet_01v8
M$2717 982 944 36 36 sky130_fd_pr__pfet_01v8 L=0.15U W=1U AS=0.265P AD=0.14P
+ PS=2.53U PD=1.28U
* device instance $2718 r0 *1 62.545,55.135 sky130_fd_pr__pfet_01v8
M$2718 36 996 982 982 sky130_fd_pr__pfet_01v8 L=0.15U W=1U AS=0.14P AD=0.1775P
+ PS=1.28U PD=1.355U
* device instance $2719 r0 *1 63.05,55.135 sky130_fd_pr__pfet_01v8
M$2719 997 982 36 36 sky130_fd_pr__pfet_01v8 L=0.15U W=4U AS=0.5975P AD=0.705P
+ PS=5.195U PD=6.41U
* device instance $2723 r0 *1 65.33,55.055 sky130_fd_pr__pfet_01v8
M$2723 981 987 36 36 sky130_fd_pr__pfet_01v8 L=0.15U W=1.68U AS=0.3318P
+ AD=0.3486P PS=3.31U PD=3.35U
* device instance $2725 r0 *1 66.71,55.425 sky130_fd_pr__pfet_01v8
M$2725 983 986 36 36 sky130_fd_pr__pfet_01v8 L=0.15U W=0.42U AS=0.14575P
+ AD=0.1092P PS=1.335U PD=1.36U
* device instance $2726 r0 *1 67.195,55.135 sky130_fd_pr__pfet_01v8
M$2726 984 956 36 36 sky130_fd_pr__pfet_01v8 L=0.15U W=1U AS=0.14575P AD=0.135P
+ PS=1.335U PD=1.27U
* device instance $2727 r0 *1 67.615,55.135 sky130_fd_pr__pfet_01v8
M$2727 36 983 984 984 sky130_fd_pr__pfet_01v8 L=0.15U W=1U AS=0.135P AD=0.265P
+ PS=1.27U PD=2.53U
* device instance $2728 r0 *1 69.05,55.135 sky130_fd_pr__pfet_01v8
M$2728 985 956 36 36 sky130_fd_pr__pfet_01v8 L=0.15U W=1U AS=0.3P AD=0.135P
+ PS=2.6U PD=1.27U
* device instance $2729 r0 *1 69.47,55.135 sky130_fd_pr__pfet_01v8
M$2729 36 986 985 985 sky130_fd_pr__pfet_01v8 L=0.15U W=1U AS=0.135P AD=0.365P
+ PS=1.27U PD=1.73U
* device instance $2730 r0 *1 70.35,55.135 sky130_fd_pr__pfet_01v8
M$2730 998 986 36 36 sky130_fd_pr__pfet_01v8 L=0.15U W=1U AS=0.365P AD=0.105P
+ PS=1.73U PD=1.21U
* device instance $2731 r0 *1 70.71,55.135 sky130_fd_pr__pfet_01v8
M$2731 987 956 998 998 sky130_fd_pr__pfet_01v8 L=0.15U W=1U AS=0.105P AD=0.165P
+ PS=1.21U PD=1.33U
* device instance $2732 r0 *1 71.19,55.135 sky130_fd_pr__pfet_01v8
M$2732 36 985 987 987 sky130_fd_pr__pfet_01v8 L=0.15U W=1U AS=0.165P AD=0.36P
+ PS=1.33U PD=2.72U
* device instance $2733 r0 *1 9.21,54.985 sky130_fd_pr__pfet_01v8
M$2733 36 682 966 966 sky130_fd_pr__pfet_01v8 L=0.15U W=0.64U AS=0.1664P
+ AD=0.0864P PS=1.8U PD=0.91U
* device instance $2734 r0 *1 9.63,54.985 sky130_fd_pr__pfet_01v8
M$2734 967 966 36 36 sky130_fd_pr__pfet_01v8 L=0.15U W=0.64U AS=0.0864P
+ AD=0.1664P PS=0.91U PD=1.8U
* device instance $2735 r0 *1 11.03,60.285 sky130_fd_pr__pfet_01v8
M$2735 1043 1074 36 36 sky130_fd_pr__pfet_01v8 L=0.15U W=0.42U AS=0.1092P
+ AD=0.0672P PS=1.36U PD=0.74U
* device instance $2736 r0 *1 11.5,60.285 sky130_fd_pr__pfet_01v8
M$2736 1045 1044 1043 1043 sky130_fd_pr__pfet_01v8 L=0.15U W=0.42U AS=0.0672P
+ AD=0.06615P PS=0.74U PD=0.735U
* device instance $2737 r0 *1 11.965,60.285 sky130_fd_pr__pfet_01v8
M$2737 1069 1042 1045 1045 sky130_fd_pr__pfet_01v8 L=0.15U W=0.42U AS=0.06615P
+ AD=0.0693P PS=0.735U PD=0.75U
* device instance $2738 r0 *1 12.445,60.285 sky130_fd_pr__pfet_01v8
M$2738 36 1046 1069 1069 sky130_fd_pr__pfet_01v8 L=0.15U W=0.42U AS=0.0693P
+ AD=0.178875P PS=0.75U PD=1.26U
* device instance $2739 r0 *1 13.58,60.285 sky130_fd_pr__pfet_01v8
M$2739 1047 1042 1046 1046 sky130_fd_pr__pfet_01v8 L=0.15U W=0.42U AS=0.1095P
+ AD=0.0567P PS=1.075U PD=0.69U
* device instance $2740 r0 *1 14,60.285 sky130_fd_pr__pfet_01v8
M$2740 1070 1044 1047 1047 sky130_fd_pr__pfet_01v8 L=0.15U W=0.42U AS=0.0567P
+ AD=0.09135P PS=0.69U PD=0.855U
* device instance $2741 r0 *1 14.585,60.285 sky130_fd_pr__pfet_01v8
M$2741 36 1048 1070 1070 sky130_fd_pr__pfet_01v8 L=0.15U W=0.42U AS=0.09135P
+ AD=0.1218P PS=0.855U PD=1.42U
* device instance $2742 r0 *1 13.105,60.45 sky130_fd_pr__pfet_01v8
M$2742 1046 1045 36 36 sky130_fd_pr__pfet_01v8 L=0.15U W=0.75U AS=0.178875P
+ AD=0.1095P PS=1.26U PD=1.075U
* device instance $2743 r0 *1 15.665,60.575 sky130_fd_pr__pfet_01v8
M$2743 36 1047 1048 1048 sky130_fd_pr__pfet_01v8 L=0.15U W=1U AS=0.28P
+ AD=0.1625P PS=2.56U PD=1.325U
* device instance $2744 r0 *1 16.14,60.575 sky130_fd_pr__pfet_01v8
M$2744 63 1048 36 36 sky130_fd_pr__pfet_01v8 L=0.15U W=4U AS=0.575P AD=0.6925P
+ PS=5.15U PD=6.385U
* device instance $2748 r0 *1 20.73,60.575 sky130_fd_pr__pfet_01v8
M$2748 36 1102 1049 1049 sky130_fd_pr__pfet_01v8 L=0.15U W=4U AS=0.685P
+ AD=0.54P PS=6.37U PD=5.08U
* device instance $2752 r0 *1 22.41,60.575 sky130_fd_pr__pfet_01v8
M$2752 1050 1011 1049 1049 sky130_fd_pr__pfet_01v8 L=0.15U W=4U AS=0.54P
+ AD=0.675P PS=5.08U PD=6.35U
* device instance $2756 r0 *1 24.85,60.575 sky130_fd_pr__pfet_01v8
M$2756 36 1050 1051 1051 sky130_fd_pr__pfet_01v8 L=0.15U W=3U AS=0.53P
+ AD=0.405P PS=5.06U PD=3.81U
* device instance $2759 r0 *1 26.11,60.575 sky130_fd_pr__pfet_01v8
M$2759 93 1051 36 36 sky130_fd_pr__pfet_01v8 L=0.15U W=8U AS=1.08P AD=1.205P
+ PS=10.16U PD=11.41U
* device instance $2767 r0 *1 24.87,59.105 sky130_fd_pr__pfet_01v8
M$2767 36 63 1033 1033 sky130_fd_pr__pfet_01v8 L=0.15U W=2U AS=0.415P AD=0.27P
+ PS=3.83U PD=2.54U
* device instance $2769 r0 *1 25.71,59.105 sky130_fd_pr__pfet_01v8
M$2769 1036 977 1033 1033 sky130_fd_pr__pfet_01v8 L=0.15U W=2U AS=0.27P
+ AD=0.415P PS=2.54U PD=3.83U
* device instance $2771 r0 *1 27.09,59.105 sky130_fd_pr__pfet_01v8
M$2771 1011 1016 1036 1036 sky130_fd_pr__pfet_01v8 L=0.15U W=2U AS=0.395P
+ AD=0.395P PS=3.79U PD=3.79U
* device instance $2773 r0 *1 28.65,59.105 sky130_fd_pr__pfet_01v8
M$2773 36 114 1013 1013 sky130_fd_pr__pfet_01v8 L=0.15U W=1U AS=0.38P AD=0.135P
+ PS=2.76U PD=1.27U
* device instance $2774 r0 *1 29.07,59.105 sky130_fd_pr__pfet_01v8
M$2774 91 1012 36 36 sky130_fd_pr__pfet_01v8 L=0.15U W=4U AS=0.54P AD=0.54P
+ PS=5.08U PD=5.08U
* device instance $2778 r0 *1 30.75,59.105 sky130_fd_pr__pfet_01v8
M$2778 1012 1013 36 36 sky130_fd_pr__pfet_01v8 L=0.15U W=2U AS=0.27P AD=0.395P
+ PS=2.54U PD=3.79U
* device instance $2780 r0 *1 32.11,59.105 sky130_fd_pr__pfet_01v8
M$2780 1012 1016 1037 1037 sky130_fd_pr__pfet_01v8 L=0.15U W=2U AS=0.395P
+ AD=0.27P PS=3.79U PD=2.54U
* device instance $2782 r0 *1 32.95,59.105 sky130_fd_pr__pfet_01v8
M$2782 36 977 1037 1037 sky130_fd_pr__pfet_01v8 L=0.15U W=2U AS=0.27P AD=0.415P
+ PS=2.54U PD=3.83U
* device instance $2784 r0 *1 32.21,60.575 sky130_fd_pr__pfet_01v8
M$2784 1082 977 1052 1052 sky130_fd_pr__pfet_01v8 L=0.15U W=1U AS=0.26P
+ AD=0.105P PS=2.52U PD=1.21U
* device instance $2785 r0 *1 32.57,60.575 sky130_fd_pr__pfet_01v8
M$2785 36 1075 1082 1082 sky130_fd_pr__pfet_01v8 L=0.15U W=1U AS=0.105P
+ AD=0.26P PS=1.21U PD=2.52U
* device instance $2786 r0 *1 33.83,60.865 sky130_fd_pr__pfet_01v8
M$2786 1053 994 36 36 sky130_fd_pr__pfet_01v8 L=0.15U W=0.42U AS=0.1573P
+ AD=0.1092P PS=1.39U PD=1.36U
* device instance $2787 r0 *1 34.37,60.575 sky130_fd_pr__pfet_01v8
M$2787 1083 894 36 36 sky130_fd_pr__pfet_01v8 L=0.15U W=1U AS=0.1573P AD=0.105P
+ PS=1.39U PD=1.21U
* device instance $2788 r0 *1 34.73,60.575 sky130_fd_pr__pfet_01v8
M$2788 1075 1053 1083 1083 sky130_fd_pr__pfet_01v8 L=0.15U W=1U AS=0.105P
+ AD=0.26P PS=1.21U PD=2.52U
* device instance $2789 r0 *1 34.97,59.105 sky130_fd_pr__pfet_01v8
M$2789 36 995 1015 1015 sky130_fd_pr__pfet_01v8 L=0.15U W=1U AS=0.26P AD=0.135P
+ PS=2.52U PD=1.27U
* device instance $2790 r0 *1 35.39,59.105 sky130_fd_pr__pfet_01v8
M$2790 1016 1015 36 36 sky130_fd_pr__pfet_01v8 L=0.15U W=4U AS=0.54P AD=0.665P
+ PS=5.08U PD=6.33U
* device instance $2794 r0 *1 37.99,59.105 sky130_fd_pr__pfet_01v8
M$2794 1017 1000 36 36 sky130_fd_pr__pfet_01v8 L=0.15U W=2U AS=0.395P AD=0.27P
+ PS=3.79U PD=2.54U
* device instance $2796 r0 *1 38.83,59.105 sky130_fd_pr__pfet_01v8
M$2796 157 1017 36 36 sky130_fd_pr__pfet_01v8 L=0.15U W=6U AS=0.81P AD=0.935P
+ PS=7.62U PD=8.87U
* device instance $2802 r0 *1 40.03,60.575 sky130_fd_pr__pfet_01v8
M$2802 1055 1054 36 36 sky130_fd_pr__pfet_01v8 L=0.15U W=2U AS=0.395P AD=0.27P
+ PS=3.79U PD=2.54U
* device instance $2804 r0 *1 40.87,60.575 sky130_fd_pr__pfet_01v8
M$2804 1055 1035 36 36 sky130_fd_pr__pfet_01v8 L=0.15U W=2U AS=0.275P AD=0.285P
+ PS=2.55U PD=2.57U
* device instance $2806 r0 *1 41.74,60.575 sky130_fd_pr__pfet_01v8
M$2806 1055 1056 36 36 sky130_fd_pr__pfet_01v8 L=0.15U W=2U AS=0.28P AD=0.395P
+ PS=2.56U PD=3.79U
* device instance $2808 r0 *1 42.79,59.105 sky130_fd_pr__pfet_01v8
M$2808 1041 1018 1019 1019 sky130_fd_pr__pfet_01v8 L=0.15U W=1U AS=0.26P
+ AD=0.105P PS=2.52U PD=1.21U
* device instance $2809 r0 *1 43.15,59.105 sky130_fd_pr__pfet_01v8
M$2809 36 1020 1041 1041 sky130_fd_pr__pfet_01v8 L=0.15U W=1U AS=0.105P
+ AD=0.26P PS=1.21U PD=2.52U
* device instance $2810 r0 *1 43.1,60.575 sky130_fd_pr__pfet_01v8
M$2810 1055 1075 1057 1057 sky130_fd_pr__pfet_01v8 L=0.15U W=2U AS=0.395P
+ AD=0.395P PS=3.79U PD=2.79U
* device instance $2812 r0 *1 44.19,60.575 sky130_fd_pr__pfet_01v8
M$2812 1076 1077 1057 1057 sky130_fd_pr__pfet_01v8 L=0.15U W=2U AS=0.395P
+ AD=0.395P PS=2.79U PD=3.79U
* device instance $2814 r0 *1 45.57,60.575 sky130_fd_pr__pfet_01v8
M$2814 1058 1056 1020 1020 sky130_fd_pr__pfet_01v8 L=0.15U W=1U AS=0.265P
+ AD=0.14P PS=2.53U PD=1.28U
* device instance $2815 r0 *1 46,60.575 sky130_fd_pr__pfet_01v8
M$2815 36 1054 1058 1058 sky130_fd_pr__pfet_01v8 L=0.15U W=1U AS=0.14P
+ AD=0.1475P PS=1.28U PD=1.295U
* device instance $2816 r0 *1 46.445,60.575 sky130_fd_pr__pfet_01v8
M$2816 1058 1078 36 36 sky130_fd_pr__pfet_01v8 L=0.15U W=1U AS=0.1475P
+ AD=0.265P PS=1.295U PD=2.53U
* device instance $2817 r0 *1 46.47,59.105 sky130_fd_pr__pfet_01v8
M$2817 36 1000 1021 1021 sky130_fd_pr__pfet_01v8 L=0.15U W=1U AS=0.26P
+ AD=0.135P PS=2.52U PD=1.27U
* device instance $2818 r0 *1 46.89,59.105 sky130_fd_pr__pfet_01v8
M$2818 1022 1021 36 36 sky130_fd_pr__pfet_01v8 L=0.15U W=4U AS=0.54P AD=0.665P
+ PS=5.08U PD=6.33U
* device instance $2822 r0 *1 49.69,60.575 sky130_fd_pr__pfet_01v8
M$2822 36 1054 1059 1059 sky130_fd_pr__pfet_01v8 L=0.15U W=2U AS=0.395P
+ AD=0.27P PS=3.79U PD=2.54U
* device instance $2824 r0 *1 50.53,60.575 sky130_fd_pr__pfet_01v8
M$2824 36 1078 1059 1059 sky130_fd_pr__pfet_01v8 L=0.15U W=2U AS=0.27P AD=0.27P
+ PS=2.54U PD=2.54U
* device instance $2826 r0 *1 51.37,60.575 sky130_fd_pr__pfet_01v8
M$2826 36 1056 1059 1059 sky130_fd_pr__pfet_01v8 L=0.15U W=2U AS=0.545P
+ AD=0.59P PS=3.09U PD=3.18U
* device instance $2828 r0 *1 52.85,60.575 sky130_fd_pr__pfet_01v8
M$2828 1060 1077 1059 1059 sky130_fd_pr__pfet_01v8 L=0.15U W=2U AS=0.355P
+ AD=0.435P PS=2.71U PD=3.87U
* device instance $2830 r0 *1 51.15,59.105 sky130_fd_pr__pfet_01v8
M$2830 36 855 1034 1034 sky130_fd_pr__pfet_01v8 L=0.15U W=4U AS=0.685P AD=0.54P
+ PS=6.37U PD=5.08U
* device instance $2834 r0 *1 52.83,59.105 sky130_fd_pr__pfet_01v8
M$2834 1038 800 1034 1034 sky130_fd_pr__pfet_01v8 L=0.15U W=4U AS=0.54P
+ AD=0.665P PS=5.08U PD=6.33U
* device instance $2838 r0 *1 55.03,59.105 sky130_fd_pr__pfet_01v8
M$2838 1038 981 1035 1035 sky130_fd_pr__pfet_01v8 L=0.15U W=4U AS=0.665P
+ AD=0.55P PS=6.33U PD=5.1U
* device instance $2842 r0 *1 56.73,59.105 sky130_fd_pr__pfet_01v8
M$2842 36 984 1035 1035 sky130_fd_pr__pfet_01v8 L=0.15U W=4U AS=0.55P AD=0.54P
+ PS=5.1U PD=5.08U
* device instance $2846 r0 *1 58.41,59.105 sky130_fd_pr__pfet_01v8
M$2846 36 1025 1035 1035 sky130_fd_pr__pfet_01v8 L=0.15U W=4U AS=0.54P
+ AD=0.665P PS=5.08U PD=6.33U
* device instance $2850 r0 *1 60.73,59.105 sky130_fd_pr__pfet_01v8
M$2850 1039 1026 1027 1027 sky130_fd_pr__pfet_01v8 L=0.15U W=1U AS=0.26P
+ AD=0.135P PS=2.52U PD=1.27U
* device instance $2851 r0 *1 61.15,59.105 sky130_fd_pr__pfet_01v8
M$2851 1040 986 1039 1039 sky130_fd_pr__pfet_01v8 L=0.15U W=1U AS=0.135P
+ AD=0.135P PS=1.27U PD=1.27U
* device instance $2852 r0 *1 61.57,59.105 sky130_fd_pr__pfet_01v8
M$2852 1039 91 1040 1040 sky130_fd_pr__pfet_01v8 L=0.15U W=1U AS=0.135P
+ AD=0.26P PS=1.27U PD=2.52U
* device instance $2853 r0 *1 62.51,59.105 sky130_fd_pr__pfet_01v8
M$2853 1040 1022 36 36 sky130_fd_pr__pfet_01v8 L=0.15U W=1U AS=0.26P AD=0.165P
+ PS=2.52U PD=1.33U
* device instance $2854 r0 *1 62.99,59.105 sky130_fd_pr__pfet_01v8
M$2854 36 997 1040 1040 sky130_fd_pr__pfet_01v8 L=0.15U W=1U AS=0.165P
+ AD=0.1575P PS=1.33U PD=1.315U
* device instance $2855 r0 *1 63.455,59.105 sky130_fd_pr__pfet_01v8
M$2855 1028 1027 36 36 sky130_fd_pr__pfet_01v8 L=0.15U W=1U AS=0.1575P AD=0.26P
+ PS=1.315U PD=2.52U
* device instance $2856 r0 *1 64.43,59.105 sky130_fd_pr__pfet_01v8
M$2856 1029 944 36 36 sky130_fd_pr__pfet_01v8 L=0.15U W=1U AS=0.26P AD=0.135P
+ PS=2.52U PD=1.27U
* device instance $2857 r0 *1 64.85,59.105 sky130_fd_pr__pfet_01v8
M$2857 36 984 1029 1029 sky130_fd_pr__pfet_01v8 L=0.15U W=1U AS=0.135P AD=0.26P
+ PS=1.27U PD=2.52U
* device instance $2858 r0 *1 64.85,60.395 sky130_fd_pr__pfet_01v8
M$2858 1081 1028 1063 1063 sky130_fd_pr__pfet_01v8 L=0.15U W=0.64U AS=0.1664P
+ AD=0.0672P PS=1.8U PD=0.85U
* device instance $2859 r0 *1 65.21,60.395 sky130_fd_pr__pfet_01v8
M$2859 36 1064 1081 1081 sky130_fd_pr__pfet_01v8 L=0.15U W=0.64U AS=0.0672P
+ AD=0.1664P PS=0.85U PD=1.8U
* device instance $2860 r0 *1 67.875,60.285 sky130_fd_pr__pfet_01v8
M$2860 1065 1062 1063 1063 sky130_fd_pr__pfet_01v8 L=0.15U W=0.42U AS=0.15985P
+ AD=0.06405P PS=1.265U PD=0.725U
* device instance $2861 r0 *1 68.33,60.285 sky130_fd_pr__pfet_01v8
M$2861 1073 1061 1065 1065 sky130_fd_pr__pfet_01v8 L=0.15U W=0.42U AS=0.06405P
+ AD=0.07665P PS=0.725U PD=0.785U
* device instance $2862 r0 *1 68.845,60.285 sky130_fd_pr__pfet_01v8
M$2862 36 1066 1073 1073 sky130_fd_pr__pfet_01v8 L=0.15U W=0.42U AS=0.07665P
+ AD=0.178875P PS=0.785U PD=1.26U
* device instance $2863 r0 *1 66.15,60.395 sky130_fd_pr__pfet_01v8
M$2863 36 302 1064 1064 sky130_fd_pr__pfet_01v8 L=0.15U W=0.64U AS=0.1664P
+ AD=0.0928P PS=1.8U PD=0.93U
* device instance $2864 r0 *1 66.59,60.395 sky130_fd_pr__pfet_01v8
M$2864 1080 302 36 36 sky130_fd_pr__pfet_01v8 L=0.15U W=0.64U AS=0.0928P
+ AD=0.1152P PS=0.93U PD=1U
* device instance $2865 r0 *1 67.1,60.395 sky130_fd_pr__pfet_01v8
M$2865 1063 1068 1080 1080 sky130_fd_pr__pfet_01v8 L=0.15U W=0.64U AS=0.1152P
+ AD=0.15985P PS=1U PD=1.265U
* device instance $2866 r0 *1 69.505,60.45 sky130_fd_pr__pfet_01v8
M$2866 1066 1065 36 36 sky130_fd_pr__pfet_01v8 L=0.15U W=0.75U AS=0.178875P
+ AD=0.195P PS=1.26U PD=2.02U
* device instance $2867 r0 *1 70.445,60.285 sky130_fd_pr__pfet_01v8
M$2867 1072 1066 36 36 sky130_fd_pr__pfet_01v8 L=0.15U W=0.42U AS=0.1092P
+ AD=0.06405P PS=1.36U PD=0.725U
* device instance $2868 r0 *1 70.9,60.285 sky130_fd_pr__pfet_01v8
M$2868 1067 1061 1072 1072 sky130_fd_pr__pfet_01v8 L=0.15U W=0.42U AS=0.06405P
+ AD=0.0567P PS=0.725U PD=0.69U
* device instance $2869 r0 *1 71.32,60.285 sky130_fd_pr__pfet_01v8
M$2869 1071 1062 1067 1067 sky130_fd_pr__pfet_01v8 L=0.15U W=0.42U AS=0.0567P
+ AD=0.0882P PS=0.69U PD=0.84U
* device instance $2870 r0 *1 71.89,60.285 sky130_fd_pr__pfet_01v8
M$2870 36 1068 1071 1071 sky130_fd_pr__pfet_01v8 L=0.15U W=0.42U AS=0.0882P
+ AD=0.1113P PS=0.84U PD=1.37U
* device instance $2871 r0 *1 72.945,60.395 sky130_fd_pr__pfet_01v8
M$2871 36 1067 1068 1068 sky130_fd_pr__pfet_01v8 L=0.15U W=0.64U AS=0.1728P
+ AD=0.154P PS=1.82U PD=1.335U
* device instance $2872 r0 *1 73.43,60.575 sky130_fd_pr__pfet_01v8
M$2872 956 1067 36 36 sky130_fd_pr__pfet_01v8 L=0.15U W=1U AS=0.154P AD=0.28P
+ PS=1.335U PD=2.56U
* device instance $2873 r0 *1 7.83,64.625 sky130_fd_pr__pfet_01v8
M$2873 1186 1129 36 36 sky130_fd_pr__pfet_01v8 L=0.15U W=1.68U AS=0.3318P
+ AD=0.3486P PS=3.31U PD=3.35U
* device instance $2875 r0 *1 9.21,64.545 sky130_fd_pr__pfet_01v8
M$2875 1136 1130 36 36 sky130_fd_pr__pfet_01v8 L=0.15U W=1U AS=0.26P AD=0.1125P
+ PS=2.52U PD=1.225U
* device instance $2876 r0 *1 9.585,64.545 sky130_fd_pr__pfet_01v8
M$2876 1099 1129 1136 1136 sky130_fd_pr__pfet_01v8 L=0.15U W=1U AS=0.1125P
+ AD=0.2325P PS=1.225U PD=1.465U
* device instance $2877 r0 *1 10.2,64.545 sky130_fd_pr__pfet_01v8
M$2877 1138 1100 1099 1099 sky130_fd_pr__pfet_01v8 L=0.15U W=1U AS=0.2325P
+ AD=0.105P PS=1.465U PD=1.21U
* device instance $2878 r0 *1 10.56,64.545 sky130_fd_pr__pfet_01v8
M$2878 36 919 1138 1138 sky130_fd_pr__pfet_01v8 L=0.15U W=1U AS=0.105P AD=0.27P
+ PS=1.21U PD=2.54U
* device instance $2879 r0 *1 9.67,60.425 sky130_fd_pr__pfet_01v8
M$2879 36 682 1042 1042 sky130_fd_pr__pfet_01v8 L=0.15U W=0.64U AS=0.1664P
+ AD=0.0864P PS=1.8U PD=0.91U
* device instance $2880 r0 *1 10.09,60.425 sky130_fd_pr__pfet_01v8
M$2880 1044 1042 36 36 sky130_fd_pr__pfet_01v8 L=0.15U W=0.64U AS=0.0864P
+ AD=0.1664P PS=0.91U PD=1.8U
* device instance $2881 r0 *1 11.53,64.545 sky130_fd_pr__pfet_01v8
M$2881 114 1131 36 36 sky130_fd_pr__pfet_01v8 L=0.15U W=1U AS=0.26P AD=0.135P
+ PS=2.52U PD=1.27U
* device instance $2882 r0 *1 11.95,64.545 sky130_fd_pr__pfet_01v8
M$2882 36 1101 114 114 sky130_fd_pr__pfet_01v8 L=0.15U W=1U AS=0.135P AD=0.26P
+ PS=1.27U PD=2.52U
* device instance $2883 r0 *1 12.89,64.625 sky130_fd_pr__pfet_01v8
M$2883 1101 63 36 36 sky130_fd_pr__pfet_01v8 L=0.15U W=1.68U AS=0.3318P
+ AD=0.3486P PS=3.31U PD=3.35U
* device instance $2885 r0 *1 17.05,64.545 sky130_fd_pr__pfet_01v8
M$2885 36 1131 1134 1134 sky130_fd_pr__pfet_01v8 L=0.15U W=4U AS=0.685P
+ AD=0.54P PS=6.37U PD=5.08U
* device instance $2889 r0 *1 18.73,64.545 sky130_fd_pr__pfet_01v8
M$2889 1102 63 1134 1134 sky130_fd_pr__pfet_01v8 L=0.15U W=4U AS=0.54P
+ AD=0.675P PS=5.08U PD=6.35U
* device instance $2893 r0 *1 22.255,64.545 sky130_fd_pr__pfet_01v8
M$2893 302 1102 36 36 sky130_fd_pr__pfet_01v8 L=0.15U W=8U AS=1.205P AD=1.205P
+ PS=11.41U PD=11.41U
* device instance $2901 r0 *1 26.49,64.545 sky130_fd_pr__pfet_01v8
M$2901 1103 1050 36 36 sky130_fd_pr__pfet_01v8 L=0.15U W=2U AS=0.395P AD=0.27P
+ PS=3.79U PD=2.54U
* device instance $2903 r0 *1 27.33,64.545 sky130_fd_pr__pfet_01v8
M$2903 409 1103 36 36 sky130_fd_pr__pfet_01v8 L=0.15U W=6U AS=0.81P AD=0.935P
+ PS=7.62U PD=8.87U
* device instance $2909 r0 *1 30.37,64.695 sky130_fd_pr__pfet_01v8
M$2909 36 682 1104 1104 sky130_fd_pr__pfet_01v8 L=0.15U W=0.64U AS=0.1664P
+ AD=0.0864P PS=1.8U PD=0.91U
* device instance $2910 r0 *1 30.79,64.695 sky130_fd_pr__pfet_01v8
M$2910 1106 1104 36 36 sky130_fd_pr__pfet_01v8 L=0.15U W=0.64U AS=0.0864P
+ AD=0.1664P PS=0.91U PD=1.8U
* device instance $2911 r0 *1 39.825,64.725 sky130_fd_pr__pfet_01v8
M$2911 1109 1112 36 36 sky130_fd_pr__pfet_01v8 L=0.15U W=0.64U AS=0.154P
+ AD=0.1728P PS=1.335U PD=1.82U
* device instance $2912 r0 *1 40.31,64.545 sky130_fd_pr__pfet_01v8
M$2912 994 1112 36 36 sky130_fd_pr__pfet_01v8 L=0.15U W=1U AS=0.154P AD=0.28P
+ PS=1.335U PD=2.56U
* device instance $2913 r0 *1 41.41,64.545 sky130_fd_pr__pfet_01v8
M$2913 36 1076 1113 1113 sky130_fd_pr__pfet_01v8 L=0.15U W=1U AS=0.26P
+ AD=0.135P PS=2.52U PD=1.27U
* device instance $2914 r0 *1 41.83,64.545 sky130_fd_pr__pfet_01v8
M$2914 995 1113 36 36 sky130_fd_pr__pfet_01v8 L=0.15U W=4U AS=0.54P AD=0.665P
+ PS=5.08U PD=6.33U
* device instance $2918 r0 *1 45.59,64.545 sky130_fd_pr__pfet_01v8
M$2918 1114 1135 36 36 sky130_fd_pr__pfet_01v8 L=0.15U W=1U AS=0.3P AD=0.135P
+ PS=2.6U PD=1.27U
* device instance $2919 r0 *1 46.01,64.545 sky130_fd_pr__pfet_01v8
M$2919 36 1115 1114 1114 sky130_fd_pr__pfet_01v8 L=0.15U W=1U AS=0.135P
+ AD=0.365P PS=1.27U PD=1.73U
* device instance $2920 r0 *1 46.89,64.545 sky130_fd_pr__pfet_01v8
M$2920 1139 1115 36 36 sky130_fd_pr__pfet_01v8 L=0.15U W=1U AS=0.365P AD=0.105P
+ PS=1.73U PD=1.21U
* device instance $2921 r0 *1 47.25,64.545 sky130_fd_pr__pfet_01v8
M$2921 1056 1135 1139 1139 sky130_fd_pr__pfet_01v8 L=0.15U W=1U AS=0.105P
+ AD=0.165P PS=1.21U PD=1.33U
* device instance $2922 r0 *1 47.73,64.545 sky130_fd_pr__pfet_01v8
M$2922 36 1114 1056 1056 sky130_fd_pr__pfet_01v8 L=0.15U W=1U AS=0.165P
+ AD=0.36P PS=1.33U PD=2.72U
* device instance $2923 r0 *1 47.39,60.85 sky130_fd_pr__pfet_01v8
M$2923 36 1056 1079 1079 sky130_fd_pr__pfet_01v8 L=0.15U W=0.42U AS=0.1092P
+ AD=0.0567P PS=1.36U PD=0.69U
* device instance $2924 r0 *1 47.81,60.85 sky130_fd_pr__pfet_01v8
M$2924 1079 1054 36 36 sky130_fd_pr__pfet_01v8 L=0.15U W=0.42U AS=0.0567P
+ AD=0.06615P PS=0.69U PD=0.735U
* device instance $2925 r0 *1 48.275,60.85 sky130_fd_pr__pfet_01v8
M$2925 1079 1078 36 36 sky130_fd_pr__pfet_01v8 L=0.15U W=0.42U AS=0.142225P
+ AD=0.06615P PS=1.335U PD=0.735U
* device instance $2926 r0 *1 48.75,60.575 sky130_fd_pr__pfet_01v8
M$2926 1018 1079 36 36 sky130_fd_pr__pfet_01v8 L=0.15U W=1U AS=0.142225P
+ AD=0.26P PS=1.335U PD=2.52U
* device instance $2927 r0 *1 48.77,64.545 sky130_fd_pr__pfet_01v8
M$2927 36 1035 1117 1117 sky130_fd_pr__pfet_01v8 L=0.15U W=1U AS=0.26P
+ AD=0.135P PS=2.52U PD=1.27U
* device instance $2928 r0 *1 49.19,64.545 sky130_fd_pr__pfet_01v8
M$2928 1078 1117 36 36 sky130_fd_pr__pfet_01v8 L=0.15U W=4U AS=0.54P AD=0.665P
+ PS=5.08U PD=6.33U
* device instance $2932 r0 *1 51.77,64.255 sky130_fd_pr__pfet_01v8
M$2932 36 1115 1118 1118 sky130_fd_pr__pfet_01v8 L=0.15U W=0.42U AS=0.1092P
+ AD=0.1573P PS=1.36U PD=1.39U
* device instance $2933 r0 *1 52.31,64.545 sky130_fd_pr__pfet_01v8
M$2933 1137 1135 36 36 sky130_fd_pr__pfet_01v8 L=0.15U W=1U AS=0.1573P
+ AD=0.105P PS=1.39U PD=1.21U
* device instance $2934 r0 *1 52.67,64.545 sky130_fd_pr__pfet_01v8
M$2934 1077 1118 1137 1137 sky130_fd_pr__pfet_01v8 L=0.15U W=1U AS=0.105P
+ AD=0.26P PS=1.21U PD=2.52U
* device instance $2935 r0 *1 63.49,60.425 sky130_fd_pr__pfet_01v8
M$2935 36 980 1061 1061 sky130_fd_pr__pfet_01v8 L=0.15U W=0.64U AS=0.1664P
+ AD=0.0864P PS=1.8U PD=0.91U
* device instance $2936 r0 *1 63.91,60.425 sky130_fd_pr__pfet_01v8
M$2936 1062 1061 36 36 sky130_fd_pr__pfet_01v8 L=0.15U W=0.64U AS=0.0864P
+ AD=0.1664P PS=0.91U PD=1.8U
* device instance $2937 r0 *1 64.41,64.255 sky130_fd_pr__pfet_01v8
M$2937 36 1132 1119 1119 sky130_fd_pr__pfet_01v8 L=0.15U W=0.42U AS=0.1092P
+ AD=0.14575P PS=1.36U PD=1.335U
* device instance $2938 r0 *1 64.895,64.545 sky130_fd_pr__pfet_01v8
M$2938 1054 1133 36 36 sky130_fd_pr__pfet_01v8 L=0.15U W=1U AS=0.14575P
+ AD=0.135P PS=1.335U PD=1.27U
* device instance $2939 r0 *1 65.315,64.545 sky130_fd_pr__pfet_01v8
M$2939 36 1119 1054 1054 sky130_fd_pr__pfet_01v8 L=0.15U W=1U AS=0.135P
+ AD=0.265P PS=1.27U PD=2.53U
* device instance $2940 r0 *1 66.71,64.545 sky130_fd_pr__pfet_01v8
M$2940 36 1133 1120 1120 sky130_fd_pr__pfet_01v8 L=0.15U W=1U AS=0.26P
+ AD=0.135P PS=2.52U PD=1.27U
* device instance $2941 r0 *1 67.13,64.545 sky130_fd_pr__pfet_01v8
M$2941 373 1120 36 36 sky130_fd_pr__pfet_01v8 L=0.15U W=4U AS=0.54P AD=0.665P
+ PS=5.08U PD=6.33U
* device instance $2945 r0 *1 5.09,66.015 sky130_fd_pr__pfet_01v8
M$2945 1130 1145 36 36 sky130_fd_pr__pfet_01v8 L=0.15U W=1U AS=0.26P AD=0.135P
+ PS=2.52U PD=1.27U
* device instance $2946 r0 *1 5.51,66.015 sky130_fd_pr__pfet_01v8
M$2946 36 63 1130 1130 sky130_fd_pr__pfet_01v8 L=0.15U W=1U AS=0.135P AD=0.26P
+ PS=1.27U PD=2.52U
* device instance $2947 r0 *1 8.805,65.835 sky130_fd_pr__pfet_01v8
M$2947 1195 1101 36 36 sky130_fd_pr__pfet_01v8 L=0.15U W=0.64U AS=0.1696P
+ AD=0.0768P PS=1.81U PD=0.88U
* device instance $2948 r0 *1 9.195,65.835 sky130_fd_pr__pfet_01v8
M$2948 1074 1145 1195 1195 sky130_fd_pr__pfet_01v8 L=0.15U W=0.64U AS=0.0768P
+ AD=0.0896P PS=0.88U PD=0.92U
* device instance $2949 r0 *1 9.625,65.835 sky130_fd_pr__pfet_01v8
M$2949 36 1146 1074 1074 sky130_fd_pr__pfet_01v8 L=0.15U W=0.64U AS=0.0896P
+ AD=0.1824P PS=0.92U PD=1.85U
* device instance $2950 r0 *1 10.61,66.015 sky130_fd_pr__pfet_01v8
M$2950 1100 1186 36 36 sky130_fd_pr__pfet_01v8 L=0.15U W=1U AS=0.26P AD=0.135P
+ PS=2.52U PD=1.27U
* device instance $2951 r0 *1 11.03,66.015 sky130_fd_pr__pfet_01v8
M$2951 36 1131 1100 1100 sky130_fd_pr__pfet_01v8 L=0.15U W=1U AS=0.135P
+ AD=0.26P PS=1.27U PD=2.52U
* device instance $2952 r0 *1 12.04,66.015 sky130_fd_pr__pfet_01v8
M$2952 36 1187 1147 1147 sky130_fd_pr__pfet_01v8 L=0.15U W=1U AS=0.33P
+ AD=0.2425P PS=2.66U PD=1.485U
* device instance $2953 r0 *1 12.675,66.015 sky130_fd_pr__pfet_01v8
M$2953 1148 919 36 36 sky130_fd_pr__pfet_01v8 L=0.15U W=1U AS=0.2425P AD=0.165P
+ PS=1.485U PD=1.33U
* device instance $2954 r0 *1 13.155,66.015 sky130_fd_pr__pfet_01v8
M$2954 36 1186 1148 1148 sky130_fd_pr__pfet_01v8 L=0.15U W=1U AS=0.165P
+ AD=0.225P PS=1.33U PD=1.45U
* device instance $2955 r0 *1 13.755,66.015 sky130_fd_pr__pfet_01v8
M$2955 1148 1131 36 36 sky130_fd_pr__pfet_01v8 L=0.15U W=1U AS=0.225P AD=0.185P
+ PS=1.45U PD=1.37U
* device instance $2956 r0 *1 14.275,66.015 sky130_fd_pr__pfet_01v8
M$2956 1187 1146 1148 1148 sky130_fd_pr__pfet_01v8 L=0.15U W=1U AS=0.185P
+ AD=0.14P PS=1.37U PD=1.28U
* device instance $2957 r0 *1 14.705,66.015 sky130_fd_pr__pfet_01v8
M$2957 1148 1188 1187 1187 sky130_fd_pr__pfet_01v8 L=0.15U W=1U AS=0.14P
+ AD=0.265P PS=1.28U PD=2.53U
* device instance $2958 r0 *1 24.46,65.725 sky130_fd_pr__pfet_01v8
M$2958 1150 1189 36 36 sky130_fd_pr__pfet_01v8 L=0.15U W=0.42U AS=0.1113P
+ AD=0.0609P PS=1.37U PD=0.71U
* device instance $2959 r0 *1 24.9,65.725 sky130_fd_pr__pfet_01v8
M$2959 36 114 1150 1150 sky130_fd_pr__pfet_01v8 L=0.15U W=0.42U AS=0.0609P
+ AD=0.1841P PS=0.71U PD=1.26U
* device instance $2960 r0 *1 25.67,65.835 sky130_fd_pr__pfet_01v8
M$2960 1151 1150 36 36 sky130_fd_pr__pfet_01v8 L=0.15U W=0.64U AS=0.1841P
+ AD=0.1696P PS=1.26U PD=1.81U
* device instance $2961 r0 *1 26.69,66.015 sky130_fd_pr__pfet_01v8
M$2961 1153 1151 1152 1152 sky130_fd_pr__pfet_01v8 L=0.15U W=1U AS=0.26P
+ AD=0.135P PS=2.52U PD=1.27U
* device instance $2962 r0 *1 27.11,66.015 sky130_fd_pr__pfet_01v8
M$2962 1154 894 1153 1153 sky130_fd_pr__pfet_01v8 L=0.15U W=1U AS=0.135P
+ AD=0.135P PS=1.27U PD=1.27U
* device instance $2963 r0 *1 27.53,66.015 sky130_fd_pr__pfet_01v8
M$2963 1153 91 1154 1154 sky130_fd_pr__pfet_01v8 L=0.15U W=1U AS=0.135P
+ AD=0.26P PS=1.27U PD=2.52U
* device instance $2964 r0 *1 28.47,66.015 sky130_fd_pr__pfet_01v8
M$2964 1154 1155 36 36 sky130_fd_pr__pfet_01v8 L=0.15U W=1U AS=0.26P AD=0.165P
+ PS=2.52U PD=1.33U
* device instance $2965 r0 *1 28.95,66.015 sky130_fd_pr__pfet_01v8
M$2965 36 1000 1154 1154 sky130_fd_pr__pfet_01v8 L=0.15U W=1U AS=0.165P
+ AD=0.1575P PS=1.33U PD=1.315U
* device instance $2966 r0 *1 29.415,66.015 sky130_fd_pr__pfet_01v8
M$2966 1105 1152 36 36 sky130_fd_pr__pfet_01v8 L=0.15U W=1U AS=0.1575P AD=0.26P
+ PS=1.315U PD=2.52U
* device instance $2967 r0 *1 31.73,64.725 sky130_fd_pr__pfet_01v8
M$2967 1144 1105 1107 1107 sky130_fd_pr__pfet_01v8 L=0.15U W=0.64U AS=0.1664P
+ AD=0.0672P PS=1.8U PD=0.85U
* device instance $2968 r0 *1 32.09,64.725 sky130_fd_pr__pfet_01v8
M$2968 36 1108 1144 1144 sky130_fd_pr__pfet_01v8 L=0.15U W=0.64U AS=0.0672P
+ AD=0.1664P PS=0.85U PD=1.8U
* device instance $2969 r0 *1 32.25,66.015 sky130_fd_pr__pfet_01v8
M$2969 1156 1060 36 36 sky130_fd_pr__pfet_01v8 L=0.15U W=1U AS=0.3P AD=0.135P
+ PS=2.6U PD=1.27U
* device instance $2970 r0 *1 32.67,66.015 sky130_fd_pr__pfet_01v8
M$2970 36 1052 1156 1156 sky130_fd_pr__pfet_01v8 L=0.15U W=1U AS=0.135P
+ AD=0.365P PS=1.27U PD=1.73U
* device instance $2971 r0 *1 33.55,66.015 sky130_fd_pr__pfet_01v8
M$2971 1199 1052 36 36 sky130_fd_pr__pfet_01v8 L=0.15U W=1U AS=0.365P AD=0.105P
+ PS=1.73U PD=1.21U
* device instance $2972 r0 *1 33.91,66.015 sky130_fd_pr__pfet_01v8
M$2972 1155 1060 1199 1199 sky130_fd_pr__pfet_01v8 L=0.15U W=1U AS=0.105P
+ AD=0.165P PS=1.21U PD=1.33U
* device instance $2973 r0 *1 34.39,66.015 sky130_fd_pr__pfet_01v8
M$2973 36 1156 1155 1155 sky130_fd_pr__pfet_01v8 L=0.15U W=1U AS=0.165P
+ AD=0.36P PS=1.33U PD=2.72U
* device instance $2974 r0 *1 33.03,64.725 sky130_fd_pr__pfet_01v8
M$2974 36 302 1108 1108 sky130_fd_pr__pfet_01v8 L=0.15U W=0.64U AS=0.1664P
+ AD=0.0928P PS=1.8U PD=0.93U
* device instance $2975 r0 *1 33.47,64.725 sky130_fd_pr__pfet_01v8
M$2975 1143 302 36 36 sky130_fd_pr__pfet_01v8 L=0.15U W=0.64U AS=0.0928P
+ AD=0.1152P PS=0.93U PD=1U
* device instance $2976 r0 *1 33.98,64.725 sky130_fd_pr__pfet_01v8
M$2976 1107 1109 1143 1143 sky130_fd_pr__pfet_01v8 L=0.15U W=0.64U AS=0.1152P
+ AD=0.15985P PS=1U PD=1.265U
* device instance $2977 r0 *1 34.755,64.835 sky130_fd_pr__pfet_01v8
M$2977 1110 1106 1107 1107 sky130_fd_pr__pfet_01v8 L=0.15U W=0.42U AS=0.15985P
+ AD=0.06405P PS=1.265U PD=0.725U
* device instance $2978 r0 *1 35.21,64.835 sky130_fd_pr__pfet_01v8
M$2978 1142 1104 1110 1110 sky130_fd_pr__pfet_01v8 L=0.15U W=0.42U AS=0.06405P
+ AD=0.07665P PS=0.725U PD=0.785U
* device instance $2979 r0 *1 35.725,64.835 sky130_fd_pr__pfet_01v8
M$2979 1142 1111 36 36 sky130_fd_pr__pfet_01v8 L=0.15U W=0.42U AS=0.178875P
+ AD=0.07665P PS=1.26U PD=0.785U
* device instance $2980 r0 *1 36.385,64.67 sky130_fd_pr__pfet_01v8
M$2980 1111 1110 36 36 sky130_fd_pr__pfet_01v8 L=0.15U W=0.75U AS=0.178875P
+ AD=0.195P PS=1.26U PD=2.02U
* device instance $2981 r0 *1 36.81,66.015 sky130_fd_pr__pfet_01v8
M$2981 1158 1190 1157 1157 sky130_fd_pr__pfet_01v8 L=0.15U W=1U AS=0.26P
+ AD=0.135P PS=2.52U PD=1.27U
* device instance $2982 r0 *1 37.23,66.015 sky130_fd_pr__pfet_01v8
M$2982 1159 1135 1158 1158 sky130_fd_pr__pfet_01v8 L=0.15U W=1U AS=0.135P
+ AD=0.135P PS=1.27U PD=1.27U
* device instance $2983 r0 *1 37.65,66.015 sky130_fd_pr__pfet_01v8
M$2983 1158 91 1159 1159 sky130_fd_pr__pfet_01v8 L=0.15U W=1U AS=0.135P
+ AD=0.26P PS=1.27U PD=2.52U
* device instance $2984 r0 *1 37.325,64.835 sky130_fd_pr__pfet_01v8
M$2984 1141 1111 36 36 sky130_fd_pr__pfet_01v8 L=0.15U W=0.42U AS=0.1092P
+ AD=0.06405P PS=1.36U PD=0.725U
* device instance $2985 r0 *1 37.78,64.835 sky130_fd_pr__pfet_01v8
M$2985 1112 1104 1141 1141 sky130_fd_pr__pfet_01v8 L=0.15U W=0.42U AS=0.06405P
+ AD=0.0567P PS=0.725U PD=0.69U
* device instance $2986 r0 *1 38.2,64.835 sky130_fd_pr__pfet_01v8
M$2986 1140 1106 1112 1112 sky130_fd_pr__pfet_01v8 L=0.15U W=0.42U AS=0.0567P
+ AD=0.0882P PS=0.69U PD=0.84U
* device instance $2987 r0 *1 38.77,64.835 sky130_fd_pr__pfet_01v8
M$2987 36 1109 1140 1140 sky130_fd_pr__pfet_01v8 L=0.15U W=0.42U AS=0.0882P
+ AD=0.1113P PS=0.84U PD=1.37U
* device instance $2988 r0 *1 38.59,66.015 sky130_fd_pr__pfet_01v8
M$2988 1159 1191 36 36 sky130_fd_pr__pfet_01v8 L=0.15U W=1U AS=0.26P AD=0.165P
+ PS=2.52U PD=1.33U
* device instance $2989 r0 *1 39.07,66.015 sky130_fd_pr__pfet_01v8
M$2989 36 1019 1159 1159 sky130_fd_pr__pfet_01v8 L=0.15U W=1U AS=0.165P
+ AD=0.1575P PS=1.33U PD=1.315U
* device instance $2990 r0 *1 39.535,66.015 sky130_fd_pr__pfet_01v8
M$2990 1205 1157 36 36 sky130_fd_pr__pfet_01v8 L=0.15U W=1U AS=0.1575P AD=0.26P
+ PS=1.315U PD=2.52U
* device instance $2991 r0 *1 41.85,65.835 sky130_fd_pr__pfet_01v8
M$2991 1201 1192 1162 1162 sky130_fd_pr__pfet_01v8 L=0.15U W=0.64U AS=0.1664P
+ AD=0.0672P PS=1.8U PD=0.85U
* device instance $2992 r0 *1 42.21,65.835 sky130_fd_pr__pfet_01v8
M$2992 36 1163 1201 1201 sky130_fd_pr__pfet_01v8 L=0.15U W=0.64U AS=0.0672P
+ AD=0.1664P PS=0.85U PD=1.8U
* device instance $2993 r0 *1 44.875,65.725 sky130_fd_pr__pfet_01v8
M$2993 1164 1161 1162 1162 sky130_fd_pr__pfet_01v8 L=0.15U W=0.42U AS=0.15985P
+ AD=0.06405P PS=1.265U PD=0.725U
* device instance $2994 r0 *1 45.33,65.725 sky130_fd_pr__pfet_01v8
M$2994 1184 1160 1164 1164 sky130_fd_pr__pfet_01v8 L=0.15U W=0.42U AS=0.06405P
+ AD=0.07665P PS=0.725U PD=0.785U
* device instance $2995 r0 *1 45.845,65.725 sky130_fd_pr__pfet_01v8
M$2995 36 1165 1184 1184 sky130_fd_pr__pfet_01v8 L=0.15U W=0.42U AS=0.07665P
+ AD=0.178875P PS=0.785U PD=1.26U
* device instance $2996 r0 *1 43.15,65.835 sky130_fd_pr__pfet_01v8
M$2996 36 409 1163 1163 sky130_fd_pr__pfet_01v8 L=0.15U W=0.64U AS=0.1664P
+ AD=0.0928P PS=1.8U PD=0.93U
* device instance $2997 r0 *1 43.59,65.835 sky130_fd_pr__pfet_01v8
M$2997 1200 409 36 36 sky130_fd_pr__pfet_01v8 L=0.15U W=0.64U AS=0.0928P
+ AD=0.1152P PS=0.93U PD=1U
* device instance $2998 r0 *1 44.1,65.835 sky130_fd_pr__pfet_01v8
M$2998 1162 1167 1200 1200 sky130_fd_pr__pfet_01v8 L=0.15U W=0.64U AS=0.1152P
+ AD=0.15985P PS=1U PD=1.265U
* device instance $2999 r0 *1 46.505,65.89 sky130_fd_pr__pfet_01v8
M$2999 1165 1164 36 36 sky130_fd_pr__pfet_01v8 L=0.15U W=0.75U AS=0.178875P
+ AD=0.195P PS=1.26U PD=2.02U
* device instance $3000 r0 *1 47.445,65.725 sky130_fd_pr__pfet_01v8
M$3000 1185 1165 36 36 sky130_fd_pr__pfet_01v8 L=0.15U W=0.42U AS=0.1092P
+ AD=0.06405P PS=1.36U PD=0.725U
* device instance $3001 r0 *1 47.9,65.725 sky130_fd_pr__pfet_01v8
M$3001 1166 1160 1185 1185 sky130_fd_pr__pfet_01v8 L=0.15U W=0.42U AS=0.06405P
+ AD=0.0567P PS=0.725U PD=0.69U
* device instance $3002 r0 *1 48.32,65.725 sky130_fd_pr__pfet_01v8
M$3002 1183 1161 1166 1166 sky130_fd_pr__pfet_01v8 L=0.15U W=0.42U AS=0.0567P
+ AD=0.0882P PS=0.69U PD=0.84U
* device instance $3003 r0 *1 48.89,65.725 sky130_fd_pr__pfet_01v8
M$3003 36 1167 1183 1183 sky130_fd_pr__pfet_01v8 L=0.15U W=0.42U AS=0.0882P
+ AD=0.1113P PS=0.84U PD=1.37U
* device instance $3004 r0 *1 49.945,65.835 sky130_fd_pr__pfet_01v8
M$3004 36 1166 1167 1167 sky130_fd_pr__pfet_01v8 L=0.15U W=0.64U AS=0.1728P
+ AD=0.154P PS=1.82U PD=1.335U
* device instance $3005 r0 *1 50.43,66.015 sky130_fd_pr__pfet_01v8
M$3005 1135 1166 36 36 sky130_fd_pr__pfet_01v8 L=0.15U W=1U AS=0.154P AD=0.28P
+ PS=1.335U PD=2.56U
* device instance $3006 r0 *1 60.34,65.725 sky130_fd_pr__pfet_01v8
M$3006 1168 1025 36 36 sky130_fd_pr__pfet_01v8 L=0.15U W=0.42U AS=0.1113P
+ AD=0.0609P PS=1.37U PD=0.71U
* device instance $3007 r0 *1 60.78,65.725 sky130_fd_pr__pfet_01v8
M$3007 36 1054 1168 1168 sky130_fd_pr__pfet_01v8 L=0.15U W=0.42U AS=0.0609P
+ AD=0.1841P PS=0.71U PD=1.26U
* device instance $3008 r0 *1 61.55,65.835 sky130_fd_pr__pfet_01v8
M$3008 1169 1168 36 36 sky130_fd_pr__pfet_01v8 L=0.15U W=0.64U AS=0.1841P
+ AD=0.1696P PS=1.26U PD=1.81U
* device instance $3009 r0 *1 62.61,66.015 sky130_fd_pr__pfet_01v8
M$3009 1198 1029 1170 1170 sky130_fd_pr__pfet_01v8 L=0.15U W=1U AS=0.26P
+ AD=0.135P PS=2.52U PD=1.27U
* device instance $3010 r0 *1 63.03,66.015 sky130_fd_pr__pfet_01v8
M$3010 36 1169 1198 1198 sky130_fd_pr__pfet_01v8 L=0.15U W=1U AS=0.135P
+ AD=0.135P PS=1.27U PD=1.27U
* device instance $3011 r0 *1 63.45,66.015 sky130_fd_pr__pfet_01v8
M$3011 1171 1169 36 36 sky130_fd_pr__pfet_01v8 L=0.15U W=1U AS=0.135P AD=0.135P
+ PS=1.27U PD=1.27U
* device instance $3012 r0 *1 63.87,66.015 sky130_fd_pr__pfet_01v8
M$3012 36 1029 1171 1171 sky130_fd_pr__pfet_01v8 L=0.15U W=1U AS=0.135P
+ AD=0.26P PS=1.27U PD=2.52U
* device instance $3013 r0 *1 64.81,66.015 sky130_fd_pr__pfet_01v8
M$3013 1193 1170 1171 1171 sky130_fd_pr__pfet_01v8 L=0.15U W=1U AS=0.26P
+ AD=0.3P PS=2.52U PD=2.6U
* device instance $3014 r0 *1 67.15,65.835 sky130_fd_pr__pfet_01v8
M$3014 1197 1194 1174 1174 sky130_fd_pr__pfet_01v8 L=0.15U W=0.64U AS=0.1664P
+ AD=0.0672P PS=1.8U PD=0.85U
* device instance $3015 r0 *1 67.51,65.835 sky130_fd_pr__pfet_01v8
M$3015 36 1175 1197 1197 sky130_fd_pr__pfet_01v8 L=0.15U W=0.64U AS=0.0672P
+ AD=0.1664P PS=0.85U PD=1.8U
* device instance $3016 r0 *1 70.175,65.725 sky130_fd_pr__pfet_01v8
M$3016 1176 1173 1174 1174 sky130_fd_pr__pfet_01v8 L=0.15U W=0.42U AS=0.15985P
+ AD=0.06405P PS=1.265U PD=0.725U
* device instance $3017 r0 *1 70.63,65.725 sky130_fd_pr__pfet_01v8
M$3017 1182 1172 1176 1176 sky130_fd_pr__pfet_01v8 L=0.15U W=0.42U AS=0.06405P
+ AD=0.07665P PS=0.725U PD=0.785U
* device instance $3018 r0 *1 71.145,65.725 sky130_fd_pr__pfet_01v8
M$3018 36 1177 1182 1182 sky130_fd_pr__pfet_01v8 L=0.15U W=0.42U AS=0.07665P
+ AD=0.178875P PS=0.785U PD=1.26U
* device instance $3019 r0 *1 68.45,65.835 sky130_fd_pr__pfet_01v8
M$3019 36 409 1175 1175 sky130_fd_pr__pfet_01v8 L=0.15U W=0.64U AS=0.1664P
+ AD=0.0928P PS=1.8U PD=0.93U
* device instance $3020 r0 *1 68.89,65.835 sky130_fd_pr__pfet_01v8
M$3020 1196 409 36 36 sky130_fd_pr__pfet_01v8 L=0.15U W=0.64U AS=0.0928P
+ AD=0.1152P PS=0.93U PD=1U
* device instance $3021 r0 *1 69.4,65.835 sky130_fd_pr__pfet_01v8
M$3021 1174 1179 1196 1196 sky130_fd_pr__pfet_01v8 L=0.15U W=0.64U AS=0.1152P
+ AD=0.15985P PS=1U PD=1.265U
* device instance $3022 r0 *1 71.805,65.89 sky130_fd_pr__pfet_01v8
M$3022 1177 1176 36 36 sky130_fd_pr__pfet_01v8 L=0.15U W=0.75U AS=0.178875P
+ AD=0.195P PS=1.26U PD=2.02U
* device instance $3023 r0 *1 72.745,65.725 sky130_fd_pr__pfet_01v8
M$3023 1181 1177 36 36 sky130_fd_pr__pfet_01v8 L=0.15U W=0.42U AS=0.1092P
+ AD=0.06405P PS=1.36U PD=0.725U
* device instance $3024 r0 *1 73.2,65.725 sky130_fd_pr__pfet_01v8
M$3024 1178 1172 1181 1181 sky130_fd_pr__pfet_01v8 L=0.15U W=0.42U AS=0.06405P
+ AD=0.0567P PS=0.725U PD=0.69U
* device instance $3025 r0 *1 73.62,65.725 sky130_fd_pr__pfet_01v8
M$3025 1180 1173 1178 1178 sky130_fd_pr__pfet_01v8 L=0.15U W=0.42U AS=0.0567P
+ AD=0.0882P PS=0.69U PD=0.84U
* device instance $3026 r0 *1 74.19,65.725 sky130_fd_pr__pfet_01v8
M$3026 36 1179 1180 1180 sky130_fd_pr__pfet_01v8 L=0.15U W=0.42U AS=0.0882P
+ AD=0.1113P PS=0.84U PD=1.37U
* device instance $3027 r0 *1 75.245,65.835 sky130_fd_pr__pfet_01v8
M$3027 36 1178 1179 1179 sky130_fd_pr__pfet_01v8 L=0.15U W=0.64U AS=0.1728P
+ AD=0.154P PS=1.82U PD=1.335U
* device instance $3028 r0 *1 75.73,66.015 sky130_fd_pr__pfet_01v8
M$3028 1133 1178 36 36 sky130_fd_pr__pfet_01v8 L=0.15U W=1U AS=0.154P AD=0.28P
+ PS=1.335U PD=2.56U
* device instance $3029 r0 *1 5.55,69.985 sky130_fd_pr__pfet_01v8
M$3029 36 1202 1292 1292 sky130_fd_pr__pfet_01v8 L=0.15U W=2U AS=0.415P
+ AD=0.275P PS=3.83U PD=2.55U
* device instance $3030 r0 *1 5.98,69.985 sky130_fd_pr__pfet_01v8
M$3030 1292 1230 36 36 sky130_fd_pr__pfet_01v8 L=0.15U W=2U AS=0.28P AD=0.275P
+ PS=2.56U PD=2.55U
* device instance $3033 r0 *1 7.25,69.985 sky130_fd_pr__pfet_01v8
M$3033 1146 1129 1292 1292 sky130_fd_pr__pfet_01v8 L=0.15U W=2U AS=0.27P
+ AD=0.495P PS=2.54U PD=3.99U
* device instance $3035 r0 *1 8.75,70.135 sky130_fd_pr__pfet_01v8
M$3035 36 682 1231 1231 sky130_fd_pr__pfet_01v8 L=0.15U W=0.64U AS=0.1664P
+ AD=0.0864P PS=1.8U PD=0.91U
* device instance $3036 r0 *1 9.17,70.135 sky130_fd_pr__pfet_01v8
M$3036 1232 1231 36 36 sky130_fd_pr__pfet_01v8 L=0.15U W=0.64U AS=0.0864P
+ AD=0.1664P PS=0.91U PD=1.8U
* device instance $3037 r0 *1 10.11,70.275 sky130_fd_pr__pfet_01v8
M$3037 1233 1147 36 36 sky130_fd_pr__pfet_01v8 L=0.15U W=0.42U AS=0.1092P
+ AD=0.05775P PS=1.36U PD=0.695U
* device instance $3038 r0 *1 10.535,70.275 sky130_fd_pr__pfet_01v8
M$3038 1234 1232 1233 1233 sky130_fd_pr__pfet_01v8 L=0.15U W=0.42U AS=0.05775P
+ AD=0.06825P PS=0.695U PD=0.745U
* device instance $3039 r0 *1 11.01,70.275 sky130_fd_pr__pfet_01v8
M$3039 1296 1231 1234 1234 sky130_fd_pr__pfet_01v8 L=0.15U W=0.42U AS=0.06825P
+ AD=0.07665P PS=0.745U PD=0.785U
* device instance $3040 r0 *1 11.525,70.275 sky130_fd_pr__pfet_01v8
M$3040 1296 1235 36 36 sky130_fd_pr__pfet_01v8 L=0.15U W=0.42U AS=0.178875P
+ AD=0.07665P PS=1.26U PD=0.785U
* device instance $3041 r0 *1 12.185,70.11 sky130_fd_pr__pfet_01v8
M$3041 1235 1234 36 36 sky130_fd_pr__pfet_01v8 L=0.15U W=0.75U AS=0.178875P
+ AD=0.1095P PS=1.26U PD=1.075U
* device instance $3042 r0 *1 12.66,70.275 sky130_fd_pr__pfet_01v8
M$3042 1236 1231 1235 1235 sky130_fd_pr__pfet_01v8 L=0.15U W=0.42U AS=0.1095P
+ AD=0.0567P PS=1.075U PD=0.69U
* device instance $3043 r0 *1 13.08,70.275 sky130_fd_pr__pfet_01v8
M$3043 1297 1232 1236 1236 sky130_fd_pr__pfet_01v8 L=0.15U W=0.42U AS=0.0567P
+ AD=0.0882P PS=0.69U PD=0.84U
* device instance $3044 r0 *1 13.65,70.275 sky130_fd_pr__pfet_01v8
M$3044 36 1237 1297 1297 sky130_fd_pr__pfet_01v8 L=0.15U W=0.42U AS=0.0882P
+ AD=0.1113P PS=0.84U PD=1.37U
* device instance $3045 r0 *1 14.7,69.985 sky130_fd_pr__pfet_01v8
M$3045 36 1236 1237 1237 sky130_fd_pr__pfet_01v8 L=0.15U W=1U AS=0.27P
+ AD=0.135P PS=2.54U PD=1.27U
* device instance $3046 r0 *1 15.12,69.985 sky130_fd_pr__pfet_01v8
M$3046 1188 1237 36 36 sky130_fd_pr__pfet_01v8 L=0.15U W=1U AS=0.135P AD=0.26P
+ PS=1.27U PD=2.52U
* device instance $3047 r0 *1 15.83,65.935 sky130_fd_pr__pfet_01v8
M$3047 1149 1188 36 36 sky130_fd_pr__pfet_01v8 L=0.15U W=0.42U AS=0.1176P
+ AD=0.0567P PS=1.4U PD=0.69U
* device instance $3048 r0 *1 16.25,65.935 sky130_fd_pr__pfet_01v8
M$3048 1149 1102 36 36 sky130_fd_pr__pfet_01v8 L=0.15U W=0.42U AS=0.16655P
+ AD=0.0567P PS=1.39U PD=0.69U
* device instance $3049 r0 *1 16.79,66.015 sky130_fd_pr__pfet_01v8
M$3049 1230 1149 36 36 sky130_fd_pr__pfet_01v8 L=0.15U W=1U AS=0.16655P
+ AD=0.475P PS=1.39U PD=2.95U
* device instance $3050 r0 *1 22.09,70.135 sky130_fd_pr__pfet_01v8
M$3050 36 682 1238 1238 sky130_fd_pr__pfet_01v8 L=0.15U W=0.64U AS=0.1664P
+ AD=0.0864P PS=1.8U PD=0.91U
* device instance $3051 r0 *1 22.51,70.135 sky130_fd_pr__pfet_01v8
M$3051 1239 1238 36 36 sky130_fd_pr__pfet_01v8 L=0.15U W=0.64U AS=0.0864P
+ AD=0.1664P PS=0.91U PD=1.8U
* device instance $3052 r0 *1 23.45,70.165 sky130_fd_pr__pfet_01v8
M$3052 1298 1275 1240 1240 sky130_fd_pr__pfet_01v8 L=0.15U W=0.64U AS=0.1664P
+ AD=0.0672P PS=1.8U PD=0.85U
* device instance $3053 r0 *1 23.81,70.165 sky130_fd_pr__pfet_01v8
M$3053 36 1241 1298 1298 sky130_fd_pr__pfet_01v8 L=0.15U W=0.64U AS=0.0672P
+ AD=0.1664P PS=0.85U PD=1.8U
* device instance $3054 r0 *1 24.75,70.165 sky130_fd_pr__pfet_01v8
M$3054 36 409 1241 1241 sky130_fd_pr__pfet_01v8 L=0.15U W=0.64U AS=0.1664P
+ AD=0.0928P PS=1.8U PD=0.93U
* device instance $3055 r0 *1 25.19,70.165 sky130_fd_pr__pfet_01v8
M$3055 1299 409 36 36 sky130_fd_pr__pfet_01v8 L=0.15U W=0.64U AS=0.0928P
+ AD=0.1152P PS=0.93U PD=1U
* device instance $3056 r0 *1 25.7,70.165 sky130_fd_pr__pfet_01v8
M$3056 1240 1276 1299 1299 sky130_fd_pr__pfet_01v8 L=0.15U W=0.64U AS=0.1152P
+ AD=0.15985P PS=1U PD=1.265U
* device instance $3057 r0 *1 26.475,70.275 sky130_fd_pr__pfet_01v8
M$3057 1242 1239 1240 1240 sky130_fd_pr__pfet_01v8 L=0.15U W=0.42U AS=0.15985P
+ AD=0.06405P PS=1.265U PD=0.725U
* device instance $3058 r0 *1 26.93,70.275 sky130_fd_pr__pfet_01v8
M$3058 1300 1238 1242 1242 sky130_fd_pr__pfet_01v8 L=0.15U W=0.42U AS=0.06405P
+ AD=0.07665P PS=0.725U PD=0.785U
* device instance $3059 r0 *1 27.445,70.275 sky130_fd_pr__pfet_01v8
M$3059 1300 1243 36 36 sky130_fd_pr__pfet_01v8 L=0.15U W=0.42U AS=0.178875P
+ AD=0.07665P PS=1.26U PD=0.785U
* device instance $3060 r0 *1 28.105,70.11 sky130_fd_pr__pfet_01v8
M$3060 1243 1242 36 36 sky130_fd_pr__pfet_01v8 L=0.15U W=0.75U AS=0.178875P
+ AD=0.195P PS=1.26U PD=2.02U
* device instance $3061 r0 *1 29.045,70.275 sky130_fd_pr__pfet_01v8
M$3061 1302 1243 36 36 sky130_fd_pr__pfet_01v8 L=0.15U W=0.42U AS=0.1092P
+ AD=0.06405P PS=1.36U PD=0.725U
* device instance $3062 r0 *1 29.5,70.275 sky130_fd_pr__pfet_01v8
M$3062 1244 1238 1302 1302 sky130_fd_pr__pfet_01v8 L=0.15U W=0.42U AS=0.06405P
+ AD=0.0567P PS=0.725U PD=0.69U
* device instance $3063 r0 *1 29.92,70.275 sky130_fd_pr__pfet_01v8
M$3063 1303 1239 1244 1244 sky130_fd_pr__pfet_01v8 L=0.15U W=0.42U AS=0.0567P
+ AD=0.0882P PS=0.69U PD=0.84U
* device instance $3064 r0 *1 30.49,70.275 sky130_fd_pr__pfet_01v8
M$3064 36 1276 1303 1303 sky130_fd_pr__pfet_01v8 L=0.15U W=0.42U AS=0.0882P
+ AD=0.1113P PS=0.84U PD=1.37U
* device instance $3065 r0 *1 31.545,70.165 sky130_fd_pr__pfet_01v8
M$3065 1276 1244 36 36 sky130_fd_pr__pfet_01v8 L=0.15U W=0.64U AS=0.154P
+ AD=0.1728P PS=1.335U PD=1.82U
* device instance $3066 r0 *1 32.03,69.985 sky130_fd_pr__pfet_01v8
M$3066 894 1244 36 36 sky130_fd_pr__pfet_01v8 L=0.15U W=1U AS=0.154P AD=0.28P
+ PS=1.335U PD=2.56U
* device instance $3067 r0 *1 33.13,69.985 sky130_fd_pr__pfet_01v8
M$3067 36 1000 1245 1245 sky130_fd_pr__pfet_01v8 L=0.15U W=1U AS=0.26P
+ AD=0.135P PS=2.52U PD=1.27U
* device instance $3068 r0 *1 33.55,69.985 sky130_fd_pr__pfet_01v8
M$3068 1191 1245 36 36 sky130_fd_pr__pfet_01v8 L=0.15U W=4U AS=0.54P AD=0.665P
+ PS=5.08U PD=6.33U
* device instance $3072 r0 *1 40.49,65.865 sky130_fd_pr__pfet_01v8
M$3072 36 980 1160 1160 sky130_fd_pr__pfet_01v8 L=0.15U W=0.64U AS=0.1664P
+ AD=0.0864P PS=1.8U PD=0.91U
* device instance $3073 r0 *1 40.91,65.865 sky130_fd_pr__pfet_01v8
M$3073 1161 1160 36 36 sky130_fd_pr__pfet_01v8 L=0.15U W=0.64U AS=0.0864P
+ AD=0.1664P PS=0.91U PD=1.8U
* device instance $3074 r0 *1 40.51,69.985 sky130_fd_pr__pfet_01v8
M$3074 846 1277 36 36 sky130_fd_pr__pfet_01v8 L=0.15U W=1U AS=0.26P AD=0.135P
+ PS=2.52U PD=1.27U
* device instance $3075 r0 *1 40.93,69.985 sky130_fd_pr__pfet_01v8
M$3075 36 63 846 846 sky130_fd_pr__pfet_01v8 L=0.15U W=1U AS=0.135P AD=0.26P
+ PS=1.27U PD=2.52U
* device instance $3076 r0 *1 41.94,70.275 sky130_fd_pr__pfet_01v8
M$3076 1246 1287 36 36 sky130_fd_pr__pfet_01v8 L=0.15U W=0.42U AS=0.1113P
+ AD=0.0609P PS=1.37U PD=0.71U
* device instance $3077 r0 *1 42.38,70.275 sky130_fd_pr__pfet_01v8
M$3077 1246 114 36 36 sky130_fd_pr__pfet_01v8 L=0.15U W=0.42U AS=0.1841P
+ AD=0.0609P PS=1.26U PD=0.71U
* device instance $3078 r0 *1 43.15,70.165 sky130_fd_pr__pfet_01v8
M$3078 1190 1246 36 36 sky130_fd_pr__pfet_01v8 L=0.15U W=0.64U AS=0.1841P
+ AD=0.1696P PS=1.26U PD=1.81U
* device instance $3079 r0 *1 44.63,70.135 sky130_fd_pr__pfet_01v8
M$3079 36 980 1247 1247 sky130_fd_pr__pfet_01v8 L=0.15U W=0.64U AS=0.1664P
+ AD=0.0864P PS=1.8U PD=0.91U
* device instance $3080 r0 *1 45.05,70.135 sky130_fd_pr__pfet_01v8
M$3080 1248 1247 36 36 sky130_fd_pr__pfet_01v8 L=0.15U W=0.64U AS=0.0864P
+ AD=0.1664P PS=0.91U PD=1.8U
* device instance $3081 r0 *1 45.99,70.165 sky130_fd_pr__pfet_01v8
M$3081 1307 1205 1249 1249 sky130_fd_pr__pfet_01v8 L=0.15U W=0.64U AS=0.1664P
+ AD=0.0672P PS=1.8U PD=0.85U
* device instance $3082 r0 *1 46.35,70.165 sky130_fd_pr__pfet_01v8
M$3082 36 1250 1307 1307 sky130_fd_pr__pfet_01v8 L=0.15U W=0.64U AS=0.0672P
+ AD=0.1664P PS=0.85U PD=1.8U
* device instance $3083 r0 *1 47.29,70.165 sky130_fd_pr__pfet_01v8
M$3083 36 302 1250 1250 sky130_fd_pr__pfet_01v8 L=0.15U W=0.64U AS=0.1664P
+ AD=0.0928P PS=1.8U PD=0.93U
* device instance $3084 r0 *1 47.73,70.165 sky130_fd_pr__pfet_01v8
M$3084 1306 302 36 36 sky130_fd_pr__pfet_01v8 L=0.15U W=0.64U AS=0.0928P
+ AD=0.1152P PS=0.93U PD=1U
* device instance $3085 r0 *1 48.24,70.165 sky130_fd_pr__pfet_01v8
M$3085 1249 1278 1306 1306 sky130_fd_pr__pfet_01v8 L=0.15U W=0.64U AS=0.1152P
+ AD=0.15985P PS=1U PD=1.265U
* device instance $3086 r0 *1 49.015,70.275 sky130_fd_pr__pfet_01v8
M$3086 1251 1248 1249 1249 sky130_fd_pr__pfet_01v8 L=0.15U W=0.42U AS=0.15985P
+ AD=0.06405P PS=1.265U PD=0.725U
* device instance $3087 r0 *1 49.47,70.275 sky130_fd_pr__pfet_01v8
M$3087 1305 1247 1251 1251 sky130_fd_pr__pfet_01v8 L=0.15U W=0.42U AS=0.06405P
+ AD=0.07665P PS=0.725U PD=0.785U
* device instance $3088 r0 *1 49.985,70.275 sky130_fd_pr__pfet_01v8
M$3088 1305 1252 36 36 sky130_fd_pr__pfet_01v8 L=0.15U W=0.42U AS=0.178875P
+ AD=0.07665P PS=1.26U PD=0.785U
* device instance $3089 r0 *1 50.645,70.11 sky130_fd_pr__pfet_01v8
M$3089 1252 1251 36 36 sky130_fd_pr__pfet_01v8 L=0.15U W=0.75U AS=0.178875P
+ AD=0.195P PS=1.26U PD=2.02U
* device instance $3090 r0 *1 51.585,70.275 sky130_fd_pr__pfet_01v8
M$3090 1304 1252 36 36 sky130_fd_pr__pfet_01v8 L=0.15U W=0.42U AS=0.1092P
+ AD=0.06405P PS=1.36U PD=0.725U
* device instance $3091 r0 *1 52.04,70.275 sky130_fd_pr__pfet_01v8
M$3091 1253 1247 1304 1304 sky130_fd_pr__pfet_01v8 L=0.15U W=0.42U AS=0.06405P
+ AD=0.0567P PS=0.725U PD=0.69U
* device instance $3092 r0 *1 52.46,70.275 sky130_fd_pr__pfet_01v8
M$3092 1301 1248 1253 1253 sky130_fd_pr__pfet_01v8 L=0.15U W=0.42U AS=0.0567P
+ AD=0.0882P PS=0.69U PD=0.84U
* device instance $3093 r0 *1 53.03,70.275 sky130_fd_pr__pfet_01v8
M$3093 36 1278 1301 1301 sky130_fd_pr__pfet_01v8 L=0.15U W=0.42U AS=0.0882P
+ AD=0.1113P PS=0.84U PD=1.37U
* device instance $3094 r0 *1 54.085,70.165 sky130_fd_pr__pfet_01v8
M$3094 1278 1253 36 36 sky130_fd_pr__pfet_01v8 L=0.15U W=0.64U AS=0.154P
+ AD=0.1728P PS=1.335U PD=1.82U
* device instance $3095 r0 *1 54.57,69.985 sky130_fd_pr__pfet_01v8
M$3095 1115 1253 36 36 sky130_fd_pr__pfet_01v8 L=0.15U W=1U AS=0.154P AD=0.28P
+ PS=1.335U PD=2.56U
* device instance $3096 r0 *1 57.12,70.275 sky130_fd_pr__pfet_01v8
M$3096 1254 1288 36 36 sky130_fd_pr__pfet_01v8 L=0.15U W=0.42U AS=0.1113P
+ AD=0.0609P PS=1.37U PD=0.71U
* device instance $3097 r0 *1 57.56,70.275 sky130_fd_pr__pfet_01v8
M$3097 1254 114 36 36 sky130_fd_pr__pfet_01v8 L=0.15U W=0.42U AS=0.1841P
+ AD=0.0609P PS=1.26U PD=0.71U
* device instance $3098 r0 *1 58.33,70.165 sky130_fd_pr__pfet_01v8
M$3098 1026 1254 36 36 sky130_fd_pr__pfet_01v8 L=0.15U W=0.64U AS=0.1841P
+ AD=0.1696P PS=1.26U PD=1.81U
* device instance $3099 r0 *1 60.27,69.985 sky130_fd_pr__pfet_01v8
M$3099 1293 1279 1255 1255 sky130_fd_pr__pfet_01v8 L=0.15U W=1U AS=0.26P
+ AD=0.135P PS=2.52U PD=1.27U
* device instance $3100 r0 *1 60.69,69.985 sky130_fd_pr__pfet_01v8
M$3100 1289 1280 1293 1293 sky130_fd_pr__pfet_01v8 L=0.15U W=1U AS=0.135P
+ AD=0.135P PS=1.27U PD=1.27U
* device instance $3101 r0 *1 61.11,69.985 sky130_fd_pr__pfet_01v8
M$3101 1293 91 1289 1289 sky130_fd_pr__pfet_01v8 L=0.15U W=1U AS=0.135P
+ AD=0.26P PS=1.27U PD=2.52U
* device instance $3102 r0 *1 62.05,69.985 sky130_fd_pr__pfet_01v8
M$3102 1289 1022 36 36 sky130_fd_pr__pfet_01v8 L=0.15U W=1U AS=0.26P AD=0.165P
+ PS=2.52U PD=1.33U
* device instance $3103 r0 *1 62.53,69.985 sky130_fd_pr__pfet_01v8
M$3103 36 1193 1289 1289 sky130_fd_pr__pfet_01v8 L=0.15U W=1U AS=0.165P
+ AD=0.1575P PS=1.33U PD=1.315U
* device instance $3104 r0 *1 62.995,69.985 sky130_fd_pr__pfet_01v8
M$3104 1290 1255 36 36 sky130_fd_pr__pfet_01v8 L=0.15U W=1U AS=0.1575P AD=0.26P
+ PS=1.315U PD=2.52U
* device instance $3105 r0 *1 63.95,69.695 sky130_fd_pr__pfet_01v8
M$3105 36 1133 1256 1256 sky130_fd_pr__pfet_01v8 L=0.15U W=0.42U AS=0.1092P
+ AD=0.14575P PS=1.36U PD=1.335U
* device instance $3106 r0 *1 64.435,69.985 sky130_fd_pr__pfet_01v8
M$3106 1025 1132 36 36 sky130_fd_pr__pfet_01v8 L=0.15U W=1U AS=0.14575P
+ AD=0.135P PS=1.335U PD=1.27U
* device instance $3107 r0 *1 64.855,69.985 sky130_fd_pr__pfet_01v8
M$3107 36 1256 1025 1025 sky130_fd_pr__pfet_01v8 L=0.15U W=1U AS=0.135P
+ AD=0.265P PS=1.27U PD=2.53U
* device instance $3108 r0 *1 65.79,65.865 sky130_fd_pr__pfet_01v8
M$3108 36 980 1172 1172 sky130_fd_pr__pfet_01v8 L=0.15U W=0.64U AS=0.1664P
+ AD=0.0864P PS=1.8U PD=0.91U
* device instance $3109 r0 *1 66.21,65.865 sky130_fd_pr__pfet_01v8
M$3109 1173 1172 36 36 sky130_fd_pr__pfet_01v8 L=0.15U W=0.64U AS=0.0864P
+ AD=0.1664P PS=0.91U PD=1.8U
* device instance $3110 r0 *1 68.175,70.08 sky130_fd_pr__pfet_01v8
M$3110 1295 63 36 36 sky130_fd_pr__pfet_01v8 L=0.15U W=0.42U AS=0.15835P
+ AD=0.07665P PS=1.395U PD=0.785U
* device instance $3111 r0 *1 68.69,70.08 sky130_fd_pr__pfet_01v8
M$3111 1257 1132 1295 1295 sky130_fd_pr__pfet_01v8 L=0.15U W=0.42U AS=0.07665P
+ AD=0.1932P PS=0.785U PD=1.34U
* device instance $3112 r0 *1 69.76,70.08 sky130_fd_pr__pfet_01v8
M$3112 1294 1291 1257 1257 sky130_fd_pr__pfet_01v8 L=0.15U W=0.42U AS=0.1932P
+ AD=0.0441P PS=1.34U PD=0.63U
* device instance $3113 r0 *1 70.12,70.08 sky130_fd_pr__pfet_01v8
M$3113 36 1258 1294 1294 sky130_fd_pr__pfet_01v8 L=0.15U W=0.42U AS=0.0441P
+ AD=0.0693P PS=0.63U PD=0.75U
* device instance $3114 r0 *1 70.6,70.08 sky130_fd_pr__pfet_01v8
M$3114 1258 63 36 36 sky130_fd_pr__pfet_01v8 L=0.15U W=0.42U AS=0.0693P
+ AD=0.1176P PS=0.75U PD=1.4U
* device instance $3115 r0 *1 67.63,69.985 sky130_fd_pr__pfet_01v8
M$3115 36 1257 1194 1194 sky130_fd_pr__pfet_01v8 L=0.15U W=1U AS=0.26P
+ AD=0.15835P PS=2.52U PD=1.395U
* device instance $3116 r0 *1 8.29,71.305 sky130_fd_pr__pfet_01v8
M$3116 36 682 1308 1308 sky130_fd_pr__pfet_01v8 L=0.15U W=0.64U AS=0.1664P
+ AD=0.0864P PS=1.8U PD=0.91U
* device instance $3117 r0 *1 8.71,71.305 sky130_fd_pr__pfet_01v8
M$3117 1309 1308 36 36 sky130_fd_pr__pfet_01v8 L=0.15U W=0.64U AS=0.0864P
+ AD=0.1664P PS=0.91U PD=1.8U
* device instance $3118 r0 *1 9.65,71.165 sky130_fd_pr__pfet_01v8
M$3118 1310 1099 36 36 sky130_fd_pr__pfet_01v8 L=0.15U W=0.42U AS=0.1092P
+ AD=0.05775P PS=1.36U PD=0.695U
* device instance $3119 r0 *1 10.075,71.165 sky130_fd_pr__pfet_01v8
M$3119 1311 1309 1310 1310 sky130_fd_pr__pfet_01v8 L=0.15U W=0.42U AS=0.05775P
+ AD=0.06825P PS=0.695U PD=0.745U
* device instance $3120 r0 *1 10.55,71.165 sky130_fd_pr__pfet_01v8
M$3120 1329 1308 1311 1311 sky130_fd_pr__pfet_01v8 L=0.15U W=0.42U AS=0.06825P
+ AD=0.07665P PS=0.745U PD=0.785U
* device instance $3121 r0 *1 11.065,71.165 sky130_fd_pr__pfet_01v8
M$3121 36 1312 1329 1329 sky130_fd_pr__pfet_01v8 L=0.15U W=0.42U AS=0.07665P
+ AD=0.178875P PS=0.785U PD=1.26U
* device instance $3122 r0 *1 12.2,71.165 sky130_fd_pr__pfet_01v8
M$3122 1313 1308 1312 1312 sky130_fd_pr__pfet_01v8 L=0.15U W=0.42U AS=0.1095P
+ AD=0.0567P PS=1.075U PD=0.69U
* device instance $3123 r0 *1 12.62,71.165 sky130_fd_pr__pfet_01v8
M$3123 1330 1309 1313 1313 sky130_fd_pr__pfet_01v8 L=0.15U W=0.42U AS=0.0567P
+ AD=0.0882P PS=0.69U PD=0.84U
* device instance $3124 r0 *1 13.19,71.165 sky130_fd_pr__pfet_01v8
M$3124 36 1314 1330 1330 sky130_fd_pr__pfet_01v8 L=0.15U W=0.42U AS=0.0882P
+ AD=0.1113P PS=0.84U PD=1.37U
* device instance $3125 r0 *1 11.725,71.33 sky130_fd_pr__pfet_01v8
M$3125 1312 1311 36 36 sky130_fd_pr__pfet_01v8 L=0.15U W=0.75U AS=0.178875P
+ AD=0.1095P PS=1.26U PD=1.075U
* device instance $3126 r0 *1 14.24,71.455 sky130_fd_pr__pfet_01v8
M$3126 36 1313 1314 1314 sky130_fd_pr__pfet_01v8 L=0.15U W=1U AS=0.27P
+ AD=0.135P PS=2.54U PD=1.27U
* device instance $3127 r0 *1 14.66,71.455 sky130_fd_pr__pfet_01v8
M$3127 1131 1314 36 36 sky130_fd_pr__pfet_01v8 L=0.15U W=1U AS=0.135P AD=0.26P
+ PS=1.27U PD=2.52U
* device instance $3128 r0 *1 26.775,71.36 sky130_fd_pr__pfet_01v8
M$3128 1331 63 36 36 sky130_fd_pr__pfet_01v8 L=0.15U W=0.42U AS=0.15835P
+ AD=0.07665P PS=1.395U PD=0.785U
* device instance $3129 r0 *1 27.29,71.36 sky130_fd_pr__pfet_01v8
M$3129 1315 994 1331 1331 sky130_fd_pr__pfet_01v8 L=0.15U W=0.42U AS=0.07665P
+ AD=0.1932P PS=0.785U PD=1.34U
* device instance $3130 r0 *1 28.36,71.36 sky130_fd_pr__pfet_01v8
M$3130 1332 1316 1315 1315 sky130_fd_pr__pfet_01v8 L=0.15U W=0.42U AS=0.1932P
+ AD=0.0441P PS=1.34U PD=0.63U
* device instance $3131 r0 *1 28.72,71.36 sky130_fd_pr__pfet_01v8
M$3131 36 1340 1332 1332 sky130_fd_pr__pfet_01v8 L=0.15U W=0.42U AS=0.0441P
+ AD=0.0693P PS=0.63U PD=0.75U
* device instance $3132 r0 *1 29.2,71.36 sky130_fd_pr__pfet_01v8
M$3132 1340 63 36 36 sky130_fd_pr__pfet_01v8 L=0.15U W=0.42U AS=0.0693P
+ AD=0.1176P PS=0.75U PD=1.4U
* device instance $3133 r0 *1 26.23,71.455 sky130_fd_pr__pfet_01v8
M$3133 36 1315 1275 1275 sky130_fd_pr__pfet_01v8 L=0.15U W=1U AS=0.26P
+ AD=0.15835P PS=2.52U PD=1.395U
* device instance $3134 r0 *1 45.175,71.36 sky130_fd_pr__pfet_01v8
M$3134 1333 63 36 36 sky130_fd_pr__pfet_01v8 L=0.15U W=0.42U AS=0.15835P
+ AD=0.07665P PS=1.395U PD=0.785U
* device instance $3135 r0 *1 45.69,71.36 sky130_fd_pr__pfet_01v8
M$3135 1317 1115 1333 1333 sky130_fd_pr__pfet_01v8 L=0.15U W=0.42U AS=0.07665P
+ AD=0.1932P PS=0.785U PD=1.34U
* device instance $3136 r0 *1 46.76,71.36 sky130_fd_pr__pfet_01v8
M$3136 1334 1318 1317 1317 sky130_fd_pr__pfet_01v8 L=0.15U W=0.42U AS=0.1932P
+ AD=0.0441P PS=1.34U PD=0.63U
* device instance $3137 r0 *1 47.12,71.36 sky130_fd_pr__pfet_01v8
M$3137 36 1341 1334 1334 sky130_fd_pr__pfet_01v8 L=0.15U W=0.42U AS=0.0441P
+ AD=0.0693P PS=0.63U PD=0.75U
* device instance $3138 r0 *1 47.6,71.36 sky130_fd_pr__pfet_01v8
M$3138 1341 63 36 36 sky130_fd_pr__pfet_01v8 L=0.15U W=0.42U AS=0.0693P
+ AD=0.1176P PS=0.75U PD=1.4U
* device instance $3139 r0 *1 44.63,71.455 sky130_fd_pr__pfet_01v8
M$3139 36 1317 1192 1192 sky130_fd_pr__pfet_01v8 L=0.15U W=1U AS=0.26P
+ AD=0.15835P PS=2.52U PD=1.395U
* device instance $3140 r0 *1 58.5,71.165 sky130_fd_pr__pfet_01v8
M$3140 1320 1319 36 36 sky130_fd_pr__pfet_01v8 L=0.15U W=0.42U AS=0.1113P
+ AD=0.0609P PS=1.37U PD=0.71U
* device instance $3141 r0 *1 58.94,71.165 sky130_fd_pr__pfet_01v8
M$3141 36 114 1320 1320 sky130_fd_pr__pfet_01v8 L=0.15U W=0.42U AS=0.0609P
+ AD=0.1841P PS=0.71U PD=1.26U
* device instance $3142 r0 *1 59.71,71.275 sky130_fd_pr__pfet_01v8
M$3142 1279 1320 36 36 sky130_fd_pr__pfet_01v8 L=0.15U W=0.64U AS=0.1841P
+ AD=0.1696P PS=1.26U PD=1.81U
* device instance $3143 r0 *1 60.73,71.305 sky130_fd_pr__pfet_01v8
M$3143 36 980 1321 1321 sky130_fd_pr__pfet_01v8 L=0.15U W=0.64U AS=0.1664P
+ AD=0.0864P PS=1.8U PD=0.91U
* device instance $3144 r0 *1 61.15,71.305 sky130_fd_pr__pfet_01v8
M$3144 1322 1321 36 36 sky130_fd_pr__pfet_01v8 L=0.15U W=0.64U AS=0.0864P
+ AD=0.1664P PS=0.91U PD=1.8U
* device instance $3145 r0 *1 62.09,71.275 sky130_fd_pr__pfet_01v8
M$3145 1337 1290 1323 1323 sky130_fd_pr__pfet_01v8 L=0.15U W=0.64U AS=0.1664P
+ AD=0.0672P PS=1.8U PD=0.85U
* device instance $3146 r0 *1 62.45,71.275 sky130_fd_pr__pfet_01v8
M$3146 36 1324 1337 1337 sky130_fd_pr__pfet_01v8 L=0.15U W=0.64U AS=0.0672P
+ AD=0.1664P PS=0.85U PD=1.8U
* device instance $3147 r0 *1 65.115,71.165 sky130_fd_pr__pfet_01v8
M$3147 1325 1322 1323 1323 sky130_fd_pr__pfet_01v8 L=0.15U W=0.42U AS=0.15985P
+ AD=0.06405P PS=1.265U PD=0.725U
* device instance $3148 r0 *1 65.57,71.165 sky130_fd_pr__pfet_01v8
M$3148 1339 1321 1325 1325 sky130_fd_pr__pfet_01v8 L=0.15U W=0.42U AS=0.06405P
+ AD=0.07665P PS=0.725U PD=0.785U
* device instance $3149 r0 *1 66.085,71.165 sky130_fd_pr__pfet_01v8
M$3149 36 1326 1339 1339 sky130_fd_pr__pfet_01v8 L=0.15U W=0.42U AS=0.07665P
+ AD=0.178875P PS=0.785U PD=1.26U
* device instance $3150 r0 *1 63.39,71.275 sky130_fd_pr__pfet_01v8
M$3150 36 302 1324 1324 sky130_fd_pr__pfet_01v8 L=0.15U W=0.64U AS=0.1664P
+ AD=0.0928P PS=1.8U PD=0.93U
* device instance $3151 r0 *1 63.83,71.275 sky130_fd_pr__pfet_01v8
M$3151 1338 302 36 36 sky130_fd_pr__pfet_01v8 L=0.15U W=0.64U AS=0.0928P
+ AD=0.1152P PS=0.93U PD=1U
* device instance $3152 r0 *1 64.34,71.275 sky130_fd_pr__pfet_01v8
M$3152 1323 1328 1338 1338 sky130_fd_pr__pfet_01v8 L=0.15U W=0.64U AS=0.1152P
+ AD=0.15985P PS=1U PD=1.265U
* device instance $3153 r0 *1 66.745,71.33 sky130_fd_pr__pfet_01v8
M$3153 1326 1325 36 36 sky130_fd_pr__pfet_01v8 L=0.15U W=0.75U AS=0.178875P
+ AD=0.195P PS=1.26U PD=2.02U
* device instance $3154 r0 *1 65.79,75.425 sky130_fd_pr__pfet_01v8
M$3154 36 1133 1354 1354 sky130_fd_pr__pfet_01v8 L=0.15U W=1U AS=0.26P
+ AD=0.135P PS=2.52U PD=1.27U
* device instance $3155 r0 *1 66.21,75.425 sky130_fd_pr__pfet_01v8
M$3155 1280 1354 36 36 sky130_fd_pr__pfet_01v8 L=0.15U W=4U AS=0.54P AD=0.665P
+ PS=5.08U PD=6.33U
* device instance $3159 r0 *1 67.685,71.165 sky130_fd_pr__pfet_01v8
M$3159 1336 1326 36 36 sky130_fd_pr__pfet_01v8 L=0.15U W=0.42U AS=0.1092P
+ AD=0.06405P PS=1.36U PD=0.725U
* device instance $3160 r0 *1 68.14,71.165 sky130_fd_pr__pfet_01v8
M$3160 1327 1321 1336 1336 sky130_fd_pr__pfet_01v8 L=0.15U W=0.42U AS=0.06405P
+ AD=0.0567P PS=0.725U PD=0.69U
* device instance $3161 r0 *1 68.56,71.165 sky130_fd_pr__pfet_01v8
M$3161 1335 1322 1327 1327 sky130_fd_pr__pfet_01v8 L=0.15U W=0.42U AS=0.0567P
+ AD=0.0882P PS=0.69U PD=0.84U
* device instance $3162 r0 *1 69.13,71.165 sky130_fd_pr__pfet_01v8
M$3162 36 1328 1335 1335 sky130_fd_pr__pfet_01v8 L=0.15U W=0.42U AS=0.0882P
+ AD=0.1113P PS=0.84U PD=1.37U
* device instance $3163 r0 *1 70.185,71.275 sky130_fd_pr__pfet_01v8
M$3163 36 1327 1328 1328 sky130_fd_pr__pfet_01v8 L=0.15U W=0.64U AS=0.1728P
+ AD=0.154P PS=1.82U PD=1.335U
* device instance $3164 r0 *1 70.67,71.455 sky130_fd_pr__pfet_01v8
M$3164 1132 1327 36 36 sky130_fd_pr__pfet_01v8 L=0.15U W=1U AS=0.154P AD=0.28P
+ PS=1.335U PD=2.56U
.ENDS gcd
