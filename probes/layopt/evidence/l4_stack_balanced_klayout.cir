* cell l4d
.SUBCKT l4d
* net 1 VGND
* net 2 a
* net 14 b
* net 15 VPWR
* device instance $1 r0 *1 0.725,0.56 sky130_fd_pr__nfet_01v8
M$1 2 7 1 1 sky130_fd_pr__nfet_01v8 L=0.25U W=0.65U AS=0.169P AD=0.169P
+ PS=1.82U PD=1.82U
* device instance $2 r0 *1 5.55,0.56 sky130_fd_pr__nfet_01v8
M$2 13 8 1 1 sky130_fd_pr__nfet_01v8 L=0.15U W=0.65U AS=0.169P AD=0.08775P
+ PS=1.82U PD=0.92U
* device instance $3 r0 *1 5.97,0.56 sky130_fd_pr__nfet_01v8
M$3 3 2 13 13 sky130_fd_pr__nfet_01v8 L=0.15U W=0.65U AS=0.08775P AD=0.169P
+ PS=0.92U PD=1.82U
* device instance $4 r0 *1 10.59,0.56 sky130_fd_pr__nfet_01v8
M$4 14 4 1 1 sky130_fd_pr__nfet_01v8 L=0.15U W=0.65U AS=0.169P AD=0.118625P
+ PS=1.82U PD=1.015U
* device instance $5 r0 *1 11.105,0.56 sky130_fd_pr__nfet_01v8
M$5 1 9 14 14 sky130_fd_pr__nfet_01v8 L=0.15U W=0.65U AS=0.118625P AD=0.089375P
+ PS=1.015U PD=0.925U
* device instance $6 r0 *1 11.53,0.56 sky130_fd_pr__nfet_01v8
M$6 14 10 1 1 sky130_fd_pr__nfet_01v8 L=0.15U W=0.65U AS=0.089375P AD=0.08775P
+ PS=0.925U PD=0.92U
* device instance $7 r0 *1 11.95,0.56 sky130_fd_pr__nfet_01v8
M$7 1 5 14 14 sky130_fd_pr__nfet_01v8 L=0.15U W=0.65U AS=0.08775P AD=0.169P
+ PS=0.92U PD=1.82U
* device instance $8 r0 *1 20.27,0.56 sky130_fd_pr__nfet_01v8
M$8 12 11 1 1 sky130_fd_pr__nfet_01v8 L=0.15U W=0.65U AS=0.169P AD=0.08775P
+ PS=1.82U PD=0.92U
* device instance $9 r0 *1 20.69,0.56 sky130_fd_pr__nfet_01v8
M$9 6 14 12 12 sky130_fd_pr__nfet_01v8 L=0.15U W=0.65U AS=0.08775P AD=0.169P
+ PS=0.92U PD=1.82U
* device instance $10 r0 *1 0.49,4.88 sky130_fd_pr__nfet_01v8
M$10 77 58 76 76 sky130_fd_pr__nfet_01v8 L=0.15U W=0.65U AS=0.169P AD=0.08775P
+ PS=1.82U PD=0.92U
* device instance $11 r0 *1 0.91,4.88 sky130_fd_pr__nfet_01v8
M$11 22 23 77 77 sky130_fd_pr__nfet_01v8 L=0.15U W=0.65U AS=0.08775P AD=0.169P
+ PS=0.92U PD=1.82U
* device instance $12 r0 *1 1.87,4.88 sky130_fd_pr__nfet_01v8
M$12 78 59 76 76 sky130_fd_pr__nfet_01v8 L=0.15U W=0.65U AS=0.169P AD=0.08775P
+ PS=1.82U PD=0.92U
* device instance $13 r0 *1 2.29,4.88 sky130_fd_pr__nfet_01v8
M$13 24 25 78 78 sky130_fd_pr__nfet_01v8 L=0.15U W=0.65U AS=0.08775P AD=0.169P
+ PS=0.92U PD=1.82U
* device instance $14 r0 *1 3.25,4.88 sky130_fd_pr__nfet_01v8
M$14 79 60 76 76 sky130_fd_pr__nfet_01v8 L=0.15U W=0.65U AS=0.169P AD=0.08775P
+ PS=1.82U PD=0.92U
* device instance $15 r0 *1 3.67,4.88 sky130_fd_pr__nfet_01v8
M$15 26 27 79 79 sky130_fd_pr__nfet_01v8 L=0.15U W=0.65U AS=0.08775P AD=0.169P
+ PS=0.92U PD=1.82U
* device instance $16 r0 *1 4.63,4.88 sky130_fd_pr__nfet_01v8
M$16 80 61 76 76 sky130_fd_pr__nfet_01v8 L=0.15U W=0.65U AS=0.169P AD=0.08775P
+ PS=1.82U PD=0.92U
* device instance $17 r0 *1 5.05,4.88 sky130_fd_pr__nfet_01v8
M$17 28 29 80 80 sky130_fd_pr__nfet_01v8 L=0.15U W=0.65U AS=0.08775P AD=0.169P
+ PS=0.92U PD=1.82U
* device instance $18 r0 *1 6.01,4.88 sky130_fd_pr__nfet_01v8
M$18 81 62 76 76 sky130_fd_pr__nfet_01v8 L=0.15U W=0.65U AS=0.169P AD=0.08775P
+ PS=1.82U PD=0.92U
* device instance $19 r0 *1 6.43,4.88 sky130_fd_pr__nfet_01v8
M$19 30 31 81 81 sky130_fd_pr__nfet_01v8 L=0.15U W=0.65U AS=0.08775P AD=0.169P
+ PS=0.92U PD=1.82U
* device instance $20 r0 *1 7.39,4.88 sky130_fd_pr__nfet_01v8
M$20 82 63 76 76 sky130_fd_pr__nfet_01v8 L=0.15U W=0.65U AS=0.169P AD=0.08775P
+ PS=1.82U PD=0.92U
* device instance $21 r0 *1 7.81,4.88 sky130_fd_pr__nfet_01v8
M$21 32 33 82 82 sky130_fd_pr__nfet_01v8 L=0.15U W=0.65U AS=0.08775P AD=0.169P
+ PS=0.92U PD=1.82U
* device instance $22 r0 *1 8.77,4.88 sky130_fd_pr__nfet_01v8
M$22 83 64 76 76 sky130_fd_pr__nfet_01v8 L=0.15U W=0.65U AS=0.169P AD=0.08775P
+ PS=1.82U PD=0.92U
* device instance $23 r0 *1 9.19,4.88 sky130_fd_pr__nfet_01v8
M$23 34 35 83 83 sky130_fd_pr__nfet_01v8 L=0.15U W=0.65U AS=0.08775P AD=0.169P
+ PS=0.92U PD=1.82U
* device instance $24 r0 *1 10.15,4.88 sky130_fd_pr__nfet_01v8
M$24 84 65 76 76 sky130_fd_pr__nfet_01v8 L=0.15U W=0.65U AS=0.169P AD=0.08775P
+ PS=1.82U PD=0.92U
* device instance $25 r0 *1 10.57,4.88 sky130_fd_pr__nfet_01v8
M$25 36 37 84 84 sky130_fd_pr__nfet_01v8 L=0.15U W=0.65U AS=0.08775P AD=0.169P
+ PS=0.92U PD=1.82U
* device instance $26 r0 *1 11.53,4.88 sky130_fd_pr__nfet_01v8
M$26 85 66 76 76 sky130_fd_pr__nfet_01v8 L=0.15U W=0.65U AS=0.169P AD=0.08775P
+ PS=1.82U PD=0.92U
* device instance $27 r0 *1 11.95,4.88 sky130_fd_pr__nfet_01v8
M$27 38 39 85 85 sky130_fd_pr__nfet_01v8 L=0.15U W=0.65U AS=0.08775P AD=0.169P
+ PS=0.92U PD=1.82U
* device instance $28 r0 *1 12.91,4.88 sky130_fd_pr__nfet_01v8
M$28 86 67 76 76 sky130_fd_pr__nfet_01v8 L=0.15U W=0.65U AS=0.169P AD=0.08775P
+ PS=1.82U PD=0.92U
* device instance $29 r0 *1 13.33,4.88 sky130_fd_pr__nfet_01v8
M$29 40 41 86 86 sky130_fd_pr__nfet_01v8 L=0.15U W=0.65U AS=0.08775P AD=0.169P
+ PS=0.92U PD=1.82U
* device instance $30 r0 *1 14.29,4.88 sky130_fd_pr__nfet_01v8
M$30 87 68 76 76 sky130_fd_pr__nfet_01v8 L=0.15U W=0.65U AS=0.169P AD=0.08775P
+ PS=1.82U PD=0.92U
* device instance $31 r0 *1 14.71,4.88 sky130_fd_pr__nfet_01v8
M$31 42 43 87 87 sky130_fd_pr__nfet_01v8 L=0.15U W=0.65U AS=0.08775P AD=0.169P
+ PS=0.92U PD=1.82U
* device instance $32 r0 *1 15.67,4.88 sky130_fd_pr__nfet_01v8
M$32 88 69 76 76 sky130_fd_pr__nfet_01v8 L=0.15U W=0.65U AS=0.169P AD=0.08775P
+ PS=1.82U PD=0.92U
* device instance $33 r0 *1 16.09,4.88 sky130_fd_pr__nfet_01v8
M$33 44 45 88 88 sky130_fd_pr__nfet_01v8 L=0.15U W=0.65U AS=0.08775P AD=0.169P
+ PS=0.92U PD=1.82U
* device instance $34 r0 *1 17.05,4.88 sky130_fd_pr__nfet_01v8
M$34 89 70 76 76 sky130_fd_pr__nfet_01v8 L=0.15U W=0.65U AS=0.169P AD=0.08775P
+ PS=1.82U PD=0.92U
* device instance $35 r0 *1 17.47,4.88 sky130_fd_pr__nfet_01v8
M$35 46 47 89 89 sky130_fd_pr__nfet_01v8 L=0.15U W=0.65U AS=0.08775P AD=0.169P
+ PS=0.92U PD=1.82U
* device instance $36 r0 *1 18.43,4.88 sky130_fd_pr__nfet_01v8
M$36 90 71 76 76 sky130_fd_pr__nfet_01v8 L=0.15U W=0.65U AS=0.169P AD=0.08775P
+ PS=1.82U PD=0.92U
* device instance $37 r0 *1 18.85,4.88 sky130_fd_pr__nfet_01v8
M$37 48 49 90 90 sky130_fd_pr__nfet_01v8 L=0.15U W=0.65U AS=0.08775P AD=0.169P
+ PS=0.92U PD=1.82U
* device instance $38 r0 *1 19.81,4.88 sky130_fd_pr__nfet_01v8
M$38 91 72 76 76 sky130_fd_pr__nfet_01v8 L=0.15U W=0.65U AS=0.169P AD=0.08775P
+ PS=1.82U PD=0.92U
* device instance $39 r0 *1 20.23,4.88 sky130_fd_pr__nfet_01v8
M$39 50 51 91 91 sky130_fd_pr__nfet_01v8 L=0.15U W=0.65U AS=0.08775P AD=0.169P
+ PS=0.92U PD=1.82U
* device instance $40 r0 *1 21.19,4.88 sky130_fd_pr__nfet_01v8
M$40 92 73 76 76 sky130_fd_pr__nfet_01v8 L=0.15U W=0.65U AS=0.169P AD=0.08775P
+ PS=1.82U PD=0.92U
* device instance $41 r0 *1 21.61,4.88 sky130_fd_pr__nfet_01v8
M$41 52 53 92 92 sky130_fd_pr__nfet_01v8 L=0.15U W=0.65U AS=0.08775P AD=0.169P
+ PS=0.92U PD=1.82U
* device instance $42 r0 *1 22.57,4.88 sky130_fd_pr__nfet_01v8
M$42 93 74 76 76 sky130_fd_pr__nfet_01v8 L=0.15U W=0.65U AS=0.169P AD=0.08775P
+ PS=1.82U PD=0.92U
* device instance $43 r0 *1 22.99,4.88 sky130_fd_pr__nfet_01v8
M$43 54 55 93 93 sky130_fd_pr__nfet_01v8 L=0.15U W=0.65U AS=0.08775P AD=0.169P
+ PS=0.92U PD=1.82U
* device instance $44 r0 *1 23.95,4.88 sky130_fd_pr__nfet_01v8
M$44 94 75 76 76 sky130_fd_pr__nfet_01v8 L=0.15U W=0.65U AS=0.169P AD=0.08775P
+ PS=1.82U PD=0.92U
* device instance $45 r0 *1 24.37,4.88 sky130_fd_pr__nfet_01v8
M$45 56 57 94 94 sky130_fd_pr__nfet_01v8 L=0.15U W=0.65U AS=0.08775P AD=0.169P
+ PS=0.92U PD=1.82U
* device instance $46 r0 *1 0.725,1.985 sky130_fd_pr__pfet_01v8
M$46 2 7 15 15 sky130_fd_pr__pfet_01v8 L=0.25U W=1U AS=0.26P AD=0.26P PS=2.52U
+ PD=2.52U
* device instance $47 r0 *1 5.55,1.985 sky130_fd_pr__pfet_01v8
M$47 3 8 15 15 sky130_fd_pr__pfet_01v8 L=0.15U W=1U AS=0.26P AD=0.135P PS=2.52U
+ PD=1.27U
* device instance $48 r0 *1 5.97,1.985 sky130_fd_pr__pfet_01v8
M$48 15 2 3 3 sky130_fd_pr__pfet_01v8 L=0.15U W=1U AS=0.135P AD=0.26P PS=1.27U
+ PD=2.52U
* device instance $49 r0 *1 10.59,1.985 sky130_fd_pr__pfet_01v8
M$49 21 4 14 14 sky130_fd_pr__pfet_01v8 L=0.15U W=1U AS=0.26P AD=0.13P PS=2.52U
+ PD=1.26U
* device instance $50 r0 *1 11,1.985 sky130_fd_pr__pfet_01v8
M$50 20 9 21 21 sky130_fd_pr__pfet_01v8 L=0.15U W=1U AS=0.13P AD=0.19P PS=1.26U
+ PD=1.38U
* device instance $51 r0 *1 11.53,1.985 sky130_fd_pr__pfet_01v8
M$51 19 10 20 20 sky130_fd_pr__pfet_01v8 L=0.15U W=1U AS=0.19P AD=0.135P
+ PS=1.38U PD=1.27U
* device instance $52 r0 *1 11.95,1.985 sky130_fd_pr__pfet_01v8
M$52 15 5 19 19 sky130_fd_pr__pfet_01v8 L=0.15U W=1U AS=0.135P AD=0.13P
+ PS=1.27U PD=1.26U
* device instance $53 r0 *1 12.36,1.985 sky130_fd_pr__pfet_01v8
M$53 18 5 15 15 sky130_fd_pr__pfet_01v8 L=0.15U W=1U AS=0.13P AD=0.345P
+ PS=1.26U PD=1.69U
* device instance $54 r0 *1 13.2,1.985 sky130_fd_pr__pfet_01v8
M$54 17 10 18 18 sky130_fd_pr__pfet_01v8 L=0.15U W=1U AS=0.345P AD=0.4P
+ PS=1.69U PD=1.8U
* device instance $55 r0 *1 14.15,1.985 sky130_fd_pr__pfet_01v8
M$55 16 9 17 17 sky130_fd_pr__pfet_01v8 L=0.15U W=1U AS=0.4P AD=0.34P PS=1.8U
+ PD=1.68U
* device instance $56 r0 *1 14.98,1.985 sky130_fd_pr__pfet_01v8
M$56 14 4 16 16 sky130_fd_pr__pfet_01v8 L=0.15U W=1U AS=0.34P AD=0.68P PS=1.68U
+ PD=3.36U
* device instance $57 r0 *1 20.27,1.985 sky130_fd_pr__pfet_01v8
M$57 6 11 15 15 sky130_fd_pr__pfet_01v8 L=0.15U W=1U AS=0.26P AD=0.135P
+ PS=2.52U PD=1.27U
* device instance $58 r0 *1 20.69,1.985 sky130_fd_pr__pfet_01v8
M$58 15 14 6 6 sky130_fd_pr__pfet_01v8 L=0.15U W=1U AS=0.135P AD=0.26P PS=1.27U
+ PD=2.52U
* device instance $59 r0 *1 0.49,3.455 sky130_fd_pr__pfet_01v8
M$59 22 58 15 15 sky130_fd_pr__pfet_01v8 L=0.15U W=1U AS=0.26P AD=0.135P
+ PS=2.52U PD=1.27U
* device instance $60 r0 *1 0.91,3.455 sky130_fd_pr__pfet_01v8
M$60 15 23 22 22 sky130_fd_pr__pfet_01v8 L=0.15U W=1U AS=0.135P AD=0.26P
+ PS=1.27U PD=2.52U
* device instance $61 r0 *1 1.87,3.455 sky130_fd_pr__pfet_01v8
M$61 24 59 15 15 sky130_fd_pr__pfet_01v8 L=0.15U W=1U AS=0.26P AD=0.135P
+ PS=2.52U PD=1.27U
* device instance $62 r0 *1 2.29,3.455 sky130_fd_pr__pfet_01v8
M$62 15 25 24 24 sky130_fd_pr__pfet_01v8 L=0.15U W=1U AS=0.135P AD=0.26P
+ PS=1.27U PD=2.52U
* device instance $63 r0 *1 3.25,3.455 sky130_fd_pr__pfet_01v8
M$63 26 60 15 15 sky130_fd_pr__pfet_01v8 L=0.15U W=1U AS=0.26P AD=0.135P
+ PS=2.52U PD=1.27U
* device instance $64 r0 *1 3.67,3.455 sky130_fd_pr__pfet_01v8
M$64 15 27 26 26 sky130_fd_pr__pfet_01v8 L=0.15U W=1U AS=0.135P AD=0.26P
+ PS=1.27U PD=2.52U
* device instance $65 r0 *1 4.63,3.455 sky130_fd_pr__pfet_01v8
M$65 28 61 15 15 sky130_fd_pr__pfet_01v8 L=0.15U W=1U AS=0.26P AD=0.135P
+ PS=2.52U PD=1.27U
* device instance $66 r0 *1 5.05,3.455 sky130_fd_pr__pfet_01v8
M$66 15 29 28 28 sky130_fd_pr__pfet_01v8 L=0.15U W=1U AS=0.135P AD=0.26P
+ PS=1.27U PD=2.52U
* device instance $67 r0 *1 6.01,3.455 sky130_fd_pr__pfet_01v8
M$67 30 62 15 15 sky130_fd_pr__pfet_01v8 L=0.15U W=1U AS=0.26P AD=0.135P
+ PS=2.52U PD=1.27U
* device instance $68 r0 *1 6.43,3.455 sky130_fd_pr__pfet_01v8
M$68 15 31 30 30 sky130_fd_pr__pfet_01v8 L=0.15U W=1U AS=0.135P AD=0.26P
+ PS=1.27U PD=2.52U
* device instance $69 r0 *1 7.39,3.455 sky130_fd_pr__pfet_01v8
M$69 32 63 15 15 sky130_fd_pr__pfet_01v8 L=0.15U W=1U AS=0.26P AD=0.135P
+ PS=2.52U PD=1.27U
* device instance $70 r0 *1 7.81,3.455 sky130_fd_pr__pfet_01v8
M$70 15 33 32 32 sky130_fd_pr__pfet_01v8 L=0.15U W=1U AS=0.135P AD=0.26P
+ PS=1.27U PD=2.52U
* device instance $71 r0 *1 8.77,3.455 sky130_fd_pr__pfet_01v8
M$71 34 64 15 15 sky130_fd_pr__pfet_01v8 L=0.15U W=1U AS=0.26P AD=0.135P
+ PS=2.52U PD=1.27U
* device instance $72 r0 *1 9.19,3.455 sky130_fd_pr__pfet_01v8
M$72 15 35 34 34 sky130_fd_pr__pfet_01v8 L=0.15U W=1U AS=0.135P AD=0.26P
+ PS=1.27U PD=2.52U
* device instance $73 r0 *1 10.15,3.455 sky130_fd_pr__pfet_01v8
M$73 36 65 15 15 sky130_fd_pr__pfet_01v8 L=0.15U W=1U AS=0.26P AD=0.135P
+ PS=2.52U PD=1.27U
* device instance $74 r0 *1 10.57,3.455 sky130_fd_pr__pfet_01v8
M$74 15 37 36 36 sky130_fd_pr__pfet_01v8 L=0.15U W=1U AS=0.135P AD=0.26P
+ PS=1.27U PD=2.52U
* device instance $75 r0 *1 11.53,3.455 sky130_fd_pr__pfet_01v8
M$75 38 66 15 15 sky130_fd_pr__pfet_01v8 L=0.15U W=1U AS=0.26P AD=0.135P
+ PS=2.52U PD=1.27U
* device instance $76 r0 *1 11.95,3.455 sky130_fd_pr__pfet_01v8
M$76 15 39 38 38 sky130_fd_pr__pfet_01v8 L=0.15U W=1U AS=0.135P AD=0.26P
+ PS=1.27U PD=2.52U
* device instance $77 r0 *1 12.91,3.455 sky130_fd_pr__pfet_01v8
M$77 40 67 15 15 sky130_fd_pr__pfet_01v8 L=0.15U W=1U AS=0.26P AD=0.135P
+ PS=2.52U PD=1.27U
* device instance $78 r0 *1 13.33,3.455 sky130_fd_pr__pfet_01v8
M$78 15 41 40 40 sky130_fd_pr__pfet_01v8 L=0.15U W=1U AS=0.135P AD=0.26P
+ PS=1.27U PD=2.52U
* device instance $79 r0 *1 14.29,3.455 sky130_fd_pr__pfet_01v8
M$79 42 68 15 15 sky130_fd_pr__pfet_01v8 L=0.15U W=1U AS=0.26P AD=0.135P
+ PS=2.52U PD=1.27U
* device instance $80 r0 *1 14.71,3.455 sky130_fd_pr__pfet_01v8
M$80 15 43 42 42 sky130_fd_pr__pfet_01v8 L=0.15U W=1U AS=0.135P AD=0.26P
+ PS=1.27U PD=2.52U
* device instance $81 r0 *1 15.67,3.455 sky130_fd_pr__pfet_01v8
M$81 44 69 15 15 sky130_fd_pr__pfet_01v8 L=0.15U W=1U AS=0.26P AD=0.135P
+ PS=2.52U PD=1.27U
* device instance $82 r0 *1 16.09,3.455 sky130_fd_pr__pfet_01v8
M$82 15 45 44 44 sky130_fd_pr__pfet_01v8 L=0.15U W=1U AS=0.135P AD=0.26P
+ PS=1.27U PD=2.52U
* device instance $83 r0 *1 17.05,3.455 sky130_fd_pr__pfet_01v8
M$83 46 70 15 15 sky130_fd_pr__pfet_01v8 L=0.15U W=1U AS=0.26P AD=0.135P
+ PS=2.52U PD=1.27U
* device instance $84 r0 *1 17.47,3.455 sky130_fd_pr__pfet_01v8
M$84 15 47 46 46 sky130_fd_pr__pfet_01v8 L=0.15U W=1U AS=0.135P AD=0.26P
+ PS=1.27U PD=2.52U
* device instance $85 r0 *1 18.43,3.455 sky130_fd_pr__pfet_01v8
M$85 48 71 15 15 sky130_fd_pr__pfet_01v8 L=0.15U W=1U AS=0.26P AD=0.135P
+ PS=2.52U PD=1.27U
* device instance $86 r0 *1 18.85,3.455 sky130_fd_pr__pfet_01v8
M$86 15 49 48 48 sky130_fd_pr__pfet_01v8 L=0.15U W=1U AS=0.135P AD=0.26P
+ PS=1.27U PD=2.52U
* device instance $87 r0 *1 19.81,3.455 sky130_fd_pr__pfet_01v8
M$87 50 72 15 15 sky130_fd_pr__pfet_01v8 L=0.15U W=1U AS=0.26P AD=0.135P
+ PS=2.52U PD=1.27U
* device instance $88 r0 *1 20.23,3.455 sky130_fd_pr__pfet_01v8
M$88 15 51 50 50 sky130_fd_pr__pfet_01v8 L=0.15U W=1U AS=0.135P AD=0.26P
+ PS=1.27U PD=2.52U
* device instance $89 r0 *1 21.19,3.455 sky130_fd_pr__pfet_01v8
M$89 52 73 15 15 sky130_fd_pr__pfet_01v8 L=0.15U W=1U AS=0.26P AD=0.135P
+ PS=2.52U PD=1.27U
* device instance $90 r0 *1 21.61,3.455 sky130_fd_pr__pfet_01v8
M$90 15 53 52 52 sky130_fd_pr__pfet_01v8 L=0.15U W=1U AS=0.135P AD=0.26P
+ PS=1.27U PD=2.52U
* device instance $91 r0 *1 22.57,3.455 sky130_fd_pr__pfet_01v8
M$91 54 74 15 15 sky130_fd_pr__pfet_01v8 L=0.15U W=1U AS=0.26P AD=0.135P
+ PS=2.52U PD=1.27U
* device instance $92 r0 *1 22.99,3.455 sky130_fd_pr__pfet_01v8
M$92 15 55 54 54 sky130_fd_pr__pfet_01v8 L=0.15U W=1U AS=0.135P AD=0.26P
+ PS=1.27U PD=2.52U
* device instance $93 r0 *1 23.95,3.455 sky130_fd_pr__pfet_01v8
M$93 56 75 15 15 sky130_fd_pr__pfet_01v8 L=0.15U W=1U AS=0.26P AD=0.135P
+ PS=2.52U PD=1.27U
* device instance $94 r0 *1 24.37,3.455 sky130_fd_pr__pfet_01v8
M$94 15 57 56 56 sky130_fd_pr__pfet_01v8 L=0.15U W=1U AS=0.135P AD=0.26P
+ PS=1.27U PD=2.52U
.ENDS l4d
